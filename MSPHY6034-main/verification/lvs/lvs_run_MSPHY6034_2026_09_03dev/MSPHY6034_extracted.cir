* Extracted by KLayout with SG13G2 LVS runset on : 21/09/2026 23:34

.SUBCKT MSPHY6034 IOVSS|anode|cathode|guard|iovss|minus
+ analog_io[19]|anode|cathode|pad analog_io[17]|anode|cathode|pad
+ anode|cathode|pad|uo_PAD[2] anode|cathode|pad|uo_PAD[0]
+ analog_io[18]|anode|cathode|pad anode|cathode|pad|uo_PAD[3]
+ anode|cathode|pad|uo_PAD[1] anode|cathode|pad|ui_PAD[6]
+ anode|cathode|pad|ui_PAD[5] VDD|in|pad|pin1|pin2|supply|vdd
+ VSS|anode|cathode|vss IOVDD|cathode|guard|in|iovdd|pad|pin1|pin2|plus|supply
+ gate|out gate|out$1 gate|ngate|o gate|ngate|o$1 gate|ngate|o$2 gate|ngate|o$3
+ gate|o|pgate gate|o|pgate$1 gate|o|pgate$2 gate|o|pgate$3
+ analog_io_padres[19]|core|padres|vin_neg analog_io_padres[18]|core|padres
+ analog_io_padres[17]|core|padres|vin_pos core core$1 D5|c2p|core|i|uo_c2p[3]
+ D6|c2p|core|i|uo_c2p[2] D7|c2p|core|i|uo_c2p[1] c2p|core|fdac_clk|i|uo_c2p[0]
+ core|p2c|reset|rst|ui_p2c[5] gate|out$2 gate|out$3 core|done_in|p2c|ui_p2c[4]
+ core|p2c|shift_in|ui_p2c[3] clk_comp core|data_in|p2c|ui_p2c[2] X4|dout[5]
+ X5|dout[6] X7|dout[8] dout[0] En|dout[1] X1|dout[2] X2|dout[3] X3|dout[4]
+ X6|dout[7] Op Om fclk_samp anode|cathode|pad|ui_PAD[4]
+ anode|cathode|pad|uo_PAD[4] gate|ngate|o$4 gate|o|pgate$4
+ D4|c2p|core|i|uo_c2p[4] core$2 VDD VBIAS|analog_io_padres[14]|core|padres
+ X10|dout[11] X8|dout[9] X9|dout[10] OUTP|analog_io_padres[16]|core|padres
+ OUTN|analog_io_padres[15]|core|padres CLK|clk|core|fclk_in|p2c|ui_p2c[6]
+ anode|cathode|pad|ui_PAD[3] anode|cathode|pad|uo_PAD[5] gate|ngate|o$5
+ gate|o|pgate$5 D3|c2p|core|i|uo_c2p[5] core$3 anode|cathode|pad|ui_PAD[2]
+ anode|cathode|pad|uo_PAD[6] gate|ngate|o$6 gate|o|pgate$6
+ D2|c2p|core|i|uo_c2p[6] core$4 Vboot|vboot anode|cathode|pad|uo_PAD[7]
+ analog_io[16]|anode|cathode|pad gate|ngate|o$7 gate|o|pgate$7
+ D1|c2p|core|i|uo_c2p[7] anode|cathode|pad|uo_PAD[8]
+ analog_io[15]|anode|cathode|pad gate|ngate|o$8 gate|o|pgate$8
+ D0|c2p|core|i|uo_c2p[8] analog_io[0]|anode|cathode|pad
+ analog_io[14]|anode|cathode|pad analog_io_padres[0]|core|padres
+ anode|cathode|pad|ui_PAD[1] analog_io[1]|anode|cathode|pad core$5
+ analog_io_padres[1]|core|padres B|IN|Y G1|TRIG|Trig
+ VBAT|analog_io_padres[8]|core|padres VBAT2|analog_io_padres[9]|core|padres
+ Vsource analog_io[2]|anode|cathode|pad analog_io[13]|anode|cathode|pad G2|vg
+ Q|Qn Q|Reset vgmd78 VFE|X|vfe RESET|Reset|reset Qn|set VRE|X|vre vgmd5 vgmd1
+ Vs|core|p2c|ui_p2c[1] VDDLS|analog_io_padres[12]|core|padres
+ analog_io_padres[2]|core|padres VHLS|analog_io_padres[13]|core|padres IN|Y
+ B|IN|Y$1 IN|Y$1 IN|Y$2 VDD$1 IN|Y$3 IN|core|p2c|ui_p2c[0]
+ VOUT|analog_io_padres[11]|core|padres VH|analog_io_padres[10]|core|padres
+ analog_io[3]|anode|cathode|pad analog_io[12]|anode|cathode|pad
+ analog_io_padres[3]|core|padres gate|out$4 gate|out$5
+ analog_io_padres[7]|core|padres analog_io[4]|anode|cathode|pad
+ analog_io_padres[4]|core|padres analog_io[5]|anode|cathode|pad
+ analog_io_padres[5]|core|padres analog_io[6]|anode|cathode|pad
+ analog_io_padres[6]|core|padres analog_io[7]|anode|cathode|pad
+ analog_io[8]|anode|cathode|pad analog_io[9]|anode|cathode|pad
+ analog_io[10]|anode|cathode|pad analog_io[11]|anode|cathode|pad core$6
+ gate|out$6 gate|out$7 anode|cathode|pad|ui_PAD[0]
M$1 \$505 D5|c2p|core|i|uo_c2p[3] VSS|anode|cathode|vss VSS|anode|cathode|vss
+ sg13_lv_nmos L=0.13u W=2.75u AS=0.935p AD=0.935p PS=6.18u PD=6.18u rfmode=0
M$2 \$506 D5|c2p|core|i|uo_c2p[3] VSS|anode|cathode|vss VSS|anode|cathode|vss
+ sg13_lv_nmos L=0.13u W=2.75u AS=0.935p AD=0.935p PS=6.18u PD=6.18u rfmode=0
M$3 \$508 D6|c2p|core|i|uo_c2p[2] VSS|anode|cathode|vss VSS|anode|cathode|vss
+ sg13_lv_nmos L=0.13u W=2.75u AS=0.935p AD=0.935p PS=6.18u PD=6.18u rfmode=0
M$4 \$509 D6|c2p|core|i|uo_c2p[2] VSS|anode|cathode|vss VSS|anode|cathode|vss
+ sg13_lv_nmos L=0.13u W=2.75u AS=0.935p AD=0.935p PS=6.18u PD=6.18u rfmode=0
M$5 \$511 D7|c2p|core|i|uo_c2p[1] VSS|anode|cathode|vss VSS|anode|cathode|vss
+ sg13_lv_nmos L=0.13u W=2.75u AS=0.935p AD=0.935p PS=6.18u PD=6.18u rfmode=0
M$6 \$512 D7|c2p|core|i|uo_c2p[1] VSS|anode|cathode|vss VSS|anode|cathode|vss
+ sg13_lv_nmos L=0.13u W=2.75u AS=0.935p AD=0.935p PS=6.18u PD=6.18u rfmode=0
M$7 \$514 c2p|core|fdac_clk|i|uo_c2p[0] VSS|anode|cathode|vss
+ VSS|anode|cathode|vss sg13_lv_nmos L=0.13u W=2.75u AS=0.935p AD=0.935p
+ PS=6.18u PD=6.18u rfmode=0
M$8 \$515 c2p|core|fdac_clk|i|uo_c2p[0] VSS|anode|cathode|vss
+ VSS|anode|cathode|vss sg13_lv_nmos L=0.13u W=2.75u AS=0.935p AD=0.935p
+ PS=6.18u PD=6.18u rfmode=0
M$9 CLK|clk|core|fclk_in|p2c|ui_p2c[6] \$516 VSS|anode|cathode|vss
+ VSS|anode|cathode|vss sg13_lv_nmos L=0.13u W=2.75u AS=0.935p AD=0.935p
+ PS=6.18u PD=6.18u rfmode=0
M$10 core|p2c|reset|rst|ui_p2c[5] \$518 VSS|anode|cathode|vss
+ VSS|anode|cathode|vss sg13_lv_nmos L=0.13u W=2.75u AS=0.935p AD=0.935p
+ PS=6.18u PD=6.18u rfmode=0
M$11 VSS|anode|cathode|vss VDD|in|pad|pin1|pin2|supply|vdd
+ VSS|anode|cathode|vss VSS|anode|cathode|vss sg13_lv_nmos L=1u W=5864.46u
+ AS=1556.0034p AD=1556.0034p PS=16219.04u PD=16219.04u rfmode=0
M$248 VSS|anode|cathode|vss core|p2c|reset|rst|ui_p2c[5] \$728
+ VSS|anode|cathode|vss sg13_lv_nmos L=0.13u W=0.55u AS=0.14875p AD=0.187p
+ PS=1.16u PD=1.78u rfmode=0
M$249 VSS|anode|cathode|vss \$728 \$725 VSS|anode|cathode|vss sg13_lv_nmos
+ L=0.13u W=0.74u AS=0.14875p AD=0.2886p PS=1.16u PD=2.26u rfmode=0
M$1894 VSS|anode|cathode|vss core|done_in|p2c|ui_p2c[4] \$767
+ VSS|anode|cathode|vss sg13_lv_nmos L=0.13u W=0.55u AS=0.14875p AD=0.187p
+ PS=1.16u PD=1.78u rfmode=0
M$1895 \$766 \$767 VSS|anode|cathode|vss VSS|anode|cathode|vss sg13_lv_nmos
+ L=0.13u W=0.74u AS=0.2886p AD=0.14875p PS=2.26u PD=1.16u rfmode=0
M$7234 \$866 \$868 VSS|anode|cathode|vss VSS|anode|cathode|vss sg13_lv_nmos
+ L=0.13u W=0.74u AS=0.2886p AD=0.14875p PS=2.26u PD=1.16u rfmode=0
M$7235 VSS|anode|cathode|vss core|p2c|shift_in|ui_p2c[3] \$868
+ VSS|anode|cathode|vss sg13_lv_nmos L=0.13u W=0.55u AS=0.14875p AD=0.187p
+ PS=1.16u PD=1.78u rfmode=0
M$11004 VDD|in|pad|pin1|pin2|supply|vdd \$922 \$758 VSS|anode|cathode|vss
+ sg13_lv_nmos L=0.13u W=1u AS=0.34p AD=0.34p PS=2.68u PD=2.68u rfmode=0
M$11005 VSS|anode|cathode|vss \$881 \$922 VSS|anode|cathode|vss sg13_lv_nmos
+ L=0.13u W=0.4u AS=0.136p AD=0.136p PS=1.48u PD=1.48u rfmode=0
M$11006 VSS|anode|cathode|vss \$881 \$758 VSS|anode|cathode|vss sg13_lv_nmos
+ L=0.13u W=1u AS=0.34p AD=0.34p PS=2.68u PD=2.68u rfmode=0
M$11007 VDD|in|pad|pin1|pin2|supply|vdd \$923 \$784 VSS|anode|cathode|vss
+ sg13_lv_nmos L=0.13u W=1u AS=0.34p AD=0.34p PS=2.68u PD=2.68u rfmode=0
M$11008 VSS|anode|cathode|vss \$882 \$923 VSS|anode|cathode|vss sg13_lv_nmos
+ L=0.13u W=0.4u AS=0.136p AD=0.136p PS=1.48u PD=1.48u rfmode=0
M$11009 VSS|anode|cathode|vss \$882 \$784 VSS|anode|cathode|vss sg13_lv_nmos
+ L=0.13u W=1u AS=0.34p AD=0.34p PS=2.68u PD=2.68u rfmode=0
M$11010 VDD|in|pad|pin1|pin2|supply|vdd \$924 \$788 VSS|anode|cathode|vss
+ sg13_lv_nmos L=0.13u W=1u AS=0.34p AD=0.34p PS=2.68u PD=2.68u rfmode=0
M$11011 VSS|anode|cathode|vss \$883 \$924 VSS|anode|cathode|vss sg13_lv_nmos
+ L=0.13u W=0.4u AS=0.136p AD=0.136p PS=1.48u PD=1.48u rfmode=0
M$11012 VSS|anode|cathode|vss \$883 \$788 VSS|anode|cathode|vss sg13_lv_nmos
+ L=0.13u W=1u AS=0.34p AD=0.34p PS=2.68u PD=2.68u rfmode=0
M$11013 VDD|in|pad|pin1|pin2|supply|vdd \$925 \$812 VSS|anode|cathode|vss
+ sg13_lv_nmos L=0.13u W=1u AS=0.34p AD=0.34p PS=2.68u PD=2.68u rfmode=0
M$11014 VSS|anode|cathode|vss \$884 \$925 VSS|anode|cathode|vss sg13_lv_nmos
+ L=0.13u W=0.4u AS=0.136p AD=0.136p PS=1.48u PD=1.48u rfmode=0
M$11015 VSS|anode|cathode|vss \$884 \$812 VSS|anode|cathode|vss sg13_lv_nmos
+ L=0.13u W=1u AS=0.34p AD=0.34p PS=2.68u PD=2.68u rfmode=0
M$11016 VDD|in|pad|pin1|pin2|supply|vdd \$926 \$822 VSS|anode|cathode|vss
+ sg13_lv_nmos L=0.13u W=1u AS=0.34p AD=0.34p PS=2.68u PD=2.68u rfmode=0
M$11017 VSS|anode|cathode|vss \$885 \$926 VSS|anode|cathode|vss sg13_lv_nmos
+ L=0.13u W=0.4u AS=0.136p AD=0.136p PS=1.48u PD=1.48u rfmode=0
M$11018 VSS|anode|cathode|vss \$885 \$822 VSS|anode|cathode|vss sg13_lv_nmos
+ L=0.13u W=1u AS=0.34p AD=0.34p PS=2.68u PD=2.68u rfmode=0
M$11019 VDD|in|pad|pin1|pin2|supply|vdd \$927 \$825 VSS|anode|cathode|vss
+ sg13_lv_nmos L=0.13u W=1u AS=0.34p AD=0.34p PS=2.68u PD=2.68u rfmode=0
M$11020 VSS|anode|cathode|vss \$886 \$927 VSS|anode|cathode|vss sg13_lv_nmos
+ L=0.13u W=0.4u AS=0.136p AD=0.136p PS=1.48u PD=1.48u rfmode=0
M$11021 VSS|anode|cathode|vss \$886 \$825 VSS|anode|cathode|vss sg13_lv_nmos
+ L=0.13u W=1u AS=0.34p AD=0.34p PS=2.68u PD=2.68u rfmode=0
M$11022 VDD|in|pad|pin1|pin2|supply|vdd \$928 \$813 VSS|anode|cathode|vss
+ sg13_lv_nmos L=0.13u W=1u AS=0.34p AD=0.34p PS=2.68u PD=2.68u rfmode=0
M$11023 VSS|anode|cathode|vss \$887 \$928 VSS|anode|cathode|vss sg13_lv_nmos
+ L=0.13u W=0.4u AS=0.136p AD=0.136p PS=1.48u PD=1.48u rfmode=0
M$11024 VSS|anode|cathode|vss \$887 \$813 VSS|anode|cathode|vss sg13_lv_nmos
+ L=0.13u W=1u AS=0.34p AD=0.34p PS=2.68u PD=2.68u rfmode=0
M$11025 \$820 \$888 VSS|anode|cathode|vss VSS|anode|cathode|vss sg13_lv_nmos
+ L=0.13u W=1u AS=0.34p AD=0.34p PS=2.68u PD=2.68u rfmode=0
M$11026 \$929 \$888 VSS|anode|cathode|vss VSS|anode|cathode|vss sg13_lv_nmos
+ L=0.13u W=0.4u AS=0.136p AD=0.136p PS=1.48u PD=1.48u rfmode=0
M$11027 \$820 \$929 VDD|in|pad|pin1|pin2|supply|vdd VSS|anode|cathode|vss
+ sg13_lv_nmos L=0.13u W=1u AS=0.34p AD=0.34p PS=2.68u PD=2.68u rfmode=0
M$11028 \$823 \$979 VSS|anode|cathode|vss VSS|anode|cathode|vss sg13_lv_nmos
+ L=0.13u W=1u AS=0.34p AD=0.34p PS=2.68u PD=2.68u rfmode=0
M$11029 \$930 \$979 VSS|anode|cathode|vss VSS|anode|cathode|vss sg13_lv_nmos
+ L=0.13u W=0.4u AS=0.136p AD=0.136p PS=1.48u PD=1.48u rfmode=0
M$11030 \$823 \$930 VDD|in|pad|pin1|pin2|supply|vdd VSS|anode|cathode|vss
+ sg13_lv_nmos L=0.13u W=1u AS=0.34p AD=0.34p PS=2.68u PD=2.68u rfmode=0
M$11031 \$824 \$889 VSS|anode|cathode|vss VSS|anode|cathode|vss sg13_lv_nmos
+ L=0.13u W=1u AS=0.34p AD=0.34p PS=2.68u PD=2.68u rfmode=0
M$11032 \$931 \$889 VSS|anode|cathode|vss VSS|anode|cathode|vss sg13_lv_nmos
+ L=0.13u W=0.4u AS=0.136p AD=0.136p PS=1.48u PD=1.48u rfmode=0
M$11033 \$824 \$931 VDD|in|pad|pin1|pin2|supply|vdd VSS|anode|cathode|vss
+ sg13_lv_nmos L=0.13u W=1u AS=0.34p AD=0.34p PS=2.68u PD=2.68u rfmode=0
M$11034 \$814 \$890 VSS|anode|cathode|vss VSS|anode|cathode|vss sg13_lv_nmos
+ L=0.13u W=1u AS=0.34p AD=0.34p PS=2.68u PD=2.68u rfmode=0
M$11035 \$932 \$890 VSS|anode|cathode|vss VSS|anode|cathode|vss sg13_lv_nmos
+ L=0.13u W=0.4u AS=0.136p AD=0.136p PS=1.48u PD=1.48u rfmode=0
M$11036 \$814 \$932 VDD|in|pad|pin1|pin2|supply|vdd VSS|anode|cathode|vss
+ sg13_lv_nmos L=0.13u W=1u AS=0.34p AD=0.34p PS=2.68u PD=2.68u rfmode=0
M$11037 \$789 \$891 VSS|anode|cathode|vss VSS|anode|cathode|vss sg13_lv_nmos
+ L=0.13u W=1u AS=0.34p AD=0.34p PS=2.68u PD=2.68u rfmode=0
M$11038 \$933 \$891 VSS|anode|cathode|vss VSS|anode|cathode|vss sg13_lv_nmos
+ L=0.13u W=0.4u AS=0.136p AD=0.136p PS=1.48u PD=1.48u rfmode=0
M$11039 \$789 \$933 VDD|in|pad|pin1|pin2|supply|vdd VSS|anode|cathode|vss
+ sg13_lv_nmos L=0.13u W=1u AS=0.34p AD=0.34p PS=2.68u PD=2.68u rfmode=0
M$11040 \$785 \$892 VSS|anode|cathode|vss VSS|anode|cathode|vss sg13_lv_nmos
+ L=0.13u W=1u AS=0.34p AD=0.34p PS=2.68u PD=2.68u rfmode=0
M$11041 \$934 \$892 VSS|anode|cathode|vss VSS|anode|cathode|vss sg13_lv_nmos
+ L=0.13u W=0.4u AS=0.136p AD=0.136p PS=1.48u PD=1.48u rfmode=0
M$11042 \$785 \$934 VDD|in|pad|pin1|pin2|supply|vdd VSS|anode|cathode|vss
+ sg13_lv_nmos L=0.13u W=1u AS=0.34p AD=0.34p PS=2.68u PD=2.68u rfmode=0
M$11043 \$759 \$893 VSS|anode|cathode|vss VSS|anode|cathode|vss sg13_lv_nmos
+ L=0.13u W=1u AS=0.34p AD=0.34p PS=2.68u PD=2.68u rfmode=0
M$11044 \$935 \$893 VSS|anode|cathode|vss VSS|anode|cathode|vss sg13_lv_nmos
+ L=0.13u W=0.4u AS=0.136p AD=0.136p PS=1.48u PD=1.48u rfmode=0
M$11045 \$759 \$935 VDD|in|pad|pin1|pin2|supply|vdd VSS|anode|cathode|vss
+ sg13_lv_nmos L=0.13u W=1u AS=0.34p AD=0.34p PS=2.68u PD=2.68u rfmode=0
M$12394 VSS|anode|cathode|vss \$1077 \$1058 VSS|anode|cathode|vss sg13_lv_nmos
+ L=0.13u W=0.74u AS=0.2516p AD=0.2516p PS=2.16u PD=2.16u rfmode=0
M$12424 VSS|anode|cathode|vss \$1078 \$1059 VSS|anode|cathode|vss sg13_lv_nmos
+ L=0.13u W=0.55u AS=0.14875p AD=0.187p PS=1.16u PD=1.78u rfmode=0
M$12425 \$1077 \$1059 VSS|anode|cathode|vss VSS|anode|cathode|vss sg13_lv_nmos
+ L=0.13u W=0.74u AS=0.2886p AD=0.14875p PS=2.26u PD=1.16u rfmode=0
M$12444 VSS|anode|cathode|vss \$1078 \$1060 VSS|anode|cathode|vss sg13_lv_nmos
+ L=0.13u W=0.74u AS=0.2516p AD=0.2516p PS=2.16u PD=2.16u rfmode=0
M$12553 VSS|anode|cathode|vss \$866 \$1064 VSS|anode|cathode|vss sg13_lv_nmos
+ L=0.13u W=0.55u AS=0.17255p AD=0.187p PS=1.25u PD=1.78u rfmode=0
M$12554 VSS|anode|cathode|vss \$1079 \$1061 VSS|anode|cathode|vss sg13_lv_nmos
+ L=0.13u W=0.74u AS=0.2516p AD=0.1406p PS=2.16u PD=1.12u rfmode=0
M$12555 \$1061 \$1064 VSS|anode|cathode|vss VSS|anode|cathode|vss sg13_lv_nmos
+ L=0.13u W=0.74u AS=0.1406p AD=0.17255p PS=1.12u PD=1.25u rfmode=0
M$12556 VSS|anode|cathode|vss \$766 \$1062 VSS|anode|cathode|vss sg13_lv_nmos
+ L=0.13u W=0.55u AS=0.14875p AD=0.187p PS=1.16u PD=1.78u rfmode=0
M$12557 \$1079 \$1062 VSS|anode|cathode|vss VSS|anode|cathode|vss sg13_lv_nmos
+ L=0.13u W=0.74u AS=0.2886p AD=0.14875p PS=2.26u PD=1.16u rfmode=0
M$12701 \$1092 \$1077 VSS|anode|cathode|vss VSS|anode|cathode|vss sg13_lv_nmos
+ L=0.13u W=0.74u AS=0.2516p AD=0.2516p PS=2.16u PD=2.16u rfmode=0
M$12703 \$1093 \$1094 VSS|anode|cathode|vss VSS|anode|cathode|vss sg13_lv_nmos
+ L=0.13u W=0.74u AS=0.4033p AD=0.148p PS=2.57u PD=1.14u rfmode=0
M$12704 VSS|anode|cathode|vss \$1129 \$1153 VSS|anode|cathode|vss sg13_lv_nmos
+ L=0.13u W=0.74u AS=0.148p AD=0.3367p PS=1.14u PD=1.65u rfmode=0
M$12705 \$1153 \$1128 \$1094 VSS|anode|cathode|vss sg13_lv_nmos L=0.13u W=0.74u
+ AS=0.3367p AD=0.1628p PS=1.65u PD=1.18u rfmode=0
M$12706 \$1094 \$1127 \$1152 VSS|anode|cathode|vss sg13_lv_nmos L=0.13u W=0.74u
+ AS=0.1628p AD=0.13135p PS=1.18u PD=1.095u rfmode=0
M$12707 \$1152 \$1079 VSS|anode|cathode|vss VSS|anode|cathode|vss sg13_lv_nmos
+ L=0.13u W=0.74u AS=0.13135p AD=0.18945p PS=1.095u PD=1.27u rfmode=0
M$12708 VSS|anode|cathode|vss \$1079 \$1129 VSS|anode|cathode|vss sg13_lv_nmos
+ L=0.13u W=0.55u AS=0.18945p AD=0.187p PS=1.27u PD=1.78u rfmode=0
M$12709 VSS|anode|cathode|vss \$1166 \$1130 VSS|anode|cathode|vss sg13_lv_nmos
+ L=0.13u W=0.55u AS=0.18945p AD=0.187p PS=1.27u PD=1.78u rfmode=0
M$12710 VSS|anode|cathode|vss \$1166 \$1156 VSS|anode|cathode|vss sg13_lv_nmos
+ L=0.13u W=0.74u AS=0.18945p AD=0.13135p PS=1.27u PD=1.095u rfmode=0
M$12711 \$1156 \$1127 \$1095 VSS|anode|cathode|vss sg13_lv_nmos L=0.13u W=0.74u
+ AS=0.13135p AD=0.1628p PS=1.095u PD=1.18u rfmode=0
M$12712 \$1095 \$1131 \$1155 VSS|anode|cathode|vss sg13_lv_nmos L=0.13u W=0.74u
+ AS=0.1628p AD=0.3367p PS=1.18u PD=1.65u rfmode=0
M$12713 \$1155 \$1130 VSS|anode|cathode|vss VSS|anode|cathode|vss sg13_lv_nmos
+ L=0.13u W=0.74u AS=0.3367p AD=0.148p PS=1.65u PD=1.14u rfmode=0
M$12714 VSS|anode|cathode|vss \$1095 \$1096 VSS|anode|cathode|vss sg13_lv_nmos
+ L=0.13u W=0.74u AS=0.148p AD=0.4033p PS=1.14u PD=2.57u rfmode=0
M$12715 \$1133 \$1096 \$1154 VSS|anode|cathode|vss sg13_lv_nmos L=0.13u W=0.42u
+ AS=0.1428p AD=0.0609p PS=1.52u PD=0.71u rfmode=0
M$12716 \$1154 \$1058 VSS|anode|cathode|vss VSS|anode|cathode|vss sg13_lv_nmos
+ L=0.13u W=0.42u AS=0.0609p AD=0.1626p PS=0.71u PD=1.415u rfmode=0
M$12717 VSS|anode|cathode|vss \$1167 \$1097 VSS|anode|cathode|vss sg13_lv_nmos
+ L=0.13u W=0.74u AS=0.1626p AD=0.2516p PS=1.415u PD=2.16u rfmode=0
M$12718 VSS|anode|cathode|vss \$1058 \$1157 VSS|anode|cathode|vss sg13_lv_nmos
+ L=0.13u W=0.42u AS=0.1701p AD=0.0378p PS=1.65u PD=0.6u rfmode=0
M$12719 \$1157 \$1097 \$1132 VSS|anode|cathode|vss sg13_lv_nmos L=0.13u W=0.42u
+ AS=0.0378p AD=0.1428p PS=0.6u PD=1.52u rfmode=0
M$12720 \$1135 \$1098 \$1099 VSS|anode|cathode|vss sg13_lv_nmos L=0.13u W=0.42u
+ AS=0.12665p AD=0.1428p PS=1.145u PD=1.52u rfmode=0
M$12721 \$1097 \$1134 \$1135 VSS|anode|cathode|vss sg13_lv_nmos L=0.13u W=0.74u
+ AS=0.3473p AD=0.12665p PS=2.71u PD=1.145u rfmode=0
M$12722 \$1099 \$1100 VSS|anode|cathode|vss VSS|anode|cathode|vss sg13_lv_nmos
+ L=0.13u W=0.42u AS=0.1428p AD=0.0798p PS=1.52u PD=0.8u rfmode=0
M$12723 VSS|anode|cathode|vss \$1058 \$1158 VSS|anode|cathode|vss sg13_lv_nmos
+ L=0.13u W=0.42u AS=0.0798p AD=0.0378p PS=0.8u PD=0.6u rfmode=0
M$12724 \$1158 \$1135 \$1100 VSS|anode|cathode|vss sg13_lv_nmos L=0.13u W=0.42u
+ AS=0.0378p AD=0.1428p PS=0.6u PD=1.52u rfmode=0
M$12725 \$1101 \$1135 VSS|anode|cathode|vss VSS|anode|cathode|vss sg13_lv_nmos
+ L=0.13u W=0.74u AS=0.2516p AD=0.1406p PS=2.16u PD=1.12u rfmode=0
M$12726 VSS|anode|cathode|vss \$1101 \$1102 VSS|anode|cathode|vss sg13_lv_nmos
+ L=0.13u W=0.74u AS=0.1406p AD=0.2516p PS=1.12u PD=2.16u rfmode=0
M$12727 VSS|anode|cathode|vss \$1077 \$1103 VSS|anode|cathode|vss sg13_lv_nmos
+ L=0.13u W=0.74u AS=0.2516p AD=0.2516p PS=2.16u PD=2.16u rfmode=0
M$12732 VSS|anode|cathode|vss \$1166 \$1136 VSS|anode|cathode|vss sg13_lv_nmos
+ L=0.13u W=0.55u AS=0.18945p AD=0.187p PS=1.27u PD=1.78u rfmode=0
M$12733 VSS|anode|cathode|vss \$1166 \$1160 VSS|anode|cathode|vss sg13_lv_nmos
+ L=0.13u W=0.74u AS=0.18945p AD=0.13135p PS=1.27u PD=1.095u rfmode=0
M$12734 \$1160 \$1453 \$1104 VSS|anode|cathode|vss sg13_lv_nmos L=0.13u W=0.74u
+ AS=0.13135p AD=0.1628p PS=1.095u PD=1.18u rfmode=0
M$12735 \$1104 \$1458 \$1159 VSS|anode|cathode|vss sg13_lv_nmos L=0.13u W=0.74u
+ AS=0.1628p AD=0.3367p PS=1.18u PD=1.65u rfmode=0
M$12736 \$1159 \$1136 VSS|anode|cathode|vss VSS|anode|cathode|vss sg13_lv_nmos
+ L=0.13u W=0.74u AS=0.3367p AD=0.148p PS=1.65u PD=1.14u rfmode=0
M$12737 VSS|anode|cathode|vss \$1104 \$1105 VSS|anode|cathode|vss sg13_lv_nmos
+ L=0.13u W=0.74u AS=0.148p AD=0.4033p PS=1.14u PD=2.57u rfmode=0
M$12750 \$1127 \$1137 VSS|anode|cathode|vss VSS|anode|cathode|vss sg13_lv_nmos
+ L=0.13u W=0.74u AS=0.2516p AD=0.1426p PS=2.16u PD=1.16u rfmode=0
M$12751 VSS|anode|cathode|vss \$1106 \$1137 VSS|anode|cathode|vss sg13_lv_nmos
+ L=0.5u W=0.42u AS=0.1426p AD=0.1428p PS=1.16u PD=1.52u rfmode=0
M$12752 \$1106 \$1107 VSS|anode|cathode|vss VSS|anode|cathode|vss sg13_lv_nmos
+ L=0.5u W=0.42u AS=0.1428p AD=0.0798p PS=1.52u PD=0.8u rfmode=0
M$12753 VSS|anode|cathode|vss \$1138 \$1107 VSS|anode|cathode|vss sg13_lv_nmos
+ L=0.13u W=0.42u AS=0.0798p AD=0.1428p PS=0.8u PD=1.52u rfmode=0
M$12754 \$1108 \$1139 VSS|anode|cathode|vss VSS|anode|cathode|vss sg13_lv_nmos
+ L=0.13u W=0.42u AS=0.1428p AD=0.0798p PS=1.52u PD=0.8u rfmode=0
M$12755 VSS|anode|cathode|vss \$1108 \$1109 VSS|anode|cathode|vss sg13_lv_nmos
+ L=0.5u W=0.42u AS=0.0798p AD=0.1428p PS=0.8u PD=1.52u rfmode=0
M$12756 VSS|anode|cathode|vss \$1109 \$1140 VSS|anode|cathode|vss sg13_lv_nmos
+ L=0.5u W=0.42u AS=0.1426p AD=0.1428p PS=1.16u PD=1.52u rfmode=0
M$12757 VSS|anode|cathode|vss \$1140 \$1110 VSS|anode|cathode|vss sg13_lv_nmos
+ L=0.13u W=0.74u AS=0.1426p AD=0.2516p PS=1.16u PD=2.16u rfmode=0
M$12762 \$1111 \$1296 VSS|anode|cathode|vss VSS|anode|cathode|vss sg13_lv_nmos
+ L=0.13u W=0.42u AS=0.1428p AD=0.0798p PS=1.52u PD=0.8u rfmode=0
M$12763 VSS|anode|cathode|vss \$1111 \$1112 VSS|anode|cathode|vss sg13_lv_nmos
+ L=0.5u W=0.42u AS=0.0798p AD=0.1428p PS=0.8u PD=1.52u rfmode=0
M$12764 VSS|anode|cathode|vss \$1112 \$1141 VSS|anode|cathode|vss sg13_lv_nmos
+ L=0.5u W=0.42u AS=0.1426p AD=0.1428p PS=1.16u PD=1.52u rfmode=0
M$12765 VSS|anode|cathode|vss \$1141 \$1298 VSS|anode|cathode|vss sg13_lv_nmos
+ L=0.13u W=0.74u AS=0.1426p AD=0.2516p PS=1.16u PD=2.16u rfmode=0
M$12773 VSS|anode|cathode|vss \$1166 \$1142 VSS|anode|cathode|vss sg13_lv_nmos
+ L=0.13u W=0.55u AS=0.18945p AD=0.187p PS=1.27u PD=1.78u rfmode=0
M$12774 VSS|anode|cathode|vss \$1166 \$1163 VSS|anode|cathode|vss sg13_lv_nmos
+ L=0.13u W=0.74u AS=0.18945p AD=0.13135p PS=1.27u PD=1.095u rfmode=0
M$12775 \$1163 \$1143 \$1113 VSS|anode|cathode|vss sg13_lv_nmos L=0.13u W=0.74u
+ AS=0.13135p AD=0.1628p PS=1.095u PD=1.18u rfmode=0
M$12776 \$1113 \$1127 \$1162 VSS|anode|cathode|vss sg13_lv_nmos L=0.13u W=0.74u
+ AS=0.1628p AD=0.3367p PS=1.18u PD=1.65u rfmode=0
M$12777 \$1162 \$1142 VSS|anode|cathode|vss VSS|anode|cathode|vss sg13_lv_nmos
+ L=0.13u W=0.74u AS=0.3367p AD=0.148p PS=1.65u PD=1.14u rfmode=0
M$12778 VSS|anode|cathode|vss \$1113 \$1114 VSS|anode|cathode|vss sg13_lv_nmos
+ L=0.13u W=0.74u AS=0.148p AD=0.4033p PS=1.14u PD=2.57u rfmode=0
M$12779 \$1145 \$1114 \$1161 VSS|anode|cathode|vss sg13_lv_nmos L=0.13u W=0.42u
+ AS=0.1428p AD=0.0609p PS=1.52u PD=0.71u rfmode=0
M$12780 \$1161 \$1060 VSS|anode|cathode|vss VSS|anode|cathode|vss sg13_lv_nmos
+ L=0.13u W=0.42u AS=0.0609p AD=0.1626p PS=0.71u PD=1.415u rfmode=0
M$12781 VSS|anode|cathode|vss \$1168 \$1115 VSS|anode|cathode|vss sg13_lv_nmos
+ L=0.13u W=0.74u AS=0.1626p AD=0.2516p PS=1.415u PD=2.16u rfmode=0
M$12782 VSS|anode|cathode|vss \$1060 \$1164 VSS|anode|cathode|vss sg13_lv_nmos
+ L=0.13u W=0.42u AS=0.1701p AD=0.0378p PS=1.65u PD=0.6u rfmode=0
M$12783 \$1164 \$1115 \$1144 VSS|anode|cathode|vss sg13_lv_nmos L=0.13u W=0.42u
+ AS=0.0378p AD=0.1428p PS=0.6u PD=1.52u rfmode=0
M$12784 \$1147 \$1116 \$1117 VSS|anode|cathode|vss sg13_lv_nmos L=0.13u W=0.42u
+ AS=0.12665p AD=0.1428p PS=1.145u PD=1.52u rfmode=0
M$12785 \$1115 \$1146 \$1147 VSS|anode|cathode|vss sg13_lv_nmos L=0.13u W=0.74u
+ AS=0.3473p AD=0.12665p PS=2.71u PD=1.145u rfmode=0
M$12786 \$1117 \$1118 VSS|anode|cathode|vss VSS|anode|cathode|vss sg13_lv_nmos
+ L=0.13u W=0.42u AS=0.1428p AD=0.0798p PS=1.52u PD=0.8u rfmode=0
M$12787 VSS|anode|cathode|vss \$1060 \$1165 VSS|anode|cathode|vss sg13_lv_nmos
+ L=0.13u W=0.42u AS=0.0798p AD=0.0378p PS=0.8u PD=0.6u rfmode=0
M$12788 \$1165 \$1147 \$1118 VSS|anode|cathode|vss sg13_lv_nmos L=0.13u W=0.42u
+ AS=0.0378p AD=0.1428p PS=0.6u PD=1.52u rfmode=0
M$12789 \$1119 \$1147 VSS|anode|cathode|vss VSS|anode|cathode|vss sg13_lv_nmos
+ L=0.13u W=0.74u AS=0.2516p AD=0.1406p PS=2.16u PD=1.12u rfmode=0
M$12790 VSS|anode|cathode|vss \$1119 \$1138 VSS|anode|cathode|vss sg13_lv_nmos
+ L=0.13u W=0.74u AS=0.1406p AD=0.2516p PS=1.12u PD=2.16u rfmode=0
M$12817 \$1121 \$1307 VSS|anode|cathode|vss VSS|anode|cathode|vss sg13_lv_nmos
+ L=0.13u W=0.74u AS=0.2516p AD=0.2516p PS=2.16u PD=2.16u rfmode=0
M$12881 VSS|anode|cathode|vss \$1120 \$1122 VSS|anode|cathode|vss sg13_lv_nmos
+ L=0.13u W=0.74u AS=0.2516p AD=0.2516p PS=2.16u PD=2.16u rfmode=0
M$12882 VSS|anode|cathode|vss \$725 \$1148 VSS|anode|cathode|vss sg13_lv_nmos
+ L=0.13u W=0.55u AS=0.14875p AD=0.187p PS=1.16u PD=1.78u rfmode=0
M$12883 VSS|anode|cathode|vss \$1148 \$1120 VSS|anode|cathode|vss sg13_lv_nmos
+ L=0.13u W=0.74u AS=0.14875p AD=0.2886p PS=1.16u PD=2.26u rfmode=0
M$12893 VSS|anode|cathode|vss \$1120 \$1123 VSS|anode|cathode|vss sg13_lv_nmos
+ L=0.13u W=0.74u AS=0.2516p AD=0.2516p PS=2.16u PD=2.16u rfmode=0
M$12900 \$1124 \$1149 VSS|anode|cathode|vss VSS|anode|cathode|vss sg13_lv_nmos
+ L=0.13u W=0.74u AS=0.2516p AD=0.1426p PS=2.16u PD=1.16u rfmode=0
M$12901 VSS|anode|cathode|vss \$1125 \$1149 VSS|anode|cathode|vss sg13_lv_nmos
+ L=0.5u W=0.42u AS=0.1426p AD=0.1428p PS=1.16u PD=1.52u rfmode=0
M$12902 \$1125 \$1126 VSS|anode|cathode|vss VSS|anode|cathode|vss sg13_lv_nmos
+ L=0.5u W=0.42u AS=0.1428p AD=0.0798p PS=1.52u PD=0.8u rfmode=0
M$12903 VSS|anode|cathode|vss \$1150 \$1126 VSS|anode|cathode|vss sg13_lv_nmos
+ L=0.13u W=0.42u AS=0.0798p AD=0.1428p PS=0.8u PD=1.52u rfmode=0
M$12956 \$1143 \$1151 VSS|anode|cathode|vss VSS|anode|cathode|vss sg13_lv_nmos
+ L=0.13u W=0.74u AS=0.2886p AD=0.14875p PS=2.26u PD=1.16u rfmode=0
M$12957 VSS|anode|cathode|vss core|data_in|p2c|ui_p2c[2] \$1151
+ VSS|anode|cathode|vss sg13_lv_nmos L=0.13u W=0.55u AS=0.14875p AD=0.187p
+ PS=1.16u PD=1.78u rfmode=0
M$13040 \$1235 \$1239 \$1237 VSS|anode|cathode|vss sg13_lv_nmos L=0.13u W=0.42u
+ AS=0.1296p AD=0.0798p PS=1.52u PD=0.8u rfmode=0
M$13041 \$1237 \$1238 \$1290 VSS|anode|cathode|vss sg13_lv_nmos L=0.13u W=0.42u
+ AS=0.0798p AD=0.2373p PS=0.8u PD=1.97u rfmode=0
M$13042 \$1238 \$1239 VSS|anode|cathode|vss VSS|anode|cathode|vss sg13_lv_nmos
+ L=0.13u W=0.74u AS=0.2516p AD=0.317325p PS=2.16u PD=1.805u rfmode=0
M$13043 VSS|anode|cathode|vss \$1201 \$1239 VSS|anode|cathode|vss sg13_lv_nmos
+ L=0.13u W=0.74u AS=0.317325p AD=0.2516p PS=1.805u PD=2.16u rfmode=0
M$13044 \$1333 \$1239 \$1291 VSS|anode|cathode|vss sg13_lv_nmos L=0.13u W=0.42u
+ AS=0.1428p AD=0.12665p PS=1.52u PD=1.145u rfmode=0
M$13045 \$1291 \$1238 \$1236 VSS|anode|cathode|vss sg13_lv_nmos L=0.13u W=0.74u
+ AS=0.12665p AD=0.3473p PS=1.145u PD=2.71u rfmode=0
M$13046 \$1189 \$1291 VSS|anode|cathode|vss VSS|anode|cathode|vss sg13_lv_nmos
+ L=0.13u W=0.74u AS=0.2516p AD=0.1406p PS=2.16u PD=1.12u rfmode=0
M$13047 VSS|anode|cathode|vss \$1189 \$1188 VSS|anode|cathode|vss sg13_lv_nmos
+ L=0.13u W=0.74u AS=0.1406p AD=0.2516p PS=1.12u PD=2.16u rfmode=0
M$13048 VSS|anode|cathode|vss \$1191 \$1190 VSS|anode|cathode|vss sg13_lv_nmos
+ L=0.5u W=0.42u AS=0.1426p AD=0.1428p PS=1.16u PD=1.52u rfmode=0
M$13049 \$1128 \$1190 VSS|anode|cathode|vss VSS|anode|cathode|vss sg13_lv_nmos
+ L=0.13u W=0.74u AS=0.2516p AD=0.1426p PS=2.16u PD=1.16u rfmode=0
M$13050 VSS|anode|cathode|vss \$1193 \$1192 VSS|anode|cathode|vss sg13_lv_nmos
+ L=0.5u W=0.42u AS=0.1426p AD=0.1428p PS=1.16u PD=1.52u rfmode=0
M$13051 \$1131 \$1192 VSS|anode|cathode|vss VSS|anode|cathode|vss sg13_lv_nmos
+ L=0.13u W=0.74u AS=0.2516p AD=0.1426p PS=2.16u PD=1.16u rfmode=0
M$13052 \$1133 \$1098 \$1167 VSS|anode|cathode|vss sg13_lv_nmos L=0.13u W=0.42u
+ AS=0.1296p AD=0.0798p PS=1.52u PD=0.8u rfmode=0
M$13053 \$1167 \$1134 \$1132 VSS|anode|cathode|vss sg13_lv_nmos L=0.13u W=0.42u
+ AS=0.0798p AD=0.2373p PS=0.8u PD=1.97u rfmode=0
M$13054 VSS|anode|cathode|vss \$1098 \$1134 VSS|anode|cathode|vss sg13_lv_nmos
+ L=0.13u W=0.74u AS=0.317325p AD=0.2516p PS=1.805u PD=2.16u rfmode=0
M$13055 VSS|anode|cathode|vss \$1201 \$1098 VSS|anode|cathode|vss sg13_lv_nmos
+ L=0.13u W=0.74u AS=0.317325p AD=0.2516p PS=1.805u PD=2.16u rfmode=0
M$13056 \$1243 \$1166 VSS|anode|cathode|vss VSS|anode|cathode|vss sg13_lv_nmos
+ L=0.13u W=0.55u AS=0.187p AD=0.18945p PS=1.78u PD=1.27u rfmode=0
M$13057 VSS|anode|cathode|vss \$1166 \$1357 VSS|anode|cathode|vss sg13_lv_nmos
+ L=0.13u W=0.74u AS=0.18945p AD=0.13135p PS=1.27u PD=1.095u rfmode=0
M$13058 \$1357 \$1131 \$1244 VSS|anode|cathode|vss sg13_lv_nmos L=0.13u W=0.74u
+ AS=0.13135p AD=0.1628p PS=1.095u PD=1.18u rfmode=0
M$13059 \$1244 \$1453 \$1356 VSS|anode|cathode|vss sg13_lv_nmos L=0.13u W=0.74u
+ AS=0.1628p AD=0.3367p PS=1.18u PD=1.65u rfmode=0
M$13060 \$1356 \$1243 VSS|anode|cathode|vss VSS|anode|cathode|vss sg13_lv_nmos
+ L=0.13u W=0.74u AS=0.3367p AD=0.148p PS=1.65u PD=1.14u rfmode=0
M$13061 VSS|anode|cathode|vss \$1244 \$1194 VSS|anode|cathode|vss sg13_lv_nmos
+ L=0.13u W=0.74u AS=0.148p AD=0.4033p PS=1.14u PD=2.57u rfmode=0
M$13062 \$1245 \$1249 \$1247 VSS|anode|cathode|vss sg13_lv_nmos L=0.13u W=0.42u
+ AS=0.1296p AD=0.0798p PS=1.52u PD=0.8u rfmode=0
M$13063 \$1247 \$1248 \$1292 VSS|anode|cathode|vss sg13_lv_nmos L=0.13u W=0.42u
+ AS=0.0798p AD=0.2373p PS=0.8u PD=1.97u rfmode=0
M$13064 \$1248 \$1249 VSS|anode|cathode|vss VSS|anode|cathode|vss sg13_lv_nmos
+ L=0.13u W=0.74u AS=0.2516p AD=0.317325p PS=2.16u PD=1.805u rfmode=0
M$13065 VSS|anode|cathode|vss \$1201 \$1249 VSS|anode|cathode|vss sg13_lv_nmos
+ L=0.13u W=0.74u AS=0.317325p AD=0.2516p PS=1.805u PD=2.16u rfmode=0
M$13066 \$1334 \$1249 \$1293 VSS|anode|cathode|vss sg13_lv_nmos L=0.13u W=0.42u
+ AS=0.1428p AD=0.12665p PS=1.52u PD=1.145u rfmode=0
M$13067 \$1293 \$1248 \$1246 VSS|anode|cathode|vss sg13_lv_nmos L=0.13u W=0.74u
+ AS=0.12665p AD=0.3473p PS=1.145u PD=2.71u rfmode=0
M$13068 \$1195 \$1293 VSS|anode|cathode|vss VSS|anode|cathode|vss sg13_lv_nmos
+ L=0.13u W=0.74u AS=0.2516p AD=0.1406p PS=2.16u PD=1.12u rfmode=0
M$13069 VSS|anode|cathode|vss \$1195 \$1196 VSS|anode|cathode|vss sg13_lv_nmos
+ L=0.13u W=0.74u AS=0.1406p AD=0.2516p PS=1.12u PD=2.16u rfmode=0
M$13070 VSS|anode|cathode|vss \$1077 \$1197 VSS|anode|cathode|vss sg13_lv_nmos
+ L=0.13u W=0.74u AS=0.2516p AD=0.2516p PS=2.16u PD=2.16u rfmode=0
M$13071 VSS|anode|cathode|vss \$1077 \$1198 VSS|anode|cathode|vss sg13_lv_nmos
+ L=0.13u W=0.74u AS=0.2516p AD=0.2516p PS=2.16u PD=2.16u rfmode=0
M$13072 \$1251 \$1255 \$1253 VSS|anode|cathode|vss sg13_lv_nmos L=0.13u W=0.42u
+ AS=0.1296p AD=0.0798p PS=1.52u PD=0.8u rfmode=0
M$13073 \$1253 \$1254 \$1294 VSS|anode|cathode|vss sg13_lv_nmos L=0.13u W=0.42u
+ AS=0.0798p AD=0.2373p PS=0.8u PD=1.97u rfmode=0
M$13074 \$1254 \$1255 VSS|anode|cathode|vss VSS|anode|cathode|vss sg13_lv_nmos
+ L=0.13u W=0.74u AS=0.2516p AD=0.317325p PS=2.16u PD=1.805u rfmode=0
M$13075 VSS|anode|cathode|vss \$1201 \$1255 VSS|anode|cathode|vss sg13_lv_nmos
+ L=0.13u W=0.74u AS=0.317325p AD=0.2516p PS=1.805u PD=2.16u rfmode=0
M$13076 \$1335 \$1255 \$1295 VSS|anode|cathode|vss sg13_lv_nmos L=0.13u W=0.42u
+ AS=0.1428p AD=0.12665p PS=1.52u PD=1.145u rfmode=0
M$13077 \$1295 \$1254 \$1252 VSS|anode|cathode|vss sg13_lv_nmos L=0.13u W=0.74u
+ AS=0.12665p AD=0.3473p PS=1.145u PD=2.71u rfmode=0
M$13078 \$1199 \$1295 VSS|anode|cathode|vss VSS|anode|cathode|vss sg13_lv_nmos
+ L=0.13u W=0.74u AS=0.2516p AD=0.1406p PS=2.16u PD=1.12u rfmode=0
M$13079 VSS|anode|cathode|vss \$1199 \$1200 VSS|anode|cathode|vss sg13_lv_nmos
+ L=0.13u W=0.74u AS=0.1406p AD=0.2516p PS=1.12u PD=2.16u rfmode=0
M$13080 \$1257 \$1079 VSS|anode|cathode|vss VSS|anode|cathode|vss sg13_lv_nmos
+ L=0.13u W=0.55u AS=0.187p AD=0.18945p PS=1.78u PD=1.27u rfmode=0
M$13081 VSS|anode|cathode|vss \$1079 \$1365 VSS|anode|cathode|vss sg13_lv_nmos
+ L=0.13u W=0.74u AS=0.18945p AD=0.13135p PS=1.27u PD=1.095u rfmode=0
M$13082 \$1365 \$1296 \$1258 VSS|anode|cathode|vss sg13_lv_nmos L=0.13u W=0.74u
+ AS=0.13135p AD=0.1628p PS=1.095u PD=1.18u rfmode=0
M$13083 \$1258 \$1297 \$1364 VSS|anode|cathode|vss sg13_lv_nmos L=0.13u W=0.74u
+ AS=0.1628p AD=0.3367p PS=1.18u PD=1.65u rfmode=0
M$13084 \$1364 \$1257 VSS|anode|cathode|vss VSS|anode|cathode|vss sg13_lv_nmos
+ L=0.13u W=0.74u AS=0.3367p AD=0.148p PS=1.65u PD=1.14u rfmode=0
M$13085 VSS|anode|cathode|vss \$1258 \$1139 VSS|anode|cathode|vss sg13_lv_nmos
+ L=0.13u W=0.74u AS=0.148p AD=0.4033p PS=1.14u PD=2.57u rfmode=0
M$13086 VSS|anode|cathode|vss \$1202 \$1201 VSS|anode|cathode|vss sg13_lv_nmos
+ L=0.13u W=11.84u AS=2.3606p AD=2.2496p PS=18.96u PD=17.92u rfmode=0
M$13102 VSS|anode|cathode|vss \$1215 \$1202 VSS|anode|cathode|vss sg13_lv_nmos
+ L=0.13u W=4.44u AS=0.8436p AD=0.9546p PS=6.72u PD=7.76u rfmode=0
M$13108 \$1259 \$1166 VSS|anode|cathode|vss VSS|anode|cathode|vss sg13_lv_nmos
+ L=0.13u W=0.55u AS=0.187p AD=0.18945p PS=1.78u PD=1.27u rfmode=0
M$13109 VSS|anode|cathode|vss \$1166 \$1366 VSS|anode|cathode|vss sg13_lv_nmos
+ L=0.13u W=0.74u AS=0.18945p AD=0.13135p PS=1.27u PD=1.095u rfmode=0
M$13110 \$1366 \$1298 \$1260 VSS|anode|cathode|vss sg13_lv_nmos L=0.13u W=0.74u
+ AS=0.13135p AD=0.1628p PS=1.095u PD=1.18u rfmode=0
M$13111 \$1260 \$1299 \$1367 VSS|anode|cathode|vss sg13_lv_nmos L=0.13u W=0.74u
+ AS=0.1628p AD=0.3367p PS=1.18u PD=1.65u rfmode=0
M$13112 \$1367 \$1259 VSS|anode|cathode|vss VSS|anode|cathode|vss sg13_lv_nmos
+ L=0.13u W=0.74u AS=0.3367p AD=0.148p PS=1.65u PD=1.14u rfmode=0
M$13113 VSS|anode|cathode|vss \$1260 \$1203 VSS|anode|cathode|vss sg13_lv_nmos
+ L=0.13u W=0.74u AS=0.148p AD=0.4033p PS=1.14u PD=2.57u rfmode=0
M$13114 VSS|anode|cathode|vss \$1206 \$1205 VSS|anode|cathode|vss sg13_lv_nmos
+ L=0.5u W=0.42u AS=0.1426p AD=0.1428p PS=1.16u PD=1.52u rfmode=0
M$13115 \$1204 \$1205 VSS|anode|cathode|vss VSS|anode|cathode|vss sg13_lv_nmos
+ L=0.13u W=0.74u AS=0.2516p AD=0.1426p PS=2.16u PD=1.16u rfmode=0
M$13124 VSS|anode|cathode|vss \$1300 \$1208 VSS|anode|cathode|vss sg13_lv_nmos
+ L=0.13u W=0.55u AS=0.14875p AD=0.187p PS=1.16u PD=1.78u rfmode=0
M$13125 X4|dout[5] \$1208 VSS|anode|cathode|vss VSS|anode|cathode|vss
+ sg13_lv_nmos L=0.13u W=0.74u AS=0.2886p AD=0.14875p PS=2.26u PD=1.16u rfmode=0
M$13126 \$1145 \$1116 \$1168 VSS|anode|cathode|vss sg13_lv_nmos L=0.13u W=0.42u
+ AS=0.1296p AD=0.0798p PS=1.52u PD=0.8u rfmode=0
M$13127 \$1168 \$1146 \$1144 VSS|anode|cathode|vss sg13_lv_nmos L=0.13u W=0.42u
+ AS=0.0798p AD=0.2373p PS=0.8u PD=1.97u rfmode=0
M$13130 VSS|anode|cathode|vss \$1116 \$1146 VSS|anode|cathode|vss sg13_lv_nmos
+ L=0.13u W=0.74u AS=0.317325p AD=0.2516p PS=1.805u PD=2.16u rfmode=0
M$13131 VSS|anode|cathode|vss \$1201 \$1116 VSS|anode|cathode|vss sg13_lv_nmos
+ L=0.13u W=0.74u AS=0.317325p AD=0.2516p PS=1.805u PD=2.16u rfmode=0
M$13134 VSS|anode|cathode|vss \$1078 \$1209 VSS|anode|cathode|vss sg13_lv_nmos
+ L=0.13u W=0.74u AS=0.2516p AD=0.2516p PS=2.16u PD=2.16u rfmode=0
M$13135 VSS|anode|cathode|vss \$1212 \$1211 VSS|anode|cathode|vss sg13_lv_nmos
+ L=0.5u W=0.42u AS=0.1426p AD=0.1428p PS=1.16u PD=1.52u rfmode=0
M$13136 \$1210 \$1211 VSS|anode|cathode|vss VSS|anode|cathode|vss sg13_lv_nmos
+ L=0.13u W=0.74u AS=0.2516p AD=0.1426p PS=2.16u PD=1.16u rfmode=0
M$13153 VSS|anode|cathode|vss \$1302 \$1213 VSS|anode|cathode|vss sg13_lv_nmos
+ L=0.13u W=0.55u AS=0.14875p AD=0.187p PS=1.16u PD=1.78u rfmode=0
M$13154 X5|dout[6] \$1213 VSS|anode|cathode|vss VSS|anode|cathode|vss
+ sg13_lv_nmos L=0.13u W=0.74u AS=0.2886p AD=0.14875p PS=2.26u PD=1.16u rfmode=0
M$13157 VSS|anode|cathode|vss CLK|clk|core|fclk_in|p2c|ui_p2c[6] \$1214
+ VSS|anode|cathode|vss sg13_lv_nmos L=0.13u W=4.44u AS=0.9546p AD=0.8436p
+ PS=7.76u PD=6.72u rfmode=0
M$13163 VSS|anode|cathode|vss \$1214 \$1215 VSS|anode|cathode|vss sg13_lv_nmos
+ L=0.13u W=11.84u AS=2.2496p AD=2.3606p PS=17.92u PD=18.96u rfmode=0
M$13187 VSS|anode|cathode|vss \$1233 \$1217 VSS|anode|cathode|vss sg13_lv_nmos
+ L=0.13u W=0.55u AS=0.18945p AD=0.187p PS=1.27u PD=1.78u rfmode=0
M$13188 \$1216 \$1303 VSS|anode|cathode|vss VSS|anode|cathode|vss sg13_lv_nmos
+ L=0.13u W=0.74u AS=0.4033p AD=0.148p PS=2.57u PD=1.14u rfmode=0
M$13189 VSS|anode|cathode|vss \$1217 \$1369 VSS|anode|cathode|vss sg13_lv_nmos
+ L=0.13u W=0.74u AS=0.148p AD=0.3367p PS=1.14u PD=1.65u rfmode=0
M$13190 \$1369 \$1305 \$1303 VSS|anode|cathode|vss sg13_lv_nmos L=0.13u W=0.74u
+ AS=0.3367p AD=0.1628p PS=1.65u PD=1.18u rfmode=0
M$13191 \$1303 \$1304 \$1368 VSS|anode|cathode|vss sg13_lv_nmos L=0.13u W=0.74u
+ AS=0.1628p AD=0.13135p PS=1.18u PD=1.095u rfmode=0
M$13192 \$1368 \$1233 VSS|anode|cathode|vss VSS|anode|cathode|vss sg13_lv_nmos
+ L=0.13u W=0.74u AS=0.13135p AD=0.18945p PS=1.095u PD=1.27u rfmode=0
M$13195 VSS|anode|cathode|vss \$1219 \$1218 VSS|anode|cathode|vss sg13_lv_nmos
+ L=0.5u W=0.42u AS=0.1426p AD=0.1428p PS=1.16u PD=1.52u rfmode=0
M$13196 \$1305 \$1218 VSS|anode|cathode|vss VSS|anode|cathode|vss sg13_lv_nmos
+ L=0.13u W=0.74u AS=0.2516p AD=0.1426p PS=2.16u PD=1.16u rfmode=0
M$13209 VSS|anode|cathode|vss \$1307 \$1220 VSS|anode|cathode|vss sg13_lv_nmos
+ L=0.13u W=0.74u AS=0.2516p AD=0.2516p PS=2.16u PD=2.16u rfmode=0
M$13226 VSS|anode|cathode|vss \$1307 \$1221 VSS|anode|cathode|vss sg13_lv_nmos
+ L=0.13u W=0.74u AS=0.2516p AD=0.2516p PS=2.16u PD=2.16u rfmode=0
M$13227 VSS|anode|cathode|vss \$1224 \$1223 VSS|anode|cathode|vss sg13_lv_nmos
+ L=0.5u W=0.42u AS=0.1426p AD=0.1428p PS=1.16u PD=1.52u rfmode=0
M$13228 \$1222 \$1223 VSS|anode|cathode|vss VSS|anode|cathode|vss sg13_lv_nmos
+ L=0.13u W=0.74u AS=0.2516p AD=0.1426p PS=2.16u PD=1.16u rfmode=0
M$13233 \$1266 \$1352 VSS|anode|cathode|vss VSS|anode|cathode|vss sg13_lv_nmos
+ L=0.13u W=0.55u AS=0.187p AD=0.18945p PS=1.78u PD=1.27u rfmode=0
M$13234 VSS|anode|cathode|vss \$1352 \$1371 VSS|anode|cathode|vss sg13_lv_nmos
+ L=0.13u W=0.74u AS=0.18945p AD=0.13135p PS=1.27u PD=1.095u rfmode=0
M$13235 \$1371 \$1308 \$1267 VSS|anode|cathode|vss sg13_lv_nmos L=0.13u W=0.74u
+ AS=0.13135p AD=0.1628p PS=1.095u PD=1.18u rfmode=0
M$13236 \$1267 \$1309 \$1370 VSS|anode|cathode|vss sg13_lv_nmos L=0.13u W=0.74u
+ AS=0.1628p AD=0.3367p PS=1.18u PD=1.65u rfmode=0
M$13237 \$1370 \$1266 VSS|anode|cathode|vss VSS|anode|cathode|vss sg13_lv_nmos
+ L=0.13u W=0.74u AS=0.3367p AD=0.148p PS=1.65u PD=1.14u rfmode=0
M$13238 VSS|anode|cathode|vss \$1267 \$1225 VSS|anode|cathode|vss sg13_lv_nmos
+ L=0.13u W=0.74u AS=0.148p AD=0.4033p PS=1.14u PD=2.57u rfmode=0
M$13239 \$1268 \$1272 \$1270 VSS|anode|cathode|vss sg13_lv_nmos L=0.13u W=0.42u
+ AS=0.1296p AD=0.0798p PS=1.52u PD=0.8u rfmode=0
M$13240 \$1270 \$1271 \$1310 VSS|anode|cathode|vss sg13_lv_nmos L=0.13u W=0.42u
+ AS=0.0798p AD=0.2373p PS=0.8u PD=1.97u rfmode=0
M$13241 \$1271 \$1272 VSS|anode|cathode|vss VSS|anode|cathode|vss sg13_lv_nmos
+ L=0.13u W=0.74u AS=0.2516p AD=0.317325p PS=2.16u PD=1.805u rfmode=0
M$13242 VSS|anode|cathode|vss \$1311 \$1272 VSS|anode|cathode|vss sg13_lv_nmos
+ L=0.13u W=0.74u AS=0.317325p AD=0.2516p PS=1.805u PD=2.16u rfmode=0
M$13243 \$1336 \$1272 \$1312 VSS|anode|cathode|vss sg13_lv_nmos L=0.13u W=0.42u
+ AS=0.1428p AD=0.12665p PS=1.52u PD=1.145u rfmode=0
M$13244 \$1312 \$1271 \$1269 VSS|anode|cathode|vss sg13_lv_nmos L=0.13u W=0.74u
+ AS=0.12665p AD=0.3473p PS=1.145u PD=2.71u rfmode=0
M$13245 \$1226 \$1312 VSS|anode|cathode|vss VSS|anode|cathode|vss sg13_lv_nmos
+ L=0.13u W=0.74u AS=0.2516p AD=0.1406p PS=2.16u PD=1.12u rfmode=0
M$13246 VSS|anode|cathode|vss \$1226 \$1227 VSS|anode|cathode|vss sg13_lv_nmos
+ L=0.13u W=0.74u AS=0.1406p AD=0.2516p PS=1.12u PD=2.16u rfmode=0
M$13247 \$1274 \$1166 VSS|anode|cathode|vss VSS|anode|cathode|vss sg13_lv_nmos
+ L=0.13u W=0.55u AS=0.187p AD=0.18945p PS=1.78u PD=1.27u rfmode=0
M$13248 VSS|anode|cathode|vss \$1166 \$1375 VSS|anode|cathode|vss sg13_lv_nmos
+ L=0.13u W=0.74u AS=0.18945p AD=0.13135p PS=1.27u PD=1.095u rfmode=0
M$13249 \$1375 \$1309 \$1275 VSS|anode|cathode|vss sg13_lv_nmos L=0.13u W=0.74u
+ AS=0.13135p AD=0.1628p PS=1.095u PD=1.18u rfmode=0
M$13250 \$1275 \$1313 \$1374 VSS|anode|cathode|vss sg13_lv_nmos L=0.13u W=0.74u
+ AS=0.1628p AD=0.3367p PS=1.18u PD=1.65u rfmode=0
M$13251 \$1374 \$1274 VSS|anode|cathode|vss VSS|anode|cathode|vss sg13_lv_nmos
+ L=0.13u W=0.74u AS=0.3367p AD=0.148p PS=1.65u PD=1.14u rfmode=0
M$13252 VSS|anode|cathode|vss \$1275 \$1228 VSS|anode|cathode|vss sg13_lv_nmos
+ L=0.13u W=0.74u AS=0.148p AD=0.4033p PS=1.14u PD=2.57u rfmode=0
M$13253 \$1276 \$1280 \$1278 VSS|anode|cathode|vss sg13_lv_nmos L=0.13u W=0.42u
+ AS=0.1296p AD=0.0798p PS=1.52u PD=0.8u rfmode=0
M$13254 \$1278 \$1279 \$1314 VSS|anode|cathode|vss sg13_lv_nmos L=0.13u W=0.42u
+ AS=0.0798p AD=0.2373p PS=0.8u PD=1.97u rfmode=0
M$13255 \$1279 \$1280 VSS|anode|cathode|vss VSS|anode|cathode|vss sg13_lv_nmos
+ L=0.13u W=0.74u AS=0.2516p AD=0.317325p PS=2.16u PD=1.805u rfmode=0
M$13256 VSS|anode|cathode|vss \$1311 \$1280 VSS|anode|cathode|vss sg13_lv_nmos
+ L=0.13u W=0.74u AS=0.317325p AD=0.2516p PS=1.805u PD=2.16u rfmode=0
M$13257 \$1337 \$1280 \$1315 VSS|anode|cathode|vss sg13_lv_nmos L=0.13u W=0.42u
+ AS=0.1428p AD=0.12665p PS=1.52u PD=1.145u rfmode=0
M$13258 \$1315 \$1279 \$1277 VSS|anode|cathode|vss sg13_lv_nmos L=0.13u W=0.74u
+ AS=0.12665p AD=0.3473p PS=1.145u PD=2.71u rfmode=0
M$13259 \$1229 \$1315 VSS|anode|cathode|vss VSS|anode|cathode|vss sg13_lv_nmos
+ L=0.13u W=0.74u AS=0.2516p AD=0.1406p PS=2.16u PD=1.12u rfmode=0
M$13260 VSS|anode|cathode|vss \$1229 \$1230 VSS|anode|cathode|vss sg13_lv_nmos
+ L=0.13u W=0.74u AS=0.1406p AD=0.2516p PS=1.12u PD=2.16u rfmode=0
M$13261 VSS|anode|cathode|vss \$1232 \$1231 VSS|anode|cathode|vss sg13_lv_nmos
+ L=0.5u W=0.42u AS=0.1426p AD=0.1428p PS=1.16u PD=1.52u rfmode=0
M$13262 \$1313 \$1231 VSS|anode|cathode|vss VSS|anode|cathode|vss sg13_lv_nmos
+ L=0.13u W=0.74u AS=0.2516p AD=0.1426p PS=2.16u PD=1.16u rfmode=0
M$13263 VSS|anode|cathode|vss \$766 \$1234 VSS|anode|cathode|vss sg13_lv_nmos
+ L=0.13u W=0.55u AS=0.14875p AD=0.187p PS=1.16u PD=1.78u rfmode=0
M$13264 \$1233 \$1234 VSS|anode|cathode|vss VSS|anode|cathode|vss sg13_lv_nmos
+ L=0.13u W=0.74u AS=0.2886p AD=0.14875p PS=2.26u PD=1.16u rfmode=0
M$13317 VSS|anode|cathode|vss VSS|anode|cathode|vss VSS|anode|cathode|vss
+ VSS|anode|cathode|vss sg13_lv_nmos L=0.2u W=16u AS=4.24p AD=4.24p PS=26.12u
+ PD=26.12u rfmode=0
M$13318 VSS|anode|cathode|vss clk_comp \$1350 VSS|anode|cathode|vss
+ sg13_lv_nmos L=0.2u W=4u AS=0.76p AD=1.44p PS=4.38u PD=4.72u rfmode=0
M$13319 \$1350 \$1351 VSS|anode|cathode|vss VSS|anode|cathode|vss sg13_lv_nmos
+ L=0.2u W=4u AS=1.44p AD=0.76p PS=4.72u PD=4.38u rfmode=0
M$13322 VSS|anode|cathode|vss \$1350 \$1351 VSS|anode|cathode|vss sg13_lv_nmos
+ L=0.2u W=4u AS=0.76p AD=1.44p PS=4.38u PD=4.72u rfmode=0
M$13323 \$1351 clk_comp VSS|anode|cathode|vss VSS|anode|cathode|vss
+ sg13_lv_nmos L=0.2u W=4u AS=1.44p AD=0.76p PS=4.72u PD=4.38u rfmode=0
M$13409 VSS|anode|cathode|vss \$1237 \$1236 VSS|anode|cathode|vss sg13_lv_nmos
+ L=0.13u W=0.74u AS=0.1626p AD=0.2516p PS=1.415u PD=2.16u rfmode=0
M$13410 \$1235 \$1093 \$1354 VSS|anode|cathode|vss sg13_lv_nmos L=0.13u W=0.42u
+ AS=0.1428p AD=0.0609p PS=1.52u PD=0.71u rfmode=0
M$13411 VSS|anode|cathode|vss \$1092 \$1354 VSS|anode|cathode|vss sg13_lv_nmos
+ L=0.13u W=0.42u AS=0.1626p AD=0.0609p PS=1.415u PD=0.71u rfmode=0
M$13412 VSS|anode|cathode|vss \$1092 \$1353 VSS|anode|cathode|vss sg13_lv_nmos
+ L=0.13u W=0.42u AS=0.1701p AD=0.0378p PS=1.65u PD=0.6u rfmode=0
M$13413 \$1353 \$1236 \$1290 VSS|anode|cathode|vss sg13_lv_nmos L=0.13u W=0.42u
+ AS=0.0378p AD=0.1428p PS=0.6u PD=1.52u rfmode=0
M$13414 \$1446 \$1077 VSS|anode|cathode|vss VSS|anode|cathode|vss sg13_lv_nmos
+ L=0.13u W=0.74u AS=0.2516p AD=0.2516p PS=2.16u PD=2.16u rfmode=0
M$13415 \$1447 \$1448 VSS|anode|cathode|vss VSS|anode|cathode|vss sg13_lv_nmos
+ L=0.13u W=0.74u AS=0.2516p AD=0.1426p PS=2.16u PD=1.16u rfmode=0
M$13416 VSS|anode|cathode|vss \$1586 \$1448 VSS|anode|cathode|vss sg13_lv_nmos
+ L=0.5u W=0.42u AS=0.1426p AD=0.1428p PS=1.16u PD=1.52u rfmode=0
M$13417 \$1586 \$1449 VSS|anode|cathode|vss VSS|anode|cathode|vss sg13_lv_nmos
+ L=0.5u W=0.42u AS=0.1428p AD=0.0798p PS=1.52u PD=0.8u rfmode=0
M$13418 VSS|anode|cathode|vss \$1450 \$1449 VSS|anode|cathode|vss sg13_lv_nmos
+ L=0.13u W=0.42u AS=0.0798p AD=0.1428p PS=0.8u PD=1.52u rfmode=0
M$13419 \$1333 \$1240 VSS|anode|cathode|vss VSS|anode|cathode|vss sg13_lv_nmos
+ L=0.13u W=0.42u AS=0.1428p AD=0.0798p PS=1.52u PD=0.8u rfmode=0
M$13420 VSS|anode|cathode|vss \$1092 \$1355 VSS|anode|cathode|vss sg13_lv_nmos
+ L=0.13u W=0.42u AS=0.0798p AD=0.0378p PS=0.8u PD=0.6u rfmode=0
M$13421 \$1355 \$1291 \$1240 VSS|anode|cathode|vss sg13_lv_nmos L=0.13u W=0.42u
+ AS=0.0378p AD=0.1428p PS=0.6u PD=1.52u rfmode=0
M$13422 \$1450 \$1380 VSS|anode|cathode|vss VSS|anode|cathode|vss sg13_lv_nmos
+ L=0.13u W=0.74u AS=0.4033p AD=0.148p PS=2.57u PD=1.14u rfmode=0
M$13423 VSS|anode|cathode|vss \$1451 \$1535 VSS|anode|cathode|vss sg13_lv_nmos
+ L=0.13u W=0.74u AS=0.148p AD=0.3367p PS=1.14u PD=1.65u rfmode=0
M$13424 \$1535 \$1764 \$1380 VSS|anode|cathode|vss sg13_lv_nmos L=0.13u W=0.74u
+ AS=0.3367p AD=0.1628p PS=1.65u PD=1.18u rfmode=0
M$13425 \$1380 \$1131 \$1534 VSS|anode|cathode|vss sg13_lv_nmos L=0.13u W=0.74u
+ AS=0.1628p AD=0.13135p PS=1.18u PD=1.095u rfmode=0
M$13426 \$1534 \$1079 VSS|anode|cathode|vss VSS|anode|cathode|vss sg13_lv_nmos
+ L=0.13u W=0.74u AS=0.13135p AD=0.18945p PS=1.095u PD=1.27u rfmode=0
M$13427 VSS|anode|cathode|vss \$1079 \$1451 VSS|anode|cathode|vss sg13_lv_nmos
+ L=0.13u W=0.55u AS=0.18945p AD=0.187p PS=1.27u PD=1.78u rfmode=0
M$13430 \$1191 \$1241 VSS|anode|cathode|vss VSS|anode|cathode|vss sg13_lv_nmos
+ L=0.5u W=0.42u AS=0.1428p AD=0.0798p PS=1.52u PD=0.8u rfmode=0
M$13431 VSS|anode|cathode|vss \$1188 \$1241 VSS|anode|cathode|vss sg13_lv_nmos
+ L=0.13u W=0.42u AS=0.0798p AD=0.1428p PS=0.8u PD=1.52u rfmode=0
M$13432 \$1452 \$1381 VSS|anode|cathode|vss VSS|anode|cathode|vss sg13_lv_nmos
+ L=0.13u W=0.74u AS=0.4033p AD=0.148p PS=2.57u PD=1.14u rfmode=0
M$13433 VSS|anode|cathode|vss \$1587 \$1537 VSS|anode|cathode|vss sg13_lv_nmos
+ L=0.13u W=0.74u AS=0.148p AD=0.3367p PS=1.14u PD=1.65u rfmode=0
M$13434 \$1537 \$1765 \$1381 VSS|anode|cathode|vss sg13_lv_nmos L=0.13u W=0.74u
+ AS=0.3367p AD=0.1628p PS=1.65u PD=1.18u rfmode=0
M$13435 \$1381 \$1453 \$1536 VSS|anode|cathode|vss sg13_lv_nmos L=0.13u W=0.74u
+ AS=0.1628p AD=0.13135p PS=1.18u PD=1.095u rfmode=0
M$13436 \$1536 \$1079 VSS|anode|cathode|vss VSS|anode|cathode|vss sg13_lv_nmos
+ L=0.13u W=0.74u AS=0.13135p AD=0.18945p PS=1.095u PD=1.27u rfmode=0
M$13437 VSS|anode|cathode|vss \$1079 \$1587 VSS|anode|cathode|vss sg13_lv_nmos
+ L=0.13u W=0.55u AS=0.18945p AD=0.187p PS=1.27u PD=1.78u rfmode=0
M$13438 \$1193 \$1242 VSS|anode|cathode|vss VSS|anode|cathode|vss sg13_lv_nmos
+ L=0.5u W=0.42u AS=0.1428p AD=0.0798p PS=1.52u PD=0.8u rfmode=0
M$13439 VSS|anode|cathode|vss \$1102 \$1242 VSS|anode|cathode|vss sg13_lv_nmos
+ L=0.13u W=0.42u AS=0.0798p AD=0.1428p PS=0.8u PD=1.52u rfmode=0
M$13440 \$1454 \$1077 VSS|anode|cathode|vss VSS|anode|cathode|vss sg13_lv_nmos
+ L=0.13u W=0.74u AS=0.2516p AD=0.2516p PS=2.16u PD=2.16u rfmode=0
M$13443 VSS|anode|cathode|vss \$1247 \$1246 VSS|anode|cathode|vss sg13_lv_nmos
+ L=0.13u W=0.74u AS=0.1626p AD=0.2516p PS=1.415u PD=2.16u rfmode=0
M$13444 \$1245 \$1194 \$1359 VSS|anode|cathode|vss sg13_lv_nmos L=0.13u W=0.42u
+ AS=0.1428p AD=0.0609p PS=1.52u PD=0.71u rfmode=0
M$13445 VSS|anode|cathode|vss \$1103 \$1359 VSS|anode|cathode|vss sg13_lv_nmos
+ L=0.13u W=0.42u AS=0.1626p AD=0.0609p PS=1.415u PD=0.71u rfmode=0
M$13447 VSS|anode|cathode|vss \$1103 \$1358 VSS|anode|cathode|vss sg13_lv_nmos
+ L=0.13u W=0.42u AS=0.1701p AD=0.0378p PS=1.65u PD=0.6u rfmode=0
M$13448 \$1358 \$1246 \$1292 VSS|anode|cathode|vss sg13_lv_nmos L=0.13u W=0.42u
+ AS=0.0378p AD=0.1428p PS=0.6u PD=1.52u rfmode=0
M$13449 \$1453 \$1455 VSS|anode|cathode|vss VSS|anode|cathode|vss sg13_lv_nmos
+ L=0.13u W=0.74u AS=0.2516p AD=0.1426p PS=2.16u PD=1.16u rfmode=0
M$13450 VSS|anode|cathode|vss \$1588 \$1455 VSS|anode|cathode|vss sg13_lv_nmos
+ L=0.5u W=0.42u AS=0.1426p AD=0.1428p PS=1.16u PD=1.52u rfmode=0
M$13451 \$1588 \$1456 VSS|anode|cathode|vss VSS|anode|cathode|vss sg13_lv_nmos
+ L=0.5u W=0.42u AS=0.1428p AD=0.0798p PS=1.52u PD=0.8u rfmode=0
M$13452 VSS|anode|cathode|vss \$1196 \$1456 VSS|anode|cathode|vss sg13_lv_nmos
+ L=0.13u W=0.42u AS=0.0798p AD=0.1428p PS=0.8u PD=1.52u rfmode=0
M$13454 \$1334 \$1250 VSS|anode|cathode|vss VSS|anode|cathode|vss sg13_lv_nmos
+ L=0.13u W=0.42u AS=0.1428p AD=0.0798p PS=1.52u PD=0.8u rfmode=0
M$13455 VSS|anode|cathode|vss \$1103 \$1360 VSS|anode|cathode|vss sg13_lv_nmos
+ L=0.13u W=0.42u AS=0.0798p AD=0.0378p PS=0.8u PD=0.6u rfmode=0
M$13456 \$1360 \$1293 \$1250 VSS|anode|cathode|vss sg13_lv_nmos L=0.13u W=0.42u
+ AS=0.0378p AD=0.1428p PS=0.6u PD=1.52u rfmode=0
M$13457 VSS|anode|cathode|vss \$1079 \$1457 VSS|anode|cathode|vss sg13_lv_nmos
+ L=0.13u W=0.55u AS=0.18945p AD=0.187p PS=1.27u PD=1.78u rfmode=0
M$13458 VSS|anode|cathode|vss \$1079 \$1539 VSS|anode|cathode|vss sg13_lv_nmos
+ L=0.13u W=0.74u AS=0.18945p AD=0.13135p PS=1.27u PD=1.095u rfmode=0
M$13459 \$1539 \$1458 \$1382 VSS|anode|cathode|vss sg13_lv_nmos L=0.13u W=0.74u
+ AS=0.13135p AD=0.1628p PS=1.095u PD=1.18u rfmode=0
M$13460 \$1382 \$1772 \$1538 VSS|anode|cathode|vss sg13_lv_nmos L=0.13u W=0.74u
+ AS=0.1628p AD=0.3367p PS=1.18u PD=1.65u rfmode=0
M$13461 \$1538 \$1457 VSS|anode|cathode|vss VSS|anode|cathode|vss sg13_lv_nmos
+ L=0.13u W=0.74u AS=0.3367p AD=0.148p PS=1.65u PD=1.14u rfmode=0
M$13462 VSS|anode|cathode|vss \$1382 \$1459 VSS|anode|cathode|vss sg13_lv_nmos
+ L=0.13u W=0.74u AS=0.148p AD=0.4033p PS=1.14u PD=2.57u rfmode=0
M$13463 \$1460 \$1459 VSS|anode|cathode|vss VSS|anode|cathode|vss sg13_lv_nmos
+ L=0.13u W=0.42u AS=0.1428p AD=0.0798p PS=1.52u PD=0.8u rfmode=0
M$13464 VSS|anode|cathode|vss \$1460 \$1461 VSS|anode|cathode|vss sg13_lv_nmos
+ L=0.5u W=0.42u AS=0.0798p AD=0.1428p PS=0.8u PD=1.52u rfmode=0
M$13465 VSS|anode|cathode|vss \$1253 \$1252 VSS|anode|cathode|vss sg13_lv_nmos
+ L=0.13u W=0.74u AS=0.1626p AD=0.2516p PS=1.415u PD=2.16u rfmode=0
M$13466 \$1251 \$1105 \$1362 VSS|anode|cathode|vss sg13_lv_nmos L=0.13u W=0.42u
+ AS=0.1428p AD=0.0609p PS=1.52u PD=0.71u rfmode=0
M$13467 VSS|anode|cathode|vss \$1198 \$1362 VSS|anode|cathode|vss sg13_lv_nmos
+ L=0.13u W=0.42u AS=0.1626p AD=0.0609p PS=1.415u PD=0.71u rfmode=0
M$13468 VSS|anode|cathode|vss \$1461 \$1462 VSS|anode|cathode|vss sg13_lv_nmos
+ L=0.5u W=0.42u AS=0.1426p AD=0.1428p PS=1.16u PD=1.52u rfmode=0
M$13469 VSS|anode|cathode|vss \$1462 \$1463 VSS|anode|cathode|vss sg13_lv_nmos
+ L=0.13u W=0.74u AS=0.1426p AD=0.2516p PS=1.16u PD=2.16u rfmode=0
M$13471 VSS|anode|cathode|vss \$1198 \$1361 VSS|anode|cathode|vss sg13_lv_nmos
+ L=0.13u W=0.42u AS=0.1701p AD=0.0378p PS=1.65u PD=0.6u rfmode=0
M$13472 \$1361 \$1252 \$1294 VSS|anode|cathode|vss sg13_lv_nmos L=0.13u W=0.42u
+ AS=0.0378p AD=0.1428p PS=0.6u PD=1.52u rfmode=0
M$13473 \$1458 \$1464 VSS|anode|cathode|vss VSS|anode|cathode|vss sg13_lv_nmos
+ L=0.13u W=0.74u AS=0.2516p AD=0.1426p PS=2.16u PD=1.16u rfmode=0
M$13474 VSS|anode|cathode|vss \$1589 \$1464 VSS|anode|cathode|vss sg13_lv_nmos
+ L=0.5u W=0.42u AS=0.1426p AD=0.1428p PS=1.16u PD=1.52u rfmode=0
M$13475 \$1589 \$1465 VSS|anode|cathode|vss VSS|anode|cathode|vss sg13_lv_nmos
+ L=0.5u W=0.42u AS=0.1428p AD=0.0798p PS=1.52u PD=0.8u rfmode=0
M$13476 VSS|anode|cathode|vss \$1200 \$1465 VSS|anode|cathode|vss sg13_lv_nmos
+ L=0.13u W=0.42u AS=0.0798p AD=0.1428p PS=0.8u PD=1.52u rfmode=0
M$13479 \$1335 \$1256 VSS|anode|cathode|vss VSS|anode|cathode|vss sg13_lv_nmos
+ L=0.13u W=0.42u AS=0.1428p AD=0.0798p PS=1.52u PD=0.8u rfmode=0
M$13480 VSS|anode|cathode|vss \$1198 \$1363 VSS|anode|cathode|vss sg13_lv_nmos
+ L=0.13u W=0.42u AS=0.0798p AD=0.0378p PS=0.8u PD=0.6u rfmode=0
M$13481 \$1363 \$1295 \$1256 VSS|anode|cathode|vss sg13_lv_nmos L=0.13u W=0.42u
+ AS=0.0378p AD=0.1428p PS=0.6u PD=1.52u rfmode=0
M$13483 VSS|anode|cathode|vss \$1166 \$1466 VSS|anode|cathode|vss sg13_lv_nmos
+ L=0.13u W=0.55u AS=0.18945p AD=0.187p PS=1.27u PD=1.78u rfmode=0
M$13484 VSS|anode|cathode|vss \$1166 \$1541 VSS|anode|cathode|vss sg13_lv_nmos
+ L=0.13u W=0.74u AS=0.18945p AD=0.13135p PS=1.27u PD=1.095u rfmode=0
M$13485 \$1541 \$1458 \$1383 VSS|anode|cathode|vss sg13_lv_nmos L=0.13u W=0.74u
+ AS=0.13135p AD=0.1628p PS=1.095u PD=1.18u rfmode=0
M$13486 \$1383 \$1298 \$1540 VSS|anode|cathode|vss sg13_lv_nmos L=0.13u W=0.74u
+ AS=0.1628p AD=0.3367p PS=1.18u PD=1.65u rfmode=0
M$13487 \$1540 \$1466 VSS|anode|cathode|vss VSS|anode|cathode|vss sg13_lv_nmos
+ L=0.13u W=0.74u AS=0.3367p AD=0.148p PS=1.65u PD=1.14u rfmode=0
M$13488 VSS|anode|cathode|vss \$1383 \$1467 VSS|anode|cathode|vss sg13_lv_nmos
+ L=0.13u W=0.74u AS=0.148p AD=0.4033p PS=1.14u PD=2.57u rfmode=0
M$13489 \$1468 \$1078 VSS|anode|cathode|vss VSS|anode|cathode|vss sg13_lv_nmos
+ L=0.13u W=0.74u AS=0.2516p AD=0.2516p PS=2.16u PD=2.16u rfmode=0
M$13490 VSS|anode|cathode|vss \$1077 \$1469 VSS|anode|cathode|vss sg13_lv_nmos
+ L=0.13u W=0.74u AS=0.2516p AD=0.2516p PS=2.16u PD=2.16u rfmode=0
M$13491 \$1384 \$1467 \$1543 VSS|anode|cathode|vss sg13_lv_nmos L=0.13u W=0.42u
+ AS=0.1428p AD=0.0609p PS=1.52u PD=0.71u rfmode=0
M$13492 \$1543 \$1469 VSS|anode|cathode|vss VSS|anode|cathode|vss sg13_lv_nmos
+ L=0.13u W=0.42u AS=0.0609p AD=0.1626p PS=0.71u PD=1.415u rfmode=0
M$13493 VSS|anode|cathode|vss \$1623 \$1385 VSS|anode|cathode|vss sg13_lv_nmos
+ L=0.13u W=0.74u AS=0.1626p AD=0.2516p PS=1.415u PD=2.16u rfmode=0
M$13494 VSS|anode|cathode|vss \$1469 \$1542 VSS|anode|cathode|vss sg13_lv_nmos
+ L=0.13u W=0.42u AS=0.1701p AD=0.0378p PS=1.65u PD=0.6u rfmode=0
M$13495 \$1542 \$1385 \$1470 VSS|anode|cathode|vss sg13_lv_nmos L=0.13u W=0.42u
+ AS=0.0378p AD=0.1428p PS=0.6u PD=1.52u rfmode=0
M$13496 \$1471 \$1386 \$1387 VSS|anode|cathode|vss sg13_lv_nmos L=0.13u W=0.42u
+ AS=0.12665p AD=0.1428p PS=1.145u PD=1.52u rfmode=0
M$13497 \$1385 \$1624 \$1471 VSS|anode|cathode|vss sg13_lv_nmos L=0.13u W=0.74u
+ AS=0.3473p AD=0.12665p PS=2.71u PD=1.145u rfmode=0
M$13499 \$1387 \$1388 VSS|anode|cathode|vss VSS|anode|cathode|vss sg13_lv_nmos
+ L=0.13u W=0.42u AS=0.1428p AD=0.0798p PS=1.52u PD=0.8u rfmode=0
M$13500 VSS|anode|cathode|vss \$1469 \$1544 VSS|anode|cathode|vss sg13_lv_nmos
+ L=0.13u W=0.42u AS=0.0798p AD=0.0378p PS=0.8u PD=0.6u rfmode=0
M$13501 \$1544 \$1471 \$1388 VSS|anode|cathode|vss sg13_lv_nmos L=0.13u W=0.42u
+ AS=0.0378p AD=0.1428p PS=0.6u PD=1.52u rfmode=0
M$13502 \$1389 \$1471 VSS|anode|cathode|vss VSS|anode|cathode|vss sg13_lv_nmos
+ L=0.13u W=0.74u AS=0.2516p AD=0.1406p PS=2.16u PD=1.12u rfmode=0
M$13503 VSS|anode|cathode|vss \$1389 \$1296 VSS|anode|cathode|vss sg13_lv_nmos
+ L=0.13u W=0.74u AS=0.1406p AD=0.2516p PS=1.12u PD=2.16u rfmode=0
M$13504 VSS|anode|cathode|vss \$1078 \$1472 VSS|anode|cathode|vss sg13_lv_nmos
+ L=0.13u W=0.74u AS=0.2516p AD=0.2516p PS=2.16u PD=2.16u rfmode=0
M$13505 \$1390 \$1204 \$1546 VSS|anode|cathode|vss sg13_lv_nmos L=0.13u W=0.42u
+ AS=0.1428p AD=0.0609p PS=1.52u PD=0.71u rfmode=0
M$13506 \$1546 \$1472 VSS|anode|cathode|vss VSS|anode|cathode|vss sg13_lv_nmos
+ L=0.13u W=0.42u AS=0.0609p AD=0.1626p PS=0.71u PD=1.415u rfmode=0
M$13507 VSS|anode|cathode|vss \$1625 \$1391 VSS|anode|cathode|vss sg13_lv_nmos
+ L=0.13u W=0.74u AS=0.1626p AD=0.2516p PS=1.415u PD=2.16u rfmode=0
M$13508 VSS|anode|cathode|vss \$1472 \$1545 VSS|anode|cathode|vss sg13_lv_nmos
+ L=0.13u W=0.42u AS=0.1701p AD=0.0378p PS=1.65u PD=0.6u rfmode=0
M$13509 \$1545 \$1391 \$1473 VSS|anode|cathode|vss sg13_lv_nmos L=0.13u W=0.42u
+ AS=0.0378p AD=0.1428p PS=0.6u PD=1.52u rfmode=0
M$13510 \$1206 \$1261 VSS|anode|cathode|vss VSS|anode|cathode|vss sg13_lv_nmos
+ L=0.5u W=0.42u AS=0.1428p AD=0.0798p PS=1.52u PD=0.8u rfmode=0
M$13511 VSS|anode|cathode|vss \$1203 \$1261 VSS|anode|cathode|vss sg13_lv_nmos
+ L=0.13u W=0.42u AS=0.0798p AD=0.1428p PS=0.8u PD=1.52u rfmode=0
M$13512 \$1474 \$1392 \$1393 VSS|anode|cathode|vss sg13_lv_nmos L=0.13u W=0.42u
+ AS=0.12665p AD=0.1428p PS=1.145u PD=1.52u rfmode=0
M$13513 \$1391 \$1626 \$1474 VSS|anode|cathode|vss sg13_lv_nmos L=0.13u W=0.74u
+ AS=0.3473p AD=0.12665p PS=2.71u PD=1.145u rfmode=0
M$13514 \$1393 \$1394 VSS|anode|cathode|vss VSS|anode|cathode|vss sg13_lv_nmos
+ L=0.13u W=0.42u AS=0.1428p AD=0.0798p PS=1.52u PD=0.8u rfmode=0
M$13515 VSS|anode|cathode|vss \$1472 \$1547 VSS|anode|cathode|vss sg13_lv_nmos
+ L=0.13u W=0.42u AS=0.0798p AD=0.0378p PS=0.8u PD=0.6u rfmode=0
M$13516 \$1547 \$1474 \$1394 VSS|anode|cathode|vss sg13_lv_nmos L=0.13u W=0.42u
+ AS=0.0378p AD=0.1428p PS=0.6u PD=1.52u rfmode=0
M$13517 \$1395 \$1474 VSS|anode|cathode|vss VSS|anode|cathode|vss sg13_lv_nmos
+ L=0.13u W=0.74u AS=0.2516p AD=0.1406p PS=2.16u PD=1.12u rfmode=0
M$13518 VSS|anode|cathode|vss \$1395 \$1299 VSS|anode|cathode|vss sg13_lv_nmos
+ L=0.13u W=0.74u AS=0.1406p AD=0.2516p PS=1.12u PD=2.16u rfmode=0
M$13519 VSS|anode|cathode|vss \$1078 \$1475 VSS|anode|cathode|vss sg13_lv_nmos
+ L=0.13u W=0.74u AS=0.2516p AD=0.2516p PS=2.16u PD=2.16u rfmode=0
M$13520 \$1476 \$1396 VSS|anode|cathode|vss VSS|anode|cathode|vss sg13_lv_nmos
+ L=0.13u W=0.74u AS=0.4033p AD=0.148p PS=2.57u PD=1.14u rfmode=0
M$13521 VSS|anode|cathode|vss \$1590 \$1549 VSS|anode|cathode|vss sg13_lv_nmos
+ L=0.13u W=0.74u AS=0.148p AD=0.3367p PS=1.14u PD=1.65u rfmode=0
M$13522 \$1549 \$1591 \$1396 VSS|anode|cathode|vss sg13_lv_nmos L=0.13u W=0.74u
+ AS=0.3367p AD=0.1628p PS=1.65u PD=1.18u rfmode=0
M$13523 \$1396 \$1299 \$1548 VSS|anode|cathode|vss sg13_lv_nmos L=0.13u W=0.74u
+ AS=0.1628p AD=0.13135p PS=1.18u PD=1.095u rfmode=0
M$13524 \$1548 \$1079 VSS|anode|cathode|vss VSS|anode|cathode|vss sg13_lv_nmos
+ L=0.13u W=0.74u AS=0.13135p AD=0.18945p PS=1.095u PD=1.27u rfmode=0
M$13525 VSS|anode|cathode|vss \$1079 \$1590 VSS|anode|cathode|vss sg13_lv_nmos
+ L=0.13u W=0.55u AS=0.18945p AD=0.187p PS=1.27u PD=1.78u rfmode=0
M$13527 \$1477 \$1299 VSS|anode|cathode|vss VSS|anode|cathode|vss sg13_lv_nmos
+ L=0.13u W=0.42u AS=0.1428p AD=0.0798p PS=1.52u PD=0.8u rfmode=0
M$13528 VSS|anode|cathode|vss \$1477 \$1478 VSS|anode|cathode|vss sg13_lv_nmos
+ L=0.5u W=0.42u AS=0.0798p AD=0.1428p PS=0.8u PD=1.52u rfmode=0
M$13529 VSS|anode|cathode|vss \$1478 \$1479 VSS|anode|cathode|vss sg13_lv_nmos
+ L=0.5u W=0.42u AS=0.1426p AD=0.1428p PS=1.16u PD=1.52u rfmode=0
M$13530 VSS|anode|cathode|vss \$1479 \$1480 VSS|anode|cathode|vss sg13_lv_nmos
+ L=0.13u W=0.74u AS=0.1426p AD=0.2516p PS=1.16u PD=2.16u rfmode=0
M$13532 VSS|anode|cathode|vss \$1166 \$1481 VSS|anode|cathode|vss sg13_lv_nmos
+ L=0.13u W=0.55u AS=0.18945p AD=0.187p PS=1.27u PD=1.78u rfmode=0
M$13533 VSS|anode|cathode|vss \$1166 \$1550 VSS|anode|cathode|vss sg13_lv_nmos
+ L=0.13u W=0.74u AS=0.18945p AD=0.13135p PS=1.27u PD=1.095u rfmode=0
M$13534 \$1550 \$1480 \$1397 VSS|anode|cathode|vss sg13_lv_nmos L=0.13u W=0.74u
+ AS=0.13135p AD=0.1628p PS=1.095u PD=1.18u rfmode=0
M$13535 \$1397 \$1404 \$1555 VSS|anode|cathode|vss sg13_lv_nmos L=0.13u W=0.74u
+ AS=0.1628p AD=0.3367p PS=1.18u PD=1.65u rfmode=0
M$13536 \$1555 \$1481 VSS|anode|cathode|vss VSS|anode|cathode|vss sg13_lv_nmos
+ L=0.13u W=0.74u AS=0.3367p AD=0.148p PS=1.65u PD=1.14u rfmode=0
M$13537 VSS|anode|cathode|vss \$1397 \$1301 VSS|anode|cathode|vss sg13_lv_nmos
+ L=0.13u W=0.74u AS=0.148p AD=0.4033p PS=1.14u PD=2.57u rfmode=0
M$13538 \$1398 \$1210 \$1553 VSS|anode|cathode|vss sg13_lv_nmos L=0.13u W=0.42u
+ AS=0.1428p AD=0.0609p PS=1.52u PD=0.71u rfmode=0
M$13539 \$1553 \$1209 VSS|anode|cathode|vss VSS|anode|cathode|vss sg13_lv_nmos
+ L=0.13u W=0.42u AS=0.0609p AD=0.1626p PS=0.71u PD=1.415u rfmode=0
M$13540 VSS|anode|cathode|vss \$1627 \$1399 VSS|anode|cathode|vss sg13_lv_nmos
+ L=0.13u W=0.74u AS=0.1626p AD=0.2516p PS=1.415u PD=2.16u rfmode=0
M$13541 VSS|anode|cathode|vss \$1209 \$1552 VSS|anode|cathode|vss sg13_lv_nmos
+ L=0.13u W=0.42u AS=0.1701p AD=0.0378p PS=1.65u PD=0.6u rfmode=0
M$13542 \$1552 \$1399 \$1482 VSS|anode|cathode|vss sg13_lv_nmos L=0.13u W=0.42u
+ AS=0.0378p AD=0.1428p PS=0.6u PD=1.52u rfmode=0
M$13543 \$1212 \$1262 VSS|anode|cathode|vss VSS|anode|cathode|vss sg13_lv_nmos
+ L=0.5u W=0.42u AS=0.1428p AD=0.0798p PS=1.52u PD=0.8u rfmode=0
M$13544 VSS|anode|cathode|vss \$1301 \$1262 VSS|anode|cathode|vss sg13_lv_nmos
+ L=0.13u W=0.42u AS=0.0798p AD=0.1428p PS=0.8u PD=1.52u rfmode=0
M$13545 \$1483 \$1400 \$1401 VSS|anode|cathode|vss sg13_lv_nmos L=0.13u W=0.42u
+ AS=0.12665p AD=0.1428p PS=1.145u PD=1.52u rfmode=0
M$13546 \$1399 \$1628 \$1483 VSS|anode|cathode|vss sg13_lv_nmos L=0.13u W=0.74u
+ AS=0.3473p AD=0.12665p PS=2.71u PD=1.145u rfmode=0
M$13547 \$1401 \$1402 VSS|anode|cathode|vss VSS|anode|cathode|vss sg13_lv_nmos
+ L=0.13u W=0.42u AS=0.1428p AD=0.0798p PS=1.52u PD=0.8u rfmode=0
M$13548 VSS|anode|cathode|vss \$1209 \$1557 VSS|anode|cathode|vss sg13_lv_nmos
+ L=0.13u W=0.42u AS=0.0798p AD=0.0378p PS=0.8u PD=0.6u rfmode=0
M$13549 \$1557 \$1483 \$1402 VSS|anode|cathode|vss sg13_lv_nmos L=0.13u W=0.42u
+ AS=0.0378p AD=0.1428p PS=0.6u PD=1.52u rfmode=0
M$13550 \$1403 \$1483 VSS|anode|cathode|vss VSS|anode|cathode|vss sg13_lv_nmos
+ L=0.13u W=0.74u AS=0.2516p AD=0.1406p PS=2.16u PD=1.12u rfmode=0
M$13551 VSS|anode|cathode|vss \$1403 \$1404 VSS|anode|cathode|vss sg13_lv_nmos
+ L=0.13u W=0.74u AS=0.1406p AD=0.2516p PS=1.12u PD=2.16u rfmode=0
M$13556 VSS|anode|cathode|vss \$1078 \$1484 VSS|anode|cathode|vss sg13_lv_nmos
+ L=0.13u W=0.74u AS=0.2516p AD=0.2516p PS=2.16u PD=2.16u rfmode=0
M$13557 \$1078 \$1485 VSS|anode|cathode|vss VSS|anode|cathode|vss sg13_lv_nmos
+ L=0.13u W=0.74u AS=0.2886p AD=0.14875p PS=2.26u PD=1.16u rfmode=0
M$13558 VSS|anode|cathode|vss \$1120 \$1485 VSS|anode|cathode|vss sg13_lv_nmos
+ L=0.13u W=0.55u AS=0.14875p AD=0.187p PS=1.16u PD=1.78u rfmode=0
M$13559 \$1486 \$1405 VSS|anode|cathode|vss VSS|anode|cathode|vss sg13_lv_nmos
+ L=0.13u W=0.74u AS=0.4033p AD=0.148p PS=2.57u PD=1.14u rfmode=0
M$13560 VSS|anode|cathode|vss \$1593 \$1563 VSS|anode|cathode|vss sg13_lv_nmos
+ L=0.13u W=0.74u AS=0.148p AD=0.3367p PS=1.14u PD=1.65u rfmode=0
M$13561 \$1563 \$1594 \$1405 VSS|anode|cathode|vss sg13_lv_nmos L=0.13u W=0.74u
+ AS=0.3367p AD=0.1628p PS=1.65u PD=1.18u rfmode=0
M$13562 \$1405 \$1404 \$1562 VSS|anode|cathode|vss sg13_lv_nmos L=0.13u W=0.74u
+ AS=0.1628p AD=0.13135p PS=1.18u PD=1.095u rfmode=0
M$13563 \$1562 \$1079 VSS|anode|cathode|vss VSS|anode|cathode|vss sg13_lv_nmos
+ L=0.13u W=0.74u AS=0.13135p AD=0.18945p PS=1.095u PD=1.27u rfmode=0
M$13564 VSS|anode|cathode|vss \$1079 \$1593 VSS|anode|cathode|vss sg13_lv_nmos
+ L=0.13u W=0.55u AS=0.18945p AD=0.187p PS=1.27u PD=1.78u rfmode=0
M$13565 \$1487 \$1404 VSS|anode|cathode|vss VSS|anode|cathode|vss sg13_lv_nmos
+ L=0.13u W=0.42u AS=0.1428p AD=0.0798p PS=1.52u PD=0.8u rfmode=0
M$13566 VSS|anode|cathode|vss \$1487 \$1488 VSS|anode|cathode|vss sg13_lv_nmos
+ L=0.5u W=0.42u AS=0.0798p AD=0.1428p PS=0.8u PD=1.52u rfmode=0
M$13568 VSS|anode|cathode|vss \$1488 \$1489 VSS|anode|cathode|vss sg13_lv_nmos
+ L=0.5u W=0.42u AS=0.1426p AD=0.1428p PS=1.16u PD=1.52u rfmode=0
M$13569 VSS|anode|cathode|vss \$1489 \$1490 VSS|anode|cathode|vss sg13_lv_nmos
+ L=0.13u W=0.74u AS=0.1426p AD=0.2516p PS=1.16u PD=2.16u rfmode=0
M$13570 \$1594 \$1491 VSS|anode|cathode|vss VSS|anode|cathode|vss sg13_lv_nmos
+ L=0.13u W=0.74u AS=0.2516p AD=0.1426p PS=2.16u PD=1.16u rfmode=0
M$13571 VSS|anode|cathode|vss \$1595 \$1491 VSS|anode|cathode|vss sg13_lv_nmos
+ L=0.5u W=0.42u AS=0.1426p AD=0.1428p PS=1.16u PD=1.52u rfmode=0
M$13572 \$1595 \$1492 VSS|anode|cathode|vss VSS|anode|cathode|vss sg13_lv_nmos
+ L=0.5u W=0.42u AS=0.1428p AD=0.0798p PS=1.52u PD=0.8u rfmode=0
M$13573 VSS|anode|cathode|vss \$1302 \$1492 VSS|anode|cathode|vss sg13_lv_nmos
+ L=0.13u W=0.42u AS=0.0798p AD=0.1428p PS=0.8u PD=1.52u rfmode=0
M$13574 VSS|anode|cathode|vss \$1352 \$1493 VSS|anode|cathode|vss sg13_lv_nmos
+ L=0.13u W=0.55u AS=0.18945p AD=0.187p PS=1.27u PD=1.78u rfmode=0
M$13575 VSS|anode|cathode|vss \$1352 \$1565 VSS|anode|cathode|vss sg13_lv_nmos
+ L=0.13u W=0.74u AS=0.18945p AD=0.13135p PS=1.27u PD=1.095u rfmode=0
M$13576 \$1565 \$1490 \$1406 VSS|anode|cathode|vss sg13_lv_nmos L=0.13u W=0.74u
+ AS=0.13135p AD=0.1628p PS=1.095u PD=1.18u rfmode=0
M$13577 \$1406 \$1596 \$1564 VSS|anode|cathode|vss sg13_lv_nmos L=0.13u W=0.74u
+ AS=0.1628p AD=0.3367p PS=1.18u PD=1.65u rfmode=0
M$13578 \$1564 \$1493 VSS|anode|cathode|vss VSS|anode|cathode|vss sg13_lv_nmos
+ L=0.13u W=0.74u AS=0.3367p AD=0.148p PS=1.65u PD=1.14u rfmode=0
M$13579 VSS|anode|cathode|vss \$1406 \$1494 VSS|anode|cathode|vss sg13_lv_nmos
+ L=0.13u W=0.74u AS=0.148p AD=0.4033p PS=1.14u PD=2.57u rfmode=0
M$13581 \$1407 \$1494 \$1569 VSS|anode|cathode|vss sg13_lv_nmos L=0.13u W=0.42u
+ AS=0.1428p AD=0.0609p PS=1.52u PD=0.71u rfmode=0
M$13582 \$1569 \$1121 VSS|anode|cathode|vss VSS|anode|cathode|vss sg13_lv_nmos
+ L=0.13u W=0.42u AS=0.0609p AD=0.1626p PS=0.71u PD=1.415u rfmode=0
M$13583 VSS|anode|cathode|vss \$1629 \$1408 VSS|anode|cathode|vss sg13_lv_nmos
+ L=0.13u W=0.74u AS=0.1626p AD=0.2516p PS=1.415u PD=2.16u rfmode=0
M$13584 VSS|anode|cathode|vss \$1121 \$1566 VSS|anode|cathode|vss sg13_lv_nmos
+ L=0.13u W=0.42u AS=0.1701p AD=0.0378p PS=1.65u PD=0.6u rfmode=0
M$13585 \$1566 \$1408 \$1495 VSS|anode|cathode|vss sg13_lv_nmos L=0.13u W=0.42u
+ AS=0.0378p AD=0.1428p PS=0.6u PD=1.52u rfmode=0
M$13586 \$1496 \$1409 \$1410 VSS|anode|cathode|vss sg13_lv_nmos L=0.13u W=0.42u
+ AS=0.12665p AD=0.1428p PS=1.145u PD=1.52u rfmode=0
M$13587 \$1408 \$1630 \$1496 VSS|anode|cathode|vss sg13_lv_nmos L=0.13u W=0.74u
+ AS=0.3473p AD=0.12665p PS=2.71u PD=1.145u rfmode=0
M$13588 \$1410 \$1411 VSS|anode|cathode|vss VSS|anode|cathode|vss sg13_lv_nmos
+ L=0.13u W=0.42u AS=0.1428p AD=0.0798p PS=1.52u PD=0.8u rfmode=0
M$13589 VSS|anode|cathode|vss \$1121 \$1570 VSS|anode|cathode|vss sg13_lv_nmos
+ L=0.13u W=0.42u AS=0.0798p AD=0.0378p PS=0.8u PD=0.6u rfmode=0
M$13590 \$1570 \$1496 \$1411 VSS|anode|cathode|vss sg13_lv_nmos L=0.13u W=0.42u
+ AS=0.0378p AD=0.1428p PS=0.6u PD=1.52u rfmode=0
M$13591 \$1412 \$1496 VSS|anode|cathode|vss VSS|anode|cathode|vss sg13_lv_nmos
+ L=0.13u W=0.74u AS=0.2516p AD=0.1406p PS=2.16u PD=1.12u rfmode=0
M$13592 VSS|anode|cathode|vss \$1412 \$1304 VSS|anode|cathode|vss sg13_lv_nmos
+ L=0.13u W=0.74u AS=0.1406p AD=0.2516p PS=1.12u PD=2.16u rfmode=0
M$13601 VSS|anode|cathode|vss \$1307 \$1497 VSS|anode|cathode|vss sg13_lv_nmos
+ L=0.13u W=0.74u AS=0.2516p AD=0.2516p PS=2.16u PD=2.16u rfmode=0
M$13602 \$1413 \$1597 \$1575 VSS|anode|cathode|vss sg13_lv_nmos L=0.13u W=0.42u
+ AS=0.1428p AD=0.0609p PS=1.52u PD=0.71u rfmode=0
M$13603 \$1575 \$1497 VSS|anode|cathode|vss VSS|anode|cathode|vss sg13_lv_nmos
+ L=0.13u W=0.42u AS=0.0609p AD=0.1626p PS=0.71u PD=1.415u rfmode=0
M$13604 VSS|anode|cathode|vss \$1631 \$1414 VSS|anode|cathode|vss sg13_lv_nmos
+ L=0.13u W=0.74u AS=0.1626p AD=0.2516p PS=1.415u PD=2.16u rfmode=0
M$13605 VSS|anode|cathode|vss \$1497 \$1573 VSS|anode|cathode|vss sg13_lv_nmos
+ L=0.13u W=0.42u AS=0.1701p AD=0.0378p PS=1.65u PD=0.6u rfmode=0
M$13606 \$1573 \$1414 \$1498 VSS|anode|cathode|vss sg13_lv_nmos L=0.13u W=0.42u
+ AS=0.0378p AD=0.1428p PS=0.6u PD=1.52u rfmode=0
M$13607 \$1499 \$1415 \$1416 VSS|anode|cathode|vss sg13_lv_nmos L=0.13u W=0.42u
+ AS=0.12665p AD=0.1428p PS=1.145u PD=1.52u rfmode=0
M$13608 \$1414 \$1632 \$1499 VSS|anode|cathode|vss sg13_lv_nmos L=0.13u W=0.74u
+ AS=0.3473p AD=0.12665p PS=2.71u PD=1.145u rfmode=0
M$13609 \$1416 \$1417 VSS|anode|cathode|vss VSS|anode|cathode|vss sg13_lv_nmos
+ L=0.13u W=0.42u AS=0.1428p AD=0.0798p PS=1.52u PD=0.8u rfmode=0
M$13610 VSS|anode|cathode|vss \$1497 \$1576 VSS|anode|cathode|vss sg13_lv_nmos
+ L=0.13u W=0.42u AS=0.0798p AD=0.0378p PS=0.8u PD=0.6u rfmode=0
M$13611 \$1576 \$1499 \$1417 VSS|anode|cathode|vss sg13_lv_nmos L=0.13u W=0.42u
+ AS=0.0378p AD=0.1428p PS=0.6u PD=1.52u rfmode=0
M$13612 \$1219 \$1264 VSS|anode|cathode|vss VSS|anode|cathode|vss sg13_lv_nmos
+ L=0.5u W=0.42u AS=0.1428p AD=0.0798p PS=1.52u PD=0.8u rfmode=0
M$13613 VSS|anode|cathode|vss \$1306 \$1264 VSS|anode|cathode|vss sg13_lv_nmos
+ L=0.13u W=0.42u AS=0.0798p AD=0.1428p PS=0.8u PD=1.52u rfmode=0
M$13614 \$1418 \$1499 VSS|anode|cathode|vss VSS|anode|cathode|vss sg13_lv_nmos
+ L=0.13u W=0.74u AS=0.2516p AD=0.1406p PS=2.16u PD=1.12u rfmode=0
M$13615 VSS|anode|cathode|vss \$1418 \$1306 VSS|anode|cathode|vss sg13_lv_nmos
+ L=0.13u W=0.74u AS=0.1406p AD=0.2516p PS=1.12u PD=2.16u rfmode=0
M$13623 VSS|anode|cathode|vss \$1352 \$1500 VSS|anode|cathode|vss sg13_lv_nmos
+ L=0.13u W=0.55u AS=0.18945p AD=0.187p PS=1.27u PD=1.78u rfmode=0
M$13624 VSS|anode|cathode|vss \$1352 \$1579 VSS|anode|cathode|vss sg13_lv_nmos
+ L=0.13u W=0.74u AS=0.18945p AD=0.13135p PS=1.27u PD=1.095u rfmode=0
M$13625 \$1579 \$1596 \$1419 VSS|anode|cathode|vss sg13_lv_nmos L=0.13u W=0.74u
+ AS=0.13135p AD=0.1628p PS=1.095u PD=1.18u rfmode=0
M$13626 \$1419 \$1598 \$1582 VSS|anode|cathode|vss sg13_lv_nmos L=0.13u W=0.74u
+ AS=0.1628p AD=0.3367p PS=1.18u PD=1.65u rfmode=0
M$13627 \$1582 \$1500 VSS|anode|cathode|vss VSS|anode|cathode|vss sg13_lv_nmos
+ L=0.13u W=0.74u AS=0.3367p AD=0.148p PS=1.65u PD=1.14u rfmode=0
M$13628 VSS|anode|cathode|vss \$1419 \$1501 VSS|anode|cathode|vss sg13_lv_nmos
+ L=0.13u W=0.74u AS=0.148p AD=0.4033p PS=1.14u PD=2.57u rfmode=0
M$13629 \$1420 \$1501 \$1581 VSS|anode|cathode|vss sg13_lv_nmos L=0.13u W=0.42u
+ AS=0.1428p AD=0.0609p PS=1.52u PD=0.71u rfmode=0
M$13630 \$1581 \$1220 VSS|anode|cathode|vss VSS|anode|cathode|vss sg13_lv_nmos
+ L=0.13u W=0.42u AS=0.0609p AD=0.1626p PS=0.71u PD=1.415u rfmode=0
M$13631 VSS|anode|cathode|vss \$1633 \$1421 VSS|anode|cathode|vss sg13_lv_nmos
+ L=0.13u W=0.74u AS=0.1626p AD=0.2516p PS=1.415u PD=2.16u rfmode=0
M$13632 VSS|anode|cathode|vss \$1220 \$1580 VSS|anode|cathode|vss sg13_lv_nmos
+ L=0.13u W=0.42u AS=0.1701p AD=0.0378p PS=1.65u PD=0.6u rfmode=0
M$13633 \$1580 \$1421 \$1502 VSS|anode|cathode|vss sg13_lv_nmos L=0.13u W=0.42u
+ AS=0.0378p AD=0.1428p PS=0.6u PD=1.52u rfmode=0
M$13634 \$1503 \$1422 \$1423 VSS|anode|cathode|vss sg13_lv_nmos L=0.13u W=0.42u
+ AS=0.12665p AD=0.1428p PS=1.145u PD=1.52u rfmode=0
M$13635 \$1421 \$1634 \$1503 VSS|anode|cathode|vss sg13_lv_nmos L=0.13u W=0.74u
+ AS=0.3473p AD=0.12665p PS=2.71u PD=1.145u rfmode=0
M$13636 \$1423 \$1424 VSS|anode|cathode|vss VSS|anode|cathode|vss sg13_lv_nmos
+ L=0.13u W=0.42u AS=0.1428p AD=0.0798p PS=1.52u PD=0.8u rfmode=0
M$13637 VSS|anode|cathode|vss \$1220 \$1583 VSS|anode|cathode|vss sg13_lv_nmos
+ L=0.13u W=0.42u AS=0.0798p AD=0.0378p PS=0.8u PD=0.6u rfmode=0
M$13638 \$1583 \$1503 \$1424 VSS|anode|cathode|vss sg13_lv_nmos L=0.13u W=0.42u
+ AS=0.0378p AD=0.1428p PS=0.6u PD=1.52u rfmode=0
M$13639 \$1425 \$1503 VSS|anode|cathode|vss VSS|anode|cathode|vss sg13_lv_nmos
+ L=0.13u W=0.74u AS=0.2516p AD=0.1406p PS=2.16u PD=1.12u rfmode=0
M$13640 VSS|anode|cathode|vss \$1425 \$1426 VSS|anode|cathode|vss sg13_lv_nmos
+ L=0.13u W=0.74u AS=0.1406p AD=0.2516p PS=1.12u PD=2.16u rfmode=0
M$13641 \$1504 \$1427 VSS|anode|cathode|vss VSS|anode|cathode|vss sg13_lv_nmos
+ L=0.13u W=0.74u AS=0.4033p AD=0.148p PS=2.57u PD=1.14u rfmode=0
M$13642 VSS|anode|cathode|vss \$1505 \$1584 VSS|anode|cathode|vss sg13_lv_nmos
+ L=0.13u W=0.74u AS=0.148p AD=0.3367p PS=1.14u PD=1.65u rfmode=0
M$13643 \$1584 \$1599 \$1427 VSS|anode|cathode|vss sg13_lv_nmos L=0.13u W=0.74u
+ AS=0.3367p AD=0.1628p PS=1.65u PD=1.18u rfmode=0
M$13644 \$1427 \$1426 \$1585 VSS|anode|cathode|vss sg13_lv_nmos L=0.13u W=0.74u
+ AS=0.1628p AD=0.13135p PS=1.18u PD=1.095u rfmode=0
M$13645 \$1585 \$1233 VSS|anode|cathode|vss VSS|anode|cathode|vss sg13_lv_nmos
+ L=0.13u W=0.74u AS=0.13135p AD=0.18945p PS=1.095u PD=1.27u rfmode=0
M$13646 VSS|anode|cathode|vss \$1233 \$1505 VSS|anode|cathode|vss sg13_lv_nmos
+ L=0.13u W=0.55u AS=0.18945p AD=0.187p PS=1.27u PD=1.78u rfmode=0
M$13647 \$1506 \$1307 VSS|anode|cathode|vss VSS|anode|cathode|vss sg13_lv_nmos
+ L=0.13u W=0.74u AS=0.2516p AD=0.2516p PS=2.16u PD=2.16u rfmode=0
M$13648 VSS|anode|cathode|vss \$1635 \$1507 VSS|anode|cathode|vss sg13_lv_nmos
+ L=0.13u W=0.55u AS=0.14875p AD=0.187p PS=1.16u PD=1.78u rfmode=0
M$13649 VSS|anode|cathode|vss \$1507 X7|dout[8] VSS|anode|cathode|vss
+ sg13_lv_nmos L=0.13u W=0.74u AS=0.14875p AD=0.2886p PS=1.16u PD=2.26u rfmode=0
M$13650 \$1508 \$1426 VSS|anode|cathode|vss VSS|anode|cathode|vss sg13_lv_nmos
+ L=0.13u W=0.42u AS=0.1428p AD=0.0798p PS=1.52u PD=0.8u rfmode=0
M$13651 VSS|anode|cathode|vss \$1508 \$1509 VSS|anode|cathode|vss sg13_lv_nmos
+ L=0.5u W=0.42u AS=0.0798p AD=0.1428p PS=0.8u PD=1.52u rfmode=0
M$13652 VSS|anode|cathode|vss \$1509 \$1510 VSS|anode|cathode|vss sg13_lv_nmos
+ L=0.5u W=0.42u AS=0.1426p AD=0.1428p PS=1.16u PD=1.52u rfmode=0
M$13653 VSS|anode|cathode|vss \$1510 \$1598 VSS|anode|cathode|vss sg13_lv_nmos
+ L=0.13u W=0.74u AS=0.1426p AD=0.2516p PS=1.16u PD=2.16u rfmode=0
M$13655 VSS|anode|cathode|vss \$1352 \$1511 VSS|anode|cathode|vss sg13_lv_nmos
+ L=0.13u W=0.55u AS=0.18945p AD=0.187p PS=1.27u PD=1.78u rfmode=0
M$13656 VSS|anode|cathode|vss \$1352 \$1577 VSS|anode|cathode|vss sg13_lv_nmos
+ L=0.13u W=0.74u AS=0.18945p AD=0.13135p PS=1.27u PD=1.095u rfmode=0
M$13657 \$1577 \$1598 \$1429 VSS|anode|cathode|vss sg13_lv_nmos L=0.13u W=0.74u
+ AS=0.13135p AD=0.1628p PS=1.095u PD=1.18u rfmode=0
M$13658 \$1429 \$1600 \$1578 VSS|anode|cathode|vss sg13_lv_nmos L=0.13u W=0.74u
+ AS=0.1628p AD=0.3367p PS=1.18u PD=1.65u rfmode=0
M$13659 \$1578 \$1511 VSS|anode|cathode|vss VSS|anode|cathode|vss sg13_lv_nmos
+ L=0.13u W=0.74u AS=0.3367p AD=0.148p PS=1.65u PD=1.14u rfmode=0
M$13660 VSS|anode|cathode|vss \$1429 \$1512 VSS|anode|cathode|vss sg13_lv_nmos
+ L=0.13u W=0.74u AS=0.148p AD=0.4033p PS=1.14u PD=2.57u rfmode=0
M$13662 \$1430 \$1222 \$1572 VSS|anode|cathode|vss sg13_lv_nmos L=0.13u W=0.42u
+ AS=0.1428p AD=0.0609p PS=1.52u PD=0.71u rfmode=0
M$13663 \$1572 \$1221 VSS|anode|cathode|vss VSS|anode|cathode|vss sg13_lv_nmos
+ L=0.13u W=0.42u AS=0.0609p AD=0.1626p PS=0.71u PD=1.415u rfmode=0
M$13664 VSS|anode|cathode|vss \$1636 \$1431 VSS|anode|cathode|vss sg13_lv_nmos
+ L=0.13u W=0.74u AS=0.1626p AD=0.2516p PS=1.415u PD=2.16u rfmode=0
M$13665 VSS|anode|cathode|vss \$1221 \$1574 VSS|anode|cathode|vss sg13_lv_nmos
+ L=0.13u W=0.42u AS=0.1701p AD=0.0378p PS=1.65u PD=0.6u rfmode=0
M$13666 \$1574 \$1431 \$1513 VSS|anode|cathode|vss sg13_lv_nmos L=0.13u W=0.42u
+ AS=0.0378p AD=0.1428p PS=0.6u PD=1.52u rfmode=0
M$13667 \$1224 \$1265 VSS|anode|cathode|vss VSS|anode|cathode|vss sg13_lv_nmos
+ L=0.5u W=0.42u AS=0.1428p AD=0.0798p PS=1.52u PD=0.8u rfmode=0
M$13668 VSS|anode|cathode|vss \$1512 \$1265 VSS|anode|cathode|vss sg13_lv_nmos
+ L=0.13u W=0.42u AS=0.0798p AD=0.1428p PS=0.8u PD=1.52u rfmode=0
M$13669 \$1514 \$1432 \$1433 VSS|anode|cathode|vss sg13_lv_nmos L=0.13u W=0.42u
+ AS=0.12665p AD=0.1428p PS=1.145u PD=1.52u rfmode=0
M$13670 \$1431 \$1637 \$1514 VSS|anode|cathode|vss sg13_lv_nmos L=0.13u W=0.74u
+ AS=0.3473p AD=0.12665p PS=2.71u PD=1.145u rfmode=0
M$13671 \$1433 \$1434 VSS|anode|cathode|vss VSS|anode|cathode|vss sg13_lv_nmos
+ L=0.13u W=0.42u AS=0.1428p AD=0.0798p PS=1.52u PD=0.8u rfmode=0
M$13672 VSS|anode|cathode|vss \$1221 \$1571 VSS|anode|cathode|vss sg13_lv_nmos
+ L=0.13u W=0.42u AS=0.0798p AD=0.0378p PS=0.8u PD=0.6u rfmode=0
M$13673 \$1571 \$1514 \$1434 VSS|anode|cathode|vss sg13_lv_nmos L=0.13u W=0.42u
+ AS=0.0378p AD=0.1428p PS=0.6u PD=1.52u rfmode=0
M$13675 \$1435 \$1514 VSS|anode|cathode|vss VSS|anode|cathode|vss sg13_lv_nmos
+ L=0.13u W=0.74u AS=0.2516p AD=0.1406p PS=2.16u PD=1.12u rfmode=0
M$13676 VSS|anode|cathode|vss \$1435 \$1600 VSS|anode|cathode|vss sg13_lv_nmos
+ L=0.13u W=0.74u AS=0.1406p AD=0.2516p PS=1.12u PD=2.16u rfmode=0
M$13677 VSS|anode|cathode|vss \$1233 \$1515 VSS|anode|cathode|vss sg13_lv_nmos
+ L=0.13u W=0.55u AS=0.18945p AD=0.187p PS=1.27u PD=1.78u rfmode=0
M$13678 VSS|anode|cathode|vss \$1233 \$1567 VSS|anode|cathode|vss sg13_lv_nmos
+ L=0.13u W=0.74u AS=0.18945p AD=0.13135p PS=1.27u PD=1.095u rfmode=0
M$13679 \$1567 \$1600 \$1436 VSS|anode|cathode|vss sg13_lv_nmos L=0.13u W=0.74u
+ AS=0.13135p AD=0.1628p PS=1.095u PD=1.18u rfmode=0
M$13680 \$1436 \$1601 \$1568 VSS|anode|cathode|vss sg13_lv_nmos L=0.13u W=0.74u
+ AS=0.1628p AD=0.3367p PS=1.18u PD=1.65u rfmode=0
M$13681 \$1568 \$1515 VSS|anode|cathode|vss VSS|anode|cathode|vss sg13_lv_nmos
+ L=0.13u W=0.74u AS=0.3367p AD=0.148p PS=1.65u PD=1.14u rfmode=0
M$13682 VSS|anode|cathode|vss \$1436 \$1602 VSS|anode|cathode|vss sg13_lv_nmos
+ L=0.13u W=0.74u AS=0.148p AD=0.4033p PS=1.14u PD=2.57u rfmode=0
M$13683 VSS|anode|cathode|vss \$1270 \$1269 VSS|anode|cathode|vss sg13_lv_nmos
+ L=0.13u W=0.74u AS=0.1626p AD=0.2516p PS=1.415u PD=2.16u rfmode=0
M$13684 \$1268 \$1225 \$1373 VSS|anode|cathode|vss sg13_lv_nmos L=0.13u W=0.42u
+ AS=0.1428p AD=0.0609p PS=1.52u PD=0.71u rfmode=0
M$13685 VSS|anode|cathode|vss \$1122 \$1373 VSS|anode|cathode|vss sg13_lv_nmos
+ L=0.13u W=0.42u AS=0.1626p AD=0.0609p PS=1.415u PD=0.71u rfmode=0
M$13686 \$1516 \$1517 VSS|anode|cathode|vss VSS|anode|cathode|vss sg13_lv_nmos
+ L=0.13u W=0.74u AS=0.2516p AD=0.1426p PS=2.16u PD=1.16u rfmode=0
M$13687 VSS|anode|cathode|vss \$1603 \$1517 VSS|anode|cathode|vss sg13_lv_nmos
+ L=0.5u W=0.42u AS=0.1426p AD=0.1428p PS=1.16u PD=1.52u rfmode=0
M$13688 VSS|anode|cathode|vss \$1122 \$1372 VSS|anode|cathode|vss sg13_lv_nmos
+ L=0.13u W=0.42u AS=0.1701p AD=0.0378p PS=1.65u PD=0.6u rfmode=0
M$13689 \$1372 \$1269 \$1310 VSS|anode|cathode|vss sg13_lv_nmos L=0.13u W=0.42u
+ AS=0.0378p AD=0.1428p PS=0.6u PD=1.52u rfmode=0
M$13690 \$1603 \$1518 VSS|anode|cathode|vss VSS|anode|cathode|vss sg13_lv_nmos
+ L=0.5u W=0.42u AS=0.1428p AD=0.0798p PS=1.52u PD=0.8u rfmode=0
M$13691 VSS|anode|cathode|vss \$1602 \$1518 VSS|anode|cathode|vss sg13_lv_nmos
+ L=0.13u W=0.42u AS=0.0798p AD=0.1428p PS=0.8u PD=1.52u rfmode=0
M$13692 \$1601 \$1519 VSS|anode|cathode|vss VSS|anode|cathode|vss sg13_lv_nmos
+ L=0.13u W=0.74u AS=0.2516p AD=0.1426p PS=2.16u PD=1.16u rfmode=0
M$13693 VSS|anode|cathode|vss \$1604 \$1519 VSS|anode|cathode|vss sg13_lv_nmos
+ L=0.5u W=0.42u AS=0.1426p AD=0.1428p PS=1.16u PD=1.52u rfmode=0
M$13694 \$1604 \$1520 VSS|anode|cathode|vss VSS|anode|cathode|vss sg13_lv_nmos
+ L=0.5u W=0.42u AS=0.1428p AD=0.0798p PS=1.52u PD=0.8u rfmode=0
M$13695 VSS|anode|cathode|vss \$1605 \$1520 VSS|anode|cathode|vss sg13_lv_nmos
+ L=0.13u W=0.42u AS=0.0798p AD=0.1428p PS=0.8u PD=1.52u rfmode=0
M$13696 \$1336 \$1273 VSS|anode|cathode|vss VSS|anode|cathode|vss sg13_lv_nmos
+ L=0.13u W=0.42u AS=0.1428p AD=0.0798p PS=1.52u PD=0.8u rfmode=0
M$13697 VSS|anode|cathode|vss \$1122 \$1376 VSS|anode|cathode|vss sg13_lv_nmos
+ L=0.13u W=0.42u AS=0.0798p AD=0.0378p PS=0.8u PD=0.6u rfmode=0
M$13698 \$1376 \$1312 \$1273 VSS|anode|cathode|vss sg13_lv_nmos L=0.13u W=0.42u
+ AS=0.0378p AD=0.1428p PS=0.6u PD=1.52u rfmode=0
M$13699 \$1307 \$1521 VSS|anode|cathode|vss VSS|anode|cathode|vss sg13_lv_nmos
+ L=0.13u W=0.74u AS=0.2886p AD=0.14875p PS=2.26u PD=1.16u rfmode=0
M$13700 VSS|anode|cathode|vss \$1120 \$1521 VSS|anode|cathode|vss sg13_lv_nmos
+ L=0.13u W=0.55u AS=0.14875p AD=0.187p PS=1.16u PD=1.78u rfmode=0
M$13701 \$1522 \$1307 VSS|anode|cathode|vss VSS|anode|cathode|vss sg13_lv_nmos
+ L=0.13u W=0.74u AS=0.2516p AD=0.2516p PS=2.16u PD=2.16u rfmode=0
M$13702 \$1523 \$1227 VSS|anode|cathode|vss VSS|anode|cathode|vss sg13_lv_nmos
+ L=0.13u W=0.42u AS=0.1428p AD=0.0798p PS=1.52u PD=0.8u rfmode=0
M$13703 VSS|anode|cathode|vss \$1523 \$1524 VSS|anode|cathode|vss sg13_lv_nmos
+ L=0.5u W=0.42u AS=0.0798p AD=0.1428p PS=0.8u PD=1.52u rfmode=0
M$13704 VSS|anode|cathode|vss \$1524 \$1525 VSS|anode|cathode|vss sg13_lv_nmos
+ L=0.5u W=0.42u AS=0.1426p AD=0.1428p PS=1.16u PD=1.52u rfmode=0
M$13705 VSS|anode|cathode|vss \$1525 \$1309 VSS|anode|cathode|vss sg13_lv_nmos
+ L=0.13u W=0.74u AS=0.1426p AD=0.2516p PS=1.16u PD=2.16u rfmode=0
M$13706 VSS|anode|cathode|vss \$1278 \$1277 VSS|anode|cathode|vss sg13_lv_nmos
+ L=0.13u W=0.74u AS=0.1626p AD=0.2516p PS=1.415u PD=2.16u rfmode=0
M$13707 \$1276 \$1228 \$1378 VSS|anode|cathode|vss sg13_lv_nmos L=0.13u W=0.42u
+ AS=0.1428p AD=0.0609p PS=1.52u PD=0.71u rfmode=0
M$13708 VSS|anode|cathode|vss \$1123 \$1378 VSS|anode|cathode|vss sg13_lv_nmos
+ L=0.13u W=0.42u AS=0.1626p AD=0.0609p PS=1.415u PD=0.71u rfmode=0
M$13709 VSS|anode|cathode|vss \$1233 \$1526 VSS|anode|cathode|vss sg13_lv_nmos
+ L=0.13u W=0.55u AS=0.18945p AD=0.187p PS=1.27u PD=1.78u rfmode=0
M$13710 VSS|anode|cathode|vss \$1233 \$1560 VSS|anode|cathode|vss sg13_lv_nmos
+ L=0.13u W=0.74u AS=0.18945p AD=0.13135p PS=1.27u PD=1.095u rfmode=0
M$13711 \$1560 \$1309 \$1437 VSS|anode|cathode|vss sg13_lv_nmos L=0.13u W=0.74u
+ AS=0.13135p AD=0.1628p PS=1.095u PD=1.18u rfmode=0
M$13712 \$1437 \$1606 \$1561 VSS|anode|cathode|vss sg13_lv_nmos L=0.13u W=0.74u
+ AS=0.1628p AD=0.3367p PS=1.18u PD=1.65u rfmode=0
M$13713 \$1561 \$1526 VSS|anode|cathode|vss VSS|anode|cathode|vss sg13_lv_nmos
+ L=0.13u W=0.74u AS=0.3367p AD=0.148p PS=1.65u PD=1.14u rfmode=0
M$13714 VSS|anode|cathode|vss \$1437 \$1527 VSS|anode|cathode|vss sg13_lv_nmos
+ L=0.13u W=0.74u AS=0.148p AD=0.4033p PS=1.14u PD=2.57u rfmode=0
M$13715 VSS|anode|cathode|vss \$1123 \$1377 VSS|anode|cathode|vss sg13_lv_nmos
+ L=0.13u W=0.42u AS=0.1701p AD=0.0378p PS=1.65u PD=0.6u rfmode=0
M$13716 \$1377 \$1277 \$1314 VSS|anode|cathode|vss sg13_lv_nmos L=0.13u W=0.42u
+ AS=0.0378p AD=0.1428p PS=0.6u PD=1.52u rfmode=0
M$13717 VSS|anode|cathode|vss \$1307 \$1528 VSS|anode|cathode|vss sg13_lv_nmos
+ L=0.13u W=0.74u AS=0.2516p AD=0.2516p PS=2.16u PD=2.16u rfmode=0
M$13718 VSS|anode|cathode|vss \$1307 \$1529 VSS|anode|cathode|vss sg13_lv_nmos
+ L=0.13u W=0.74u AS=0.2516p AD=0.2516p PS=2.16u PD=2.16u rfmode=0
M$13719 VSS|anode|cathode|vss \$1233 \$1530 VSS|anode|cathode|vss sg13_lv_nmos
+ L=0.13u W=0.55u AS=0.18945p AD=0.187p PS=1.27u PD=1.78u rfmode=0
M$13720 VSS|anode|cathode|vss \$1233 \$1558 VSS|anode|cathode|vss sg13_lv_nmos
+ L=0.13u W=0.74u AS=0.18945p AD=0.13135p PS=1.27u PD=1.095u rfmode=0
M$13721 \$1558 \$1313 \$1438 VSS|anode|cathode|vss sg13_lv_nmos L=0.13u W=0.74u
+ AS=0.13135p AD=0.1628p PS=1.095u PD=1.18u rfmode=0
M$13722 \$1438 \$1445 \$1559 VSS|anode|cathode|vss sg13_lv_nmos L=0.13u W=0.74u
+ AS=0.1628p AD=0.3367p PS=1.18u PD=1.65u rfmode=0
M$13723 \$1559 \$1530 VSS|anode|cathode|vss VSS|anode|cathode|vss sg13_lv_nmos
+ L=0.13u W=0.74u AS=0.3367p AD=0.148p PS=1.65u PD=1.14u rfmode=0
M$13724 VSS|anode|cathode|vss \$1438 \$1150 VSS|anode|cathode|vss sg13_lv_nmos
+ L=0.13u W=0.74u AS=0.148p AD=0.4033p PS=1.14u PD=2.57u rfmode=0
M$13725 \$1337 \$1281 VSS|anode|cathode|vss VSS|anode|cathode|vss sg13_lv_nmos
+ L=0.13u W=0.42u AS=0.1428p AD=0.0798p PS=1.52u PD=0.8u rfmode=0
M$13726 VSS|anode|cathode|vss \$1123 \$1379 VSS|anode|cathode|vss sg13_lv_nmos
+ L=0.13u W=0.42u AS=0.0798p AD=0.0378p PS=0.8u PD=0.6u rfmode=0
M$13727 \$1379 \$1315 \$1281 VSS|anode|cathode|vss sg13_lv_nmos L=0.13u W=0.42u
+ AS=0.0378p AD=0.1428p PS=0.6u PD=1.52u rfmode=0
M$13728 \$1439 \$1124 \$1554 VSS|anode|cathode|vss sg13_lv_nmos L=0.13u W=0.42u
+ AS=0.1428p AD=0.0609p PS=1.52u PD=0.71u rfmode=0
M$13729 \$1554 \$1528 VSS|anode|cathode|vss VSS|anode|cathode|vss sg13_lv_nmos
+ L=0.13u W=0.42u AS=0.0609p AD=0.1626p PS=0.71u PD=1.415u rfmode=0
M$13730 VSS|anode|cathode|vss \$1638 \$1440 VSS|anode|cathode|vss sg13_lv_nmos
+ L=0.13u W=0.74u AS=0.1626p AD=0.2516p PS=1.415u PD=2.16u rfmode=0
M$13731 VSS|anode|cathode|vss \$1528 \$1556 VSS|anode|cathode|vss sg13_lv_nmos
+ L=0.13u W=0.42u AS=0.1701p AD=0.0378p PS=1.65u PD=0.6u rfmode=0
M$13732 \$1556 \$1440 \$1531 VSS|anode|cathode|vss sg13_lv_nmos L=0.13u W=0.42u
+ AS=0.0378p AD=0.1428p PS=0.6u PD=1.52u rfmode=0
M$13733 \$1232 \$1282 VSS|anode|cathode|vss VSS|anode|cathode|vss sg13_lv_nmos
+ L=0.5u W=0.42u AS=0.1428p AD=0.0798p PS=1.52u PD=0.8u rfmode=0
M$13734 VSS|anode|cathode|vss \$1230 \$1282 VSS|anode|cathode|vss sg13_lv_nmos
+ L=0.13u W=0.42u AS=0.0798p AD=0.1428p PS=0.8u PD=1.52u rfmode=0
M$13735 \$1532 \$1441 \$1442 VSS|anode|cathode|vss sg13_lv_nmos L=0.13u W=0.42u
+ AS=0.12665p AD=0.1428p PS=1.145u PD=1.52u rfmode=0
M$13736 \$1440 \$1639 \$1532 VSS|anode|cathode|vss sg13_lv_nmos L=0.13u W=0.74u
+ AS=0.3473p AD=0.12665p PS=2.71u PD=1.145u rfmode=0
M$13737 \$1442 \$1443 VSS|anode|cathode|vss VSS|anode|cathode|vss sg13_lv_nmos
+ L=0.13u W=0.42u AS=0.1428p AD=0.0798p PS=1.52u PD=0.8u rfmode=0
M$13738 VSS|anode|cathode|vss \$1528 \$1551 VSS|anode|cathode|vss sg13_lv_nmos
+ L=0.13u W=0.42u AS=0.0798p AD=0.0378p PS=0.8u PD=0.6u rfmode=0
M$13739 \$1551 \$1532 \$1443 VSS|anode|cathode|vss sg13_lv_nmos L=0.13u W=0.42u
+ AS=0.0378p AD=0.1428p PS=0.6u PD=1.52u rfmode=0
M$13740 \$1444 \$1532 VSS|anode|cathode|vss VSS|anode|cathode|vss sg13_lv_nmos
+ L=0.13u W=0.74u AS=0.2516p AD=0.1406p PS=2.16u PD=1.12u rfmode=0
M$13741 VSS|anode|cathode|vss \$1444 \$1445 VSS|anode|cathode|vss sg13_lv_nmos
+ L=0.13u W=0.74u AS=0.1406p AD=0.2516p PS=1.12u PD=2.16u rfmode=0
M$13790 Op \$1350 VSS|anode|cathode|vss VSS|anode|cathode|vss sg13_lv_nmos
+ L=0.2u W=4u AS=1.06p AD=1.06p PS=7.06u PD=7.06u rfmode=0
M$13804 VSS|anode|cathode|vss \$1188 \$1705 VSS|anode|cathode|vss sg13_lv_nmos
+ L=0.13u W=0.55u AS=0.14875p AD=0.187p PS=1.16u PD=1.78u rfmode=0
M$13805 dout[0] \$1705 VSS|anode|cathode|vss VSS|anode|cathode|vss sg13_lv_nmos
+ L=0.13u W=0.74u AS=0.2886p AD=0.14875p PS=2.26u PD=1.16u rfmode=0
M$13830 VSS|anode|cathode|vss \$1764 \$1707 VSS|anode|cathode|vss sg13_lv_nmos
+ L=0.13u W=0.55u AS=0.14875p AD=0.187p PS=1.16u PD=1.78u rfmode=0
M$13831 En|dout[1] \$1707 VSS|anode|cathode|vss VSS|anode|cathode|vss
+ sg13_lv_nmos L=0.13u W=0.74u AS=0.2886p AD=0.14875p PS=2.26u PD=1.16u rfmode=0
M$13856 VSS|anode|cathode|vss \$1765 \$1709 VSS|anode|cathode|vss sg13_lv_nmos
+ L=0.13u W=0.55u AS=0.14875p AD=0.187p PS=1.16u PD=1.78u rfmode=0
M$13857 X1|dout[2] \$1709 VSS|anode|cathode|vss VSS|anode|cathode|vss
+ sg13_lv_nmos L=0.13u W=0.74u AS=0.2886p AD=0.14875p PS=2.26u PD=1.16u rfmode=0
M$13874 \$1766 \$1770 \$1768 VSS|anode|cathode|vss sg13_lv_nmos L=0.13u W=0.42u
+ AS=0.1296p AD=0.0798p PS=1.52u PD=0.8u rfmode=0
M$13875 \$1768 \$1769 \$1841 VSS|anode|cathode|vss sg13_lv_nmos L=0.13u W=0.42u
+ AS=0.0798p AD=0.2373p PS=0.8u PD=1.97u rfmode=0
M$13876 \$1769 \$1770 VSS|anode|cathode|vss VSS|anode|cathode|vss sg13_lv_nmos
+ L=0.13u W=0.74u AS=0.2516p AD=0.317325p PS=2.16u PD=1.805u rfmode=0
M$13877 VSS|anode|cathode|vss \$1725 \$1770 VSS|anode|cathode|vss sg13_lv_nmos
+ L=0.13u W=0.74u AS=0.317325p AD=0.2516p PS=1.805u PD=2.16u rfmode=0
M$13878 \$1875 \$1770 \$1842 VSS|anode|cathode|vss sg13_lv_nmos L=0.13u W=0.42u
+ AS=0.1428p AD=0.12665p PS=1.52u PD=1.145u rfmode=0
M$13879 \$1842 \$1769 \$1767 VSS|anode|cathode|vss sg13_lv_nmos L=0.13u W=0.74u
+ AS=0.12665p AD=0.3473p PS=1.145u PD=2.71u rfmode=0
M$13880 \$1710 \$1842 VSS|anode|cathode|vss VSS|anode|cathode|vss sg13_lv_nmos
+ L=0.13u W=0.74u AS=0.2516p AD=0.1406p PS=2.16u PD=1.12u rfmode=0
M$13881 VSS|anode|cathode|vss \$1710 \$1764 VSS|anode|cathode|vss sg13_lv_nmos
+ L=0.13u W=0.74u AS=0.1406p AD=0.2516p PS=1.12u PD=2.16u rfmode=0
M$13882 VSS|anode|cathode|vss \$1772 \$1712 VSS|anode|cathode|vss sg13_lv_nmos
+ L=0.13u W=0.55u AS=0.14875p AD=0.187p PS=1.16u PD=1.78u rfmode=0
M$13883 X2|dout[3] \$1712 VSS|anode|cathode|vss VSS|anode|cathode|vss
+ sg13_lv_nmos L=0.13u W=0.74u AS=0.2886p AD=0.14875p PS=2.26u PD=1.16u rfmode=0
M$13884 \$1714 \$1713 VSS|anode|cathode|vss VSS|anode|cathode|vss sg13_lv_nmos
+ L=0.5u W=0.42u AS=0.1428p AD=0.1426p PS=1.52u PD=1.16u rfmode=0
M$13885 VSS|anode|cathode|vss \$1714 \$1715 VSS|anode|cathode|vss sg13_lv_nmos
+ L=0.13u W=0.74u AS=0.1426p AD=0.2516p PS=1.16u PD=2.16u rfmode=0
M$13886 \$1774 \$1778 \$1776 VSS|anode|cathode|vss sg13_lv_nmos L=0.13u W=0.42u
+ AS=0.1296p AD=0.0798p PS=1.52u PD=0.8u rfmode=0
M$13887 \$1776 \$1777 \$1843 VSS|anode|cathode|vss sg13_lv_nmos L=0.13u W=0.42u
+ AS=0.0798p AD=0.2373p PS=0.8u PD=1.97u rfmode=0
M$13888 \$1777 \$1778 VSS|anode|cathode|vss VSS|anode|cathode|vss sg13_lv_nmos
+ L=0.13u W=0.74u AS=0.2516p AD=0.317325p PS=2.16u PD=1.805u rfmode=0
M$13889 VSS|anode|cathode|vss \$1725 \$1778 VSS|anode|cathode|vss sg13_lv_nmos
+ L=0.13u W=0.74u AS=0.317325p AD=0.2516p PS=1.805u PD=2.16u rfmode=0
M$13890 \$1876 \$1778 \$1844 VSS|anode|cathode|vss sg13_lv_nmos L=0.13u W=0.42u
+ AS=0.1428p AD=0.12665p PS=1.52u PD=1.145u rfmode=0
M$13891 \$1844 \$1777 \$1775 VSS|anode|cathode|vss sg13_lv_nmos L=0.13u W=0.74u
+ AS=0.12665p AD=0.3473p PS=1.145u PD=2.71u rfmode=0
M$13892 \$1716 \$1844 VSS|anode|cathode|vss VSS|anode|cathode|vss sg13_lv_nmos
+ L=0.13u W=0.74u AS=0.2516p AD=0.1406p PS=2.16u PD=1.12u rfmode=0
M$13893 VSS|anode|cathode|vss \$1716 \$1765 VSS|anode|cathode|vss sg13_lv_nmos
+ L=0.13u W=0.74u AS=0.1406p AD=0.2516p PS=1.12u PD=2.16u rfmode=0
M$13898 \$1772 \$1717 VSS|anode|cathode|vss VSS|anode|cathode|vss sg13_lv_nmos
+ L=0.13u W=0.74u AS=0.2516p AD=0.1406p PS=2.16u PD=1.12u rfmode=0
M$13899 VSS|anode|cathode|vss \$1845 \$1717 VSS|anode|cathode|vss sg13_lv_nmos
+ L=0.13u W=0.74u AS=0.1406p AD=0.2516p PS=1.12u PD=2.16u rfmode=0
M$13900 \$1845 \$1782 \$1877 VSS|anode|cathode|vss sg13_lv_nmos L=0.13u W=0.42u
+ AS=0.12665p AD=0.1428p PS=1.145u PD=1.52u rfmode=0
M$13901 \$1847 \$1781 \$1845 VSS|anode|cathode|vss sg13_lv_nmos L=0.13u W=0.74u
+ AS=0.3473p AD=0.12665p PS=2.71u PD=1.145u rfmode=0
M$13902 \$1782 \$1725 VSS|anode|cathode|vss VSS|anode|cathode|vss sg13_lv_nmos
+ L=0.13u W=0.74u AS=0.2516p AD=0.317325p PS=2.16u PD=1.805u rfmode=0
M$13903 VSS|anode|cathode|vss \$1782 \$1781 VSS|anode|cathode|vss sg13_lv_nmos
+ L=0.13u W=0.74u AS=0.317325p AD=0.2516p PS=1.805u PD=2.16u rfmode=0
M$13904 \$1846 \$1781 \$1783 VSS|anode|cathode|vss sg13_lv_nmos L=0.13u W=0.42u
+ AS=0.2373p AD=0.0798p PS=1.97u PD=0.8u rfmode=0
M$13905 \$1783 \$1782 \$1718 VSS|anode|cathode|vss sg13_lv_nmos L=0.13u W=0.42u
+ AS=0.0798p AD=0.1296p PS=0.8u PD=1.52u rfmode=0
M$13906 \$1847 \$1783 VSS|anode|cathode|vss VSS|anode|cathode|vss sg13_lv_nmos
+ L=0.13u W=0.74u AS=0.2516p AD=0.1626p PS=2.16u PD=1.415u rfmode=0
M$13907 VSS|anode|cathode|vss \$1197 \$1908 VSS|anode|cathode|vss sg13_lv_nmos
+ L=0.13u W=0.42u AS=0.1626p AD=0.0609p PS=1.415u PD=0.71u rfmode=0
M$13908 \$1908 \$1463 \$1718 VSS|anode|cathode|vss sg13_lv_nmos L=0.13u W=0.42u
+ AS=0.0609p AD=0.1428p PS=0.71u PD=1.52u rfmode=0
M$13909 \$1719 \$1784 VSS|anode|cathode|vss VSS|anode|cathode|vss sg13_lv_nmos
+ L=0.13u W=0.55u AS=0.187p AD=0.14875p PS=1.78u PD=1.16u rfmode=0
M$13910 VSS|anode|cathode|vss \$1719 X3|dout[4] VSS|anode|cathode|vss
+ sg13_lv_nmos L=0.13u W=0.74u AS=0.14875p AD=0.2886p PS=1.16u PD=2.26u rfmode=0
M$13911 \$1722 \$1721 VSS|anode|cathode|vss VSS|anode|cathode|vss sg13_lv_nmos
+ L=0.5u W=0.42u AS=0.1428p AD=0.1426p PS=1.52u PD=1.16u rfmode=0
M$13912 VSS|anode|cathode|vss \$1722 \$1297 VSS|anode|cathode|vss sg13_lv_nmos
+ L=0.13u W=0.74u AS=0.1426p AD=0.2516p PS=1.16u PD=2.16u rfmode=0
M$13913 \$1784 \$1723 VSS|anode|cathode|vss VSS|anode|cathode|vss sg13_lv_nmos
+ L=0.13u W=0.74u AS=0.2516p AD=0.1406p PS=2.16u PD=1.12u rfmode=0
M$13914 VSS|anode|cathode|vss \$1848 \$1723 VSS|anode|cathode|vss sg13_lv_nmos
+ L=0.13u W=0.74u AS=0.1406p AD=0.2516p PS=1.12u PD=2.16u rfmode=0
M$13915 \$1848 \$1788 \$1878 VSS|anode|cathode|vss sg13_lv_nmos L=0.13u W=0.42u
+ AS=0.12665p AD=0.1428p PS=1.145u PD=1.52u rfmode=0
M$13916 \$1850 \$1787 \$1848 VSS|anode|cathode|vss sg13_lv_nmos L=0.13u W=0.74u
+ AS=0.3473p AD=0.12665p PS=2.71u PD=1.145u rfmode=0
M$13917 \$1788 \$1725 VSS|anode|cathode|vss VSS|anode|cathode|vss sg13_lv_nmos
+ L=0.13u W=0.74u AS=0.2516p AD=0.317325p PS=2.16u PD=1.805u rfmode=0
M$13918 VSS|anode|cathode|vss \$1788 \$1787 VSS|anode|cathode|vss sg13_lv_nmos
+ L=0.13u W=0.74u AS=0.317325p AD=0.2516p PS=1.805u PD=2.16u rfmode=0
M$13919 \$1849 \$1787 \$1789 VSS|anode|cathode|vss sg13_lv_nmos L=0.13u W=0.42u
+ AS=0.2373p AD=0.0798p PS=1.97u PD=0.8u rfmode=0
M$13920 \$1789 \$1788 \$1724 VSS|anode|cathode|vss sg13_lv_nmos L=0.13u W=0.42u
+ AS=0.0798p AD=0.1296p PS=0.8u PD=1.52u rfmode=0
M$13921 \$1384 \$1386 \$1623 VSS|anode|cathode|vss sg13_lv_nmos L=0.13u W=0.42u
+ AS=0.1296p AD=0.0798p PS=1.52u PD=0.8u rfmode=0
M$13922 \$1623 \$1624 \$1470 VSS|anode|cathode|vss sg13_lv_nmos L=0.13u W=0.42u
+ AS=0.0798p AD=0.2373p PS=0.8u PD=1.97u rfmode=0
M$13923 \$1850 \$1789 VSS|anode|cathode|vss VSS|anode|cathode|vss sg13_lv_nmos
+ L=0.13u W=0.74u AS=0.2516p AD=0.1626p PS=2.16u PD=1.415u rfmode=0
M$13924 VSS|anode|cathode|vss \$1468 \$1910 VSS|anode|cathode|vss sg13_lv_nmos
+ L=0.13u W=0.42u AS=0.1626p AD=0.0609p PS=1.415u PD=0.71u rfmode=0
M$13925 \$1910 \$1110 \$1724 VSS|anode|cathode|vss sg13_lv_nmos L=0.13u W=0.42u
+ AS=0.0609p AD=0.1428p PS=0.71u PD=1.52u rfmode=0
M$13926 VSS|anode|cathode|vss \$1386 \$1624 VSS|anode|cathode|vss sg13_lv_nmos
+ L=0.13u W=0.74u AS=0.317325p AD=0.2516p PS=1.805u PD=2.16u rfmode=0
M$13927 VSS|anode|cathode|vss \$1201 \$1386 VSS|anode|cathode|vss sg13_lv_nmos
+ L=0.13u W=0.74u AS=0.317325p AD=0.2516p PS=1.805u PD=2.16u rfmode=0
M$13928 VSS|anode|cathode|vss \$1726 \$1725 VSS|anode|cathode|vss sg13_lv_nmos
+ L=0.13u W=11.84u AS=2.3606p AD=2.2496p PS=18.96u PD=17.92u rfmode=0
M$13944 VSS|anode|cathode|vss \$1215 \$1726 VSS|anode|cathode|vss sg13_lv_nmos
+ L=0.13u W=4.44u AS=0.8436p AD=0.9546p PS=6.72u PD=7.76u rfmode=0
M$13952 \$1390 \$1392 \$1625 VSS|anode|cathode|vss sg13_lv_nmos L=0.13u W=0.42u
+ AS=0.1296p AD=0.0798p PS=1.52u PD=0.8u rfmode=0
M$13953 \$1625 \$1626 \$1473 VSS|anode|cathode|vss sg13_lv_nmos L=0.13u W=0.42u
+ AS=0.0798p AD=0.2373p PS=0.8u PD=1.97u rfmode=0
M$13954 VSS|anode|cathode|vss \$1392 \$1626 VSS|anode|cathode|vss sg13_lv_nmos
+ L=0.13u W=0.74u AS=0.317325p AD=0.2516p PS=1.805u PD=2.16u rfmode=0
M$13955 VSS|anode|cathode|vss \$1725 \$1392 VSS|anode|cathode|vss sg13_lv_nmos
+ L=0.13u W=0.74u AS=0.317325p AD=0.2516p PS=1.805u PD=2.16u rfmode=0
M$13958 \$1728 \$1727 VSS|anode|cathode|vss VSS|anode|cathode|vss sg13_lv_nmos
+ L=0.5u W=0.42u AS=0.1428p AD=0.1426p PS=1.52u PD=1.16u rfmode=0
M$13959 VSS|anode|cathode|vss \$1728 \$1729 VSS|anode|cathode|vss sg13_lv_nmos
+ L=0.13u W=0.74u AS=0.1426p AD=0.2516p PS=1.16u PD=2.16u rfmode=0
M$13960 \$1791 \$1795 \$1793 VSS|anode|cathode|vss sg13_lv_nmos L=0.13u W=0.42u
+ AS=0.1296p AD=0.0798p PS=1.52u PD=0.8u rfmode=0
M$13961 \$1793 \$1794 \$1851 VSS|anode|cathode|vss sg13_lv_nmos L=0.13u W=0.42u
+ AS=0.0798p AD=0.2373p PS=0.8u PD=1.97u rfmode=0
M$13962 \$1794 \$1795 VSS|anode|cathode|vss VSS|anode|cathode|vss sg13_lv_nmos
+ L=0.13u W=0.74u AS=0.2516p AD=0.317325p PS=2.16u PD=1.805u rfmode=0
M$13963 VSS|anode|cathode|vss \$1725 \$1795 VSS|anode|cathode|vss sg13_lv_nmos
+ L=0.13u W=0.74u AS=0.317325p AD=0.2516p PS=1.805u PD=2.16u rfmode=0
M$13964 \$1879 \$1795 \$1852 VSS|anode|cathode|vss sg13_lv_nmos L=0.13u W=0.42u
+ AS=0.1428p AD=0.12665p PS=1.52u PD=1.145u rfmode=0
M$13965 \$1852 \$1794 \$1792 VSS|anode|cathode|vss sg13_lv_nmos L=0.13u W=0.74u
+ AS=0.12665p AD=0.3473p PS=1.145u PD=2.71u rfmode=0
M$13966 \$1730 \$1852 VSS|anode|cathode|vss VSS|anode|cathode|vss sg13_lv_nmos
+ L=0.13u W=0.74u AS=0.2516p AD=0.1406p PS=2.16u PD=1.12u rfmode=0
M$13967 VSS|anode|cathode|vss \$1730 \$1300 VSS|anode|cathode|vss sg13_lv_nmos
+ L=0.13u W=0.74u AS=0.1406p AD=0.2516p PS=1.12u PD=2.16u rfmode=0
M$13968 VSS|anode|cathode|vss \$1732 \$1731 VSS|anode|cathode|vss sg13_lv_nmos
+ L=0.5u W=0.42u AS=0.1426p AD=0.1428p PS=1.16u PD=1.52u rfmode=0
M$13969 \$1591 \$1731 VSS|anode|cathode|vss VSS|anode|cathode|vss sg13_lv_nmos
+ L=0.13u W=0.74u AS=0.2516p AD=0.1426p PS=2.16u PD=1.16u rfmode=0
M$13972 \$1398 \$1400 \$1627 VSS|anode|cathode|vss sg13_lv_nmos L=0.13u W=0.42u
+ AS=0.1296p AD=0.0798p PS=1.52u PD=0.8u rfmode=0
M$13973 \$1627 \$1628 \$1482 VSS|anode|cathode|vss sg13_lv_nmos L=0.13u W=0.42u
+ AS=0.0798p AD=0.2373p PS=0.8u PD=1.97u rfmode=0
M$13976 VSS|anode|cathode|vss \$1400 \$1628 VSS|anode|cathode|vss sg13_lv_nmos
+ L=0.13u W=0.74u AS=0.317325p AD=0.2516p PS=1.805u PD=2.16u rfmode=0
M$13977 VSS|anode|cathode|vss \$1592 \$1400 VSS|anode|cathode|vss sg13_lv_nmos
+ L=0.13u W=0.74u AS=0.317325p AD=0.2516p PS=1.805u PD=2.16u rfmode=0
M$13984 \$1734 \$1733 VSS|anode|cathode|vss VSS|anode|cathode|vss sg13_lv_nmos
+ L=0.5u W=0.42u AS=0.1428p AD=0.1426p PS=1.52u PD=1.16u rfmode=0
M$13985 VSS|anode|cathode|vss \$1734 \$1735 VSS|anode|cathode|vss sg13_lv_nmos
+ L=0.13u W=0.74u AS=0.1426p AD=0.2516p PS=1.16u PD=2.16u rfmode=0
M$13986 \$1799 \$1803 \$1801 VSS|anode|cathode|vss sg13_lv_nmos L=0.13u W=0.42u
+ AS=0.1296p AD=0.0798p PS=1.52u PD=0.8u rfmode=0
M$13987 \$1801 \$1802 \$1853 VSS|anode|cathode|vss sg13_lv_nmos L=0.13u W=0.42u
+ AS=0.0798p AD=0.2373p PS=0.8u PD=1.97u rfmode=0
M$13988 \$1802 \$1803 VSS|anode|cathode|vss VSS|anode|cathode|vss sg13_lv_nmos
+ L=0.13u W=0.74u AS=0.2516p AD=0.317325p PS=2.16u PD=1.805u rfmode=0
M$13989 VSS|anode|cathode|vss \$1592 \$1803 VSS|anode|cathode|vss sg13_lv_nmos
+ L=0.13u W=0.74u AS=0.317325p AD=0.2516p PS=1.805u PD=2.16u rfmode=0
M$13990 \$1880 \$1803 \$1854 VSS|anode|cathode|vss sg13_lv_nmos L=0.13u W=0.42u
+ AS=0.1428p AD=0.12665p PS=1.52u PD=1.145u rfmode=0
M$13991 \$1854 \$1802 \$1800 VSS|anode|cathode|vss sg13_lv_nmos L=0.13u W=0.74u
+ AS=0.12665p AD=0.3473p PS=1.145u PD=2.71u rfmode=0
M$13992 \$1736 \$1854 VSS|anode|cathode|vss VSS|anode|cathode|vss sg13_lv_nmos
+ L=0.13u W=0.74u AS=0.2516p AD=0.1406p PS=2.16u PD=1.12u rfmode=0
M$13993 VSS|anode|cathode|vss \$1736 \$1302 VSS|anode|cathode|vss sg13_lv_nmos
+ L=0.13u W=0.74u AS=0.1406p AD=0.2516p PS=1.12u PD=2.16u rfmode=0
M$14000 \$1407 \$1409 \$1629 VSS|anode|cathode|vss sg13_lv_nmos L=0.13u W=0.42u
+ AS=0.1296p AD=0.0798p PS=1.52u PD=0.8u rfmode=0
M$14001 \$1629 \$1630 \$1495 VSS|anode|cathode|vss sg13_lv_nmos L=0.13u W=0.42u
+ AS=0.0798p AD=0.2373p PS=0.8u PD=1.97u rfmode=0
M$14004 VSS|anode|cathode|vss \$1409 \$1630 VSS|anode|cathode|vss sg13_lv_nmos
+ L=0.13u W=0.74u AS=0.317325p AD=0.2516p PS=1.805u PD=2.16u rfmode=0
M$14005 VSS|anode|cathode|vss \$1592 \$1409 VSS|anode|cathode|vss sg13_lv_nmos
+ L=0.13u W=0.74u AS=0.317325p AD=0.2516p PS=1.805u PD=2.16u rfmode=0
M$14016 VSS|anode|cathode|vss \$1738 \$1737 VSS|anode|cathode|vss sg13_lv_nmos
+ L=0.5u W=0.42u AS=0.1426p AD=0.1428p PS=1.16u PD=1.52u rfmode=0
M$14017 \$1597 \$1737 VSS|anode|cathode|vss VSS|anode|cathode|vss sg13_lv_nmos
+ L=0.13u W=0.74u AS=0.2516p AD=0.1426p PS=2.16u PD=1.16u rfmode=0
M$14018 \$1413 \$1415 \$1631 VSS|anode|cathode|vss sg13_lv_nmos L=0.13u W=0.42u
+ AS=0.1296p AD=0.0798p PS=1.52u PD=0.8u rfmode=0
M$14019 \$1631 \$1632 \$1498 VSS|anode|cathode|vss sg13_lv_nmos L=0.13u W=0.42u
+ AS=0.0798p AD=0.2373p PS=0.8u PD=1.97u rfmode=0
M$14020 VSS|anode|cathode|vss \$1415 \$1632 VSS|anode|cathode|vss sg13_lv_nmos
+ L=0.13u W=0.74u AS=0.317325p AD=0.2516p PS=1.805u PD=2.16u rfmode=0
M$14021 VSS|anode|cathode|vss \$1592 \$1415 VSS|anode|cathode|vss sg13_lv_nmos
+ L=0.13u W=0.74u AS=0.317325p AD=0.2516p PS=1.805u PD=2.16u rfmode=0
M$14022 \$1740 \$1739 VSS|anode|cathode|vss VSS|anode|cathode|vss sg13_lv_nmos
+ L=0.5u W=0.42u AS=0.1428p AD=0.1426p PS=1.52u PD=1.16u rfmode=0
M$14023 VSS|anode|cathode|vss \$1740 \$1596 VSS|anode|cathode|vss sg13_lv_nmos
+ L=0.13u W=0.74u AS=0.1426p AD=0.2516p PS=1.16u PD=2.16u rfmode=0
M$14024 VSS|anode|cathode|vss \$1306 \$1742 VSS|anode|cathode|vss sg13_lv_nmos
+ L=0.13u W=0.55u AS=0.14875p AD=0.187p PS=1.16u PD=1.78u rfmode=0
M$14025 X6|dout[7] \$1742 VSS|anode|cathode|vss VSS|anode|cathode|vss
+ sg13_lv_nmos L=0.13u W=0.74u AS=0.2886p AD=0.14875p PS=2.26u PD=1.16u rfmode=0
M$14034 VSS|anode|cathode|vss \$1215 \$1743 VSS|anode|cathode|vss sg13_lv_nmos
+ L=0.13u W=4.44u AS=0.9546p AD=0.8436p PS=7.76u PD=6.72u rfmode=0
M$14040 VSS|anode|cathode|vss \$1743 \$1592 VSS|anode|cathode|vss sg13_lv_nmos
+ L=0.13u W=11.84u AS=2.2496p AD=2.3606p PS=17.92u PD=18.96u rfmode=0
M$14056 \$1420 \$1422 \$1633 VSS|anode|cathode|vss sg13_lv_nmos L=0.13u W=0.42u
+ AS=0.1296p AD=0.0798p PS=1.52u PD=0.8u rfmode=0
M$14057 \$1633 \$1634 \$1502 VSS|anode|cathode|vss sg13_lv_nmos L=0.13u W=0.42u
+ AS=0.0798p AD=0.2373p PS=0.8u PD=1.97u rfmode=0
M$14058 VSS|anode|cathode|vss \$1422 \$1634 VSS|anode|cathode|vss sg13_lv_nmos
+ L=0.13u W=0.74u AS=0.317325p AD=0.2516p PS=1.805u PD=2.16u rfmode=0
M$14059 VSS|anode|cathode|vss \$1592 \$1422 VSS|anode|cathode|vss sg13_lv_nmos
+ L=0.13u W=0.74u AS=0.317325p AD=0.2516p PS=1.805u PD=2.16u rfmode=0
M$14060 \$1745 \$1744 VSS|anode|cathode|vss VSS|anode|cathode|vss sg13_lv_nmos
+ L=0.5u W=0.42u AS=0.1428p AD=0.1426p PS=1.52u PD=1.16u rfmode=0
M$14061 VSS|anode|cathode|vss \$1745 \$1746 VSS|anode|cathode|vss sg13_lv_nmos
+ L=0.13u W=0.74u AS=0.1426p AD=0.2516p PS=1.16u PD=2.16u rfmode=0
M$14062 \$1808 \$1812 \$1810 VSS|anode|cathode|vss sg13_lv_nmos L=0.13u W=0.42u
+ AS=0.1296p AD=0.0798p PS=1.52u PD=0.8u rfmode=0
M$14063 \$1810 \$1811 \$1855 VSS|anode|cathode|vss sg13_lv_nmos L=0.13u W=0.42u
+ AS=0.0798p AD=0.2373p PS=0.8u PD=1.97u rfmode=0
M$14064 \$1811 \$1812 VSS|anode|cathode|vss VSS|anode|cathode|vss sg13_lv_nmos
+ L=0.13u W=0.74u AS=0.2516p AD=0.317325p PS=2.16u PD=1.805u rfmode=0
M$14065 VSS|anode|cathode|vss \$1592 \$1812 VSS|anode|cathode|vss sg13_lv_nmos
+ L=0.13u W=0.74u AS=0.317325p AD=0.2516p PS=1.805u PD=2.16u rfmode=0
M$14066 \$1881 \$1812 \$1856 VSS|anode|cathode|vss sg13_lv_nmos L=0.13u W=0.42u
+ AS=0.1428p AD=0.12665p PS=1.52u PD=1.145u rfmode=0
M$14067 \$1856 \$1811 \$1809 VSS|anode|cathode|vss sg13_lv_nmos L=0.13u W=0.74u
+ AS=0.12665p AD=0.3473p PS=1.145u PD=2.71u rfmode=0
M$14068 \$1747 \$1856 VSS|anode|cathode|vss VSS|anode|cathode|vss sg13_lv_nmos
+ L=0.13u W=0.74u AS=0.2516p AD=0.1406p PS=2.16u PD=1.12u rfmode=0
M$14069 VSS|anode|cathode|vss \$1747 \$1635 VSS|anode|cathode|vss sg13_lv_nmos
+ L=0.13u W=0.74u AS=0.1406p AD=0.2516p PS=1.12u PD=2.16u rfmode=0
M$14070 VSS|anode|cathode|vss \$1749 \$1748 VSS|anode|cathode|vss sg13_lv_nmos
+ L=0.5u W=0.42u AS=0.1426p AD=0.1428p PS=1.16u PD=1.52u rfmode=0
M$14071 \$1599 \$1748 VSS|anode|cathode|vss VSS|anode|cathode|vss sg13_lv_nmos
+ L=0.13u W=0.74u AS=0.2516p AD=0.1426p PS=2.16u PD=1.16u rfmode=0
M$14072 VSS|anode|cathode|vss \$1215 \$1750 VSS|anode|cathode|vss sg13_lv_nmos
+ L=0.13u W=4.44u AS=0.9546p AD=0.8436p PS=7.76u PD=6.72u rfmode=0
M$14078 VSS|anode|cathode|vss \$1750 \$1311 VSS|anode|cathode|vss sg13_lv_nmos
+ L=0.13u W=11.84u AS=2.2496p AD=2.3606p PS=17.92u PD=18.96u rfmode=0
M$14094 \$1430 \$1432 \$1636 VSS|anode|cathode|vss sg13_lv_nmos L=0.13u W=0.42u
+ AS=0.1296p AD=0.0798p PS=1.52u PD=0.8u rfmode=0
M$14095 \$1636 \$1637 \$1513 VSS|anode|cathode|vss sg13_lv_nmos L=0.13u W=0.42u
+ AS=0.0798p AD=0.2373p PS=0.8u PD=1.97u rfmode=0
M$14096 VSS|anode|cathode|vss \$1432 \$1637 VSS|anode|cathode|vss sg13_lv_nmos
+ L=0.13u W=0.74u AS=0.317325p AD=0.2516p PS=1.805u PD=2.16u rfmode=0
M$14097 VSS|anode|cathode|vss \$1311 \$1432 VSS|anode|cathode|vss sg13_lv_nmos
+ L=0.13u W=0.74u AS=0.317325p AD=0.2516p PS=1.805u PD=2.16u rfmode=0
M$14098 VSS|anode|cathode|vss \$1061 \$1751 VSS|anode|cathode|vss sg13_lv_nmos
+ L=0.13u W=0.55u AS=0.14875p AD=0.187p PS=1.16u PD=1.78u rfmode=0
M$14099 \$1352 \$1751 VSS|anode|cathode|vss VSS|anode|cathode|vss sg13_lv_nmos
+ L=0.13u W=0.74u AS=0.2886p AD=0.14875p PS=2.26u PD=1.16u rfmode=0
M$14100 \$1753 \$1752 VSS|anode|cathode|vss VSS|anode|cathode|vss sg13_lv_nmos
+ L=0.5u W=0.42u AS=0.1428p AD=0.1426p PS=1.52u PD=1.16u rfmode=0
M$14101 VSS|anode|cathode|vss \$1753 \$1308 VSS|anode|cathode|vss sg13_lv_nmos
+ L=0.13u W=0.74u AS=0.1426p AD=0.2516p PS=1.16u PD=2.16u rfmode=0
M$14102 \$1816 \$1820 \$1818 VSS|anode|cathode|vss sg13_lv_nmos L=0.13u W=0.42u
+ AS=0.1296p AD=0.0798p PS=1.52u PD=0.8u rfmode=0
M$14103 \$1818 \$1819 \$1857 VSS|anode|cathode|vss sg13_lv_nmos L=0.13u W=0.42u
+ AS=0.0798p AD=0.2373p PS=0.8u PD=1.97u rfmode=0
M$14104 \$1819 \$1820 VSS|anode|cathode|vss VSS|anode|cathode|vss sg13_lv_nmos
+ L=0.13u W=0.74u AS=0.2516p AD=0.317325p PS=2.16u PD=1.805u rfmode=0
M$14105 VSS|anode|cathode|vss \$1311 \$1820 VSS|anode|cathode|vss sg13_lv_nmos
+ L=0.13u W=0.74u AS=0.317325p AD=0.2516p PS=1.805u PD=2.16u rfmode=0
M$14106 \$1882 \$1820 \$1858 VSS|anode|cathode|vss sg13_lv_nmos L=0.13u W=0.42u
+ AS=0.1428p AD=0.12665p PS=1.52u PD=1.145u rfmode=0
M$14107 \$1858 \$1819 \$1817 VSS|anode|cathode|vss sg13_lv_nmos L=0.13u W=0.74u
+ AS=0.12665p AD=0.3473p PS=1.145u PD=2.71u rfmode=0
M$14108 \$1754 \$1858 VSS|anode|cathode|vss VSS|anode|cathode|vss sg13_lv_nmos
+ L=0.13u W=0.74u AS=0.2516p AD=0.1406p PS=2.16u PD=1.12u rfmode=0
M$14109 VSS|anode|cathode|vss \$1754 \$1605 VSS|anode|cathode|vss sg13_lv_nmos
+ L=0.13u W=0.74u AS=0.1406p AD=0.2516p PS=1.12u PD=2.16u rfmode=0
M$14110 VSS|anode|cathode|vss \$1605 \$1755 VSS|anode|cathode|vss sg13_lv_nmos
+ L=0.13u W=0.55u AS=0.14875p AD=0.187p PS=1.16u PD=1.78u rfmode=0
M$14111 X8|dout[9] \$1755 VSS|anode|cathode|vss VSS|anode|cathode|vss
+ sg13_lv_nmos L=0.13u W=0.74u AS=0.2886p AD=0.14875p PS=2.26u PD=1.16u rfmode=0
M$14112 VSS|anode|cathode|vss \$1061 \$1756 VSS|anode|cathode|vss sg13_lv_nmos
+ L=0.13u W=0.55u AS=0.14875p AD=0.187p PS=1.16u PD=1.78u rfmode=0
M$14113 \$1166 \$1756 VSS|anode|cathode|vss VSS|anode|cathode|vss sg13_lv_nmos
+ L=0.13u W=0.74u AS=0.2886p AD=0.14875p PS=2.26u PD=1.16u rfmode=0
M$14114 VSS|anode|cathode|vss \$1758 \$1757 VSS|anode|cathode|vss sg13_lv_nmos
+ L=0.5u W=0.42u AS=0.1426p AD=0.1428p PS=1.16u PD=1.52u rfmode=0
M$14115 \$1606 \$1757 VSS|anode|cathode|vss VSS|anode|cathode|vss sg13_lv_nmos
+ L=0.13u W=0.74u AS=0.2516p AD=0.1426p PS=2.16u PD=1.16u rfmode=0
M$14116 \$1823 \$1827 \$1825 VSS|anode|cathode|vss sg13_lv_nmos L=0.13u W=0.42u
+ AS=0.1296p AD=0.0798p PS=1.52u PD=0.8u rfmode=0
M$14117 \$1825 \$1826 \$1859 VSS|anode|cathode|vss sg13_lv_nmos L=0.13u W=0.42u
+ AS=0.0798p AD=0.2373p PS=0.8u PD=1.97u rfmode=0
M$14118 \$1826 \$1827 VSS|anode|cathode|vss VSS|anode|cathode|vss sg13_lv_nmos
+ L=0.13u W=0.74u AS=0.2516p AD=0.317325p PS=2.16u PD=1.805u rfmode=0
M$14119 VSS|anode|cathode|vss \$1311 \$1827 VSS|anode|cathode|vss sg13_lv_nmos
+ L=0.13u W=0.74u AS=0.317325p AD=0.2516p PS=1.805u PD=2.16u rfmode=0
M$14120 \$1883 \$1827 \$1860 VSS|anode|cathode|vss sg13_lv_nmos L=0.13u W=0.42u
+ AS=0.1428p AD=0.12665p PS=1.52u PD=1.145u rfmode=0
M$14121 \$1860 \$1826 \$1824 VSS|anode|cathode|vss sg13_lv_nmos L=0.13u W=0.74u
+ AS=0.12665p AD=0.3473p PS=1.145u PD=2.71u rfmode=0
M$14122 \$1439 \$1441 \$1638 VSS|anode|cathode|vss sg13_lv_nmos L=0.13u W=0.42u
+ AS=0.1296p AD=0.0798p PS=1.52u PD=0.8u rfmode=0
M$14123 \$1638 \$1639 \$1531 VSS|anode|cathode|vss sg13_lv_nmos L=0.13u W=0.42u
+ AS=0.0798p AD=0.2373p PS=0.8u PD=1.97u rfmode=0
M$14124 \$1759 \$1860 VSS|anode|cathode|vss VSS|anode|cathode|vss sg13_lv_nmos
+ L=0.13u W=0.74u AS=0.2516p AD=0.1406p PS=2.16u PD=1.12u rfmode=0
M$14125 VSS|anode|cathode|vss \$1759 \$1760 VSS|anode|cathode|vss sg13_lv_nmos
+ L=0.13u W=0.74u AS=0.1406p AD=0.2516p PS=1.12u PD=2.16u rfmode=0
M$14126 VSS|anode|cathode|vss \$1441 \$1639 VSS|anode|cathode|vss sg13_lv_nmos
+ L=0.13u W=0.74u AS=0.317325p AD=0.2516p PS=1.805u PD=2.16u rfmode=0
M$14127 VSS|anode|cathode|vss \$1311 \$1441 VSS|anode|cathode|vss sg13_lv_nmos
+ L=0.13u W=0.74u AS=0.317325p AD=0.2516p PS=1.805u PD=2.16u rfmode=0
M$14140 VSS|anode|cathode|vss \$1760 \$1761 VSS|anode|cathode|vss sg13_lv_nmos
+ L=0.13u W=0.55u AS=0.14875p AD=0.187p PS=1.16u PD=1.78u rfmode=0
M$14141 X9|dout[10] \$1761 VSS|anode|cathode|vss VSS|anode|cathode|vss
+ sg13_lv_nmos L=0.13u W=0.74u AS=0.2886p AD=0.14875p PS=2.26u PD=1.16u rfmode=0
M$14166 VSS|anode|cathode|vss \$1445 \$1762 VSS|anode|cathode|vss sg13_lv_nmos
+ L=0.13u W=0.55u AS=0.14875p AD=0.187p PS=1.16u PD=1.78u rfmode=0
M$14167 X10|dout[11] \$1762 VSS|anode|cathode|vss VSS|anode|cathode|vss
+ sg13_lv_nmos L=0.13u W=0.74u AS=0.2886p AD=0.14875p PS=2.26u PD=1.16u rfmode=0
M$14180 \$2046 D4|c2p|core|i|uo_c2p[4] VSS|anode|cathode|vss
+ VSS|anode|cathode|vss sg13_lv_nmos L=0.13u W=2.75u AS=0.935p AD=0.935p
+ PS=6.18u PD=6.18u rfmode=0
M$14181 \$2057 D4|c2p|core|i|uo_c2p[4] VSS|anode|cathode|vss
+ VSS|anode|cathode|vss sg13_lv_nmos L=0.13u W=2.75u AS=0.935p AD=0.935p
+ PS=6.18u PD=6.18u rfmode=0
M$14182 \$887 \$2103 VSS|anode|cathode|vss VSS|anode|cathode|vss sg13_lv_nmos
+ L=0.13u W=0.74u AS=0.2886p AD=0.14875p PS=2.26u PD=1.16u rfmode=0
M$14183 VSS|anode|cathode|vss \$2132 \$2103 VSS|anode|cathode|vss sg13_lv_nmos
+ L=0.13u W=0.55u AS=0.14875p AD=0.187p PS=1.16u PD=1.78u rfmode=0
M$14184 VSS|anode|cathode|vss \$2245 \$2183 VSS|anode|cathode|vss sg13_lv_nmos
+ L=0.13u W=0.55u AS=0.14875p AD=0.187p PS=1.16u PD=1.78u rfmode=0
M$14185 \$886 \$2183 VSS|anode|cathode|vss VSS|anode|cathode|vss sg13_lv_nmos
+ L=0.13u W=0.74u AS=0.2886p AD=0.14875p PS=2.26u PD=1.16u rfmode=0
M$14188 \$770 \$1977 analog_io_padres[19]|core|padres|vin_neg
+ VSS|anode|cathode|vss sg13_lv_nmos L=0.13u W=2.5u AS=0.85p AD=0.85p PS=5.68u
+ PD=5.68u rfmode=0
M$14189 VSS|anode|cathode|vss Op \$2104 VSS|anode|cathode|vss sg13_lv_nmos
+ L=0.13u W=0.55u AS=0.14875p AD=0.187p PS=1.16u PD=1.78u rfmode=0
M$14190 VSS|anode|cathode|vss \$2104 \$2073 VSS|anode|cathode|vss sg13_lv_nmos
+ L=0.13u W=0.74u AS=0.14875p AD=0.2886p PS=1.16u PD=2.26u rfmode=0
M$14191 analog_io_padres[19]|core|padres|vin_neg \$1928 \$1870
+ VSS|anode|cathode|vss sg13_lv_nmos L=0.13u W=3u AS=1.02p AD=1.02p PS=6.68u
+ PD=6.68u rfmode=0
M$14194 \$1928 VDD|in|pad|pin1|pin2|supply|vdd \$1929 VSS|anode|cathode|vss
+ sg13_lv_nmos L=0.13u W=3u AS=1.02p AD=1.02p PS=6.68u PD=6.68u rfmode=0
M$14195 \$1929 \$1839 VSS|anode|cathode|vss VSS|anode|cathode|vss sg13_lv_nmos
+ L=0.13u W=3u AS=1.02p AD=1.02p PS=6.68u PD=6.68u rfmode=0
M$14196 VSS|anode|cathode|vss \$1839 \$1870 VSS|anode|cathode|vss sg13_lv_nmos
+ L=0.4u W=1.3u AS=0.442p AD=0.442p PS=3.28u PD=3.28u rfmode=0
M$14197 \$1992 \$1996 VSS|anode|cathode|vss VSS|anode|cathode|vss sg13_lv_nmos
+ L=0.13u W=0.4u AS=0.136p AD=0.136p PS=1.48u PD=1.48u rfmode=0
M$14200 VSS|anode|cathode|vss \$1839 \$1970 VSS|anode|cathode|vss sg13_lv_nmos
+ L=0.13u W=0.5u AS=0.17p AD=0.17p PS=1.68u PD=1.68u rfmode=0
M$14201 \$1970 VDD|in|pad|pin1|pin2|supply|vdd \$1977 VSS|anode|cathode|vss
+ sg13_lv_nmos L=0.13u W=0.5u AS=0.17p AD=0.17p PS=1.68u PD=1.68u rfmode=0
M$14204 \$1968 \$2013 VDD|in|pad|pin1|pin2|supply|vdd VSS|anode|cathode|vss
+ sg13_lv_nmos L=0.13u W=1.3u AS=0.442p AD=0.442p PS=3.28u PD=3.28u rfmode=0
M$14205 \$1838 \$1839 VSS|anode|cathode|vss VSS|anode|cathode|vss sg13_lv_nmos
+ L=0.13u W=0.4u AS=0.136p AD=0.136p PS=1.48u PD=1.48u rfmode=0
M$14206 VDD|in|pad|pin1|pin2|supply|vdd \$2013 \$2012 VSS|anode|cathode|vss
+ sg13_lv_nmos L=0.13u W=1.3u AS=0.442p AD=0.442p PS=3.28u PD=3.28u rfmode=0
M$14207 \$2013 \$2012 VDD|in|pad|pin1|pin2|supply|vdd VSS|anode|cathode|vss
+ sg13_lv_nmos L=0.13u W=1.3u AS=0.442p AD=0.442p PS=3.28u PD=3.28u rfmode=0
M$14208 \$1839 fclk_samp VSS|anode|cathode|vss VSS|anode|cathode|vss
+ sg13_lv_nmos L=0.13u W=0.4u AS=0.136p AD=0.136p PS=1.48u PD=1.48u rfmode=0
M$14209 VSS|anode|cathode|vss \$2149 \$2105 VSS|anode|cathode|vss sg13_lv_nmos
+ L=0.13u W=0.55u AS=0.14875p AD=0.187p PS=1.16u PD=1.78u rfmode=0
M$14210 VSS|anode|cathode|vss \$2105 clk_comp VSS|anode|cathode|vss
+ sg13_lv_nmos L=0.13u W=0.74u AS=0.14875p AD=0.2886p PS=1.16u PD=2.26u rfmode=0
M$14211 VSS|anode|cathode|vss \$2131 \$2074 VSS|anode|cathode|vss sg13_lv_nmos
+ L=0.13u W=0.55u AS=0.18945p AD=0.187p PS=1.27u PD=1.78u rfmode=0
M$14212 VSS|anode|cathode|vss \$2131 \$2123 VSS|anode|cathode|vss sg13_lv_nmos
+ L=0.13u W=0.74u AS=0.18945p AD=0.13135p PS=1.27u PD=1.095u rfmode=0
M$14213 \$2123 \$2106 \$2075 VSS|anode|cathode|vss sg13_lv_nmos L=0.13u W=0.74u
+ AS=0.13135p AD=0.1628p PS=1.095u PD=1.18u rfmode=0
M$14214 \$2075 \$2132 \$2122 VSS|anode|cathode|vss sg13_lv_nmos L=0.13u W=0.74u
+ AS=0.1628p AD=0.3367p PS=1.18u PD=1.65u rfmode=0
M$14215 \$2122 \$2074 VSS|anode|cathode|vss VSS|anode|cathode|vss sg13_lv_nmos
+ L=0.13u W=0.74u AS=0.3367p AD=0.148p PS=1.65u PD=1.14u rfmode=0
M$14216 VSS|anode|cathode|vss \$2075 \$2076 VSS|anode|cathode|vss sg13_lv_nmos
+ L=0.13u W=0.74u AS=0.148p AD=0.4033p PS=1.14u PD=2.57u rfmode=0
M$14217 \$2184 \$2205 VSS|anode|cathode|vss VSS|anode|cathode|vss sg13_lv_nmos
+ L=0.13u W=0.74u AS=0.2516p AD=0.2516p PS=2.16u PD=2.16u rfmode=0
M$14218 VSS|anode|cathode|vss \$2373 \$2185 VSS|anode|cathode|vss sg13_lv_nmos
+ L=0.13u W=0.55u AS=0.14875p AD=0.187p PS=1.16u PD=1.78u rfmode=0
M$14219 \$2149 \$2185 VSS|anode|cathode|vss VSS|anode|cathode|vss sg13_lv_nmos
+ L=0.13u W=0.74u AS=0.2886p AD=0.14875p PS=2.26u PD=1.16u rfmode=0
M$14220 VSS|anode|cathode|vss \$2078 \$2077 VSS|anode|cathode|vss sg13_lv_nmos
+ L=0.13u W=11.84u AS=2.3606p AD=2.2496p PS=18.96u PD=17.92u rfmode=0
M$14236 VSS|anode|cathode|vss CLK|clk|core|fclk_in|p2c|ui_p2c[6] \$2078
+ VSS|anode|cathode|vss sg13_lv_nmos L=0.13u W=4.44u AS=0.8436p AD=0.9546p
+ PS=6.72u PD=7.76u rfmode=0
M$14242 \$2175 \$2246 \$2207 VSS|anode|cathode|vss sg13_lv_nmos L=0.13u W=0.42u
+ AS=0.1296p AD=0.0798p PS=1.52u PD=0.8u rfmode=0
M$14243 \$2207 \$2208 \$2268 VSS|anode|cathode|vss sg13_lv_nmos L=0.13u W=0.42u
+ AS=0.0798p AD=0.2373p PS=0.8u PD=1.97u rfmode=0
M$14244 \$2208 \$2246 VSS|anode|cathode|vss VSS|anode|cathode|vss sg13_lv_nmos
+ L=0.13u W=0.74u AS=0.2516p AD=0.317325p PS=2.16u PD=1.805u rfmode=0
M$14245 VSS|anode|cathode|vss \$2247 \$2246 VSS|anode|cathode|vss sg13_lv_nmos
+ L=0.13u W=0.74u AS=0.317325p AD=0.2516p PS=1.805u PD=2.16u rfmode=0
M$14246 \$2269 \$2246 \$2209 VSS|anode|cathode|vss sg13_lv_nmos L=0.13u W=0.42u
+ AS=0.1428p AD=0.12665p PS=1.52u PD=1.145u rfmode=0
M$14247 \$2209 \$2208 \$2206 VSS|anode|cathode|vss sg13_lv_nmos L=0.13u W=0.74u
+ AS=0.12665p AD=0.3473p PS=1.145u PD=2.71u rfmode=0
M$14248 \$2186 \$2209 VSS|anode|cathode|vss VSS|anode|cathode|vss sg13_lv_nmos
+ L=0.13u W=0.74u AS=0.2516p AD=0.1406p PS=2.16u PD=1.12u rfmode=0
M$14249 VSS|anode|cathode|vss \$2186 \$2132 VSS|anode|cathode|vss sg13_lv_nmos
+ L=0.13u W=0.74u AS=0.1406p AD=0.2516p PS=1.12u PD=2.16u rfmode=0
M$14250 VSS|anode|cathode|vss \$2136 \$2125 VSS|anode|cathode|vss sg13_lv_nmos
+ L=0.13u W=0.74u AS=0.2886p AD=0.1406p PS=2.26u PD=1.12u rfmode=0
M$14251 \$2125 \$2133 \$2124 VSS|anode|cathode|vss sg13_lv_nmos L=0.13u W=0.74u
+ AS=0.1406p AD=0.1406p PS=1.12u PD=1.12u rfmode=0
M$14252 \$2124 \$2134 \$2079 VSS|anode|cathode|vss sg13_lv_nmos L=0.13u W=0.74u
+ AS=0.1406p AD=0.2516p PS=1.12u PD=2.16u rfmode=0
M$14253 VSS|anode|cathode|vss \$2248 \$2187 VSS|anode|cathode|vss sg13_lv_nmos
+ L=0.13u W=0.55u AS=0.14875p AD=0.187p PS=1.16u PD=1.78u rfmode=0
M$14254 \$2205 \$2187 VSS|anode|cathode|vss VSS|anode|cathode|vss sg13_lv_nmos
+ L=0.13u W=0.74u AS=0.2886p AD=0.14875p PS=2.26u PD=1.16u rfmode=0
M$14255 VSS|anode|cathode|vss \$2135 \$2080 VSS|anode|cathode|vss sg13_lv_nmos
+ L=0.13u W=0.74u AS=0.3108p AD=0.1628p PS=2.32u PD=1.18u rfmode=0
M$14256 \$2080 \$2136 \$2127 VSS|anode|cathode|vss sg13_lv_nmos L=0.13u W=0.74u
+ AS=0.1628p AD=0.0888p PS=1.18u PD=0.98u rfmode=0
M$14257 \$2127 \$2134 VSS|anode|cathode|vss VSS|anode|cathode|vss sg13_lv_nmos
+ L=0.13u W=0.74u AS=0.0888p AD=0.15245p PS=0.98u PD=1.17u rfmode=0
M$14258 VSS|anode|cathode|vss \$2136 \$2135 VSS|anode|cathode|vss sg13_lv_nmos
+ L=0.13u W=0.55u AS=0.15245p AD=0.174625p PS=1.17u PD=1.185u rfmode=0
M$14259 \$2135 \$2134 VSS|anode|cathode|vss VSS|anode|cathode|vss sg13_lv_nmos
+ L=0.13u W=0.55u AS=0.174625p AD=0.374p PS=1.185u PD=2.46u rfmode=0
M$14260 \$2176 \$2249 \$2212 VSS|anode|cathode|vss sg13_lv_nmos L=0.13u W=0.42u
+ AS=0.1296p AD=0.0798p PS=1.52u PD=0.8u rfmode=0
M$14261 \$2212 \$2213 \$2270 VSS|anode|cathode|vss sg13_lv_nmos L=0.13u W=0.42u
+ AS=0.0798p AD=0.2373p PS=0.8u PD=1.97u rfmode=0
M$14262 VSS|anode|cathode|vss \$2137 \$2126 VSS|anode|cathode|vss sg13_lv_nmos
+ L=0.13u W=0.64u AS=0.2272p AD=0.0784p PS=1.99u PD=0.885u rfmode=0
M$14263 \$2126 \$2079 \$2107 VSS|anode|cathode|vss sg13_lv_nmos L=0.13u W=0.64u
+ AS=0.0784p AD=0.2176p PS=0.885u PD=1.96u rfmode=0
M$14264 \$2213 \$2249 VSS|anode|cathode|vss VSS|anode|cathode|vss sg13_lv_nmos
+ L=0.13u W=0.74u AS=0.2516p AD=0.317325p PS=2.16u PD=1.805u rfmode=0
M$14265 VSS|anode|cathode|vss \$2368 \$2249 VSS|anode|cathode|vss sg13_lv_nmos
+ L=0.13u W=0.74u AS=0.317325p AD=0.2516p PS=1.805u PD=2.16u rfmode=0
M$14266 VSS|anode|cathode|vss \$2137 \$2081 VSS|anode|cathode|vss sg13_lv_nmos
+ L=0.13u W=0.74u AS=0.1898p AD=0.2516p PS=1.36u PD=2.16u rfmode=0
M$14267 VSS|anode|cathode|vss \$2079 \$2081 VSS|anode|cathode|vss sg13_lv_nmos
+ L=0.13u W=0.74u AS=0.1898p AD=0.1406p PS=1.36u PD=1.12u rfmode=0
M$14268 \$2081 \$2107 \$2150 VSS|anode|cathode|vss sg13_lv_nmos L=0.13u W=0.74u
+ AS=0.1406p AD=0.2516p PS=1.12u PD=2.16u rfmode=0
M$14269 \$2271 \$2249 \$2214 VSS|anode|cathode|vss sg13_lv_nmos L=0.13u W=0.42u
+ AS=0.1428p AD=0.12665p PS=1.52u PD=1.145u rfmode=0
M$14270 \$2214 \$2213 \$2211 VSS|anode|cathode|vss sg13_lv_nmos L=0.13u W=0.74u
+ AS=0.12665p AD=0.3473p PS=1.145u PD=2.71u rfmode=0
M$14271 \$2136 \$2108 VSS|anode|cathode|vss VSS|anode|cathode|vss sg13_lv_nmos
+ L=0.13u W=0.74u AS=0.2516p AD=0.1426p PS=2.16u PD=1.16u rfmode=0
M$14272 VSS|anode|cathode|vss \$2138 \$2108 VSS|anode|cathode|vss sg13_lv_nmos
+ L=0.5u W=0.42u AS=0.1426p AD=0.1428p PS=1.16u PD=1.52u rfmode=0
M$14273 \$2138 \$2082 VSS|anode|cathode|vss VSS|anode|cathode|vss sg13_lv_nmos
+ L=0.5u W=0.42u AS=0.1428p AD=0.0798p PS=1.52u PD=0.8u rfmode=0
M$14274 VSS|anode|cathode|vss \$2139 \$2082 VSS|anode|cathode|vss sg13_lv_nmos
+ L=0.13u W=0.42u AS=0.0798p AD=0.1428p PS=0.8u PD=1.52u rfmode=0
M$14275 \$2188 \$2214 VSS|anode|cathode|vss VSS|anode|cathode|vss sg13_lv_nmos
+ L=0.13u W=0.74u AS=0.2516p AD=0.1406p PS=2.16u PD=1.12u rfmode=0
M$14276 VSS|anode|cathode|vss \$2188 \$2139 VSS|anode|cathode|vss sg13_lv_nmos
+ L=0.13u W=0.74u AS=0.1406p AD=0.2516p PS=1.12u PD=2.16u rfmode=0
M$14278 \$2083 \$2109 VSS|anode|cathode|vss VSS|anode|cathode|vss sg13_lv_nmos
+ L=0.13u W=0.74u AS=0.2516p AD=0.1426p PS=2.16u PD=1.16u rfmode=0
M$14279 VSS|anode|cathode|vss \$2140 \$2109 VSS|anode|cathode|vss sg13_lv_nmos
+ L=0.5u W=0.42u AS=0.1426p AD=0.1428p PS=1.16u PD=1.52u rfmode=0
M$14280 \$2140 \$2084 VSS|anode|cathode|vss VSS|anode|cathode|vss sg13_lv_nmos
+ L=0.5u W=0.42u AS=0.1428p AD=0.0798p PS=1.52u PD=0.8u rfmode=0
M$14281 VSS|anode|cathode|vss \$2150 \$2084 VSS|anode|cathode|vss sg13_lv_nmos
+ L=0.13u W=0.42u AS=0.0798p AD=0.1428p PS=0.8u PD=1.52u rfmode=0
M$14282 \$2178 \$2250 \$2217 VSS|anode|cathode|vss sg13_lv_nmos L=0.13u W=0.42u
+ AS=0.1296p AD=0.0798p PS=1.52u PD=0.8u rfmode=0
M$14283 \$2217 \$2218 \$2272 VSS|anode|cathode|vss sg13_lv_nmos L=0.13u W=0.42u
+ AS=0.0798p AD=0.2373p PS=0.8u PD=1.97u rfmode=0
M$14284 \$2218 \$2250 VSS|anode|cathode|vss VSS|anode|cathode|vss sg13_lv_nmos
+ L=0.13u W=0.74u AS=0.2516p AD=0.317325p PS=2.16u PD=1.805u rfmode=0
M$14285 VSS|anode|cathode|vss \$2368 \$2250 VSS|anode|cathode|vss sg13_lv_nmos
+ L=0.13u W=0.74u AS=0.317325p AD=0.2516p PS=1.805u PD=2.16u rfmode=0
M$14286 \$2137 \$2110 VSS|anode|cathode|vss VSS|anode|cathode|vss sg13_lv_nmos
+ L=0.13u W=0.74u AS=0.2516p AD=0.1426p PS=2.16u PD=1.16u rfmode=0
M$14287 VSS|anode|cathode|vss \$2141 \$2110 VSS|anode|cathode|vss sg13_lv_nmos
+ L=0.5u W=0.42u AS=0.1426p AD=0.1428p PS=1.16u PD=1.52u rfmode=0
M$14288 \$2273 \$2250 \$2219 VSS|anode|cathode|vss sg13_lv_nmos L=0.13u W=0.42u
+ AS=0.1428p AD=0.12665p PS=1.52u PD=1.145u rfmode=0
M$14289 \$2219 \$2218 \$2216 VSS|anode|cathode|vss sg13_lv_nmos L=0.13u W=0.74u
+ AS=0.12665p AD=0.3473p PS=1.145u PD=2.71u rfmode=0
M$14290 \$2141 \$2085 VSS|anode|cathode|vss VSS|anode|cathode|vss sg13_lv_nmos
+ L=0.5u W=0.42u AS=0.1428p AD=0.0798p PS=1.52u PD=0.8u rfmode=0
M$14291 VSS|anode|cathode|vss \$2142 \$2085 VSS|anode|cathode|vss sg13_lv_nmos
+ L=0.13u W=0.42u AS=0.0798p AD=0.1428p PS=0.8u PD=1.52u rfmode=0
M$14292 \$2086 \$2111 VSS|anode|cathode|vss VSS|anode|cathode|vss sg13_lv_nmos
+ L=0.13u W=0.74u AS=0.2886p AD=0.14875p PS=2.26u PD=1.16u rfmode=0
M$14293 VSS|anode|cathode|vss core|p2c|reset|rst|ui_p2c[5] \$2111
+ VSS|anode|cathode|vss sg13_lv_nmos L=0.13u W=0.55u AS=0.14875p AD=0.187p
+ PS=1.16u PD=1.78u rfmode=0
M$14294 \$2189 \$2219 VSS|anode|cathode|vss VSS|anode|cathode|vss sg13_lv_nmos
+ L=0.13u W=0.74u AS=0.2516p AD=0.1406p PS=2.16u PD=1.12u rfmode=0
M$14295 VSS|anode|cathode|vss \$2189 \$2142 VSS|anode|cathode|vss sg13_lv_nmos
+ L=0.13u W=0.74u AS=0.1406p AD=0.2516p PS=1.12u PD=2.16u rfmode=0
M$14296 \$2087 \$2143 VSS|anode|cathode|vss VSS|anode|cathode|vss sg13_lv_nmos
+ L=0.13u W=0.42u AS=0.1428p AD=0.0798p PS=1.52u PD=0.8u rfmode=0
M$14297 VSS|anode|cathode|vss \$2087 \$2088 VSS|anode|cathode|vss sg13_lv_nmos
+ L=0.5u W=0.42u AS=0.0798p AD=0.1428p PS=0.8u PD=1.52u rfmode=0
M$14298 VSS|anode|cathode|vss \$2088 \$2112 VSS|anode|cathode|vss sg13_lv_nmos
+ L=0.5u W=0.42u AS=0.1426p AD=0.1428p PS=1.16u PD=1.52u rfmode=0
M$14299 VSS|anode|cathode|vss \$2112 \$2089 VSS|anode|cathode|vss sg13_lv_nmos
+ L=0.13u W=0.74u AS=0.1426p AD=0.2516p PS=1.16u PD=2.16u rfmode=0
M$14300 \$2191 \$2190 VSS|anode|cathode|vss VSS|anode|cathode|vss sg13_lv_nmos
+ L=0.5u W=0.42u AS=0.1428p AD=0.1426p PS=1.52u PD=1.16u rfmode=0
M$14301 VSS|anode|cathode|vss \$2191 \$2192 VSS|anode|cathode|vss sg13_lv_nmos
+ L=0.13u W=0.74u AS=0.1426p AD=0.2516p PS=1.16u PD=2.16u rfmode=0
M$14302 \$2113 \$2089 \$2129 VSS|anode|cathode|vss sg13_lv_nmos L=0.13u W=0.42u
+ AS=0.1428p AD=0.0609p PS=1.52u PD=0.71u rfmode=0
M$14303 \$2129 \$2145 VSS|anode|cathode|vss VSS|anode|cathode|vss sg13_lv_nmos
+ L=0.13u W=0.42u AS=0.0609p AD=0.1626p PS=0.71u PD=1.415u rfmode=0
M$14304 VSS|anode|cathode|vss \$2144 \$2071 VSS|anode|cathode|vss sg13_lv_nmos
+ L=0.13u W=0.74u AS=0.1626p AD=0.2516p PS=1.415u PD=2.16u rfmode=0
M$14305 VSS|anode|cathode|vss \$2096 \$2222 VSS|anode|cathode|vss sg13_lv_nmos
+ L=0.13u W=0.55u AS=0.17255p AD=0.187p PS=1.25u PD=1.78u rfmode=0
M$14306 VSS|anode|cathode|vss \$2089 \$2193 VSS|anode|cathode|vss sg13_lv_nmos
+ L=0.13u W=0.74u AS=0.2516p AD=0.1406p PS=2.16u PD=1.12u rfmode=0
M$14307 \$2193 \$2222 VSS|anode|cathode|vss VSS|anode|cathode|vss sg13_lv_nmos
+ L=0.13u W=0.74u AS=0.1406p AD=0.17255p PS=1.12u PD=1.25u rfmode=0
M$14308 VSS|anode|cathode|vss \$2145 \$2128 VSS|anode|cathode|vss sg13_lv_nmos
+ L=0.13u W=0.42u AS=0.1701p AD=0.0378p PS=1.65u PD=0.6u rfmode=0
M$14309 \$2128 \$2071 \$2090 VSS|anode|cathode|vss sg13_lv_nmos L=0.13u W=0.42u
+ AS=0.0378p AD=0.1428p PS=0.6u PD=1.52u rfmode=0
M$14310 \$2035 Op \$2038 VSS|anode|cathode|vss sg13_lv_nmos L=0.13u W=0.25u
+ AS=0.1075p AD=0.0625p PS=1.34u PD=0.74u rfmode=0
M$14311 \$2038 Om VSS|anode|cathode|vss VSS|anode|cathode|vss sg13_lv_nmos
+ L=0.13u W=0.25u AS=0.0625p AD=0.1075p PS=0.74u PD=1.34u rfmode=0
M$14312 \$2113 \$2072 \$2144 VSS|anode|cathode|vss sg13_lv_nmos L=0.13u W=0.42u
+ AS=0.1296p AD=0.0798p PS=1.52u PD=0.8u rfmode=0
M$14313 \$2144 \$2151 \$2090 VSS|anode|cathode|vss sg13_lv_nmos L=0.13u W=0.42u
+ AS=0.0798p AD=0.2373p PS=0.8u PD=1.97u rfmode=0
M$14314 VSS|anode|cathode|vss \$2072 \$2151 VSS|anode|cathode|vss sg13_lv_nmos
+ L=0.13u W=0.74u AS=0.317325p AD=0.2516p PS=1.805u PD=2.16u rfmode=0
M$14315 VSS|anode|cathode|vss \$2325 \$2072 VSS|anode|cathode|vss sg13_lv_nmos
+ L=0.13u W=0.74u AS=0.317325p AD=0.2516p PS=1.805u PD=2.16u rfmode=0
M$14316 \$2180 \$2253 \$2224 VSS|anode|cathode|vss sg13_lv_nmos L=0.13u W=0.42u
+ AS=0.1296p AD=0.0798p PS=1.52u PD=0.8u rfmode=0
M$14317 \$2224 \$2225 \$2275 VSS|anode|cathode|vss sg13_lv_nmos L=0.13u W=0.42u
+ AS=0.0798p AD=0.2373p PS=0.8u PD=1.97u rfmode=0
M$14318 \$2114 \$2072 \$2091 VSS|anode|cathode|vss sg13_lv_nmos L=0.13u W=0.42u
+ AS=0.12665p AD=0.1428p PS=1.145u PD=1.52u rfmode=0
M$14319 \$2071 \$2151 \$2114 VSS|anode|cathode|vss sg13_lv_nmos L=0.13u W=0.74u
+ AS=0.3473p AD=0.12665p PS=2.71u PD=1.145u rfmode=0
M$14320 Om \$1351 VSS|anode|cathode|vss VSS|anode|cathode|vss sg13_lv_nmos
+ L=0.2u W=4u AS=1.06p AD=1.06p PS=7.06u PD=7.06u rfmode=0
M$14322 \$2225 \$2253 VSS|anode|cathode|vss VSS|anode|cathode|vss sg13_lv_nmos
+ L=0.13u W=0.74u AS=0.2516p AD=0.317325p PS=2.16u PD=1.805u rfmode=0
M$14323 VSS|anode|cathode|vss \$2325 \$2253 VSS|anode|cathode|vss sg13_lv_nmos
+ L=0.13u W=0.74u AS=0.317325p AD=0.2516p PS=1.805u PD=2.16u rfmode=0
M$14324 \$2091 \$2092 VSS|anode|cathode|vss VSS|anode|cathode|vss sg13_lv_nmos
+ L=0.13u W=0.42u AS=0.1428p AD=0.0798p PS=1.52u PD=0.8u rfmode=0
M$14325 VSS|anode|cathode|vss \$2145 \$2130 VSS|anode|cathode|vss sg13_lv_nmos
+ L=0.13u W=0.42u AS=0.0798p AD=0.0378p PS=0.8u PD=0.6u rfmode=0
M$14326 \$2130 \$2114 \$2092 VSS|anode|cathode|vss sg13_lv_nmos L=0.13u W=0.42u
+ AS=0.0378p AD=0.1428p PS=0.6u PD=1.52u rfmode=0
M$14327 \$2276 \$2253 \$2226 VSS|anode|cathode|vss sg13_lv_nmos L=0.13u W=0.42u
+ AS=0.1428p AD=0.12665p PS=1.52u PD=1.145u rfmode=0
M$14328 \$2226 \$2225 \$2223 VSS|anode|cathode|vss sg13_lv_nmos L=0.13u W=0.74u
+ AS=0.12665p AD=0.3473p PS=1.145u PD=2.71u rfmode=0
M$14329 \$2093 \$2114 VSS|anode|cathode|vss VSS|anode|cathode|vss sg13_lv_nmos
+ L=0.13u W=0.74u AS=0.2516p AD=0.1406p PS=2.16u PD=1.12u rfmode=0
M$14330 VSS|anode|cathode|vss \$2093 \$2094 VSS|anode|cathode|vss sg13_lv_nmos
+ L=0.13u W=0.74u AS=0.1406p AD=0.2516p PS=1.12u PD=2.16u rfmode=0
M$14331 \$2095 \$2321 VSS|anode|cathode|vss VSS|anode|cathode|vss sg13_lv_nmos
+ L=0.15u W=0.74u AS=0.2516p AD=0.1406p PS=2.16u PD=1.12u rfmode=0
M$14332 VSS|anode|cathode|vss \$2192 \$2095 VSS|anode|cathode|vss sg13_lv_nmos
+ L=0.15u W=0.74u AS=0.1406p AD=0.1406p PS=1.12u PD=1.12u rfmode=0
M$14333 \$2095 \$2146 \$2096 VSS|anode|cathode|vss sg13_lv_nmos L=0.15u W=0.74u
+ AS=0.1406p AD=0.2516p PS=1.12u PD=2.16u rfmode=0
M$14334 \$2194 \$2226 VSS|anode|cathode|vss VSS|anode|cathode|vss sg13_lv_nmos
+ L=0.13u W=0.74u AS=0.2516p AD=0.1406p PS=2.16u PD=1.12u rfmode=0
M$14335 VSS|anode|cathode|vss \$2194 \$2195 VSS|anode|cathode|vss sg13_lv_nmos
+ L=0.13u W=0.74u AS=0.1406p AD=0.2516p PS=1.12u PD=2.16u rfmode=0
M$14336 VSS|anode|cathode|vss \$2400 \$2145 VSS|anode|cathode|vss sg13_lv_nmos
+ L=0.13u W=0.74u AS=0.2516p AD=0.2516p PS=2.16u PD=2.16u rfmode=0
M$14339 VSS|anode|cathode|vss \$2131 \$2196 VSS|anode|cathode|vss sg13_lv_nmos
+ L=0.13u W=0.74u AS=0.2516p AD=0.1406p PS=2.16u PD=1.12u rfmode=0
M$14340 \$2196 \$2152 VSS|anode|cathode|vss VSS|anode|cathode|vss sg13_lv_nmos
+ L=0.13u W=0.74u AS=0.1406p AD=0.2516p PS=1.12u PD=2.16u rfmode=0
M$14341 VSS|anode|cathode|vss \$2196 \$2197 VSS|anode|cathode|vss sg13_lv_nmos
+ L=0.13u W=0.74u AS=0.2516p AD=0.1406p PS=2.16u PD=1.12u rfmode=0
M$14342 \$2197 \$2131 \$2299 VSS|anode|cathode|vss sg13_lv_nmos L=0.13u W=0.74u
+ AS=0.1406p AD=0.1406p PS=1.12u PD=1.12u rfmode=0
M$14343 \$2299 \$2106 VSS|anode|cathode|vss VSS|anode|cathode|vss sg13_lv_nmos
+ L=0.13u W=0.74u AS=0.1406p AD=0.2516p PS=1.12u PD=2.16u rfmode=0
M$14344 VSS|anode|cathode|vss \$2073 \$2115 VSS|anode|cathode|vss sg13_lv_nmos
+ L=0.13u W=0.55u AS=0.17255p AD=0.187p PS=1.25u PD=1.78u rfmode=0
M$14345 VSS|anode|cathode|vss \$2115 \$2097 VSS|anode|cathode|vss sg13_lv_nmos
+ L=0.13u W=0.74u AS=0.17255p AD=0.1406p PS=1.25u PD=1.12u rfmode=0
M$14346 \$2097 \$2147 VSS|anode|cathode|vss VSS|anode|cathode|vss sg13_lv_nmos
+ L=0.13u W=0.74u AS=0.1406p AD=0.2516p PS=1.12u PD=2.16u rfmode=0
M$14347 \$2098 \$2116 VSS|anode|cathode|vss VSS|anode|cathode|vss sg13_lv_nmos
+ L=0.13u W=0.74u AS=0.2886p AD=0.14875p PS=2.26u PD=1.16u rfmode=0
M$14348 VSS|anode|cathode|vss \$2429 \$2116 VSS|anode|cathode|vss sg13_lv_nmos
+ L=0.13u W=0.55u AS=0.14875p AD=0.187p PS=1.16u PD=1.78u rfmode=0
M$14349 \$2181 \$2255 \$2229 VSS|anode|cathode|vss sg13_lv_nmos L=0.13u W=0.42u
+ AS=0.1296p AD=0.0798p PS=1.52u PD=0.8u rfmode=0
M$14350 \$2229 \$2230 \$2277 VSS|anode|cathode|vss sg13_lv_nmos L=0.13u W=0.42u
+ AS=0.0798p AD=0.2373p PS=0.8u PD=1.97u rfmode=0
M$14353 \$2230 \$2255 VSS|anode|cathode|vss VSS|anode|cathode|vss sg13_lv_nmos
+ L=0.13u W=0.74u AS=0.2516p AD=0.317325p PS=2.16u PD=1.805u rfmode=0
M$14354 VSS|anode|cathode|vss \$2256 \$2255 VSS|anode|cathode|vss sg13_lv_nmos
+ L=0.13u W=0.74u AS=0.317325p AD=0.2516p PS=1.805u PD=2.16u rfmode=0
M$14355 \$2278 \$2255 \$2231 VSS|anode|cathode|vss sg13_lv_nmos L=0.13u W=0.42u
+ AS=0.1428p AD=0.12665p PS=1.52u PD=1.145u rfmode=0
M$14356 \$2231 \$2230 \$2228 VSS|anode|cathode|vss sg13_lv_nmos L=0.13u W=0.74u
+ AS=0.12665p AD=0.3473p PS=1.145u PD=2.71u rfmode=0
M$14361 \$2199 \$2231 VSS|anode|cathode|vss VSS|anode|cathode|vss sg13_lv_nmos
+ L=0.13u W=0.74u AS=0.2516p AD=0.1406p PS=2.16u PD=1.12u rfmode=0
M$14362 VSS|anode|cathode|vss \$2199 \$2152 VSS|anode|cathode|vss sg13_lv_nmos
+ L=0.13u W=0.74u AS=0.1406p AD=0.2516p PS=1.12u PD=2.16u rfmode=0
M$14364 VSS|anode|cathode|vss \$2035 \$2117 VSS|anode|cathode|vss sg13_lv_nmos
+ L=0.13u W=0.55u AS=0.14875p AD=0.187p PS=1.16u PD=1.78u rfmode=0
M$14365 VSS|anode|cathode|vss \$2117 \$2099 VSS|anode|cathode|vss sg13_lv_nmos
+ L=0.13u W=0.74u AS=0.14875p AD=0.2886p PS=1.16u PD=2.26u rfmode=0
M$14366 \$2233 \$2690 VSS|anode|cathode|vss VSS|anode|cathode|vss sg13_lv_nmos
+ L=0.13u W=0.55u AS=0.187p AD=0.18945p PS=1.78u PD=1.27u rfmode=0
M$14367 VSS|anode|cathode|vss \$2690 \$2304 VSS|anode|cathode|vss sg13_lv_nmos
+ L=0.13u W=0.74u AS=0.18945p AD=0.13135p PS=1.27u PD=1.095u rfmode=0
M$14368 \$2304 \$2390 \$2200 VSS|anode|cathode|vss sg13_lv_nmos L=0.13u W=0.74u
+ AS=0.13135p AD=0.1628p PS=1.095u PD=1.18u rfmode=0
M$14369 \$2200 \$2203 \$2303 VSS|anode|cathode|vss sg13_lv_nmos L=0.13u W=0.74u
+ AS=0.1628p AD=0.3367p PS=1.18u PD=1.65u rfmode=0
M$14370 \$2303 \$2233 VSS|anode|cathode|vss VSS|anode|cathode|vss sg13_lv_nmos
+ L=0.13u W=0.74u AS=0.3367p AD=0.148p PS=1.65u PD=1.14u rfmode=0
M$14371 VSS|anode|cathode|vss \$2200 \$2201 VSS|anode|cathode|vss sg13_lv_nmos
+ L=0.13u W=0.74u AS=0.148p AD=0.4033p PS=1.14u PD=2.57u rfmode=0
M$14374 VSS|anode|cathode|vss \$2098 \$2100 VSS|anode|cathode|vss sg13_lv_nmos
+ L=0.13u W=0.74u AS=0.2516p AD=0.2516p PS=2.16u PD=2.16u rfmode=0
M$14377 \$2182 \$2257 \$2235 VSS|anode|cathode|vss sg13_lv_nmos L=0.13u W=0.42u
+ AS=0.1296p AD=0.0798p PS=1.52u PD=0.8u rfmode=0
M$14378 \$2235 \$2236 \$2279 VSS|anode|cathode|vss sg13_lv_nmos L=0.13u W=0.42u
+ AS=0.0798p AD=0.2373p PS=0.8u PD=1.97u rfmode=0
M$14379 \$2236 \$2257 VSS|anode|cathode|vss VSS|anode|cathode|vss sg13_lv_nmos
+ L=0.13u W=0.74u AS=0.2516p AD=0.317325p PS=2.16u PD=1.805u rfmode=0
M$14380 VSS|anode|cathode|vss \$2256 \$2257 VSS|anode|cathode|vss sg13_lv_nmos
+ L=0.13u W=0.74u AS=0.317325p AD=0.2516p PS=1.805u PD=2.16u rfmode=0
M$14383 \$2280 \$2257 \$2237 VSS|anode|cathode|vss sg13_lv_nmos L=0.13u W=0.42u
+ AS=0.1428p AD=0.12665p PS=1.52u PD=1.145u rfmode=0
M$14384 \$2237 \$2236 \$2234 VSS|anode|cathode|vss sg13_lv_nmos L=0.13u W=0.74u
+ AS=0.12665p AD=0.3473p PS=1.145u PD=2.71u rfmode=0
M$14387 \$2202 \$2237 VSS|anode|cathode|vss VSS|anode|cathode|vss sg13_lv_nmos
+ L=0.13u W=0.74u AS=0.2516p AD=0.1406p PS=2.16u PD=1.12u rfmode=0
M$14388 VSS|anode|cathode|vss \$2202 \$2203 VSS|anode|cathode|vss sg13_lv_nmos
+ L=0.13u W=0.74u AS=0.1406p AD=0.2516p PS=1.12u PD=2.16u rfmode=0
M$14389 fclk_samp \$2118 VSS|anode|cathode|vss VSS|anode|cathode|vss
+ sg13_lv_nmos L=0.13u W=0.74u AS=0.2886p AD=0.14875p PS=2.26u PD=1.16u rfmode=0
M$14390 VSS|anode|cathode|vss \$2146 \$2118 VSS|anode|cathode|vss sg13_lv_nmos
+ L=0.13u W=0.55u AS=0.14875p AD=0.187p PS=1.16u PD=1.78u rfmode=0
M$14393 VSS|anode|cathode|vss fclk_samp \$1840 VSS|anode|cathode|vss
+ sg13_lv_nmos L=0.13u W=0.4u AS=0.136p AD=0.136p PS=1.48u PD=1.48u rfmode=0
M$14394 VDD|in|pad|pin1|pin2|supply|vdd \$2015 \$2014 VSS|anode|cathode|vss
+ sg13_lv_nmos L=0.13u W=1.3u AS=0.442p AD=0.442p PS=3.28u PD=3.28u rfmode=0
M$14395 \$2015 \$2014 VDD|in|pad|pin1|pin2|supply|vdd VSS|anode|cathode|vss
+ sg13_lv_nmos L=0.13u W=1.3u AS=0.442p AD=0.442p PS=3.28u PD=3.28u rfmode=0
M$14398 VSS|anode|cathode|vss \$1840 \$1873 VSS|anode|cathode|vss sg13_lv_nmos
+ L=0.13u W=0.4u AS=0.136p AD=0.136p PS=1.48u PD=1.48u rfmode=0
M$14399 VDD|in|pad|pin1|pin2|supply|vdd \$2014 \$1969 VSS|anode|cathode|vss
+ sg13_lv_nmos L=0.13u W=1.3u AS=0.442p AD=0.442p PS=3.28u PD=3.28u rfmode=0
M$14400 \$1971 VDD|in|pad|pin1|pin2|supply|vdd \$1972 VSS|anode|cathode|vss
+ sg13_lv_nmos L=0.13u W=0.5u AS=0.17p AD=0.17p PS=1.68u PD=1.68u rfmode=0
M$14403 \$1972 \$1840 VSS|anode|cathode|vss VSS|anode|cathode|vss sg13_lv_nmos
+ L=0.13u W=0.5u AS=0.17p AD=0.17p PS=1.68u PD=1.68u rfmode=0
M$14404 VSS|anode|cathode|vss \$1997 \$1993 VSS|anode|cathode|vss sg13_lv_nmos
+ L=0.13u W=0.4u AS=0.136p AD=0.136p PS=1.48u PD=1.48u rfmode=0
M$14405 \$1874 \$1840 VSS|anode|cathode|vss VSS|anode|cathode|vss sg13_lv_nmos
+ L=0.4u W=1.3u AS=0.442p AD=0.442p PS=3.28u PD=3.28u rfmode=0
M$14408 VSS|anode|cathode|vss \$1840 \$1932 VSS|anode|cathode|vss sg13_lv_nmos
+ L=0.13u W=3u AS=1.02p AD=1.02p PS=6.68u PD=6.68u rfmode=0
M$14409 \$1932 VDD|in|pad|pin1|pin2|supply|vdd \$1933 VSS|anode|cathode|vss
+ sg13_lv_nmos L=0.13u W=3u AS=1.02p AD=1.02p PS=6.68u PD=6.68u rfmode=0
M$14410 \$1874 \$1933 analog_io_padres[17]|core|padres|vin_pos
+ VSS|anode|cathode|vss sg13_lv_nmos L=0.13u W=3u AS=1.02p AD=1.02p PS=6.68u
+ PD=6.68u rfmode=0
M$14412 analog_io_padres[17]|core|padres|vin_pos \$1971 \$741
+ VSS|anode|cathode|vss sg13_lv_nmos L=0.13u W=2.5u AS=0.85p AD=0.85p PS=5.68u
+ PD=5.68u rfmode=0
M$14413 \$2147 \$2119 VSS|anode|cathode|vss VSS|anode|cathode|vss sg13_lv_nmos
+ L=0.13u W=0.74u AS=0.2886p AD=0.14875p PS=2.26u PD=1.16u rfmode=0
M$14414 VSS|anode|cathode|vss Om \$2119 VSS|anode|cathode|vss sg13_lv_nmos
+ L=0.13u W=0.55u AS=0.14875p AD=0.187p PS=1.16u PD=1.78u rfmode=0
M$14415 VSS|anode|cathode|vss \$2152 \$2120 VSS|anode|cathode|vss sg13_lv_nmos
+ L=0.13u W=0.55u AS=0.14875p AD=0.187p PS=1.16u PD=1.78u rfmode=0
M$14416 VSS|anode|cathode|vss \$2120 \$888 VSS|anode|cathode|vss sg13_lv_nmos
+ L=0.13u W=0.74u AS=0.14875p AD=0.2886p PS=1.16u PD=2.26u rfmode=0
M$14417 \$2204 \$2203 VSS|anode|cathode|vss VSS|anode|cathode|vss sg13_lv_nmos
+ L=0.13u W=0.55u AS=0.187p AD=0.14875p PS=1.78u PD=1.16u rfmode=0
M$14418 VSS|anode|cathode|vss \$2204 \$979 VSS|anode|cathode|vss sg13_lv_nmos
+ L=0.13u W=0.74u AS=0.14875p AD=0.2886p PS=1.16u PD=2.26u rfmode=0
M$14422 VSS|anode|cathode|vss \$1768 \$1767 VSS|anode|cathode|vss sg13_lv_nmos
+ L=0.13u W=0.74u AS=0.1626p AD=0.2516p PS=1.415u PD=2.16u rfmode=0
M$14423 \$1766 \$1447 \$1901 VSS|anode|cathode|vss sg13_lv_nmos L=0.13u W=0.42u
+ AS=0.1428p AD=0.0609p PS=1.52u PD=0.71u rfmode=0
M$14424 VSS|anode|cathode|vss \$1446 \$1901 VSS|anode|cathode|vss sg13_lv_nmos
+ L=0.13u W=0.42u AS=0.1626p AD=0.0609p PS=1.415u PD=0.71u rfmode=0
M$14425 VSS|anode|cathode|vss \$1446 \$1903 VSS|anode|cathode|vss sg13_lv_nmos
+ L=0.13u W=0.42u AS=0.1701p AD=0.0378p PS=1.65u PD=0.6u rfmode=0
M$14426 \$1903 \$1767 \$1841 VSS|anode|cathode|vss sg13_lv_nmos L=0.13u W=0.42u
+ AS=0.0378p AD=0.1428p PS=0.6u PD=1.52u rfmode=0
M$14427 \$1875 \$1771 VSS|anode|cathode|vss VSS|anode|cathode|vss sg13_lv_nmos
+ L=0.13u W=0.42u AS=0.1428p AD=0.0798p PS=1.52u PD=0.8u rfmode=0
M$14428 VSS|anode|cathode|vss \$1446 \$1902 VSS|anode|cathode|vss sg13_lv_nmos
+ L=0.13u W=0.42u AS=0.0798p AD=0.0378p PS=0.8u PD=0.6u rfmode=0
M$14429 \$1902 \$1842 \$1771 VSS|anode|cathode|vss sg13_lv_nmos L=0.13u W=0.42u
+ AS=0.0378p AD=0.1428p PS=0.6u PD=1.52u rfmode=0
M$14430 \$1773 \$1452 VSS|anode|cathode|vss VSS|anode|cathode|vss sg13_lv_nmos
+ L=0.13u W=0.42u AS=0.1428p AD=0.0798p PS=1.52u PD=0.8u rfmode=0
M$14431 VSS|anode|cathode|vss \$1773 \$1713 VSS|anode|cathode|vss sg13_lv_nmos
+ L=0.5u W=0.42u AS=0.0798p AD=0.1428p PS=0.8u PD=1.52u rfmode=0
M$14432 VSS|anode|cathode|vss \$1776 \$1775 VSS|anode|cathode|vss sg13_lv_nmos
+ L=0.13u W=0.74u AS=0.1626p AD=0.2516p PS=1.415u PD=2.16u rfmode=0
M$14433 \$1774 \$1715 \$1904 VSS|anode|cathode|vss sg13_lv_nmos L=0.13u W=0.42u
+ AS=0.1428p AD=0.0609p PS=1.52u PD=0.71u rfmode=0
M$14434 VSS|anode|cathode|vss \$1454 \$1904 VSS|anode|cathode|vss sg13_lv_nmos
+ L=0.13u W=0.42u AS=0.1626p AD=0.0609p PS=1.415u PD=0.71u rfmode=0
M$14435 VSS|anode|cathode|vss \$1454 \$1906 VSS|anode|cathode|vss sg13_lv_nmos
+ L=0.13u W=0.42u AS=0.1701p AD=0.0378p PS=1.65u PD=0.6u rfmode=0
M$14436 \$1906 \$1775 \$1843 VSS|anode|cathode|vss sg13_lv_nmos L=0.13u W=0.42u
+ AS=0.0378p AD=0.1428p PS=0.6u PD=1.52u rfmode=0
M$14437 \$1876 \$1779 VSS|anode|cathode|vss VSS|anode|cathode|vss sg13_lv_nmos
+ L=0.13u W=0.42u AS=0.1428p AD=0.0798p PS=1.52u PD=0.8u rfmode=0
M$14438 VSS|anode|cathode|vss \$1454 \$1905 VSS|anode|cathode|vss sg13_lv_nmos
+ L=0.13u W=0.42u AS=0.0798p AD=0.0378p PS=0.8u PD=0.6u rfmode=0
M$14439 \$1905 \$1844 \$1779 VSS|anode|cathode|vss sg13_lv_nmos L=0.13u W=0.42u
+ AS=0.0378p AD=0.1428p PS=0.6u PD=1.52u rfmode=0
M$14440 \$1780 \$1845 \$1907 VSS|anode|cathode|vss sg13_lv_nmos L=0.13u W=0.42u
+ AS=0.1428p AD=0.0378p PS=1.52u PD=0.6u rfmode=0
M$14441 \$1907 \$1197 VSS|anode|cathode|vss VSS|anode|cathode|vss sg13_lv_nmos
+ L=0.13u W=0.42u AS=0.0378p AD=0.0798p PS=0.6u PD=0.8u rfmode=0
M$14442 VSS|anode|cathode|vss \$1780 \$1877 VSS|anode|cathode|vss sg13_lv_nmos
+ L=0.13u W=0.42u AS=0.0798p AD=0.1428p PS=0.8u PD=1.52u rfmode=0
M$14443 \$1846 \$1847 \$1909 VSS|anode|cathode|vss sg13_lv_nmos L=0.13u W=0.42u
+ AS=0.1428p AD=0.0378p PS=1.52u PD=0.6u rfmode=0
M$14444 \$1909 \$1197 VSS|anode|cathode|vss VSS|anode|cathode|vss sg13_lv_nmos
+ L=0.13u W=0.42u AS=0.0378p AD=0.1701p PS=0.6u PD=1.65u rfmode=0
M$14445 \$1785 \$1784 VSS|anode|cathode|vss VSS|anode|cathode|vss sg13_lv_nmos
+ L=0.13u W=0.42u AS=0.1428p AD=0.0798p PS=1.52u PD=0.8u rfmode=0
M$14446 VSS|anode|cathode|vss \$1785 \$1721 VSS|anode|cathode|vss sg13_lv_nmos
+ L=0.5u W=0.42u AS=0.0798p AD=0.1428p PS=0.8u PD=1.52u rfmode=0
M$14447 \$1786 \$1848 \$1912 VSS|anode|cathode|vss sg13_lv_nmos L=0.13u W=0.42u
+ AS=0.1428p AD=0.0378p PS=1.52u PD=0.6u rfmode=0
M$14448 \$1912 \$1468 VSS|anode|cathode|vss VSS|anode|cathode|vss sg13_lv_nmos
+ L=0.13u W=0.42u AS=0.0378p AD=0.0798p PS=0.6u PD=0.8u rfmode=0
M$14449 VSS|anode|cathode|vss \$1786 \$1878 VSS|anode|cathode|vss sg13_lv_nmos
+ L=0.13u W=0.42u AS=0.0798p AD=0.1428p PS=0.8u PD=1.52u rfmode=0
M$14450 \$1849 \$1850 \$1911 VSS|anode|cathode|vss sg13_lv_nmos L=0.13u W=0.42u
+ AS=0.1428p AD=0.0378p PS=1.52u PD=0.6u rfmode=0
M$14451 \$1911 \$1468 VSS|anode|cathode|vss VSS|anode|cathode|vss sg13_lv_nmos
+ L=0.13u W=0.42u AS=0.0378p AD=0.1701p PS=0.6u PD=1.65u rfmode=0
M$14452 \$1790 \$1476 VSS|anode|cathode|vss VSS|anode|cathode|vss sg13_lv_nmos
+ L=0.13u W=0.42u AS=0.1428p AD=0.0798p PS=1.52u PD=0.8u rfmode=0
M$14453 VSS|anode|cathode|vss \$1790 \$1727 VSS|anode|cathode|vss sg13_lv_nmos
+ L=0.5u W=0.42u AS=0.0798p AD=0.1428p PS=0.8u PD=1.52u rfmode=0
M$14454 VSS|anode|cathode|vss \$1793 \$1792 VSS|anode|cathode|vss sg13_lv_nmos
+ L=0.13u W=0.74u AS=0.1626p AD=0.2516p PS=1.415u PD=2.16u rfmode=0
M$14455 \$1791 \$1729 \$1914 VSS|anode|cathode|vss sg13_lv_nmos L=0.13u W=0.42u
+ AS=0.1428p AD=0.0609p PS=1.52u PD=0.71u rfmode=0
M$14456 VSS|anode|cathode|vss \$1475 \$1914 VSS|anode|cathode|vss sg13_lv_nmos
+ L=0.13u W=0.42u AS=0.1626p AD=0.0609p PS=1.415u PD=0.71u rfmode=0
M$14457 VSS|anode|cathode|vss \$1475 \$1913 VSS|anode|cathode|vss sg13_lv_nmos
+ L=0.13u W=0.42u AS=0.1701p AD=0.0378p PS=1.65u PD=0.6u rfmode=0
M$14458 \$1913 \$1792 \$1851 VSS|anode|cathode|vss sg13_lv_nmos L=0.13u W=0.42u
+ AS=0.0378p AD=0.1428p PS=0.6u PD=1.52u rfmode=0
M$14459 \$1879 \$1796 VSS|anode|cathode|vss VSS|anode|cathode|vss sg13_lv_nmos
+ L=0.13u W=0.42u AS=0.1428p AD=0.0798p PS=1.52u PD=0.8u rfmode=0
M$14460 VSS|anode|cathode|vss \$1475 \$1915 VSS|anode|cathode|vss sg13_lv_nmos
+ L=0.13u W=0.42u AS=0.0798p AD=0.0378p PS=0.8u PD=0.6u rfmode=0
M$14461 \$1915 \$1852 \$1796 VSS|anode|cathode|vss sg13_lv_nmos L=0.13u W=0.42u
+ AS=0.0378p AD=0.1428p PS=0.6u PD=1.52u rfmode=0
M$14462 \$1732 \$1797 VSS|anode|cathode|vss VSS|anode|cathode|vss sg13_lv_nmos
+ L=0.5u W=0.42u AS=0.1428p AD=0.0798p PS=1.52u PD=0.8u rfmode=0
M$14463 VSS|anode|cathode|vss \$1300 \$1797 VSS|anode|cathode|vss sg13_lv_nmos
+ L=0.13u W=0.42u AS=0.0798p AD=0.1428p PS=0.8u PD=1.52u rfmode=0
M$14465 \$1798 \$1486 VSS|anode|cathode|vss VSS|anode|cathode|vss sg13_lv_nmos
+ L=0.13u W=0.42u AS=0.1428p AD=0.0798p PS=1.52u PD=0.8u rfmode=0
M$14466 VSS|anode|cathode|vss \$1798 \$1733 VSS|anode|cathode|vss sg13_lv_nmos
+ L=0.5u W=0.42u AS=0.0798p AD=0.1428p PS=0.8u PD=1.52u rfmode=0
M$14467 VSS|anode|cathode|vss \$1801 \$1800 VSS|anode|cathode|vss sg13_lv_nmos
+ L=0.13u W=0.74u AS=0.1626p AD=0.2516p PS=1.415u PD=2.16u rfmode=0
M$14468 \$1799 \$1735 \$1916 VSS|anode|cathode|vss sg13_lv_nmos L=0.13u W=0.42u
+ AS=0.1428p AD=0.0609p PS=1.52u PD=0.71u rfmode=0
M$14469 VSS|anode|cathode|vss \$1484 \$1916 VSS|anode|cathode|vss sg13_lv_nmos
+ L=0.13u W=0.42u AS=0.1626p AD=0.0609p PS=1.415u PD=0.71u rfmode=0
M$14470 VSS|anode|cathode|vss \$1484 \$1918 VSS|anode|cathode|vss sg13_lv_nmos
+ L=0.13u W=0.42u AS=0.1701p AD=0.0378p PS=1.65u PD=0.6u rfmode=0
M$14471 \$1918 \$1800 \$1853 VSS|anode|cathode|vss sg13_lv_nmos L=0.13u W=0.42u
+ AS=0.0378p AD=0.1428p PS=0.6u PD=1.52u rfmode=0
M$14472 \$1880 \$1804 VSS|anode|cathode|vss VSS|anode|cathode|vss sg13_lv_nmos
+ L=0.13u W=0.42u AS=0.1428p AD=0.0798p PS=1.52u PD=0.8u rfmode=0
M$14473 VSS|anode|cathode|vss \$1484 \$1917 VSS|anode|cathode|vss sg13_lv_nmos
+ L=0.13u W=0.42u AS=0.0798p AD=0.0378p PS=0.8u PD=0.6u rfmode=0
M$14474 \$1917 \$1854 \$1804 VSS|anode|cathode|vss sg13_lv_nmos L=0.13u W=0.42u
+ AS=0.0378p AD=0.1428p PS=0.6u PD=1.52u rfmode=0
M$14475 \$1738 \$1805 VSS|anode|cathode|vss VSS|anode|cathode|vss sg13_lv_nmos
+ L=0.5u W=0.42u AS=0.1428p AD=0.0798p PS=1.52u PD=0.8u rfmode=0
M$14476 VSS|anode|cathode|vss \$1216 \$1805 VSS|anode|cathode|vss sg13_lv_nmos
+ L=0.13u W=0.42u AS=0.0798p AD=0.1428p PS=0.8u PD=1.52u rfmode=0
M$14478 \$1806 \$1304 VSS|anode|cathode|vss VSS|anode|cathode|vss sg13_lv_nmos
+ L=0.13u W=0.42u AS=0.1428p AD=0.0798p PS=1.52u PD=0.8u rfmode=0
M$14479 VSS|anode|cathode|vss \$1806 \$1739 VSS|anode|cathode|vss sg13_lv_nmos
+ L=0.5u W=0.42u AS=0.0798p AD=0.1428p PS=0.8u PD=1.52u rfmode=0
M$14481 \$1807 \$1504 VSS|anode|cathode|vss VSS|anode|cathode|vss sg13_lv_nmos
+ L=0.13u W=0.42u AS=0.1428p AD=0.0798p PS=1.52u PD=0.8u rfmode=0
M$14482 VSS|anode|cathode|vss \$1807 \$1744 VSS|anode|cathode|vss sg13_lv_nmos
+ L=0.5u W=0.42u AS=0.0798p AD=0.1428p PS=0.8u PD=1.52u rfmode=0
M$14483 VSS|anode|cathode|vss \$1810 \$1809 VSS|anode|cathode|vss sg13_lv_nmos
+ L=0.13u W=0.74u AS=0.1626p AD=0.2516p PS=1.415u PD=2.16u rfmode=0
M$14484 \$1808 \$1746 \$1920 VSS|anode|cathode|vss sg13_lv_nmos L=0.13u W=0.42u
+ AS=0.1428p AD=0.0609p PS=1.52u PD=0.71u rfmode=0
M$14485 VSS|anode|cathode|vss \$1506 \$1920 VSS|anode|cathode|vss sg13_lv_nmos
+ L=0.13u W=0.42u AS=0.1626p AD=0.0609p PS=1.415u PD=0.71u rfmode=0
M$14486 VSS|anode|cathode|vss \$1506 \$1919 VSS|anode|cathode|vss sg13_lv_nmos
+ L=0.13u W=0.42u AS=0.1701p AD=0.0378p PS=1.65u PD=0.6u rfmode=0
M$14487 \$1919 \$1809 \$1855 VSS|anode|cathode|vss sg13_lv_nmos L=0.13u W=0.42u
+ AS=0.0378p AD=0.1428p PS=0.6u PD=1.52u rfmode=0
M$14488 \$1881 \$1813 VSS|anode|cathode|vss VSS|anode|cathode|vss sg13_lv_nmos
+ L=0.13u W=0.42u AS=0.1428p AD=0.0798p PS=1.52u PD=0.8u rfmode=0
M$14489 VSS|anode|cathode|vss \$1506 \$1921 VSS|anode|cathode|vss sg13_lv_nmos
+ L=0.13u W=0.42u AS=0.0798p AD=0.0378p PS=0.8u PD=0.6u rfmode=0
M$14490 \$1921 \$1856 \$1813 VSS|anode|cathode|vss sg13_lv_nmos L=0.13u W=0.42u
+ AS=0.0378p AD=0.1428p PS=0.6u PD=1.52u rfmode=0
M$14491 \$1749 \$1814 VSS|anode|cathode|vss VSS|anode|cathode|vss sg13_lv_nmos
+ L=0.5u W=0.42u AS=0.1428p AD=0.0798p PS=1.52u PD=0.8u rfmode=0
M$14492 VSS|anode|cathode|vss \$1635 \$1814 VSS|anode|cathode|vss sg13_lv_nmos
+ L=0.13u W=0.42u AS=0.0798p AD=0.1428p PS=0.8u PD=1.52u rfmode=0
M$14493 \$1815 \$1600 VSS|anode|cathode|vss VSS|anode|cathode|vss sg13_lv_nmos
+ L=0.13u W=0.42u AS=0.1428p AD=0.0798p PS=1.52u PD=0.8u rfmode=0
M$14494 VSS|anode|cathode|vss \$1815 \$1752 VSS|anode|cathode|vss sg13_lv_nmos
+ L=0.5u W=0.42u AS=0.0798p AD=0.1428p PS=0.8u PD=1.52u rfmode=0
M$14495 VSS|anode|cathode|vss \$1818 \$1817 VSS|anode|cathode|vss sg13_lv_nmos
+ L=0.13u W=0.74u AS=0.1626p AD=0.2516p PS=1.415u PD=2.16u rfmode=0
M$14496 \$1816 \$1516 \$1923 VSS|anode|cathode|vss sg13_lv_nmos L=0.13u W=0.42u
+ AS=0.1428p AD=0.0609p PS=1.52u PD=0.71u rfmode=0
M$14497 VSS|anode|cathode|vss \$1522 \$1923 VSS|anode|cathode|vss sg13_lv_nmos
+ L=0.13u W=0.42u AS=0.1626p AD=0.0609p PS=1.415u PD=0.71u rfmode=0
M$14498 VSS|anode|cathode|vss \$1522 \$1922 VSS|anode|cathode|vss sg13_lv_nmos
+ L=0.13u W=0.42u AS=0.1701p AD=0.0378p PS=1.65u PD=0.6u rfmode=0
M$14499 \$1922 \$1817 \$1857 VSS|anode|cathode|vss sg13_lv_nmos L=0.13u W=0.42u
+ AS=0.0378p AD=0.1428p PS=0.6u PD=1.52u rfmode=0
M$14500 \$1882 \$1821 VSS|anode|cathode|vss VSS|anode|cathode|vss sg13_lv_nmos
+ L=0.13u W=0.42u AS=0.1428p AD=0.0798p PS=1.52u PD=0.8u rfmode=0
M$14501 VSS|anode|cathode|vss \$1522 \$1924 VSS|anode|cathode|vss sg13_lv_nmos
+ L=0.13u W=0.42u AS=0.0798p AD=0.0378p PS=0.8u PD=0.6u rfmode=0
M$14502 \$1924 \$1858 \$1821 VSS|anode|cathode|vss sg13_lv_nmos L=0.13u W=0.42u
+ AS=0.0378p AD=0.1428p PS=0.6u PD=1.52u rfmode=0
M$14504 \$1758 \$1822 VSS|anode|cathode|vss VSS|anode|cathode|vss sg13_lv_nmos
+ L=0.5u W=0.42u AS=0.1428p AD=0.0798p PS=1.52u PD=0.8u rfmode=0
M$14505 VSS|anode|cathode|vss \$1760 \$1822 VSS|anode|cathode|vss sg13_lv_nmos
+ L=0.13u W=0.42u AS=0.0798p AD=0.1428p PS=0.8u PD=1.52u rfmode=0
M$14506 VSS|anode|cathode|vss \$1825 \$1824 VSS|anode|cathode|vss sg13_lv_nmos
+ L=0.13u W=0.74u AS=0.1626p AD=0.2516p PS=1.415u PD=2.16u rfmode=0
M$14507 \$1823 \$1527 \$1925 VSS|anode|cathode|vss sg13_lv_nmos L=0.13u W=0.42u
+ AS=0.1428p AD=0.0609p PS=1.52u PD=0.71u rfmode=0
M$14508 VSS|anode|cathode|vss \$1529 \$1925 VSS|anode|cathode|vss sg13_lv_nmos
+ L=0.13u W=0.42u AS=0.1626p AD=0.0609p PS=1.415u PD=0.71u rfmode=0
M$14509 VSS|anode|cathode|vss \$1529 \$1927 VSS|anode|cathode|vss sg13_lv_nmos
+ L=0.13u W=0.42u AS=0.1701p AD=0.0378p PS=1.65u PD=0.6u rfmode=0
M$14510 \$1927 \$1824 \$1859 VSS|anode|cathode|vss sg13_lv_nmos L=0.13u W=0.42u
+ AS=0.0378p AD=0.1428p PS=0.6u PD=1.52u rfmode=0
M$14511 \$1883 \$1828 VSS|anode|cathode|vss VSS|anode|cathode|vss sg13_lv_nmos
+ L=0.13u W=0.42u AS=0.1428p AD=0.0798p PS=1.52u PD=0.8u rfmode=0
M$14512 VSS|anode|cathode|vss \$1529 \$1926 VSS|anode|cathode|vss sg13_lv_nmos
+ L=0.13u W=0.42u AS=0.0798p AD=0.0378p PS=0.8u PD=0.6u rfmode=0
M$14513 \$1926 \$1860 \$1828 VSS|anode|cathode|vss sg13_lv_nmos L=0.13u W=0.42u
+ AS=0.0378p AD=0.1428p PS=0.6u PD=1.52u rfmode=0
M$14515 core|done_in|p2c|ui_p2c[4] \$2051 VSS|anode|cathode|vss
+ VSS|anode|cathode|vss sg13_lv_nmos L=0.13u W=2.75u AS=0.935p AD=0.935p
+ PS=6.18u PD=6.18u rfmode=0
M$14528 VSS|anode|cathode|vss \$2207 \$2206 VSS|anode|cathode|vss sg13_lv_nmos
+ L=0.13u W=0.74u AS=0.1626p AD=0.2516p PS=1.415u PD=2.16u rfmode=0
M$14529 \$2175 \$2076 \$2287 VSS|anode|cathode|vss sg13_lv_nmos L=0.13u W=0.42u
+ AS=0.1428p AD=0.0609p PS=1.52u PD=0.71u rfmode=0
M$14530 VSS|anode|cathode|vss \$2184 \$2287 VSS|anode|cathode|vss sg13_lv_nmos
+ L=0.13u W=0.42u AS=0.1626p AD=0.0609p PS=1.415u PD=0.71u rfmode=0
M$14531 VSS|anode|cathode|vss \$2184 \$2286 VSS|anode|cathode|vss sg13_lv_nmos
+ L=0.13u W=0.42u AS=0.1701p AD=0.0378p PS=1.65u PD=0.6u rfmode=0
M$14532 \$2286 \$2206 \$2268 VSS|anode|cathode|vss sg13_lv_nmos L=0.13u W=0.42u
+ AS=0.0378p AD=0.1428p PS=0.6u PD=1.52u rfmode=0
M$14533 \$2269 \$2210 VSS|anode|cathode|vss VSS|anode|cathode|vss sg13_lv_nmos
+ L=0.13u W=0.42u AS=0.1428p AD=0.0798p PS=1.52u PD=0.8u rfmode=0
M$14534 VSS|anode|cathode|vss \$2184 \$2289 VSS|anode|cathode|vss sg13_lv_nmos
+ L=0.13u W=0.42u AS=0.0798p AD=0.0378p PS=0.8u PD=0.6u rfmode=0
M$14535 \$2289 \$2209 \$2210 VSS|anode|cathode|vss sg13_lv_nmos L=0.13u W=0.42u
+ AS=0.0378p AD=0.1428p PS=0.6u PD=1.52u rfmode=0
M$14536 VSS|anode|cathode|vss \$2212 \$2211 VSS|anode|cathode|vss sg13_lv_nmos
+ L=0.13u W=0.74u AS=0.1626p AD=0.2516p PS=1.415u PD=2.16u rfmode=0
M$14537 \$2176 \$2080 \$2288 VSS|anode|cathode|vss sg13_lv_nmos L=0.13u W=0.42u
+ AS=0.1428p AD=0.0609p PS=1.52u PD=0.71u rfmode=0
M$14538 VSS|anode|cathode|vss \$2177 \$2288 VSS|anode|cathode|vss sg13_lv_nmos
+ L=0.13u W=0.42u AS=0.1626p AD=0.0609p PS=1.415u PD=0.71u rfmode=0
M$14539 VSS|anode|cathode|vss \$2177 \$2290 VSS|anode|cathode|vss sg13_lv_nmos
+ L=0.13u W=0.42u AS=0.1701p AD=0.0378p PS=1.65u PD=0.6u rfmode=0
M$14540 \$2290 \$2211 \$2270 VSS|anode|cathode|vss sg13_lv_nmos L=0.13u W=0.42u
+ AS=0.0378p AD=0.1428p PS=0.6u PD=1.52u rfmode=0
M$14541 \$2271 \$2215 VSS|anode|cathode|vss VSS|anode|cathode|vss sg13_lv_nmos
+ L=0.13u W=0.42u AS=0.1428p AD=0.0798p PS=1.52u PD=0.8u rfmode=0
M$14542 VSS|anode|cathode|vss \$2177 \$2292 VSS|anode|cathode|vss sg13_lv_nmos
+ L=0.13u W=0.42u AS=0.0798p AD=0.0378p PS=0.8u PD=0.6u rfmode=0
M$14543 \$2292 \$2214 \$2215 VSS|anode|cathode|vss sg13_lv_nmos L=0.13u W=0.42u
+ AS=0.0378p AD=0.1428p PS=0.6u PD=1.52u rfmode=0
M$14544 VSS|anode|cathode|vss \$2217 \$2216 VSS|anode|cathode|vss sg13_lv_nmos
+ L=0.13u W=0.74u AS=0.1626p AD=0.2516p PS=1.415u PD=2.16u rfmode=0
M$14545 \$2178 \$2083 \$2291 VSS|anode|cathode|vss sg13_lv_nmos L=0.13u W=0.42u
+ AS=0.1428p AD=0.0609p PS=1.52u PD=0.71u rfmode=0
M$14546 VSS|anode|cathode|vss \$2179 \$2291 VSS|anode|cathode|vss sg13_lv_nmos
+ L=0.13u W=0.42u AS=0.1626p AD=0.0609p PS=1.415u PD=0.71u rfmode=0
M$14547 VSS|anode|cathode|vss \$2179 \$2294 VSS|anode|cathode|vss sg13_lv_nmos
+ L=0.13u W=0.42u AS=0.1701p AD=0.0378p PS=1.65u PD=0.6u rfmode=0
M$14548 \$2294 \$2216 \$2272 VSS|anode|cathode|vss sg13_lv_nmos L=0.13u W=0.42u
+ AS=0.0378p AD=0.1428p PS=0.6u PD=1.52u rfmode=0
M$14549 \$2273 \$2220 VSS|anode|cathode|vss VSS|anode|cathode|vss sg13_lv_nmos
+ L=0.13u W=0.42u AS=0.1428p AD=0.0798p PS=1.52u PD=0.8u rfmode=0
M$14550 VSS|anode|cathode|vss \$2179 \$2293 VSS|anode|cathode|vss sg13_lv_nmos
+ L=0.13u W=0.42u AS=0.0798p AD=0.0378p PS=0.8u PD=0.6u rfmode=0
M$14551 \$2293 \$2219 \$2220 VSS|anode|cathode|vss sg13_lv_nmos L=0.13u W=0.42u
+ AS=0.0378p AD=0.1428p PS=0.6u PD=1.52u rfmode=0
M$14552 \$2221 \$2251 VSS|anode|cathode|vss VSS|anode|cathode|vss sg13_lv_nmos
+ L=0.13u W=0.42u AS=0.1428p AD=0.0798p PS=1.52u PD=0.8u rfmode=0
M$14553 VSS|anode|cathode|vss \$2221 \$2190 VSS|anode|cathode|vss sg13_lv_nmos
+ L=0.5u W=0.42u AS=0.0798p AD=0.1428p PS=0.8u PD=1.52u rfmode=0
M$14554 VSS|anode|cathode|vss \$2224 \$2223 VSS|anode|cathode|vss sg13_lv_nmos
+ L=0.13u W=0.74u AS=0.1626p AD=0.2516p PS=1.415u PD=2.16u rfmode=0
M$14555 \$2180 \$2274 \$2296 VSS|anode|cathode|vss sg13_lv_nmos L=0.13u W=0.42u
+ AS=0.1428p AD=0.0609p PS=1.52u PD=0.71u rfmode=0
M$14556 VSS|anode|cathode|vss \$2252 \$2296 VSS|anode|cathode|vss sg13_lv_nmos
+ L=0.13u W=0.42u AS=0.1626p AD=0.0609p PS=1.415u PD=0.71u rfmode=0
M$14557 VSS|anode|cathode|vss \$2252 \$2295 VSS|anode|cathode|vss sg13_lv_nmos
+ L=0.13u W=0.42u AS=0.1701p AD=0.0378p PS=1.65u PD=0.6u rfmode=0
M$14558 \$2295 \$2223 \$2275 VSS|anode|cathode|vss sg13_lv_nmos L=0.13u W=0.42u
+ AS=0.0378p AD=0.1428p PS=0.6u PD=1.52u rfmode=0
M$14559 \$2276 \$2227 VSS|anode|cathode|vss VSS|anode|cathode|vss sg13_lv_nmos
+ L=0.13u W=0.42u AS=0.1428p AD=0.0798p PS=1.52u PD=0.8u rfmode=0
M$14560 VSS|anode|cathode|vss \$2252 \$2297 VSS|anode|cathode|vss sg13_lv_nmos
+ L=0.13u W=0.42u AS=0.0798p AD=0.0378p PS=0.8u PD=0.6u rfmode=0
M$14561 \$2297 \$2226 \$2227 VSS|anode|cathode|vss sg13_lv_nmos L=0.13u W=0.42u
+ AS=0.0378p AD=0.1428p PS=0.6u PD=1.52u rfmode=0
M$14562 VSS|anode|cathode|vss \$2229 \$2228 VSS|anode|cathode|vss sg13_lv_nmos
+ L=0.13u W=0.74u AS=0.1626p AD=0.2516p PS=1.415u PD=2.16u rfmode=0
M$14563 \$2181 \$2197 \$2298 VSS|anode|cathode|vss sg13_lv_nmos L=0.13u W=0.42u
+ AS=0.1428p AD=0.0609p PS=1.52u PD=0.71u rfmode=0
M$14564 VSS|anode|cathode|vss \$2254 \$2298 VSS|anode|cathode|vss sg13_lv_nmos
+ L=0.13u W=0.42u AS=0.1626p AD=0.0609p PS=1.415u PD=0.71u rfmode=0
M$14565 VSS|anode|cathode|vss \$2254 \$2300 VSS|anode|cathode|vss sg13_lv_nmos
+ L=0.13u W=0.42u AS=0.1701p AD=0.0378p PS=1.65u PD=0.6u rfmode=0
M$14566 \$2300 \$2228 \$2277 VSS|anode|cathode|vss sg13_lv_nmos L=0.13u W=0.42u
+ AS=0.0378p AD=0.1428p PS=0.6u PD=1.52u rfmode=0
M$14567 \$2278 \$2232 VSS|anode|cathode|vss VSS|anode|cathode|vss sg13_lv_nmos
+ L=0.13u W=0.42u AS=0.1428p AD=0.0798p PS=1.52u PD=0.8u rfmode=0
M$14568 VSS|anode|cathode|vss \$2254 \$2301 VSS|anode|cathode|vss sg13_lv_nmos
+ L=0.13u W=0.42u AS=0.0798p AD=0.0378p PS=0.8u PD=0.6u rfmode=0
M$14569 \$2301 \$2231 \$2232 VSS|anode|cathode|vss sg13_lv_nmos L=0.13u W=0.42u
+ AS=0.0378p AD=0.1428p PS=0.6u PD=1.52u rfmode=0
M$14572 VSS|anode|cathode|vss \$2235 \$2234 VSS|anode|cathode|vss sg13_lv_nmos
+ L=0.13u W=0.74u AS=0.1626p AD=0.2516p PS=1.415u PD=2.16u rfmode=0
M$14573 \$2182 \$2201 \$2302 VSS|anode|cathode|vss sg13_lv_nmos L=0.13u W=0.42u
+ AS=0.1428p AD=0.0609p PS=1.52u PD=0.71u rfmode=0
M$14574 VSS|anode|cathode|vss \$2100 \$2302 VSS|anode|cathode|vss sg13_lv_nmos
+ L=0.13u W=0.42u AS=0.1626p AD=0.0609p PS=1.415u PD=0.71u rfmode=0
M$14575 VSS|anode|cathode|vss \$2100 \$2306 VSS|anode|cathode|vss sg13_lv_nmos
+ L=0.13u W=0.42u AS=0.1701p AD=0.0378p PS=1.65u PD=0.6u rfmode=0
M$14576 \$2306 \$2234 \$2279 VSS|anode|cathode|vss sg13_lv_nmos L=0.13u W=0.42u
+ AS=0.0378p AD=0.1428p PS=0.6u PD=1.52u rfmode=0
M$14577 \$2280 \$2238 VSS|anode|cathode|vss VSS|anode|cathode|vss sg13_lv_nmos
+ L=0.13u W=0.42u AS=0.1428p AD=0.0798p PS=1.52u PD=0.8u rfmode=0
M$14578 VSS|anode|cathode|vss \$2100 \$2305 VSS|anode|cathode|vss sg13_lv_nmos
+ L=0.13u W=0.42u AS=0.0798p AD=0.0378p PS=0.8u PD=0.6u rfmode=0
M$14579 \$2305 \$2237 \$2238 VSS|anode|cathode|vss sg13_lv_nmos L=0.13u W=0.42u
+ AS=0.0378p AD=0.1428p PS=0.6u PD=1.52u rfmode=0
M$14591 \$2326 \$2343 \$2336 VSS|anode|cathode|vss sg13_lv_nmos L=0.13u W=0.42u
+ AS=0.1428p AD=0.0609p PS=1.52u PD=0.71u rfmode=0
M$14592 \$2336 \$2311 VSS|anode|cathode|vss VSS|anode|cathode|vss sg13_lv_nmos
+ L=0.13u W=0.42u AS=0.0609p AD=0.1626p PS=0.71u PD=1.415u rfmode=0
M$14593 VSS|anode|cathode|vss \$2344 \$2307 VSS|anode|cathode|vss sg13_lv_nmos
+ L=0.13u W=0.74u AS=0.1626p AD=0.2516p PS=1.415u PD=2.16u rfmode=0
M$14594 \$2313 \$2314 VSS|anode|cathode|vss VSS|anode|cathode|vss sg13_lv_nmos
+ L=0.13u W=0.42u AS=0.1428p AD=0.0798p PS=1.52u PD=0.8u rfmode=0
M$14595 VSS|anode|cathode|vss \$2311 \$2338 VSS|anode|cathode|vss sg13_lv_nmos
+ L=0.13u W=0.42u AS=0.0798p AD=0.0378p PS=0.8u PD=0.6u rfmode=0
M$14596 \$2338 \$2327 \$2314 VSS|anode|cathode|vss sg13_lv_nmos L=0.13u W=0.42u
+ AS=0.0378p AD=0.1428p PS=0.6u PD=1.52u rfmode=0
M$14597 \$2315 \$2327 VSS|anode|cathode|vss VSS|anode|cathode|vss sg13_lv_nmos
+ L=0.13u W=0.74u AS=0.2516p AD=0.1406p PS=2.16u PD=1.12u rfmode=0
M$14598 VSS|anode|cathode|vss \$2315 \$2245 VSS|anode|cathode|vss sg13_lv_nmos
+ L=0.13u W=0.74u AS=0.1406p AD=0.2516p PS=1.12u PD=2.16u rfmode=0
M$14599 VSS|anode|cathode|vss En|dout[1] \$2328 VSS|anode|cathode|vss
+ sg13_lv_nmos L=0.13u W=0.55u AS=0.14875p AD=0.187p PS=1.16u PD=1.78u rfmode=0
M$14600 VSS|anode|cathode|vss \$2328 \$2134 VSS|anode|cathode|vss sg13_lv_nmos
+ L=0.13u W=0.74u AS=0.14875p AD=0.2886p PS=1.16u PD=2.26u rfmode=0
M$14601 \$2247 \$2329 VSS|anode|cathode|vss VSS|anode|cathode|vss sg13_lv_nmos
+ L=0.13u W=0.74u AS=0.2886p AD=0.14875p PS=2.26u PD=1.16u rfmode=0
M$14602 VSS|anode|cathode|vss \$2530 \$2329 VSS|anode|cathode|vss sg13_lv_nmos
+ L=0.13u W=0.55u AS=0.14875p AD=0.187p PS=1.16u PD=1.78u rfmode=0
M$14603 \$2330 \$2345 \$2339 VSS|anode|cathode|vss sg13_lv_nmos L=0.13u W=0.42u
+ AS=0.1428p AD=0.0609p PS=1.52u PD=0.71u rfmode=0
M$14604 \$2339 \$2347 VSS|anode|cathode|vss VSS|anode|cathode|vss sg13_lv_nmos
+ L=0.13u W=0.42u AS=0.0609p AD=0.1626p PS=0.71u PD=1.415u rfmode=0
M$14605 VSS|anode|cathode|vss \$2346 \$2309 VSS|anode|cathode|vss sg13_lv_nmos
+ L=0.13u W=0.74u AS=0.1626p AD=0.2516p PS=1.415u PD=2.16u rfmode=0
M$14606 \$2317 \$2318 VSS|anode|cathode|vss VSS|anode|cathode|vss sg13_lv_nmos
+ L=0.13u W=0.42u AS=0.1428p AD=0.0798p PS=1.52u PD=0.8u rfmode=0
M$14607 VSS|anode|cathode|vss \$2347 \$2341 VSS|anode|cathode|vss sg13_lv_nmos
+ L=0.13u W=0.42u AS=0.0798p AD=0.0378p PS=0.8u PD=0.6u rfmode=0
M$14608 \$2341 \$2331 \$2318 VSS|anode|cathode|vss sg13_lv_nmos L=0.13u W=0.42u
+ AS=0.0378p AD=0.1428p PS=0.6u PD=1.52u rfmode=0
M$14609 \$2319 \$2331 VSS|anode|cathode|vss VSS|anode|cathode|vss sg13_lv_nmos
+ L=0.13u W=0.74u AS=0.2516p AD=0.1406p PS=2.16u PD=1.12u rfmode=0
M$14610 VSS|anode|cathode|vss \$2319 \$2349 VSS|anode|cathode|vss sg13_lv_nmos
+ L=0.13u W=0.74u AS=0.1406p AD=0.2516p PS=1.12u PD=2.16u rfmode=0
M$14611 \$2256 \$2335 VSS|anode|cathode|vss VSS|anode|cathode|vss sg13_lv_nmos
+ L=0.13u W=0.74u AS=0.2886p AD=0.14875p PS=2.26u PD=1.16u rfmode=0
M$14612 VSS|anode|cathode|vss \$2099 \$2335 VSS|anode|cathode|vss sg13_lv_nmos
+ L=0.13u W=0.55u AS=0.14875p AD=0.187p PS=1.16u PD=1.78u rfmode=0
M$14613 VSS|anode|cathode|vss \$2205 \$2311 VSS|anode|cathode|vss sg13_lv_nmos
+ L=0.13u W=0.74u AS=0.2516p AD=0.2516p PS=2.16u PD=2.16u rfmode=0
M$14614 \$2177 \$2205 VSS|anode|cathode|vss VSS|anode|cathode|vss sg13_lv_nmos
+ L=0.13u W=0.74u AS=0.2516p AD=0.2516p PS=2.16u PD=2.16u rfmode=0
M$14615 \$2133 \$2332 VSS|anode|cathode|vss VSS|anode|cathode|vss sg13_lv_nmos
+ L=0.13u W=0.74u AS=0.2516p AD=0.1426p PS=2.16u PD=1.16u rfmode=0
M$14616 VSS|anode|cathode|vss \$2348 \$2332 VSS|anode|cathode|vss sg13_lv_nmos
+ L=0.5u W=0.42u AS=0.1426p AD=0.1428p PS=1.16u PD=1.52u rfmode=0
M$14617 \$2348 \$2320 VSS|anode|cathode|vss VSS|anode|cathode|vss sg13_lv_nmos
+ L=0.5u W=0.42u AS=0.1428p AD=0.0798p PS=1.52u PD=0.8u rfmode=0
M$14618 VSS|anode|cathode|vss \$2349 \$2320 VSS|anode|cathode|vss sg13_lv_nmos
+ L=0.13u W=0.42u AS=0.0798p AD=0.1428p PS=0.8u PD=1.52u rfmode=0
M$14619 VSS|anode|cathode|vss \$2322 \$2350 VSS|anode|cathode|vss sg13_lv_nmos
+ L=0.13u W=11.84u AS=2.3606p AD=2.2496p PS=18.96u PD=17.92u rfmode=0
M$14635 VSS|anode|cathode|vss \$2433 \$2322 VSS|anode|cathode|vss sg13_lv_nmos
+ L=0.13u W=4.44u AS=0.8436p AD=0.9546p PS=6.72u PD=7.76u rfmode=0
M$14641 \$2321 \$2333 VSS|anode|cathode|vss VSS|anode|cathode|vss sg13_lv_nmos
+ L=0.13u W=0.74u AS=0.2516p AD=0.1426p PS=2.16u PD=1.16u rfmode=0
M$14642 VSS|anode|cathode|vss \$2351 \$2333 VSS|anode|cathode|vss sg13_lv_nmos
+ L=0.5u W=0.42u AS=0.1426p AD=0.1428p PS=1.16u PD=1.52u rfmode=0
M$14643 \$2351 \$2323 VSS|anode|cathode|vss VSS|anode|cathode|vss sg13_lv_nmos
+ L=0.5u W=0.42u AS=0.1428p AD=0.0798p PS=1.52u PD=0.8u rfmode=0
M$14644 VSS|anode|cathode|vss \$2195 \$2323 VSS|anode|cathode|vss sg13_lv_nmos
+ L=0.13u W=0.42u AS=0.0798p AD=0.1428p PS=0.8u PD=1.52u rfmode=0
M$14645 VSS|anode|cathode|vss \$2350 \$2324 VSS|anode|cathode|vss sg13_lv_nmos
+ L=0.13u W=4.44u AS=0.9546p AD=0.8436p PS=7.76u PD=6.72u rfmode=0
M$14651 VSS|anode|cathode|vss \$2324 \$2325 VSS|anode|cathode|vss sg13_lv_nmos
+ L=0.13u W=11.84u AS=2.2496p AD=2.3606p PS=17.92u PD=18.96u rfmode=0
M$14667 \$2106 \$2334 \$2342 VSS|anode|cathode|vss sg13_lv_nmos L=0.13u W=0.74u
+ AS=0.333p AD=0.1406p PS=2.38u PD=1.12u rfmode=0
M$14668 \$2342 \$2073 VSS|anode|cathode|vss VSS|anode|cathode|vss sg13_lv_nmos
+ L=0.13u W=0.74u AS=0.1406p AD=0.14505p PS=1.12u PD=1.15u rfmode=0
M$14669 VSS|anode|cathode|vss \$2147 \$2334 VSS|anode|cathode|vss sg13_lv_nmos
+ L=0.13u W=0.55u AS=0.14505p AD=0.187p PS=1.15u PD=1.78u rfmode=0
M$14670 \$2254 \$2098 VSS|anode|cathode|vss VSS|anode|cathode|vss sg13_lv_nmos
+ L=0.13u W=0.74u AS=0.2516p AD=0.2516p PS=2.16u PD=2.16u rfmode=0
M$14685 VSS|anode|cathode|vss \$2311 \$2337 VSS|anode|cathode|vss sg13_lv_nmos
+ L=0.13u W=0.42u AS=0.1701p AD=0.0378p PS=1.65u PD=0.6u rfmode=0
M$14686 \$2337 \$2307 \$2312 VSS|anode|cathode|vss sg13_lv_nmos L=0.13u W=0.42u
+ AS=0.0378p AD=0.1428p PS=0.6u PD=1.52u rfmode=0
M$14687 \$2326 \$2308 \$2344 VSS|anode|cathode|vss sg13_lv_nmos L=0.13u W=0.42u
+ AS=0.1296p AD=0.0798p PS=1.52u PD=0.8u rfmode=0
M$14688 \$2344 \$2352 \$2312 VSS|anode|cathode|vss sg13_lv_nmos L=0.13u W=0.42u
+ AS=0.0798p AD=0.2373p PS=0.8u PD=1.97u rfmode=0
M$14689 VSS|anode|cathode|vss \$2308 \$2352 VSS|anode|cathode|vss sg13_lv_nmos
+ L=0.13u W=0.74u AS=0.317325p AD=0.2516p PS=1.805u PD=2.16u rfmode=0
M$14690 VSS|anode|cathode|vss \$2247 \$2308 VSS|anode|cathode|vss sg13_lv_nmos
+ L=0.13u W=0.74u AS=0.317325p AD=0.2516p PS=1.805u PD=2.16u rfmode=0
M$14691 \$2327 \$2308 \$2313 VSS|anode|cathode|vss sg13_lv_nmos L=0.13u W=0.42u
+ AS=0.12665p AD=0.1428p PS=1.145u PD=1.52u rfmode=0
M$14692 \$2307 \$2352 \$2327 VSS|anode|cathode|vss sg13_lv_nmos L=0.13u W=0.74u
+ AS=0.3473p AD=0.12665p PS=2.71u PD=1.145u rfmode=0
M$14693 VSS|anode|cathode|vss \$2347 \$2340 VSS|anode|cathode|vss sg13_lv_nmos
+ L=0.13u W=0.42u AS=0.1701p AD=0.0378p PS=1.65u PD=0.6u rfmode=0
M$14694 \$2340 \$2309 \$2316 VSS|anode|cathode|vss sg13_lv_nmos L=0.13u W=0.42u
+ AS=0.0378p AD=0.1428p PS=0.6u PD=1.52u rfmode=0
M$14695 \$2330 \$2310 \$2346 VSS|anode|cathode|vss sg13_lv_nmos L=0.13u W=0.42u
+ AS=0.1296p AD=0.0798p PS=1.52u PD=0.8u rfmode=0
M$14696 \$2346 \$2353 \$2316 VSS|anode|cathode|vss sg13_lv_nmos L=0.13u W=0.42u
+ AS=0.0798p AD=0.2373p PS=0.8u PD=1.97u rfmode=0
M$14697 VSS|anode|cathode|vss \$2310 \$2353 VSS|anode|cathode|vss sg13_lv_nmos
+ L=0.13u W=0.74u AS=0.317325p AD=0.2516p PS=1.805u PD=2.16u rfmode=0
M$14698 VSS|anode|cathode|vss \$2368 \$2310 VSS|anode|cathode|vss sg13_lv_nmos
+ L=0.13u W=0.74u AS=0.317325p AD=0.2516p PS=1.805u PD=2.16u rfmode=0
M$14699 \$2331 \$2310 \$2317 VSS|anode|cathode|vss sg13_lv_nmos L=0.13u W=0.42u
+ AS=0.12665p AD=0.1428p PS=1.145u PD=1.52u rfmode=0
M$14700 \$2309 \$2353 \$2331 VSS|anode|cathode|vss sg13_lv_nmos L=0.13u W=0.74u
+ AS=0.3473p AD=0.12665p PS=2.71u PD=1.145u rfmode=0
M$14701 \$2380 \$2321 \$2406 VSS|anode|cathode|vss sg13_lv_nmos L=0.13u W=0.64u
+ AS=0.2176p AD=0.1216p PS=1.96u PD=1.02u rfmode=0
M$14702 \$2406 \$2192 VSS|anode|cathode|vss VSS|anode|cathode|vss sg13_lv_nmos
+ L=0.13u W=0.64u AS=0.1216p AD=0.1331p PS=1.02u PD=1.12u rfmode=0
M$14703 VSS|anode|cathode|vss \$2380 \$2274 VSS|anode|cathode|vss sg13_lv_nmos
+ L=0.13u W=0.74u AS=0.1331p AD=0.2516p PS=1.12u PD=2.16u rfmode=0
M$14704 \$2369 \$2387 \$2381 VSS|anode|cathode|vss sg13_lv_nmos L=0.13u W=0.42u
+ AS=0.1296p AD=0.0798p PS=1.52u PD=0.8u rfmode=0
M$14705 \$2381 \$2386 \$2401 VSS|anode|cathode|vss sg13_lv_nmos L=0.13u W=0.42u
+ AS=0.0798p AD=0.2373p PS=0.8u PD=1.97u rfmode=0
M$14734 \$2143 \$2251 VSS|anode|cathode|vss VSS|anode|cathode|vss sg13_lv_nmos
+ L=0.13u W=0.77u AS=0.2618p AD=0.1463p PS=2.22u PD=1.15u rfmode=0
M$14735 VSS|anode|cathode|vss \$2146 \$2143 VSS|anode|cathode|vss sg13_lv_nmos
+ L=0.13u W=0.77u AS=0.1463p AD=0.1694p PS=1.15u PD=1.21u rfmode=0
M$14736 \$2143 \$2321 VSS|anode|cathode|vss VSS|anode|cathode|vss sg13_lv_nmos
+ L=0.13u W=0.77u AS=0.1694p AD=0.2618p PS=1.21u PD=2.22u rfmode=0
M$14737 \$2386 \$2387 VSS|anode|cathode|vss VSS|anode|cathode|vss sg13_lv_nmos
+ L=0.13u W=0.74u AS=0.2516p AD=0.317325p PS=2.16u PD=1.805u rfmode=0
M$14738 VSS|anode|cathode|vss \$2325 \$2387 VSS|anode|cathode|vss sg13_lv_nmos
+ L=0.13u W=0.74u AS=0.317325p AD=0.2516p PS=1.805u PD=2.16u rfmode=0
M$14739 \$2402 \$2387 \$2388 VSS|anode|cathode|vss sg13_lv_nmos L=0.13u W=0.42u
+ AS=0.1428p AD=0.12665p PS=1.52u PD=1.145u rfmode=0
M$14740 \$2388 \$2386 \$2394 VSS|anode|cathode|vss sg13_lv_nmos L=0.13u W=0.74u
+ AS=0.12665p AD=0.3473p PS=1.145u PD=2.71u rfmode=0
M$14741 VSS|anode|cathode|vss \$2077 \$2372 VSS|anode|cathode|vss sg13_lv_nmos
+ L=0.13u W=4.44u AS=0.9546p AD=0.8436p PS=7.76u PD=6.72u rfmode=0
M$14747 VSS|anode|cathode|vss \$2372 \$2373 VSS|anode|cathode|vss sg13_lv_nmos
+ L=0.13u W=11.84u AS=2.2496p AD=2.3606p PS=17.92u PD=18.96u rfmode=0
M$14763 VSS|anode|cathode|vss \$2375 \$2367 VSS|anode|cathode|vss sg13_lv_nmos
+ L=0.13u W=0.55u AS=0.18945p AD=0.187p PS=1.27u PD=1.78u rfmode=0
M$14764 \$2374 \$2399 VSS|anode|cathode|vss VSS|anode|cathode|vss sg13_lv_nmos
+ L=0.13u W=0.74u AS=0.4033p AD=0.148p PS=2.57u PD=1.14u rfmode=0
M$14765 VSS|anode|cathode|vss \$2367 \$2411 VSS|anode|cathode|vss sg13_lv_nmos
+ L=0.13u W=0.74u AS=0.148p AD=0.3367p PS=1.14u PD=1.65u rfmode=0
M$14766 \$2411 \$2480 \$2399 VSS|anode|cathode|vss sg13_lv_nmos L=0.13u W=0.74u
+ AS=0.3367p AD=0.1628p PS=1.65u PD=1.18u rfmode=0
M$14767 \$2399 \$2106 \$2410 VSS|anode|cathode|vss sg13_lv_nmos L=0.13u W=0.74u
+ AS=0.1628p AD=0.13135p PS=1.18u PD=1.095u rfmode=0
M$14768 \$2410 \$2375 VSS|anode|cathode|vss VSS|anode|cathode|vss sg13_lv_nmos
+ L=0.13u W=0.74u AS=0.13135p AD=0.18945p PS=1.095u PD=1.27u rfmode=0
M$14769 VSS|anode|cathode|vss \$2205 \$2347 VSS|anode|cathode|vss sg13_lv_nmos
+ L=0.13u W=0.74u AS=0.2516p AD=0.2516p PS=2.16u PD=2.16u rfmode=0
M$14770 VSS|anode|cathode|vss \$2376 \$2368 VSS|anode|cathode|vss sg13_lv_nmos
+ L=0.13u W=11.84u AS=2.3606p AD=2.2496p PS=18.96u PD=17.92u rfmode=0
M$14786 VSS|anode|cathode|vss \$2350 \$2376 VSS|anode|cathode|vss sg13_lv_nmos
+ L=0.13u W=4.44u AS=0.8436p AD=0.9546p PS=6.72u PD=7.76u rfmode=0
M$14792 VSS|anode|cathode|vss \$2139 \$2413 VSS|anode|cathode|vss sg13_lv_nmos
+ L=0.13u W=0.74u AS=0.2516p AD=0.1406p PS=2.16u PD=1.12u rfmode=0
M$14793 \$2413 \$2133 \$2412 VSS|anode|cathode|vss sg13_lv_nmos L=0.13u W=0.74u
+ AS=0.1406p AD=0.1406p PS=1.12u PD=1.12u rfmode=0
M$14794 \$2412 \$2137 \$2416 VSS|anode|cathode|vss sg13_lv_nmos L=0.13u W=0.74u
+ AS=0.1406p AD=0.1406p PS=1.12u PD=1.12u rfmode=0
M$14795 \$2416 \$2134 \$2251 VSS|anode|cathode|vss sg13_lv_nmos L=0.13u W=0.74u
+ AS=0.1406p AD=0.2516p PS=1.12u PD=2.16u rfmode=0
M$14796 \$2377 \$2134 \$2415 VSS|anode|cathode|vss sg13_lv_nmos L=0.13u W=0.74u
+ AS=0.2516p AD=0.1406p PS=2.16u PD=1.12u rfmode=0
M$14797 \$2415 \$2146 VSS|anode|cathode|vss VSS|anode|cathode|vss sg13_lv_nmos
+ L=0.13u W=0.74u AS=0.1406p AD=0.2516p PS=1.12u PD=2.16u rfmode=0
M$14798 \$2378 \$2393 VSS|anode|cathode|vss VSS|anode|cathode|vss sg13_lv_nmos
+ L=0.13u W=0.55u AS=0.187p AD=0.18575p PS=1.78u PD=1.26u rfmode=0
M$14799 VSS|anode|cathode|vss \$2134 \$2414 VSS|anode|cathode|vss sg13_lv_nmos
+ L=0.13u W=0.74u AS=0.18575p AD=0.1406p PS=1.26u PD=1.12u rfmode=0
M$14800 \$2414 \$2383 \$2418 VSS|anode|cathode|vss sg13_lv_nmos L=0.13u W=0.74u
+ AS=0.1406p AD=0.1406p PS=1.12u PD=1.12u rfmode=0
M$14801 \$2418 \$2378 \$2379 VSS|anode|cathode|vss sg13_lv_nmos L=0.13u W=0.74u
+ AS=0.1406p AD=0.3404p PS=1.12u PD=2.4u rfmode=0
M$14802 VSS|anode|cathode|vss \$2400 \$2252 VSS|anode|cathode|vss sg13_lv_nmos
+ L=0.13u W=0.74u AS=0.2516p AD=0.2516p PS=2.16u PD=2.16u rfmode=0
M$14803 VSS|anode|cathode|vss \$2098 \$2371 VSS|anode|cathode|vss sg13_lv_nmos
+ L=0.13u W=0.74u AS=0.2516p AD=0.2516p PS=2.16u PD=2.16u rfmode=0
M$14806 \$885 \$2444 VSS|anode|cathode|vss VSS|anode|cathode|vss sg13_lv_nmos
+ L=0.13u W=0.74u AS=0.2886p AD=0.14875p PS=2.26u PD=1.16u rfmode=0
M$14807 VSS|anode|cathode|vss \$2480 \$2444 VSS|anode|cathode|vss sg13_lv_nmos
+ L=0.13u W=0.55u AS=0.14875p AD=0.187p PS=1.16u PD=1.78u rfmode=0
M$14820 \$2423 \$2374 \$2459 VSS|anode|cathode|vss sg13_lv_nmos L=0.13u W=0.42u
+ AS=0.1428p AD=0.0609p PS=1.52u PD=0.71u rfmode=0
M$14821 \$2459 \$2422 VSS|anode|cathode|vss VSS|anode|cathode|vss sg13_lv_nmos
+ L=0.13u W=0.42u AS=0.0609p AD=0.1626p PS=0.71u PD=1.415u rfmode=0
M$14822 VSS|anode|cathode|vss \$2481 \$2424 VSS|anode|cathode|vss sg13_lv_nmos
+ L=0.13u W=0.74u AS=0.1626p AD=0.2516p PS=1.415u PD=2.16u rfmode=0
M$14824 \$2426 \$2427 VSS|anode|cathode|vss VSS|anode|cathode|vss sg13_lv_nmos
+ L=0.13u W=0.42u AS=0.1428p AD=0.0798p PS=1.52u PD=0.8u rfmode=0
M$14825 VSS|anode|cathode|vss \$2422 \$2461 VSS|anode|cathode|vss sg13_lv_nmos
+ L=0.13u W=0.42u AS=0.0798p AD=0.0378p PS=0.8u PD=0.6u rfmode=0
M$14826 \$2461 \$2447 \$2427 VSS|anode|cathode|vss sg13_lv_nmos L=0.13u W=0.42u
+ AS=0.0378p AD=0.1428p PS=0.6u PD=1.52u rfmode=0
M$14827 \$2428 \$2447 VSS|anode|cathode|vss VSS|anode|cathode|vss sg13_lv_nmos
+ L=0.13u W=0.74u AS=0.2516p AD=0.1406p PS=2.16u PD=1.12u rfmode=0
M$14828 VSS|anode|cathode|vss \$2428 \$2480 VSS|anode|cathode|vss sg13_lv_nmos
+ L=0.13u W=0.74u AS=0.1406p AD=0.2516p PS=1.12u PD=2.16u rfmode=0
M$14829 \$2429 \$2449 VSS|anode|cathode|vss VSS|anode|cathode|vss sg13_lv_nmos
+ L=0.13u W=0.74u AS=0.2886p AD=0.14875p PS=2.26u PD=1.16u rfmode=0
M$14830 VSS|anode|cathode|vss \$2086 \$2449 VSS|anode|cathode|vss sg13_lv_nmos
+ L=0.13u W=0.55u AS=0.14875p AD=0.187p PS=1.16u PD=1.78u rfmode=0
M$14831 VSS|anode|cathode|vss \$2429 \$2450 VSS|anode|cathode|vss sg13_lv_nmos
+ L=0.13u W=0.55u AS=0.14875p AD=0.187p PS=1.16u PD=1.78u rfmode=0
M$14832 VSS|anode|cathode|vss \$2450 \$2400 VSS|anode|cathode|vss sg13_lv_nmos
+ L=0.13u W=0.74u AS=0.14875p AD=0.2886p PS=1.16u PD=2.26u rfmode=0
M$14833 \$2430 \$2146 VSS|anode|cathode|vss VSS|anode|cathode|vss sg13_lv_nmos
+ L=0.15u W=0.74u AS=0.2516p AD=0.1406p PS=2.16u PD=1.12u rfmode=0
M$14834 VSS|anode|cathode|vss \$2469 \$2430 VSS|anode|cathode|vss sg13_lv_nmos
+ L=0.15u W=0.74u AS=0.1406p AD=0.1406p PS=1.12u PD=1.12u rfmode=0
M$14835 \$2430 \$2134 \$2431 VSS|anode|cathode|vss sg13_lv_nmos L=0.15u W=0.74u
+ AS=0.1406p AD=0.2516p PS=1.12u PD=2.16u rfmode=0
M$14836 VSS|anode|cathode|vss \$2381 \$2394 VSS|anode|cathode|vss sg13_lv_nmos
+ L=0.13u W=0.74u AS=0.1626p AD=0.2516p PS=1.415u PD=2.16u rfmode=0
M$14837 \$2369 \$2193 \$2417 VSS|anode|cathode|vss sg13_lv_nmos L=0.13u W=0.42u
+ AS=0.1428p AD=0.0609p PS=1.52u PD=0.71u rfmode=0
M$14838 VSS|anode|cathode|vss \$2370 \$2417 VSS|anode|cathode|vss sg13_lv_nmos
+ L=0.13u W=0.42u AS=0.1626p AD=0.0609p PS=1.415u PD=0.71u rfmode=0
M$14839 VSS|anode|cathode|vss \$2370 \$2420 VSS|anode|cathode|vss sg13_lv_nmos
+ L=0.13u W=0.42u AS=0.1701p AD=0.0378p PS=1.65u PD=0.6u rfmode=0
M$14840 \$2420 \$2394 \$2401 VSS|anode|cathode|vss sg13_lv_nmos L=0.13u W=0.42u
+ AS=0.0378p AD=0.1428p PS=0.6u PD=1.52u rfmode=0
M$14841 c2p|core|fdac_clk|i|uo_c2p[0] \$2452 VSS|anode|cathode|vss
+ VSS|anode|cathode|vss sg13_lv_nmos L=0.13u W=0.74u AS=0.2886p AD=0.14875p
+ PS=2.26u PD=1.16u rfmode=0
M$14842 VSS|anode|cathode|vss \$2094 \$2452 VSS|anode|cathode|vss sg13_lv_nmos
+ L=0.13u W=0.55u AS=0.14875p AD=0.187p PS=1.16u PD=1.78u rfmode=0
M$14843 \$2402 \$2389 VSS|anode|cathode|vss VSS|anode|cathode|vss sg13_lv_nmos
+ L=0.13u W=0.42u AS=0.1428p AD=0.0798p PS=1.52u PD=0.8u rfmode=0
M$14844 VSS|anode|cathode|vss \$2370 \$2419 VSS|anode|cathode|vss sg13_lv_nmos
+ L=0.13u W=0.42u AS=0.0798p AD=0.0378p PS=0.8u PD=0.6u rfmode=0
M$14845 \$2419 \$2388 \$2389 VSS|anode|cathode|vss sg13_lv_nmos L=0.13u W=0.42u
+ AS=0.0378p AD=0.1428p PS=0.6u PD=1.52u rfmode=0
M$14846 \$2382 \$2388 VSS|anode|cathode|vss VSS|anode|cathode|vss sg13_lv_nmos
+ L=0.13u W=0.74u AS=0.2516p AD=0.1406p PS=2.16u PD=1.12u rfmode=0
M$14847 VSS|anode|cathode|vss \$2382 \$2383 VSS|anode|cathode|vss sg13_lv_nmos
+ L=0.13u W=0.74u AS=0.1406p AD=0.2516p PS=1.12u PD=2.16u rfmode=0
M$14850 VSS|anode|cathode|vss \$2390 \$2385 VSS|anode|cathode|vss sg13_lv_nmos
+ L=0.13u W=0.55u AS=0.14875p AD=0.187p PS=1.16u PD=1.78u rfmode=0
M$14851 \$2384 \$2385 VSS|anode|cathode|vss VSS|anode|cathode|vss sg13_lv_nmos
+ L=0.13u W=0.74u AS=0.2886p AD=0.14875p PS=2.26u PD=1.16u rfmode=0
M$14852 \$2438 \$2437 \$2464 VSS|anode|cathode|vss sg13_lv_nmos L=0.13u W=0.42u
+ AS=0.1428p AD=0.0609p PS=1.52u PD=0.71u rfmode=0
M$14853 \$2464 \$2371 VSS|anode|cathode|vss VSS|anode|cathode|vss sg13_lv_nmos
+ L=0.13u W=0.42u AS=0.0609p AD=0.1626p PS=0.71u PD=1.415u rfmode=0
M$14854 VSS|anode|cathode|vss \$2482 \$2439 VSS|anode|cathode|vss sg13_lv_nmos
+ L=0.13u W=0.74u AS=0.1626p AD=0.2516p PS=1.415u PD=2.16u rfmode=0
M$14859 \$2441 \$2442 VSS|anode|cathode|vss VSS|anode|cathode|vss sg13_lv_nmos
+ L=0.13u W=0.42u AS=0.1428p AD=0.0798p PS=1.52u PD=0.8u rfmode=0
M$14860 VSS|anode|cathode|vss \$2371 \$2462 VSS|anode|cathode|vss sg13_lv_nmos
+ L=0.13u W=0.42u AS=0.0798p AD=0.0378p PS=0.8u PD=0.6u rfmode=0
M$14861 \$2462 \$2457 \$2442 VSS|anode|cathode|vss sg13_lv_nmos L=0.13u W=0.42u
+ AS=0.0378p AD=0.1428p PS=0.6u PD=1.52u rfmode=0
M$14864 \$2443 \$2457 VSS|anode|cathode|vss VSS|anode|cathode|vss sg13_lv_nmos
+ L=0.13u W=0.74u AS=0.2516p AD=0.1406p PS=2.16u PD=1.12u rfmode=0
M$14865 VSS|anode|cathode|vss \$2443 \$2472 VSS|anode|cathode|vss sg13_lv_nmos
+ L=0.13u W=0.74u AS=0.1406p AD=0.2516p PS=1.12u PD=2.16u rfmode=0
M$14892 VSS|anode|cathode|vss \$2472 \$2458 VSS|anode|cathode|vss sg13_lv_nmos
+ L=0.13u W=0.55u AS=0.14875p AD=0.187p PS=1.16u PD=1.78u rfmode=0
M$14893 VSS|anode|cathode|vss \$2458 \$889 VSS|anode|cathode|vss sg13_lv_nmos
+ L=0.13u W=0.74u AS=0.14875p AD=0.2886p PS=1.16u PD=2.26u rfmode=0
M$14894 \$2343 \$2421 VSS|anode|cathode|vss VSS|anode|cathode|vss sg13_lv_nmos
+ L=0.13u W=0.74u AS=0.4033p AD=0.148p PS=2.57u PD=1.14u rfmode=0
M$14895 VSS|anode|cathode|vss \$2465 \$2474 VSS|anode|cathode|vss sg13_lv_nmos
+ L=0.13u W=0.74u AS=0.148p AD=0.3367p PS=1.14u PD=1.65u rfmode=0
M$14896 \$2474 \$2245 \$2421 VSS|anode|cathode|vss sg13_lv_nmos L=0.13u W=0.74u
+ AS=0.3367p AD=0.1628p PS=1.65u PD=1.18u rfmode=0
M$14897 \$2421 \$2106 \$2473 VSS|anode|cathode|vss sg13_lv_nmos L=0.13u W=0.74u
+ AS=0.1628p AD=0.13135p PS=1.18u PD=1.095u rfmode=0
M$14898 \$2473 \$2690 VSS|anode|cathode|vss VSS|anode|cathode|vss sg13_lv_nmos
+ L=0.13u W=0.74u AS=0.13135p AD=0.18945p PS=1.095u PD=1.27u rfmode=0
M$14899 VSS|anode|cathode|vss \$2690 \$2465 VSS|anode|cathode|vss sg13_lv_nmos
+ L=0.13u W=0.55u AS=0.18945p AD=0.187p PS=1.27u PD=1.78u rfmode=0
M$14900 VSS|anode|cathode|vss \$2205 \$2422 VSS|anode|cathode|vss sg13_lv_nmos
+ L=0.13u W=0.74u AS=0.2516p AD=0.2516p PS=2.16u PD=2.16u rfmode=0
M$14901 \$2469 \$2393 VSS|anode|cathode|vss VSS|anode|cathode|vss sg13_lv_nmos
+ L=0.13u W=0.74u AS=0.2516p AD=0.2516p PS=2.16u PD=2.16u rfmode=0
M$14902 VSS|anode|cathode|vss CLK|clk|core|fclk_in|p2c|ui_p2c[6] \$2432
+ VSS|anode|cathode|vss sg13_lv_nmos L=0.13u W=4.44u AS=0.9546p AD=0.8436p
+ PS=7.76u PD=6.72u rfmode=0
M$14908 VSS|anode|cathode|vss \$2432 \$2433 VSS|anode|cathode|vss sg13_lv_nmos
+ L=0.13u W=11.84u AS=2.2496p AD=2.3606p PS=17.92u PD=18.96u rfmode=0
M$14924 VSS|anode|cathode|vss \$2248 \$2434 VSS|anode|cathode|vss sg13_lv_nmos
+ L=0.13u W=0.74u AS=0.2516p AD=0.2516p PS=2.16u PD=2.16u rfmode=0
M$14925 \$2146 \$2470 VSS|anode|cathode|vss VSS|anode|cathode|vss sg13_lv_nmos
+ L=0.13u W=0.74u AS=0.2516p AD=0.2516p PS=2.16u PD=2.16u rfmode=0
M$14926 \$2470 \$2453 VSS|anode|cathode|vss VSS|anode|cathode|vss sg13_lv_nmos
+ L=0.13u W=0.74u AS=0.2516p AD=0.1426p PS=2.16u PD=1.16u rfmode=0
M$14927 VSS|anode|cathode|vss \$2471 \$2453 VSS|anode|cathode|vss sg13_lv_nmos
+ L=0.5u W=0.42u AS=0.1426p AD=0.1428p PS=1.16u PD=1.52u rfmode=0
M$14928 \$2471 \$2435 VSS|anode|cathode|vss VSS|anode|cathode|vss sg13_lv_nmos
+ L=0.5u W=0.42u AS=0.1428p AD=0.0798p PS=1.52u PD=0.8u rfmode=0
M$14929 VSS|anode|cathode|vss \$2383 \$2435 VSS|anode|cathode|vss sg13_lv_nmos
+ L=0.13u W=0.42u AS=0.0798p AD=0.1428p PS=0.8u PD=1.52u rfmode=0
M$14930 VSS|anode|cathode|vss \$2375 \$2454 VSS|anode|cathode|vss sg13_lv_nmos
+ L=0.13u W=0.55u AS=0.18945p AD=0.187p PS=1.27u PD=1.78u rfmode=0
M$14931 VSS|anode|cathode|vss \$2375 \$2478 VSS|anode|cathode|vss sg13_lv_nmos
+ L=0.13u W=0.74u AS=0.18945p AD=0.13135p PS=1.27u PD=1.095u rfmode=0
M$14932 \$2478 \$2384 \$2436 VSS|anode|cathode|vss sg13_lv_nmos L=0.13u W=0.74u
+ AS=0.13135p AD=0.1628p PS=1.095u PD=1.18u rfmode=0
M$14933 \$2436 \$2472 \$2479 VSS|anode|cathode|vss sg13_lv_nmos L=0.13u W=0.74u
+ AS=0.1628p AD=0.3367p PS=1.18u PD=1.65u rfmode=0
M$14934 \$2479 \$2454 VSS|anode|cathode|vss VSS|anode|cathode|vss sg13_lv_nmos
+ L=0.13u W=0.74u AS=0.3367p AD=0.148p PS=1.65u PD=1.14u rfmode=0
M$14935 VSS|anode|cathode|vss \$2436 \$2437 VSS|anode|cathode|vss sg13_lv_nmos
+ L=0.13u W=0.74u AS=0.148p AD=0.4033p PS=1.14u PD=2.57u rfmode=0
M$14951 VSS|anode|cathode|vss \$2422 \$2460 VSS|anode|cathode|vss sg13_lv_nmos
+ L=0.13u W=0.42u AS=0.1701p AD=0.0378p PS=1.65u PD=0.6u rfmode=0
M$14952 \$2460 \$2424 \$2445 VSS|anode|cathode|vss sg13_lv_nmos L=0.13u W=0.42u
+ AS=0.0378p AD=0.1428p PS=0.6u PD=1.52u rfmode=0
M$14953 VSS|anode|cathode|vss \$2425 \$2446 VSS|anode|cathode|vss sg13_lv_nmos
+ L=0.13u W=0.74u AS=0.317325p AD=0.2516p PS=1.805u PD=2.16u rfmode=0
M$14954 VSS|anode|cathode|vss \$2247 \$2425 VSS|anode|cathode|vss sg13_lv_nmos
+ L=0.13u W=0.74u AS=0.317325p AD=0.2516p PS=1.805u PD=2.16u rfmode=0
M$14955 \$2447 \$2425 \$2426 VSS|anode|cathode|vss sg13_lv_nmos L=0.13u W=0.42u
+ AS=0.12665p AD=0.1428p PS=1.145u PD=1.52u rfmode=0
M$14956 \$2424 \$2446 \$2447 VSS|anode|cathode|vss sg13_lv_nmos L=0.13u W=0.74u
+ AS=0.3473p AD=0.12665p PS=2.71u PD=1.145u rfmode=0
M$14957 \$2345 \$2448 VSS|anode|cathode|vss VSS|anode|cathode|vss sg13_lv_nmos
+ L=0.13u W=0.74u AS=0.2516p AD=0.1331p PS=2.16u PD=1.12u rfmode=0
M$14958 VSS|anode|cathode|vss \$2466 \$2476 VSS|anode|cathode|vss sg13_lv_nmos
+ L=0.13u W=0.64u AS=0.1331p AD=0.1216p PS=1.12u PD=1.02u rfmode=0
M$14959 \$2476 \$2079 \$2448 VSS|anode|cathode|vss sg13_lv_nmos L=0.13u W=0.64u
+ AS=0.1216p AD=0.2176p PS=1.02u PD=1.96u rfmode=0
M$14960 \$2466 \$2467 VSS|anode|cathode|vss VSS|anode|cathode|vss sg13_lv_nmos
+ L=0.13u W=0.74u AS=0.2351p AD=0.15745p PS=2.16u PD=1.175u rfmode=0
M$14961 VSS|anode|cathode|vss \$2133 \$2467 VSS|anode|cathode|vss sg13_lv_nmos
+ L=0.13u W=0.64u AS=0.15745p AD=0.1216p PS=1.175u PD=1.02u rfmode=0
M$14962 \$2467 \$2134 \$2475 VSS|anode|cathode|vss sg13_lv_nmos L=0.13u W=0.64u
+ AS=0.1216p AD=0.0816p PS=1.02u PD=0.895u rfmode=0
M$14963 \$2475 \$2136 VSS|anode|cathode|vss VSS|anode|cathode|vss sg13_lv_nmos
+ L=0.13u W=0.64u AS=0.0816p AD=0.2176p PS=0.895u PD=1.96u rfmode=0
M$14964 \$2451 \$2468 VSS|anode|cathode|vss VSS|anode|cathode|vss sg13_lv_nmos
+ L=0.13u W=0.74u AS=0.2351p AD=0.15745p PS=2.16u PD=1.175u rfmode=0
M$14965 VSS|anode|cathode|vss \$2556 \$2468 VSS|anode|cathode|vss sg13_lv_nmos
+ L=0.13u W=0.64u AS=0.15745p AD=0.1216p PS=1.175u PD=1.02u rfmode=0
M$14966 \$2468 \$2393 \$2477 VSS|anode|cathode|vss sg13_lv_nmos L=0.13u W=0.64u
+ AS=0.1216p AD=0.0816p PS=1.02u PD=0.895u rfmode=0
M$14967 \$2477 \$2377 VSS|anode|cathode|vss VSS|anode|cathode|vss sg13_lv_nmos
+ L=0.13u W=0.64u AS=0.0816p AD=0.2176p PS=0.895u PD=1.96u rfmode=0
M$14968 VSS|anode|cathode|vss \$2371 \$2463 VSS|anode|cathode|vss sg13_lv_nmos
+ L=0.13u W=0.42u AS=0.1701p AD=0.0378p PS=1.65u PD=0.6u rfmode=0
M$14969 \$2463 \$2439 \$2455 VSS|anode|cathode|vss sg13_lv_nmos L=0.13u W=0.42u
+ AS=0.0378p AD=0.1428p PS=0.6u PD=1.52u rfmode=0
M$14970 VSS|anode|cathode|vss \$2440 \$2456 VSS|anode|cathode|vss sg13_lv_nmos
+ L=0.13u W=0.74u AS=0.317325p AD=0.2516p PS=1.805u PD=2.16u rfmode=0
M$14971 VSS|anode|cathode|vss \$2256 \$2440 VSS|anode|cathode|vss sg13_lv_nmos
+ L=0.13u W=0.74u AS=0.317325p AD=0.2516p PS=1.805u PD=2.16u rfmode=0
M$14972 \$2457 \$2440 \$2441 VSS|anode|cathode|vss sg13_lv_nmos L=0.13u W=0.42u
+ AS=0.12665p AD=0.1428p PS=1.145u PD=1.52u rfmode=0
M$14973 \$2439 \$2456 \$2457 VSS|anode|cathode|vss sg13_lv_nmos L=0.13u W=0.74u
+ AS=0.3473p AD=0.12665p PS=2.71u PD=1.145u rfmode=0
M$15021 \$2423 \$2425 \$2481 VSS|anode|cathode|vss sg13_lv_nmos L=0.13u W=0.42u
+ AS=0.1296p AD=0.0798p PS=1.52u PD=0.8u rfmode=0
M$15022 \$2481 \$2446 \$2445 VSS|anode|cathode|vss sg13_lv_nmos L=0.13u W=0.42u
+ AS=0.0798p AD=0.2373p PS=0.8u PD=1.97u rfmode=0
M$15024 VSS|anode|cathode|vss \$2520 \$2496 VSS|anode|cathode|vss sg13_lv_nmos
+ L=0.13u W=0.55u AS=0.18945p AD=0.187p PS=1.27u PD=1.78u rfmode=0
M$15025 \$2500 \$2528 VSS|anode|cathode|vss VSS|anode|cathode|vss sg13_lv_nmos
+ L=0.13u W=0.74u AS=0.4033p AD=0.148p PS=2.57u PD=1.14u rfmode=0
M$15026 VSS|anode|cathode|vss \$2496 \$2540 VSS|anode|cathode|vss sg13_lv_nmos
+ L=0.13u W=0.74u AS=0.148p AD=0.3367p PS=1.14u PD=1.65u rfmode=0
M$15027 \$2540 \$2529 \$2528 VSS|anode|cathode|vss sg13_lv_nmos L=0.13u W=0.74u
+ AS=0.3367p AD=0.1628p PS=1.65u PD=1.18u rfmode=0
M$15028 \$2528 \$2106 \$2541 VSS|anode|cathode|vss sg13_lv_nmos L=0.13u W=0.74u
+ AS=0.1628p AD=0.13135p PS=1.18u PD=1.095u rfmode=0
M$15029 \$2541 \$2520 VSS|anode|cathode|vss VSS|anode|cathode|vss sg13_lv_nmos
+ L=0.13u W=0.74u AS=0.13135p AD=0.18945p PS=1.095u PD=1.27u rfmode=0
M$15034 \$2179 \$2400 VSS|anode|cathode|vss VSS|anode|cathode|vss sg13_lv_nmos
+ L=0.13u W=0.74u AS=0.2516p AD=0.2516p PS=2.16u PD=2.16u rfmode=0
M$15035 VSS|anode|cathode|vss \$2429 \$2501 VSS|anode|cathode|vss sg13_lv_nmos
+ L=0.13u W=0.55u AS=0.14875p AD=0.187p PS=1.16u PD=1.78u rfmode=0
M$15036 \$2248 \$2501 VSS|anode|cathode|vss VSS|anode|cathode|vss sg13_lv_nmos
+ L=0.13u W=0.74u AS=0.2886p AD=0.14875p PS=2.26u PD=1.16u rfmode=0
M$15037 VSS|anode|cathode|vss \$2502 \$2521 VSS|anode|cathode|vss sg13_lv_nmos
+ L=0.13u W=0.74u AS=0.1626p AD=0.2516p PS=1.415u PD=2.16u rfmode=0
M$15038 \$2497 \$2451 \$2543 VSS|anode|cathode|vss sg13_lv_nmos L=0.13u W=0.42u
+ AS=0.1428p AD=0.0609p PS=1.52u PD=0.71u rfmode=0
M$15039 VSS|anode|cathode|vss \$2498 \$2543 VSS|anode|cathode|vss sg13_lv_nmos
+ L=0.13u W=0.42u AS=0.1626p AD=0.0609p PS=1.415u PD=0.71u rfmode=0
M$15040 VSS|anode|cathode|vss \$2498 \$2542 VSS|anode|cathode|vss sg13_lv_nmos
+ L=0.13u W=0.42u AS=0.1701p AD=0.0378p PS=1.65u PD=0.6u rfmode=0
M$15041 \$2542 \$2521 \$2531 VSS|anode|cathode|vss sg13_lv_nmos L=0.13u W=0.42u
+ AS=0.0378p AD=0.1428p PS=0.6u PD=1.52u rfmode=0
M$15042 \$2497 \$2511 \$2502 VSS|anode|cathode|vss sg13_lv_nmos L=0.13u W=0.42u
+ AS=0.1296p AD=0.0798p PS=1.52u PD=0.8u rfmode=0
M$15043 \$2502 \$2510 \$2531 VSS|anode|cathode|vss sg13_lv_nmos L=0.13u W=0.42u
+ AS=0.0798p AD=0.2373p PS=0.8u PD=1.97u rfmode=0
M$15044 \$2510 \$2511 VSS|anode|cathode|vss VSS|anode|cathode|vss sg13_lv_nmos
+ L=0.13u W=0.74u AS=0.2516p AD=0.317325p PS=2.16u PD=1.805u rfmode=0
M$15045 VSS|anode|cathode|vss \$2530 \$2511 VSS|anode|cathode|vss sg13_lv_nmos
+ L=0.13u W=0.74u AS=0.317325p AD=0.2516p PS=1.805u PD=2.16u rfmode=0
M$15046 \$2534 \$2511 \$2512 VSS|anode|cathode|vss sg13_lv_nmos L=0.13u W=0.42u
+ AS=0.1428p AD=0.12665p PS=1.52u PD=1.145u rfmode=0
M$15047 \$2512 \$2510 \$2521 VSS|anode|cathode|vss sg13_lv_nmos L=0.13u W=0.74u
+ AS=0.12665p AD=0.3473p PS=1.145u PD=2.71u rfmode=0
M$15048 \$2534 \$2513 VSS|anode|cathode|vss VSS|anode|cathode|vss sg13_lv_nmos
+ L=0.13u W=0.42u AS=0.1428p AD=0.0798p PS=1.52u PD=0.8u rfmode=0
M$15049 VSS|anode|cathode|vss \$2498 \$2544 VSS|anode|cathode|vss sg13_lv_nmos
+ L=0.13u W=0.42u AS=0.0798p AD=0.0378p PS=0.8u PD=0.6u rfmode=0
M$15050 \$2544 \$2512 \$2513 VSS|anode|cathode|vss sg13_lv_nmos L=0.13u W=0.42u
+ AS=0.0378p AD=0.1428p PS=0.6u PD=1.52u rfmode=0
M$15051 \$2503 \$2512 VSS|anode|cathode|vss VSS|anode|cathode|vss sg13_lv_nmos
+ L=0.13u W=0.74u AS=0.2516p AD=0.1406p PS=2.16u PD=1.12u rfmode=0
M$15052 VSS|anode|cathode|vss \$2503 \$2393 VSS|anode|cathode|vss sg13_lv_nmos
+ L=0.13u W=0.74u AS=0.1406p AD=0.2516p PS=1.12u PD=2.16u rfmode=0
M$15053 VSS|anode|cathode|vss \$2400 \$2370 VSS|anode|cathode|vss sg13_lv_nmos
+ L=0.13u W=0.74u AS=0.2516p AD=0.2516p PS=2.16u PD=2.16u rfmode=0
M$15054 VSS|anode|cathode|vss \$2431 \$2547 VSS|anode|cathode|vss sg13_lv_nmos
+ L=0.13u W=0.74u AS=0.2516p AD=0.1406p PS=2.16u PD=1.12u rfmode=0
M$15055 \$2547 \$2532 \$2504 VSS|anode|cathode|vss sg13_lv_nmos L=0.13u W=0.74u
+ AS=0.1406p AD=0.2516p PS=1.12u PD=2.16u rfmode=0
M$15056 \$2535 \$2532 VSS|anode|cathode|vss VSS|anode|cathode|vss sg13_lv_nmos
+ L=0.15u W=0.74u AS=0.2516p AD=0.1406p PS=2.16u PD=1.12u rfmode=0
M$15057 VSS|anode|cathode|vss \$2586 \$2535 VSS|anode|cathode|vss sg13_lv_nmos
+ L=0.15u W=0.74u AS=0.1406p AD=0.1406p PS=1.12u PD=1.12u rfmode=0
M$15058 \$2535 \$2504 \$2505 VSS|anode|cathode|vss sg13_lv_nmos L=0.15u W=0.74u
+ AS=0.1406p AD=0.2516p PS=1.12u PD=2.16u rfmode=0
M$15059 VSS|anode|cathode|vss \$2506 \$2522 VSS|anode|cathode|vss sg13_lv_nmos
+ L=0.13u W=0.74u AS=0.1626p AD=0.2516p PS=1.415u PD=2.16u rfmode=0
M$15060 \$2499 \$2505 \$2546 VSS|anode|cathode|vss sg13_lv_nmos L=0.13u W=0.42u
+ AS=0.1428p AD=0.0609p PS=1.52u PD=0.71u rfmode=0
M$15061 VSS|anode|cathode|vss \$2434 \$2546 VSS|anode|cathode|vss sg13_lv_nmos
+ L=0.13u W=0.42u AS=0.1626p AD=0.0609p PS=1.415u PD=0.71u rfmode=0
M$15062 VSS|anode|cathode|vss \$2434 \$2545 VSS|anode|cathode|vss sg13_lv_nmos
+ L=0.13u W=0.42u AS=0.1701p AD=0.0378p PS=1.65u PD=0.6u rfmode=0
M$15063 \$2545 \$2522 \$2533 VSS|anode|cathode|vss sg13_lv_nmos L=0.13u W=0.42u
+ AS=0.0378p AD=0.1428p PS=0.6u PD=1.52u rfmode=0
M$15064 \$2499 \$2515 \$2506 VSS|anode|cathode|vss sg13_lv_nmos L=0.13u W=0.42u
+ AS=0.1296p AD=0.0798p PS=1.52u PD=0.8u rfmode=0
M$15065 \$2506 \$2514 \$2533 VSS|anode|cathode|vss sg13_lv_nmos L=0.13u W=0.42u
+ AS=0.0798p AD=0.2373p PS=0.8u PD=1.97u rfmode=0
M$15066 \$2514 \$2515 VSS|anode|cathode|vss VSS|anode|cathode|vss sg13_lv_nmos
+ L=0.13u W=0.74u AS=0.2516p AD=0.317325p PS=2.16u PD=1.805u rfmode=0
M$15067 VSS|anode|cathode|vss \$2530 \$2515 VSS|anode|cathode|vss sg13_lv_nmos
+ L=0.13u W=0.74u AS=0.317325p AD=0.2516p PS=1.805u PD=2.16u rfmode=0
M$15068 \$2536 \$2515 \$2516 VSS|anode|cathode|vss sg13_lv_nmos L=0.13u W=0.42u
+ AS=0.1428p AD=0.12665p PS=1.52u PD=1.145u rfmode=0
M$15069 \$2516 \$2514 \$2522 VSS|anode|cathode|vss sg13_lv_nmos L=0.13u W=0.74u
+ AS=0.12665p AD=0.3473p PS=1.145u PD=2.71u rfmode=0
M$15070 \$2536 \$2517 VSS|anode|cathode|vss VSS|anode|cathode|vss sg13_lv_nmos
+ L=0.13u W=0.42u AS=0.1428p AD=0.0798p PS=1.52u PD=0.8u rfmode=0
M$15071 VSS|anode|cathode|vss \$2434 \$2548 VSS|anode|cathode|vss sg13_lv_nmos
+ L=0.13u W=0.42u AS=0.0798p AD=0.0378p PS=0.8u PD=0.6u rfmode=0
M$15072 \$2548 \$2516 \$2517 VSS|anode|cathode|vss sg13_lv_nmos L=0.13u W=0.42u
+ AS=0.0378p AD=0.1428p PS=0.6u PD=1.52u rfmode=0
M$15073 \$2507 \$2516 VSS|anode|cathode|vss VSS|anode|cathode|vss sg13_lv_nmos
+ L=0.13u W=0.74u AS=0.2516p AD=0.1406p PS=2.16u PD=1.12u rfmode=0
M$15074 VSS|anode|cathode|vss \$2507 \$2532 VSS|anode|cathode|vss sg13_lv_nmos
+ L=0.13u W=0.74u AS=0.1406p AD=0.2516p PS=1.12u PD=2.16u rfmode=0
M$15077 VSS|anode|cathode|vss \$2097 \$2508 VSS|anode|cathode|vss sg13_lv_nmos
+ L=0.13u W=0.55u AS=0.14875p AD=0.187p PS=1.16u PD=1.78u rfmode=0
M$15078 \$2390 \$2508 VSS|anode|cathode|vss VSS|anode|cathode|vss sg13_lv_nmos
+ L=0.13u W=0.74u AS=0.2886p AD=0.14875p PS=2.26u PD=1.16u rfmode=0
M$15081 \$2438 \$2440 \$2482 VSS|anode|cathode|vss sg13_lv_nmos L=0.13u W=0.42u
+ AS=0.1296p AD=0.0798p PS=1.52u PD=0.8u rfmode=0
M$15082 \$2482 \$2456 \$2455 VSS|anode|cathode|vss sg13_lv_nmos L=0.13u W=0.42u
+ AS=0.0798p AD=0.2373p PS=0.8u PD=1.97u rfmode=0
M$15084 VSS|anode|cathode|vss \$2098 \$2509 VSS|anode|cathode|vss sg13_lv_nmos
+ L=0.13u W=0.74u AS=0.2516p AD=0.2516p PS=2.16u PD=2.16u rfmode=0
M$15135 VSS|anode|cathode|vss \$2205 \$2551 VSS|anode|cathode|vss sg13_lv_nmos
+ L=0.13u W=0.74u AS=0.2516p AD=0.2516p PS=2.16u PD=2.16u rfmode=0
M$15136 \$2565 \$2500 \$2577 VSS|anode|cathode|vss sg13_lv_nmos L=0.13u W=0.42u
+ AS=0.1428p AD=0.0609p PS=1.52u PD=0.71u rfmode=0
M$15137 \$2577 \$2551 VSS|anode|cathode|vss VSS|anode|cathode|vss sg13_lv_nmos
+ L=0.13u W=0.42u AS=0.0609p AD=0.1626p PS=0.71u PD=1.415u rfmode=0
M$15138 VSS|anode|cathode|vss \$2583 \$2549 VSS|anode|cathode|vss sg13_lv_nmos
+ L=0.13u W=0.74u AS=0.1626p AD=0.2516p PS=1.415u PD=2.16u rfmode=0
M$15139 VSS|anode|cathode|vss \$2551 \$2576 VSS|anode|cathode|vss sg13_lv_nmos
+ L=0.13u W=0.42u AS=0.1701p AD=0.0378p PS=1.65u PD=0.6u rfmode=0
M$15140 \$2576 \$2549 \$2564 VSS|anode|cathode|vss sg13_lv_nmos L=0.13u W=0.42u
+ AS=0.0378p AD=0.1428p PS=0.6u PD=1.52u rfmode=0
M$15141 VSS|anode|cathode|vss \$2552 \$2566 VSS|anode|cathode|vss sg13_lv_nmos
+ L=0.13u W=0.74u AS=0.317325p AD=0.2516p PS=1.805u PD=2.16u rfmode=0
M$15142 VSS|anode|cathode|vss \$2247 \$2552 VSS|anode|cathode|vss sg13_lv_nmos
+ L=0.13u W=0.74u AS=0.317325p AD=0.2516p PS=1.805u PD=2.16u rfmode=0
M$15143 \$2567 \$2552 \$2553 VSS|anode|cathode|vss sg13_lv_nmos L=0.13u W=0.42u
+ AS=0.12665p AD=0.1428p PS=1.145u PD=1.52u rfmode=0
M$15144 \$2549 \$2566 \$2567 VSS|anode|cathode|vss sg13_lv_nmos L=0.13u W=0.74u
+ AS=0.3473p AD=0.12665p PS=2.71u PD=1.145u rfmode=0
M$15145 \$2553 \$2554 VSS|anode|cathode|vss VSS|anode|cathode|vss sg13_lv_nmos
+ L=0.13u W=0.42u AS=0.1428p AD=0.0798p PS=1.52u PD=0.8u rfmode=0
M$15146 VSS|anode|cathode|vss \$2551 \$2578 VSS|anode|cathode|vss sg13_lv_nmos
+ L=0.13u W=0.42u AS=0.0798p AD=0.0378p PS=0.8u PD=0.6u rfmode=0
M$15147 \$2578 \$2567 \$2554 VSS|anode|cathode|vss sg13_lv_nmos L=0.13u W=0.42u
+ AS=0.0378p AD=0.1428p PS=0.6u PD=1.52u rfmode=0
M$15148 \$2555 \$2567 VSS|anode|cathode|vss VSS|anode|cathode|vss sg13_lv_nmos
+ L=0.13u W=0.74u AS=0.2516p AD=0.1406p PS=2.16u PD=1.12u rfmode=0
M$15149 VSS|anode|cathode|vss \$2555 \$2529 VSS|anode|cathode|vss sg13_lv_nmos
+ L=0.13u W=0.74u AS=0.1406p AD=0.2516p PS=1.12u PD=2.16u rfmode=0
M$15152 VSS|anode|cathode|vss \$2248 \$2498 VSS|anode|cathode|vss sg13_lv_nmos
+ L=0.13u W=0.74u AS=0.2516p AD=0.2516p PS=2.16u PD=2.16u rfmode=0
M$15155 VSS|anode|cathode|vss \$2584 \$2556 VSS|anode|cathode|vss sg13_lv_nmos
+ L=0.13u W=0.74u AS=0.2516p AD=0.1406p PS=2.16u PD=1.12u rfmode=0
M$15156 \$2556 \$2585 VSS|anode|cathode|vss VSS|anode|cathode|vss sg13_lv_nmos
+ L=0.13u W=0.74u AS=0.1406p AD=0.2516p PS=1.12u PD=2.16u rfmode=0
M$15157 VSS|anode|cathode|vss \$2613 \$2520 VSS|anode|cathode|vss sg13_lv_nmos
+ L=0.13u W=0.77u AS=0.2618p AD=0.1694p PS=2.22u PD=1.21u rfmode=0
M$15158 \$2520 \$2585 VSS|anode|cathode|vss VSS|anode|cathode|vss sg13_lv_nmos
+ L=0.13u W=0.77u AS=0.1694p AD=0.1463p PS=1.21u PD=1.15u rfmode=0
M$15159 VSS|anode|cathode|vss \$2586 \$2520 VSS|anode|cathode|vss sg13_lv_nmos
+ L=0.13u W=0.77u AS=0.1463p AD=0.2618p PS=1.15u PD=2.22u rfmode=0
M$15160 VSS|anode|cathode|vss \$2586 \$2557 VSS|anode|cathode|vss sg13_lv_nmos
+ L=0.13u W=0.55u AS=0.187p AD=0.1045p PS=1.78u PD=0.93u rfmode=0
M$15161 \$2557 \$2568 VSS|anode|cathode|vss VSS|anode|cathode|vss sg13_lv_nmos
+ L=0.13u W=0.55u AS=0.1045p AD=0.1469p PS=0.93u PD=1.155u rfmode=0
M$15162 VSS|anode|cathode|vss \$2557 \$2584 VSS|anode|cathode|vss sg13_lv_nmos
+ L=0.13u W=0.74u AS=0.1469p AD=0.2516p PS=1.155u PD=2.16u rfmode=0
M$15163 VSS|anode|cathode|vss \$2568 \$2558 VSS|anode|cathode|vss sg13_lv_nmos
+ L=0.13u W=0.74u AS=0.2516p AD=0.1406p PS=2.16u PD=1.12u rfmode=0
M$15164 \$2558 \$2586 VSS|anode|cathode|vss VSS|anode|cathode|vss sg13_lv_nmos
+ L=0.13u W=0.74u AS=0.1406p AD=0.2516p PS=1.12u PD=2.16u rfmode=0
M$15167 \$2586 \$2569 VSS|anode|cathode|vss VSS|anode|cathode|vss sg13_lv_nmos
+ L=0.13u W=0.74u AS=0.2886p AD=0.14875p PS=2.26u PD=1.16u rfmode=0
M$15168 VSS|anode|cathode|vss \$2379 \$2569 VSS|anode|cathode|vss sg13_lv_nmos
+ L=0.13u W=0.55u AS=0.14875p AD=0.187p PS=1.16u PD=1.78u rfmode=0
M$15173 \$2530 \$2570 VSS|anode|cathode|vss VSS|anode|cathode|vss sg13_lv_nmos
+ L=0.13u W=0.74u AS=0.2886p AD=0.14875p PS=2.26u PD=1.16u rfmode=0
M$15174 VSS|anode|cathode|vss \$2099 \$2570 VSS|anode|cathode|vss sg13_lv_nmos
+ L=0.13u W=0.55u AS=0.14875p AD=0.187p PS=1.16u PD=1.78u rfmode=0
M$15180 VSS|anode|cathode|vss \$2520 \$2559 VSS|anode|cathode|vss sg13_lv_nmos
+ L=0.13u W=0.74u AS=0.2516p AD=0.1406p PS=2.16u PD=1.12u rfmode=0
M$15181 \$2559 \$2587 VSS|anode|cathode|vss VSS|anode|cathode|vss sg13_lv_nmos
+ L=0.13u W=0.74u AS=0.1406p AD=0.2516p PS=1.12u PD=2.16u rfmode=0
M$15182 VSS|anode|cathode|vss \$2106 \$2580 VSS|anode|cathode|vss sg13_lv_nmos
+ L=0.13u W=0.74u AS=0.2516p AD=0.1406p PS=2.16u PD=1.12u rfmode=0
M$15183 \$2580 \$2520 \$2571 VSS|anode|cathode|vss sg13_lv_nmos L=0.13u W=0.74u
+ AS=0.1406p AD=0.1406p PS=1.12u PD=1.12u rfmode=0
M$15184 \$2571 \$2559 VSS|anode|cathode|vss VSS|anode|cathode|vss sg13_lv_nmos
+ L=0.13u W=0.74u AS=0.1406p AD=0.2516p PS=1.12u PD=2.16u rfmode=0
M$15185 \$2573 \$2571 \$2579 VSS|anode|cathode|vss sg13_lv_nmos L=0.13u W=0.42u
+ AS=0.1428p AD=0.0609p PS=1.52u PD=0.71u rfmode=0
M$15186 \$2579 \$2509 VSS|anode|cathode|vss VSS|anode|cathode|vss sg13_lv_nmos
+ L=0.13u W=0.42u AS=0.0609p AD=0.1626p PS=0.71u PD=1.415u rfmode=0
M$15187 VSS|anode|cathode|vss \$2588 \$2550 VSS|anode|cathode|vss sg13_lv_nmos
+ L=0.13u W=0.74u AS=0.1626p AD=0.2516p PS=1.415u PD=2.16u rfmode=0
M$15188 VSS|anode|cathode|vss \$2509 \$2581 VSS|anode|cathode|vss sg13_lv_nmos
+ L=0.13u W=0.42u AS=0.1701p AD=0.0378p PS=1.65u PD=0.6u rfmode=0
M$15189 \$2581 \$2550 \$2572 VSS|anode|cathode|vss sg13_lv_nmos L=0.13u W=0.42u
+ AS=0.0378p AD=0.1428p PS=0.6u PD=1.52u rfmode=0
M$15190 VSS|anode|cathode|vss \$2560 \$2574 VSS|anode|cathode|vss sg13_lv_nmos
+ L=0.13u W=0.74u AS=0.317325p AD=0.2516p PS=1.805u PD=2.16u rfmode=0
M$15191 VSS|anode|cathode|vss \$2256 \$2560 VSS|anode|cathode|vss sg13_lv_nmos
+ L=0.13u W=0.74u AS=0.317325p AD=0.2516p PS=1.805u PD=2.16u rfmode=0
M$15192 \$2575 \$2560 \$2561 VSS|anode|cathode|vss sg13_lv_nmos L=0.13u W=0.42u
+ AS=0.12665p AD=0.1428p PS=1.145u PD=1.52u rfmode=0
M$15193 \$2550 \$2574 \$2575 VSS|anode|cathode|vss sg13_lv_nmos L=0.13u W=0.74u
+ AS=0.3473p AD=0.12665p PS=2.71u PD=1.145u rfmode=0
M$15194 \$2561 \$2562 VSS|anode|cathode|vss VSS|anode|cathode|vss sg13_lv_nmos
+ L=0.13u W=0.42u AS=0.1428p AD=0.0798p PS=1.52u PD=0.8u rfmode=0
M$15195 VSS|anode|cathode|vss \$2509 \$2582 VSS|anode|cathode|vss sg13_lv_nmos
+ L=0.13u W=0.42u AS=0.0798p AD=0.0378p PS=0.8u PD=0.6u rfmode=0
M$15196 \$2582 \$2575 \$2562 VSS|anode|cathode|vss sg13_lv_nmos L=0.13u W=0.42u
+ AS=0.0378p AD=0.1428p PS=0.6u PD=1.52u rfmode=0
M$15197 \$2563 \$2575 VSS|anode|cathode|vss VSS|anode|cathode|vss sg13_lv_nmos
+ L=0.13u W=0.74u AS=0.2516p AD=0.1406p PS=2.16u PD=1.12u rfmode=0
M$15198 VSS|anode|cathode|vss \$2563 \$2587 VSS|anode|cathode|vss sg13_lv_nmos
+ L=0.13u W=0.74u AS=0.1406p AD=0.2516p PS=1.12u PD=2.16u rfmode=0
M$15222 VSS|anode|cathode|vss \$2529 \$2608 VSS|anode|cathode|vss sg13_lv_nmos
+ L=0.13u W=0.55u AS=0.14875p AD=0.187p PS=1.16u PD=1.78u rfmode=0
M$15223 \$884 \$2608 VSS|anode|cathode|vss VSS|anode|cathode|vss sg13_lv_nmos
+ L=0.13u W=0.74u AS=0.2886p AD=0.14875p PS=2.26u PD=1.16u rfmode=0
M$15238 VSS|anode|cathode|vss \$2631 \$2609 VSS|anode|cathode|vss sg13_lv_nmos
+ L=0.13u W=0.74u AS=0.2516p AD=0.1406p PS=2.16u PD=1.12u rfmode=0
M$15239 \$2609 \$2131 \$2662 VSS|anode|cathode|vss sg13_lv_nmos L=0.13u W=0.74u
+ AS=0.1406p AD=0.1406p PS=1.12u PD=1.12u rfmode=0
M$15240 \$2662 \$2106 VSS|anode|cathode|vss VSS|anode|cathode|vss sg13_lv_nmos
+ L=0.13u W=0.74u AS=0.1406p AD=0.2516p PS=1.12u PD=2.16u rfmode=0
M$15249 \$2565 \$2552 \$2583 VSS|anode|cathode|vss sg13_lv_nmos L=0.13u W=0.42u
+ AS=0.1296p AD=0.0798p PS=1.52u PD=0.8u rfmode=0
M$15250 \$2583 \$2566 \$2564 VSS|anode|cathode|vss sg13_lv_nmos L=0.13u W=0.42u
+ AS=0.0798p AD=0.2373p PS=0.8u PD=1.97u rfmode=0
M$15252 \$2624 \$2520 VSS|anode|cathode|vss VSS|anode|cathode|vss sg13_lv_nmos
+ L=0.13u W=0.55u AS=0.187p AD=0.14505p PS=1.78u PD=1.15u rfmode=0
M$15253 VSS|anode|cathode|vss \$2645 \$2663 VSS|anode|cathode|vss sg13_lv_nmos
+ L=0.13u W=0.74u AS=0.14505p AD=0.1406p PS=1.15u PD=1.12u rfmode=0
M$15254 \$2663 \$2624 \$2611 VSS|anode|cathode|vss sg13_lv_nmos L=0.13u W=0.74u
+ AS=0.1406p AD=0.333p PS=1.12u PD=2.38u rfmode=0
M$15255 VSS|anode|cathode|vss \$2605 \$2664 VSS|anode|cathode|vss sg13_lv_nmos
+ L=0.13u W=0.42u AS=0.1701p AD=0.0378p PS=1.65u PD=0.6u rfmode=0
M$15256 \$2664 \$2632 \$2646 VSS|anode|cathode|vss sg13_lv_nmos L=0.13u W=0.42u
+ AS=0.0378p AD=0.1428p PS=0.6u PD=1.52u rfmode=0
M$15257 \$2604 \$2633 \$2625 VSS|anode|cathode|vss sg13_lv_nmos L=0.13u W=0.42u
+ AS=0.1296p AD=0.0798p PS=1.52u PD=0.8u rfmode=0
M$15258 \$2625 \$2626 \$2646 VSS|anode|cathode|vss sg13_lv_nmos L=0.13u W=0.42u
+ AS=0.0798p AD=0.2373p PS=0.8u PD=1.97u rfmode=0
M$15259 \$2626 \$2633 VSS|anode|cathode|vss VSS|anode|cathode|vss sg13_lv_nmos
+ L=0.13u W=0.74u AS=0.2516p AD=0.317325p PS=2.16u PD=1.805u rfmode=0
M$15260 VSS|anode|cathode|vss \$2530 \$2633 VSS|anode|cathode|vss sg13_lv_nmos
+ L=0.13u W=0.74u AS=0.317325p AD=0.2516p PS=1.805u PD=2.16u rfmode=0
M$15261 \$2652 \$2633 \$2634 VSS|anode|cathode|vss sg13_lv_nmos L=0.13u W=0.42u
+ AS=0.1428p AD=0.12665p PS=1.52u PD=1.145u rfmode=0
M$15262 \$2634 \$2626 \$2632 VSS|anode|cathode|vss sg13_lv_nmos L=0.13u W=0.74u
+ AS=0.12665p AD=0.3473p PS=1.145u PD=2.71u rfmode=0
M$15263 \$2612 \$2634 VSS|anode|cathode|vss VSS|anode|cathode|vss sg13_lv_nmos
+ L=0.13u W=0.74u AS=0.2516p AD=0.1406p PS=2.16u PD=1.12u rfmode=0
M$15264 VSS|anode|cathode|vss \$2612 \$2613 VSS|anode|cathode|vss sg13_lv_nmos
+ L=0.13u W=0.74u AS=0.1406p AD=0.2516p PS=1.12u PD=2.16u rfmode=0
M$15265 VSS|anode|cathode|vss \$2431 \$2669 VSS|anode|cathode|vss sg13_lv_nmos
+ L=0.13u W=0.74u AS=0.2553p AD=0.13875p PS=2.17u PD=1.115u rfmode=0
M$15266 \$2669 \$2613 \$2645 VSS|anode|cathode|vss sg13_lv_nmos L=0.13u W=0.74u
+ AS=0.13875p AD=0.2664p PS=1.115u PD=1.46u rfmode=0
M$15267 \$2645 \$2585 \$2668 VSS|anode|cathode|vss sg13_lv_nmos L=0.13u W=0.74u
+ AS=0.2664p AD=0.0962p PS=1.46u PD=1u rfmode=0
M$15268 \$2668 \$2558 VSS|anode|cathode|vss VSS|anode|cathode|vss sg13_lv_nmos
+ L=0.13u W=0.74u AS=0.0962p AD=0.2516p PS=1u PD=2.16u rfmode=0
M$15269 \$2585 \$2647 \$2667 VSS|anode|cathode|vss sg13_lv_nmos L=0.13u W=0.74u
+ AS=0.2516p AD=0.1406p PS=2.16u PD=1.12u rfmode=0
M$15270 \$2667 \$2532 VSS|anode|cathode|vss VSS|anode|cathode|vss sg13_lv_nmos
+ L=0.13u W=0.74u AS=0.1406p AD=0.2516p PS=1.12u PD=2.16u rfmode=0
M$15271 VSS|anode|cathode|vss \$2647 \$2375 VSS|anode|cathode|vss sg13_lv_nmos
+ L=0.13u W=0.77u AS=0.2618p AD=0.1694p PS=2.22u PD=1.21u rfmode=0
M$15272 \$2375 \$2532 VSS|anode|cathode|vss VSS|anode|cathode|vss sg13_lv_nmos
+ L=0.13u W=0.77u AS=0.1694p AD=0.1463p PS=1.21u PD=1.15u rfmode=0
M$15273 VSS|anode|cathode|vss \$2584 \$2375 VSS|anode|cathode|vss sg13_lv_nmos
+ L=0.13u W=0.77u AS=0.1463p AD=0.2618p PS=1.15u PD=2.22u rfmode=0
M$15274 VSS|anode|cathode|vss \$2431 \$2670 VSS|anode|cathode|vss sg13_lv_nmos
+ L=0.13u W=0.64u AS=0.2176p AD=0.0816p PS=1.96u PD=0.895u rfmode=0
M$15275 \$2670 \$2647 \$2615 VSS|anode|cathode|vss sg13_lv_nmos L=0.13u W=0.64u
+ AS=0.0816p AD=0.1216p PS=0.895u PD=1.02u rfmode=0
M$15276 \$2615 \$2648 VSS|anode|cathode|vss VSS|anode|cathode|vss sg13_lv_nmos
+ L=0.13u W=0.64u AS=0.1216p AD=0.15745p PS=1.02u PD=1.175u rfmode=0
M$15277 VSS|anode|cathode|vss \$2615 \$2616 VSS|anode|cathode|vss sg13_lv_nmos
+ L=0.13u W=0.74u AS=0.15745p AD=0.2351p PS=1.175u PD=2.16u rfmode=0
M$15278 \$2617 \$2098 VSS|anode|cathode|vss VSS|anode|cathode|vss sg13_lv_nmos
+ L=0.13u W=0.74u AS=0.2516p AD=0.2516p PS=2.16u PD=2.16u rfmode=0
M$15279 VSS|anode|cathode|vss \$2617 \$2672 VSS|anode|cathode|vss sg13_lv_nmos
+ L=0.13u W=0.42u AS=0.1701p AD=0.0378p PS=1.65u PD=0.6u rfmode=0
M$15280 \$2672 \$2636 \$2649 VSS|anode|cathode|vss sg13_lv_nmos L=0.13u W=0.42u
+ AS=0.0378p AD=0.1428p PS=0.6u PD=1.52u rfmode=0
M$15281 \$2607 \$2637 \$2627 VSS|anode|cathode|vss sg13_lv_nmos L=0.13u W=0.42u
+ AS=0.1296p AD=0.0798p PS=1.52u PD=0.8u rfmode=0
M$15282 \$2627 \$2628 \$2649 VSS|anode|cathode|vss sg13_lv_nmos L=0.13u W=0.42u
+ AS=0.0798p AD=0.2373p PS=0.8u PD=1.97u rfmode=0
M$15283 \$2628 \$2637 VSS|anode|cathode|vss VSS|anode|cathode|vss sg13_lv_nmos
+ L=0.13u W=0.74u AS=0.2516p AD=0.317325p PS=2.16u PD=1.805u rfmode=0
M$15284 VSS|anode|cathode|vss \$2530 \$2637 VSS|anode|cathode|vss sg13_lv_nmos
+ L=0.13u W=0.74u AS=0.317325p AD=0.2516p PS=1.805u PD=2.16u rfmode=0
M$15285 \$2653 \$2637 \$2638 VSS|anode|cathode|vss sg13_lv_nmos L=0.13u W=0.42u
+ AS=0.1428p AD=0.12665p PS=1.52u PD=1.145u rfmode=0
M$15286 \$2638 \$2628 \$2636 VSS|anode|cathode|vss sg13_lv_nmos L=0.13u W=0.74u
+ AS=0.12665p AD=0.3473p PS=1.145u PD=2.71u rfmode=0
M$15287 \$2618 \$2638 VSS|anode|cathode|vss VSS|anode|cathode|vss sg13_lv_nmos
+ L=0.13u W=0.74u AS=0.2516p AD=0.1406p PS=2.16u PD=1.12u rfmode=0
M$15288 VSS|anode|cathode|vss \$2618 \$2647 VSS|anode|cathode|vss sg13_lv_nmos
+ L=0.13u W=0.74u AS=0.1406p AD=0.2516p PS=1.12u PD=2.16u rfmode=0
M$15289 VSS|anode|cathode|vss \$2650 \$2619 VSS|anode|cathode|vss sg13_lv_nmos
+ L=0.13u W=0.74u AS=0.2516p AD=0.1406p PS=2.16u PD=1.12u rfmode=0
M$15290 \$2619 \$2520 VSS|anode|cathode|vss VSS|anode|cathode|vss sg13_lv_nmos
+ L=0.13u W=0.74u AS=0.1406p AD=0.2516p PS=1.12u PD=2.16u rfmode=0
M$15291 VSS|anode|cathode|vss \$2619 \$2620 VSS|anode|cathode|vss sg13_lv_nmos
+ L=0.13u W=0.74u AS=0.2516p AD=0.1406p PS=2.16u PD=1.12u rfmode=0
M$15292 \$2620 \$2520 \$2674 VSS|anode|cathode|vss sg13_lv_nmos L=0.13u W=0.74u
+ AS=0.1406p AD=0.1406p PS=1.12u PD=1.12u rfmode=0
M$15293 \$2674 \$2106 VSS|anode|cathode|vss VSS|anode|cathode|vss sg13_lv_nmos
+ L=0.13u W=0.74u AS=0.1406p AD=0.2516p PS=1.12u PD=2.16u rfmode=0
M$15298 \$2573 \$2560 \$2588 VSS|anode|cathode|vss sg13_lv_nmos L=0.13u W=0.42u
+ AS=0.1296p AD=0.0798p PS=1.52u PD=0.8u rfmode=0
M$15299 \$2588 \$2574 \$2572 VSS|anode|cathode|vss sg13_lv_nmos L=0.13u W=0.42u
+ AS=0.0798p AD=0.2373p PS=0.8u PD=1.97u rfmode=0
M$15306 VSS|anode|cathode|vss \$2651 \$2622 VSS|anode|cathode|vss sg13_lv_nmos
+ L=0.13u W=0.74u AS=0.2516p AD=0.2516p PS=2.16u PD=2.16u rfmode=0
M$15327 \$2623 \$2587 VSS|anode|cathode|vss VSS|anode|cathode|vss sg13_lv_nmos
+ L=0.13u W=0.55u AS=0.187p AD=0.14875p PS=1.78u PD=1.16u rfmode=0
M$15328 VSS|anode|cathode|vss \$2623 \$890 VSS|anode|cathode|vss sg13_lv_nmos
+ L=0.13u W=0.74u AS=0.14875p AD=0.2886p PS=1.16u PD=2.26u rfmode=0
M$15343 VSS|anode|cathode|vss \$2205 \$2725 VSS|anode|cathode|vss sg13_lv_nmos
+ L=0.13u W=0.74u AS=0.2516p AD=0.2516p PS=2.16u PD=2.16u rfmode=0
M$15344 \$2682 \$2609 \$2709 VSS|anode|cathode|vss sg13_lv_nmos L=0.13u W=0.42u
+ AS=0.1428p AD=0.0609p PS=1.52u PD=0.71u rfmode=0
M$15345 \$2709 \$2725 VSS|anode|cathode|vss VSS|anode|cathode|vss sg13_lv_nmos
+ L=0.13u W=0.42u AS=0.0609p AD=0.1626p PS=0.71u PD=1.415u rfmode=0
M$15346 VSS|anode|cathode|vss \$2724 \$2675 VSS|anode|cathode|vss sg13_lv_nmos
+ L=0.13u W=0.74u AS=0.1626p AD=0.2516p PS=1.415u PD=2.16u rfmode=0
M$15347 VSS|anode|cathode|vss \$2725 \$2710 VSS|anode|cathode|vss sg13_lv_nmos
+ L=0.13u W=0.42u AS=0.1701p AD=0.0378p PS=1.65u PD=0.6u rfmode=0
M$15348 \$2710 \$2675 \$2683 VSS|anode|cathode|vss sg13_lv_nmos L=0.13u W=0.42u
+ AS=0.0378p AD=0.1428p PS=0.6u PD=1.52u rfmode=0
M$15349 \$2703 \$2676 \$2684 VSS|anode|cathode|vss sg13_lv_nmos L=0.13u W=0.42u
+ AS=0.12665p AD=0.1428p PS=1.145u PD=1.52u rfmode=0
M$15350 \$2675 \$2732 \$2703 VSS|anode|cathode|vss sg13_lv_nmos L=0.13u W=0.74u
+ AS=0.3473p AD=0.12665p PS=2.71u PD=1.145u rfmode=0
M$15351 \$2684 \$2685 VSS|anode|cathode|vss VSS|anode|cathode|vss sg13_lv_nmos
+ L=0.13u W=0.42u AS=0.1428p AD=0.0798p PS=1.52u PD=0.8u rfmode=0
M$15352 VSS|anode|cathode|vss \$2725 \$2711 VSS|anode|cathode|vss sg13_lv_nmos
+ L=0.13u W=0.42u AS=0.0798p AD=0.0378p PS=0.8u PD=0.6u rfmode=0
M$15353 \$2711 \$2703 \$2685 VSS|anode|cathode|vss sg13_lv_nmos L=0.13u W=0.42u
+ AS=0.0378p AD=0.1428p PS=0.6u PD=1.52u rfmode=0
M$15354 \$2686 \$2703 VSS|anode|cathode|vss VSS|anode|cathode|vss sg13_lv_nmos
+ L=0.13u W=0.74u AS=0.2516p AD=0.1406p PS=2.16u PD=1.12u rfmode=0
M$15355 VSS|anode|cathode|vss \$2686 \$2687 VSS|anode|cathode|vss sg13_lv_nmos
+ L=0.13u W=0.74u AS=0.1406p AD=0.2516p PS=1.12u PD=2.16u rfmode=0
M$15359 VSS|anode|cathode|vss \$2625 \$2632 VSS|anode|cathode|vss sg13_lv_nmos
+ L=0.13u W=0.74u AS=0.1626p AD=0.2516p PS=1.415u PD=2.16u rfmode=0
M$15360 \$2604 \$2611 \$2665 VSS|anode|cathode|vss sg13_lv_nmos L=0.13u W=0.42u
+ AS=0.1428p AD=0.0609p PS=1.52u PD=0.71u rfmode=0
M$15361 VSS|anode|cathode|vss \$2605 \$2665 VSS|anode|cathode|vss sg13_lv_nmos
+ L=0.13u W=0.42u AS=0.1626p AD=0.0609p PS=1.415u PD=0.71u rfmode=0
M$15362 VSS|anode|cathode|vss \$2248 \$2605 VSS|anode|cathode|vss sg13_lv_nmos
+ L=0.13u W=0.74u AS=0.2516p AD=0.2516p PS=2.16u PD=2.16u rfmode=0
M$15369 \$2652 \$2635 VSS|anode|cathode|vss VSS|anode|cathode|vss sg13_lv_nmos
+ L=0.13u W=0.42u AS=0.1428p AD=0.0798p PS=1.52u PD=0.8u rfmode=0
M$15370 VSS|anode|cathode|vss \$2605 \$2666 VSS|anode|cathode|vss sg13_lv_nmos
+ L=0.13u W=0.42u AS=0.0798p AD=0.0378p PS=0.8u PD=0.6u rfmode=0
M$15371 \$2666 \$2634 \$2635 VSS|anode|cathode|vss sg13_lv_nmos L=0.13u W=0.42u
+ AS=0.0378p AD=0.1428p PS=0.6u PD=1.52u rfmode=0
M$15372 VSS|anode|cathode|vss \$2568 \$2131 VSS|anode|cathode|vss sg13_lv_nmos
+ L=0.13u W=0.77u AS=0.2618p AD=0.1694p PS=2.22u PD=1.21u rfmode=0
M$15373 \$2131 \$2586 VSS|anode|cathode|vss VSS|anode|cathode|vss sg13_lv_nmos
+ L=0.13u W=0.77u AS=0.1694p AD=0.1463p PS=1.21u PD=1.15u rfmode=0
M$15374 VSS|anode|cathode|vss \$2728 \$2131 VSS|anode|cathode|vss sg13_lv_nmos
+ L=0.13u W=0.77u AS=0.1463p AD=0.2618p PS=1.15u PD=2.22u rfmode=0
M$15375 VSS|anode|cathode|vss \$2613 \$2727 VSS|anode|cathode|vss sg13_lv_nmos
+ L=0.13u W=0.77u AS=0.2618p AD=0.1694p PS=2.22u PD=1.21u rfmode=0
M$15376 \$2727 \$2379 VSS|anode|cathode|vss VSS|anode|cathode|vss sg13_lv_nmos
+ L=0.13u W=0.77u AS=0.1694p AD=0.1463p PS=1.21u PD=1.15u rfmode=0
M$15377 VSS|anode|cathode|vss \$2728 \$2727 VSS|anode|cathode|vss sg13_lv_nmos
+ L=0.13u W=0.77u AS=0.1463p AD=0.2618p PS=1.15u PD=2.22u rfmode=0
M$15378 \$2728 \$2704 \$2713 VSS|anode|cathode|vss sg13_lv_nmos L=0.13u W=0.74u
+ AS=0.333p AD=0.1406p PS=2.38u PD=1.12u rfmode=0
M$15379 \$2713 \$2647 VSS|anode|cathode|vss VSS|anode|cathode|vss sg13_lv_nmos
+ L=0.13u W=0.74u AS=0.1406p AD=0.14505p PS=1.12u PD=1.15u rfmode=0
M$15380 VSS|anode|cathode|vss \$2532 \$2704 VSS|anode|cathode|vss sg13_lv_nmos
+ L=0.13u W=0.55u AS=0.14505p AD=0.187p PS=1.15u PD=1.78u rfmode=0
M$15381 VSS|anode|cathode|vss \$2647 \$2705 VSS|anode|cathode|vss sg13_lv_nmos
+ L=0.13u W=0.55u AS=0.14505p AD=0.187p PS=1.15u PD=1.78u rfmode=0
M$15382 VSS|anode|cathode|vss \$2532 \$2714 VSS|anode|cathode|vss sg13_lv_nmos
+ L=0.13u W=0.74u AS=0.14505p AD=0.1406p PS=1.15u PD=1.12u rfmode=0
M$15383 \$2714 \$2705 \$2689 VSS|anode|cathode|vss sg13_lv_nmos L=0.13u W=0.74u
+ AS=0.1406p AD=0.333p PS=1.12u PD=2.38u rfmode=0
M$15384 VSS|anode|cathode|vss \$2689 \$2690 VSS|anode|cathode|vss sg13_lv_nmos
+ L=0.13u W=0.74u AS=0.2516p AD=0.1406p PS=2.16u PD=1.12u rfmode=0
M$15385 \$2690 \$2584 VSS|anode|cathode|vss VSS|anode|cathode|vss sg13_lv_nmos
+ L=0.13u W=0.74u AS=0.1406p AD=0.2516p PS=1.12u PD=2.16u rfmode=0
M$15388 VSS|anode|cathode|vss \$2627 \$2636 VSS|anode|cathode|vss sg13_lv_nmos
+ L=0.13u W=0.74u AS=0.1626p AD=0.2516p PS=1.415u PD=2.16u rfmode=0
M$15389 \$2607 \$2616 \$2671 VSS|anode|cathode|vss sg13_lv_nmos L=0.13u W=0.42u
+ AS=0.1428p AD=0.0609p PS=1.52u PD=0.71u rfmode=0
M$15390 VSS|anode|cathode|vss \$2617 \$2671 VSS|anode|cathode|vss sg13_lv_nmos
+ L=0.13u W=0.42u AS=0.1626p AD=0.0609p PS=1.415u PD=0.71u rfmode=0
M$15395 \$2653 \$2639 VSS|anode|cathode|vss VSS|anode|cathode|vss sg13_lv_nmos
+ L=0.13u W=0.42u AS=0.1428p AD=0.0798p PS=1.52u PD=0.8u rfmode=0
M$15396 VSS|anode|cathode|vss \$2617 \$2673 VSS|anode|cathode|vss sg13_lv_nmos
+ L=0.13u W=0.42u AS=0.0798p AD=0.0378p PS=0.8u PD=0.6u rfmode=0
M$15397 \$2673 \$2638 \$2639 VSS|anode|cathode|vss sg13_lv_nmos L=0.13u W=0.42u
+ AS=0.0378p AD=0.1428p PS=0.6u PD=1.52u rfmode=0
M$15400 VSS|anode|cathode|vss \$2098 \$2730 VSS|anode|cathode|vss sg13_lv_nmos
+ L=0.13u W=0.74u AS=0.2516p AD=0.2516p PS=2.16u PD=2.16u rfmode=0
M$15401 \$2691 \$2620 \$2717 VSS|anode|cathode|vss sg13_lv_nmos L=0.13u W=0.42u
+ AS=0.1428p AD=0.0609p PS=1.52u PD=0.71u rfmode=0
M$15402 \$2717 \$2730 VSS|anode|cathode|vss VSS|anode|cathode|vss sg13_lv_nmos
+ L=0.13u W=0.42u AS=0.0609p AD=0.1626p PS=0.71u PD=1.415u rfmode=0
M$15403 VSS|anode|cathode|vss \$2729 \$2677 VSS|anode|cathode|vss sg13_lv_nmos
+ L=0.13u W=0.74u AS=0.1626p AD=0.2516p PS=1.415u PD=2.16u rfmode=0
M$15404 VSS|anode|cathode|vss \$2730 \$2716 VSS|anode|cathode|vss sg13_lv_nmos
+ L=0.13u W=0.42u AS=0.1701p AD=0.0378p PS=1.65u PD=0.6u rfmode=0
M$15405 \$2716 \$2677 \$2692 VSS|anode|cathode|vss sg13_lv_nmos L=0.13u W=0.42u
+ AS=0.0378p AD=0.1428p PS=0.6u PD=1.52u rfmode=0
M$15406 \$2706 \$2678 \$2693 VSS|anode|cathode|vss sg13_lv_nmos L=0.13u W=0.42u
+ AS=0.12665p AD=0.1428p PS=1.145u PD=1.52u rfmode=0
M$15407 \$2677 \$2735 \$2706 VSS|anode|cathode|vss sg13_lv_nmos L=0.13u W=0.74u
+ AS=0.3473p AD=0.12665p PS=2.71u PD=1.145u rfmode=0
M$15408 \$2693 \$2694 VSS|anode|cathode|vss VSS|anode|cathode|vss sg13_lv_nmos
+ L=0.13u W=0.42u AS=0.1428p AD=0.0798p PS=1.52u PD=0.8u rfmode=0
M$15409 VSS|anode|cathode|vss \$2730 \$2718 VSS|anode|cathode|vss sg13_lv_nmos
+ L=0.13u W=0.42u AS=0.0798p AD=0.0378p PS=0.8u PD=0.6u rfmode=0
M$15410 \$2718 \$2706 \$2694 VSS|anode|cathode|vss sg13_lv_nmos L=0.13u W=0.42u
+ AS=0.0378p AD=0.1428p PS=0.6u PD=1.52u rfmode=0
M$15411 \$2695 \$2706 VSS|anode|cathode|vss VSS|anode|cathode|vss sg13_lv_nmos
+ L=0.13u W=0.74u AS=0.2516p AD=0.1406p PS=2.16u PD=1.12u rfmode=0
M$15412 VSS|anode|cathode|vss \$2695 \$2650 VSS|anode|cathode|vss sg13_lv_nmos
+ L=0.13u W=0.74u AS=0.1406p AD=0.2516p PS=1.12u PD=2.16u rfmode=0
M$15413 VSS|anode|cathode|vss \$2727 \$2696 VSS|anode|cathode|vss sg13_lv_nmos
+ L=0.13u W=0.55u AS=0.18945p AD=0.187p PS=1.27u PD=1.78u rfmode=0
M$15414 VSS|anode|cathode|vss \$2727 \$2720 VSS|anode|cathode|vss sg13_lv_nmos
+ L=0.13u W=0.74u AS=0.18945p AD=0.13135p PS=1.27u PD=1.095u rfmode=0
M$15415 \$2720 \$2384 \$2679 VSS|anode|cathode|vss sg13_lv_nmos L=0.13u W=0.74u
+ AS=0.13135p AD=0.1628p PS=1.095u PD=1.18u rfmode=0
M$15416 \$2679 \$2707 \$2719 VSS|anode|cathode|vss sg13_lv_nmos L=0.13u W=0.74u
+ AS=0.1628p AD=0.3367p PS=1.18u PD=1.65u rfmode=0
M$15417 \$2719 \$2696 VSS|anode|cathode|vss VSS|anode|cathode|vss sg13_lv_nmos
+ L=0.13u W=0.74u AS=0.3367p AD=0.148p PS=1.65u PD=1.14u rfmode=0
M$15418 VSS|anode|cathode|vss \$2679 \$2697 VSS|anode|cathode|vss sg13_lv_nmos
+ L=0.13u W=0.74u AS=0.148p AD=0.4033p PS=1.14u PD=2.57u rfmode=0
M$15419 \$2698 \$2697 \$2722 VSS|anode|cathode|vss sg13_lv_nmos L=0.13u W=0.42u
+ AS=0.1428p AD=0.0609p PS=1.52u PD=0.71u rfmode=0
M$15420 \$2722 \$2622 VSS|anode|cathode|vss VSS|anode|cathode|vss sg13_lv_nmos
+ L=0.13u W=0.42u AS=0.0609p AD=0.1626p PS=0.71u PD=1.415u rfmode=0
M$15421 VSS|anode|cathode|vss \$2731 \$2680 VSS|anode|cathode|vss sg13_lv_nmos
+ L=0.13u W=0.74u AS=0.1626p AD=0.2516p PS=1.415u PD=2.16u rfmode=0
M$15422 VSS|anode|cathode|vss \$2622 \$2721 VSS|anode|cathode|vss sg13_lv_nmos
+ L=0.13u W=0.42u AS=0.1701p AD=0.0378p PS=1.65u PD=0.6u rfmode=0
M$15423 \$2721 \$2680 \$2699 VSS|anode|cathode|vss sg13_lv_nmos L=0.13u W=0.42u
+ AS=0.0378p AD=0.1428p PS=0.6u PD=1.52u rfmode=0
M$15424 \$2708 \$2681 \$2700 VSS|anode|cathode|vss sg13_lv_nmos L=0.13u W=0.42u
+ AS=0.12665p AD=0.1428p PS=1.145u PD=1.52u rfmode=0
M$15425 \$2680 \$2736 \$2708 VSS|anode|cathode|vss sg13_lv_nmos L=0.13u W=0.74u
+ AS=0.3473p AD=0.12665p PS=2.71u PD=1.145u rfmode=0
M$15426 \$2700 \$2701 VSS|anode|cathode|vss VSS|anode|cathode|vss sg13_lv_nmos
+ L=0.13u W=0.42u AS=0.1428p AD=0.0798p PS=1.52u PD=0.8u rfmode=0
M$15427 VSS|anode|cathode|vss \$2622 \$2723 VSS|anode|cathode|vss sg13_lv_nmos
+ L=0.13u W=0.42u AS=0.0798p AD=0.0378p PS=0.8u PD=0.6u rfmode=0
M$15428 \$2723 \$2708 \$2701 VSS|anode|cathode|vss sg13_lv_nmos L=0.13u W=0.42u
+ AS=0.0378p AD=0.1428p PS=0.6u PD=1.52u rfmode=0
M$15429 \$2702 \$2708 VSS|anode|cathode|vss VSS|anode|cathode|vss sg13_lv_nmos
+ L=0.13u W=0.74u AS=0.2516p AD=0.1406p PS=2.16u PD=1.12u rfmode=0
M$15430 VSS|anode|cathode|vss \$2702 \$2707 VSS|anode|cathode|vss sg13_lv_nmos
+ L=0.13u W=0.74u AS=0.1406p AD=0.2516p PS=1.12u PD=2.16u rfmode=0
M$15446 VSS|anode|cathode|vss \$2788 \$2760 VSS|anode|cathode|vss sg13_lv_nmos
+ L=0.13u W=0.55u AS=0.14875p AD=0.187p PS=1.16u PD=1.78u rfmode=0
M$15447 \$883 \$2760 VSS|anode|cathode|vss VSS|anode|cathode|vss sg13_lv_nmos
+ L=0.13u W=0.74u AS=0.2886p AD=0.14875p PS=2.26u PD=1.16u rfmode=0
M$15462 VSS|anode|cathode|vss \$2131 \$2631 VSS|anode|cathode|vss sg13_lv_nmos
+ L=0.13u W=0.74u AS=0.2516p AD=0.1406p PS=2.16u PD=1.12u rfmode=0
M$15463 \$2631 \$2687 VSS|anode|cathode|vss VSS|anode|cathode|vss sg13_lv_nmos
+ L=0.13u W=0.74u AS=0.1406p AD=0.2516p PS=1.12u PD=2.16u rfmode=0
M$15464 \$2682 \$2676 \$2724 VSS|anode|cathode|vss sg13_lv_nmos L=0.13u W=0.42u
+ AS=0.1296p AD=0.0798p PS=1.52u PD=0.8u rfmode=0
M$15465 \$2724 \$2732 \$2683 VSS|anode|cathode|vss sg13_lv_nmos L=0.13u W=0.42u
+ AS=0.0798p AD=0.2373p PS=0.8u PD=1.97u rfmode=0
M$15468 VSS|anode|cathode|vss \$2676 \$2732 VSS|anode|cathode|vss sg13_lv_nmos
+ L=0.13u W=0.74u AS=0.317325p AD=0.2516p PS=1.805u PD=2.16u rfmode=0
M$15469 VSS|anode|cathode|vss \$2247 \$2676 VSS|anode|cathode|vss sg13_lv_nmos
+ L=0.13u W=0.74u AS=0.317325p AD=0.2516p PS=1.805u PD=2.16u rfmode=0
M$15470 \$2761 \$2248 VSS|anode|cathode|vss VSS|anode|cathode|vss sg13_lv_nmos
+ L=0.13u W=0.74u AS=0.2516p AD=0.2516p PS=2.16u PD=2.16u rfmode=0
M$15471 \$2762 \$2791 \$2763 VSS|anode|cathode|vss sg13_lv_nmos L=0.13u W=0.42u
+ AS=0.1296p AD=0.0798p PS=1.52u PD=0.8u rfmode=0
M$15472 \$2763 \$2790 \$2799 VSS|anode|cathode|vss sg13_lv_nmos L=0.13u W=0.42u
+ AS=0.0798p AD=0.2373p PS=0.8u PD=1.97u rfmode=0
M$15473 \$2790 \$2791 VSS|anode|cathode|vss VSS|anode|cathode|vss sg13_lv_nmos
+ L=0.13u W=0.74u AS=0.2516p AD=0.317325p PS=2.16u PD=1.805u rfmode=0
M$15474 VSS|anode|cathode|vss \$2247 \$2791 VSS|anode|cathode|vss sg13_lv_nmos
+ L=0.13u W=0.74u AS=0.317325p AD=0.2516p PS=1.805u PD=2.16u rfmode=0
M$15475 \$2818 \$2791 \$2792 VSS|anode|cathode|vss sg13_lv_nmos L=0.13u W=0.42u
+ AS=0.1428p AD=0.12665p PS=1.52u PD=1.145u rfmode=0
M$15476 \$2792 \$2790 \$2789 VSS|anode|cathode|vss sg13_lv_nmos L=0.13u W=0.74u
+ AS=0.12665p AD=0.3473p PS=1.145u PD=2.71u rfmode=0
M$15477 VSS|anode|cathode|vss \$2726 \$2688 VSS|anode|cathode|vss sg13_lv_nmos
+ L=0.13u W=0.74u AS=0.2516p AD=0.1406p PS=2.16u PD=1.12u rfmode=0
M$15478 \$2688 \$2390 \$2712 VSS|anode|cathode|vss sg13_lv_nmos L=0.13u W=0.74u
+ AS=0.1406p AD=0.1406p PS=1.12u PD=1.12u rfmode=0
M$15479 \$2712 \$2727 VSS|anode|cathode|vss VSS|anode|cathode|vss sg13_lv_nmos
+ L=0.13u W=0.74u AS=0.1406p AD=0.2516p PS=1.12u PD=2.16u rfmode=0
M$15480 \$2764 \$2792 VSS|anode|cathode|vss VSS|anode|cathode|vss sg13_lv_nmos
+ L=0.13u W=0.74u AS=0.2516p AD=0.1406p PS=2.16u PD=1.12u rfmode=0
M$15481 VSS|anode|cathode|vss \$2764 \$2788 VSS|anode|cathode|vss sg13_lv_nmos
+ L=0.13u W=0.74u AS=0.1406p AD=0.2516p PS=1.12u PD=2.16u rfmode=0
M$15482 VSS|anode|cathode|vss \$2788 \$2726 VSS|anode|cathode|vss sg13_lv_nmos
+ L=0.13u W=0.74u AS=0.2516p AD=0.1406p PS=2.16u PD=1.12u rfmode=0
M$15483 \$2726 \$2727 VSS|anode|cathode|vss VSS|anode|cathode|vss sg13_lv_nmos
+ L=0.13u W=0.74u AS=0.1406p AD=0.2516p PS=1.12u PD=2.16u rfmode=0
M$15492 \$2568 \$2613 VSS|anode|cathode|vss VSS|anode|cathode|vss sg13_lv_nmos
+ L=0.13u W=0.74u AS=0.2516p AD=0.2516p PS=2.16u PD=2.16u rfmode=0
M$15493 VSS|anode|cathode|vss \$2613 \$2765 VSS|anode|cathode|vss sg13_lv_nmos
+ L=0.13u W=0.77u AS=0.2618p AD=0.1694p PS=2.22u PD=1.21u rfmode=0
M$15494 \$2765 \$2647 VSS|anode|cathode|vss VSS|anode|cathode|vss sg13_lv_nmos
+ L=0.13u W=0.77u AS=0.1694p AD=0.1463p PS=1.21u PD=1.15u rfmode=0
M$15495 VSS|anode|cathode|vss \$2586 \$2765 VSS|anode|cathode|vss sg13_lv_nmos
+ L=0.13u W=0.77u AS=0.1463p AD=0.2618p PS=1.15u PD=2.22u rfmode=0
M$15496 VSS|anode|cathode|vss \$2728 \$2715 VSS|anode|cathode|vss sg13_lv_nmos
+ L=0.13u W=0.74u AS=0.2516p AD=0.1406p PS=2.16u PD=1.12u rfmode=0
M$15497 \$2715 \$2689 \$2648 VSS|anode|cathode|vss sg13_lv_nmos L=0.13u W=0.74u
+ AS=0.1406p AD=0.1406p PS=1.12u PD=1.12u rfmode=0
M$15498 \$2648 \$2586 VSS|anode|cathode|vss VSS|anode|cathode|vss sg13_lv_nmos
+ L=0.13u W=0.74u AS=0.1406p AD=0.2516p PS=1.12u PD=2.16u rfmode=0
M$15499 VSS|anode|cathode|vss \$2613 \$2766 VSS|anode|cathode|vss sg13_lv_nmos
+ L=0.13u W=0.77u AS=0.2618p AD=0.1694p PS=2.22u PD=1.21u rfmode=0
M$15500 \$2766 \$2586 VSS|anode|cathode|vss VSS|anode|cathode|vss sg13_lv_nmos
+ L=0.13u W=0.77u AS=0.1694p AD=0.1463p PS=1.21u PD=1.15u rfmode=0
M$15501 VSS|anode|cathode|vss \$2689 \$2766 VSS|anode|cathode|vss sg13_lv_nmos
+ L=0.13u W=0.77u AS=0.1463p AD=0.2618p PS=1.15u PD=2.22u rfmode=0
M$15502 VSS|anode|cathode|vss \$2689 \$2767 VSS|anode|cathode|vss sg13_lv_nmos
+ L=0.13u W=0.74u AS=0.2516p AD=0.1406p PS=2.16u PD=1.12u rfmode=0
M$15503 \$2767 \$2390 VSS|anode|cathode|vss VSS|anode|cathode|vss sg13_lv_nmos
+ L=0.13u W=0.74u AS=0.1406p AD=0.2516p PS=1.12u PD=2.16u rfmode=0
M$15508 VSS|anode|cathode|vss \$2647 \$2768 VSS|anode|cathode|vss sg13_lv_nmos
+ L=0.13u W=0.77u AS=0.2618p AD=0.1694p PS=2.22u PD=1.21u rfmode=0
M$15509 \$2768 \$2532 VSS|anode|cathode|vss VSS|anode|cathode|vss sg13_lv_nmos
+ L=0.13u W=0.77u AS=0.1694p AD=0.1463p PS=1.21u PD=1.15u rfmode=0
M$15510 VSS|anode|cathode|vss \$2384 \$2768 VSS|anode|cathode|vss sg13_lv_nmos
+ L=0.13u W=0.77u AS=0.1463p AD=0.2618p PS=1.15u PD=2.22u rfmode=0
M$15511 \$2819 \$2765 VSS|anode|cathode|vss VSS|anode|cathode|vss sg13_lv_nmos
+ L=0.15u W=0.74u AS=0.2516p AD=0.1406p PS=2.16u PD=1.12u rfmode=0
M$15512 VSS|anode|cathode|vss \$2131 \$2819 VSS|anode|cathode|vss sg13_lv_nmos
+ L=0.15u W=0.74u AS=0.1406p AD=0.1406p PS=1.12u PD=1.12u rfmode=0
M$15513 \$2819 \$2768 \$2769 VSS|anode|cathode|vss sg13_lv_nmos L=0.15u W=0.74u
+ AS=0.1406p AD=0.2516p PS=1.12u PD=2.16u rfmode=0
M$15518 \$2691 \$2678 \$2729 VSS|anode|cathode|vss sg13_lv_nmos L=0.13u W=0.42u
+ AS=0.1296p AD=0.0798p PS=1.52u PD=0.8u rfmode=0
M$15519 \$2729 \$2735 \$2692 VSS|anode|cathode|vss sg13_lv_nmos L=0.13u W=0.42u
+ AS=0.0798p AD=0.2373p PS=0.8u PD=1.97u rfmode=0
M$15520 VSS|anode|cathode|vss \$2727 \$2759 VSS|anode|cathode|vss sg13_lv_nmos
+ L=0.13u W=0.55u AS=0.18945p AD=0.187p PS=1.27u PD=1.78u rfmode=0
M$15521 \$2770 \$2800 VSS|anode|cathode|vss VSS|anode|cathode|vss sg13_lv_nmos
+ L=0.13u W=0.74u AS=0.4033p AD=0.148p PS=2.57u PD=1.14u rfmode=0
M$15522 VSS|anode|cathode|vss \$2759 \$2834 VSS|anode|cathode|vss sg13_lv_nmos
+ L=0.13u W=0.74u AS=0.148p AD=0.3367p PS=1.14u PD=1.65u rfmode=0
M$15523 \$2834 \$2801 \$2800 VSS|anode|cathode|vss sg13_lv_nmos L=0.13u W=0.74u
+ AS=0.3367p AD=0.1628p PS=1.65u PD=1.18u rfmode=0
M$15524 \$2800 \$2384 \$2833 VSS|anode|cathode|vss sg13_lv_nmos L=0.13u W=0.74u
+ AS=0.1628p AD=0.13135p PS=1.18u PD=1.095u rfmode=0
M$15525 \$2833 \$2727 VSS|anode|cathode|vss VSS|anode|cathode|vss sg13_lv_nmos
+ L=0.13u W=0.74u AS=0.13135p AD=0.18945p PS=1.095u PD=1.27u rfmode=0
M$15526 VSS|anode|cathode|vss \$2678 \$2735 VSS|anode|cathode|vss sg13_lv_nmos
+ L=0.13u W=0.74u AS=0.317325p AD=0.2516p PS=1.805u PD=2.16u rfmode=0
M$15527 VSS|anode|cathode|vss \$2256 \$2678 VSS|anode|cathode|vss sg13_lv_nmos
+ L=0.13u W=0.74u AS=0.317325p AD=0.2516p PS=1.805u PD=2.16u rfmode=0
M$15530 \$2771 \$2766 VSS|anode|cathode|vss VSS|anode|cathode|vss sg13_lv_nmos
+ L=0.13u W=0.55u AS=0.187p AD=0.18945p PS=1.78u PD=1.27u rfmode=0
M$15531 VSS|anode|cathode|vss \$2766 \$2835 VSS|anode|cathode|vss sg13_lv_nmos
+ L=0.13u W=0.74u AS=0.18945p AD=0.13135p PS=1.27u PD=1.095u rfmode=0
M$15532 \$2835 \$2384 \$2772 VSS|anode|cathode|vss sg13_lv_nmos L=0.13u W=0.74u
+ AS=0.13135p AD=0.1628p PS=1.095u PD=1.18u rfmode=0
M$15533 \$2772 \$2802 \$2836 VSS|anode|cathode|vss sg13_lv_nmos L=0.13u W=0.74u
+ AS=0.1628p AD=0.3367p PS=1.18u PD=1.65u rfmode=0
M$15534 \$2836 \$2771 VSS|anode|cathode|vss VSS|anode|cathode|vss sg13_lv_nmos
+ L=0.13u W=0.74u AS=0.3367p AD=0.148p PS=1.65u PD=1.14u rfmode=0
M$15535 VSS|anode|cathode|vss \$2772 \$2773 VSS|anode|cathode|vss sg13_lv_nmos
+ L=0.13u W=0.74u AS=0.148p AD=0.4033p PS=1.14u PD=2.57u rfmode=0
M$15536 \$2774 \$2429 VSS|anode|cathode|vss VSS|anode|cathode|vss sg13_lv_nmos
+ L=0.13u W=0.55u AS=0.187p AD=0.14875p PS=1.78u PD=1.16u rfmode=0
M$15537 VSS|anode|cathode|vss \$2774 \$2651 VSS|anode|cathode|vss sg13_lv_nmos
+ L=0.13u W=0.74u AS=0.14875p AD=0.2886p PS=1.16u PD=2.26u rfmode=0
M$15538 \$2698 \$2681 \$2731 VSS|anode|cathode|vss sg13_lv_nmos L=0.13u W=0.42u
+ AS=0.1296p AD=0.0798p PS=1.52u PD=0.8u rfmode=0
M$15539 \$2731 \$2736 \$2699 VSS|anode|cathode|vss sg13_lv_nmos L=0.13u W=0.42u
+ AS=0.0798p AD=0.2373p PS=0.8u PD=1.97u rfmode=0
M$15542 VSS|anode|cathode|vss \$2681 \$2736 VSS|anode|cathode|vss sg13_lv_nmos
+ L=0.13u W=0.74u AS=0.317325p AD=0.2516p PS=1.805u PD=2.16u rfmode=0
M$15543 VSS|anode|cathode|vss \$2256 \$2681 VSS|anode|cathode|vss sg13_lv_nmos
+ L=0.13u W=0.74u AS=0.317325p AD=0.2516p PS=1.805u PD=2.16u rfmode=0
M$15562 \$2775 \$2707 VSS|anode|cathode|vss VSS|anode|cathode|vss sg13_lv_nmos
+ L=0.13u W=0.55u AS=0.187p AD=0.14875p PS=1.78u PD=1.16u rfmode=0
M$15563 VSS|anode|cathode|vss \$2775 \$891 VSS|anode|cathode|vss sg13_lv_nmos
+ L=0.13u W=0.74u AS=0.14875p AD=0.2886p PS=1.16u PD=2.26u rfmode=0
M$15584 VSS|anode|cathode|vss \$2763 \$2789 VSS|anode|cathode|vss sg13_lv_nmos
+ L=0.13u W=0.74u AS=0.1626p AD=0.2516p PS=1.415u PD=2.16u rfmode=0
M$15585 \$2762 \$2688 \$2831 VSS|anode|cathode|vss sg13_lv_nmos L=0.13u W=0.42u
+ AS=0.1428p AD=0.0609p PS=1.52u PD=0.71u rfmode=0
M$15586 VSS|anode|cathode|vss \$2761 \$2831 VSS|anode|cathode|vss sg13_lv_nmos
+ L=0.13u W=0.42u AS=0.1626p AD=0.0609p PS=1.415u PD=0.71u rfmode=0
M$15587 \$2873 \$2905 \$2891 VSS|anode|cathode|vss sg13_lv_nmos L=0.13u W=0.42u
+ AS=0.1428p AD=0.0609p PS=1.52u PD=0.71u rfmode=0
M$15588 \$2891 \$2907 VSS|anode|cathode|vss VSS|anode|cathode|vss sg13_lv_nmos
+ L=0.13u W=0.42u AS=0.0609p AD=0.1626p PS=0.71u PD=1.415u rfmode=0
M$15589 VSS|anode|cathode|vss \$2906 \$2837 VSS|anode|cathode|vss sg13_lv_nmos
+ L=0.13u W=0.74u AS=0.1626p AD=0.2516p PS=1.415u PD=2.16u rfmode=0
M$15590 VSS|anode|cathode|vss \$2761 \$2830 VSS|anode|cathode|vss sg13_lv_nmos
+ L=0.13u W=0.42u AS=0.1701p AD=0.0378p PS=1.65u PD=0.6u rfmode=0
M$15591 \$2830 \$2789 \$2799 VSS|anode|cathode|vss sg13_lv_nmos L=0.13u W=0.42u
+ AS=0.0378p AD=0.1428p PS=0.6u PD=1.52u rfmode=0
M$15592 VSS|anode|cathode|vss \$2907 \$2892 VSS|anode|cathode|vss sg13_lv_nmos
+ L=0.13u W=0.42u AS=0.1701p AD=0.0378p PS=1.65u PD=0.6u rfmode=0
M$15593 \$2892 \$2837 \$2872 VSS|anode|cathode|vss sg13_lv_nmos L=0.13u W=0.42u
+ AS=0.0378p AD=0.1428p PS=0.6u PD=1.52u rfmode=0
M$15594 \$2875 \$2838 \$2839 VSS|anode|cathode|vss sg13_lv_nmos L=0.13u W=0.42u
+ AS=0.12665p AD=0.1428p PS=1.145u PD=1.52u rfmode=0
M$15595 \$2837 \$2874 \$2875 VSS|anode|cathode|vss sg13_lv_nmos L=0.13u W=0.74u
+ AS=0.3473p AD=0.12665p PS=2.71u PD=1.145u rfmode=0
M$15596 \$2818 \$2793 VSS|anode|cathode|vss VSS|anode|cathode|vss sg13_lv_nmos
+ L=0.13u W=0.42u AS=0.1428p AD=0.0798p PS=1.52u PD=0.8u rfmode=0
M$15597 VSS|anode|cathode|vss \$2761 \$2832 VSS|anode|cathode|vss sg13_lv_nmos
+ L=0.13u W=0.42u AS=0.0798p AD=0.0378p PS=0.8u PD=0.6u rfmode=0
M$15598 \$2832 \$2792 \$2793 VSS|anode|cathode|vss sg13_lv_nmos L=0.13u W=0.42u
+ AS=0.0378p AD=0.1428p PS=0.6u PD=1.52u rfmode=0
M$15599 \$2839 \$2840 VSS|anode|cathode|vss VSS|anode|cathode|vss sg13_lv_nmos
+ L=0.13u W=0.42u AS=0.1428p AD=0.0798p PS=1.52u PD=0.8u rfmode=0
M$15600 VSS|anode|cathode|vss \$2907 \$2893 VSS|anode|cathode|vss sg13_lv_nmos
+ L=0.13u W=0.42u AS=0.0798p AD=0.0378p PS=0.8u PD=0.6u rfmode=0
M$15601 \$2893 \$2875 \$2840 VSS|anode|cathode|vss sg13_lv_nmos L=0.13u W=0.42u
+ AS=0.0378p AD=0.1428p PS=0.6u PD=1.52u rfmode=0
M$15602 \$2841 \$2875 VSS|anode|cathode|vss VSS|anode|cathode|vss sg13_lv_nmos
+ L=0.13u W=0.74u AS=0.2516p AD=0.1406p PS=2.16u PD=1.12u rfmode=0
M$15603 VSS|anode|cathode|vss \$2841 \$2842 VSS|anode|cathode|vss sg13_lv_nmos
+ L=0.13u W=0.74u AS=0.1406p AD=0.2516p PS=1.12u PD=2.16u rfmode=0
M$15604 VSS|anode|cathode|vss \$2205 \$2843 VSS|anode|cathode|vss sg13_lv_nmos
+ L=0.13u W=0.74u AS=0.2516p AD=0.2516p PS=2.16u PD=2.16u rfmode=0
M$15609 \$2844 \$2845 VSS|anode|cathode|vss VSS|anode|cathode|vss sg13_lv_nmos
+ L=0.13u W=0.74u AS=0.4033p AD=0.148p PS=2.57u PD=1.14u rfmode=0
M$15610 VSS|anode|cathode|vss \$2876 \$2895 VSS|anode|cathode|vss sg13_lv_nmos
+ L=0.13u W=0.74u AS=0.148p AD=0.3367p PS=1.14u PD=1.65u rfmode=0
M$15611 \$2895 \$2908 \$2845 VSS|anode|cathode|vss sg13_lv_nmos L=0.13u W=0.74u
+ AS=0.3367p AD=0.1628p PS=1.65u PD=1.18u rfmode=0
M$15612 \$2845 \$2390 \$2894 VSS|anode|cathode|vss sg13_lv_nmos L=0.13u W=0.74u
+ AS=0.1628p AD=0.13135p PS=1.18u PD=1.095u rfmode=0
M$15613 \$2894 \$2375 VSS|anode|cathode|vss VSS|anode|cathode|vss sg13_lv_nmos
+ L=0.13u W=0.74u AS=0.13135p AD=0.18945p PS=1.095u PD=1.27u rfmode=0
M$15614 VSS|anode|cathode|vss \$2375 \$2876 VSS|anode|cathode|vss sg13_lv_nmos
+ L=0.13u W=0.55u AS=0.18945p AD=0.187p PS=1.27u PD=1.78u rfmode=0
M$15619 VSS|anode|cathode|vss \$2909 \$2846 VSS|anode|cathode|vss sg13_lv_nmos
+ L=0.13u W=0.74u AS=0.2516p AD=0.2516p PS=2.16u PD=2.16u rfmode=0
M$15620 \$2847 \$2846 VSS|anode|cathode|vss VSS|anode|cathode|vss sg13_lv_nmos
+ L=0.15u W=0.74u AS=0.2516p AD=0.1406p PS=2.16u PD=1.12u rfmode=0
M$15621 VSS|anode|cathode|vss \$2766 \$2847 VSS|anode|cathode|vss sg13_lv_nmos
+ L=0.15u W=0.74u AS=0.1406p AD=0.1406p PS=1.12u PD=1.12u rfmode=0
M$15622 \$2847 \$2910 \$2877 VSS|anode|cathode|vss sg13_lv_nmos L=0.15u W=0.74u
+ AS=0.1406p AD=0.2516p PS=1.12u PD=2.16u rfmode=0
M$15623 \$2910 \$2767 \$2848 VSS|anode|cathode|vss sg13_lv_nmos L=0.15u W=0.74u
+ AS=0.2516p AD=0.1406p PS=2.16u PD=1.12u rfmode=0
M$15624 \$2848 \$2131 VSS|anode|cathode|vss VSS|anode|cathode|vss sg13_lv_nmos
+ L=0.15u W=0.74u AS=0.1406p AD=0.1406p PS=1.12u PD=1.12u rfmode=0
M$15625 VSS|anode|cathode|vss \$2765 \$2848 VSS|anode|cathode|vss sg13_lv_nmos
+ L=0.15u W=0.74u AS=0.1406p AD=0.2516p PS=1.12u PD=2.16u rfmode=0
M$15629 VSS|anode|cathode|vss \$2765 \$2878 VSS|anode|cathode|vss sg13_lv_nmos
+ L=0.13u W=0.55u AS=0.17255p AD=0.187p PS=1.25u PD=1.78u rfmode=0
M$15630 VSS|anode|cathode|vss \$2878 \$2849 VSS|anode|cathode|vss sg13_lv_nmos
+ L=0.13u W=0.74u AS=0.17255p AD=0.1406p PS=1.25u PD=1.12u rfmode=0
M$15631 \$2849 \$2532 VSS|anode|cathode|vss VSS|anode|cathode|vss sg13_lv_nmos
+ L=0.13u W=0.74u AS=0.1406p AD=0.2516p PS=1.12u PD=2.16u rfmode=0
M$15632 \$2850 \$2911 VSS|anode|cathode|vss VSS|anode|cathode|vss sg13_lv_nmos
+ L=0.15u W=0.74u AS=0.2516p AD=0.1406p PS=2.16u PD=1.12u rfmode=0
M$15633 VSS|anode|cathode|vss \$2849 \$2850 VSS|anode|cathode|vss sg13_lv_nmos
+ L=0.15u W=0.74u AS=0.1406p AD=0.1406p PS=1.12u PD=1.12u rfmode=0
M$15634 \$2850 \$2769 \$2851 VSS|anode|cathode|vss sg13_lv_nmos L=0.15u W=0.74u
+ AS=0.1406p AD=0.2516p PS=1.12u PD=2.16u rfmode=0
M$15635 \$2852 \$2098 VSS|anode|cathode|vss VSS|anode|cathode|vss sg13_lv_nmos
+ L=0.13u W=0.74u AS=0.2516p AD=0.2516p PS=2.16u PD=2.16u rfmode=0
M$15638 VSS|anode|cathode|vss \$2098 \$2853 VSS|anode|cathode|vss sg13_lv_nmos
+ L=0.13u W=0.74u AS=0.2516p AD=0.2516p PS=2.16u PD=2.16u rfmode=0
M$15640 \$2880 \$2770 \$2896 VSS|anode|cathode|vss sg13_lv_nmos L=0.13u W=0.42u
+ AS=0.1428p AD=0.0609p PS=1.52u PD=0.71u rfmode=0
M$15641 \$2896 \$2853 VSS|anode|cathode|vss VSS|anode|cathode|vss sg13_lv_nmos
+ L=0.13u W=0.42u AS=0.0609p AD=0.1626p PS=0.71u PD=1.415u rfmode=0
M$15642 VSS|anode|cathode|vss \$2912 \$2854 VSS|anode|cathode|vss sg13_lv_nmos
+ L=0.13u W=0.74u AS=0.1626p AD=0.2516p PS=1.415u PD=2.16u rfmode=0
M$15643 VSS|anode|cathode|vss \$2853 \$2897 VSS|anode|cathode|vss sg13_lv_nmos
+ L=0.13u W=0.42u AS=0.1701p AD=0.0378p PS=1.65u PD=0.6u rfmode=0
M$15644 \$2897 \$2854 \$2879 VSS|anode|cathode|vss sg13_lv_nmos L=0.13u W=0.42u
+ AS=0.0378p AD=0.1428p PS=0.6u PD=1.52u rfmode=0
M$15645 \$2882 \$2855 \$2856 VSS|anode|cathode|vss sg13_lv_nmos L=0.13u W=0.42u
+ AS=0.12665p AD=0.1428p PS=1.145u PD=1.52u rfmode=0
M$15646 \$2854 \$2881 \$2882 VSS|anode|cathode|vss sg13_lv_nmos L=0.13u W=0.74u
+ AS=0.3473p AD=0.12665p PS=2.71u PD=1.145u rfmode=0
M$15647 \$2856 \$2857 VSS|anode|cathode|vss VSS|anode|cathode|vss sg13_lv_nmos
+ L=0.13u W=0.42u AS=0.1428p AD=0.0798p PS=1.52u PD=0.8u rfmode=0
M$15648 VSS|anode|cathode|vss \$2853 \$2898 VSS|anode|cathode|vss sg13_lv_nmos
+ L=0.13u W=0.42u AS=0.0798p AD=0.0378p PS=0.8u PD=0.6u rfmode=0
M$15649 \$2898 \$2882 \$2857 VSS|anode|cathode|vss sg13_lv_nmos L=0.13u W=0.42u
+ AS=0.0378p AD=0.1428p PS=0.6u PD=1.52u rfmode=0
M$15651 \$2858 \$2882 VSS|anode|cathode|vss VSS|anode|cathode|vss sg13_lv_nmos
+ L=0.13u W=0.74u AS=0.2516p AD=0.1406p PS=2.16u PD=1.12u rfmode=0
M$15652 VSS|anode|cathode|vss \$2858 \$2801 VSS|anode|cathode|vss sg13_lv_nmos
+ L=0.13u W=0.74u AS=0.1406p AD=0.2516p PS=1.12u PD=2.16u rfmode=0
M$15653 \$2859 \$2651 VSS|anode|cathode|vss VSS|anode|cathode|vss sg13_lv_nmos
+ L=0.13u W=0.74u AS=0.2516p AD=0.2516p PS=2.16u PD=2.16u rfmode=0
M$15654 VSS|anode|cathode|vss \$2651 \$2913 VSS|anode|cathode|vss sg13_lv_nmos
+ L=0.13u W=0.74u AS=0.2516p AD=0.2516p PS=2.16u PD=2.16u rfmode=0
M$15655 \$2884 \$2773 \$2900 VSS|anode|cathode|vss sg13_lv_nmos L=0.13u W=0.42u
+ AS=0.1428p AD=0.0609p PS=1.52u PD=0.71u rfmode=0
M$15656 \$2900 \$2913 VSS|anode|cathode|vss VSS|anode|cathode|vss sg13_lv_nmos
+ L=0.13u W=0.42u AS=0.0609p AD=0.1626p PS=0.71u PD=1.415u rfmode=0
M$15657 VSS|anode|cathode|vss \$2914 \$2860 VSS|anode|cathode|vss sg13_lv_nmos
+ L=0.13u W=0.74u AS=0.1626p AD=0.2516p PS=1.415u PD=2.16u rfmode=0
M$15658 VSS|anode|cathode|vss \$2913 \$2899 VSS|anode|cathode|vss sg13_lv_nmos
+ L=0.13u W=0.42u AS=0.1701p AD=0.0378p PS=1.65u PD=0.6u rfmode=0
M$15659 \$2899 \$2860 \$2883 VSS|anode|cathode|vss sg13_lv_nmos L=0.13u W=0.42u
+ AS=0.0378p AD=0.1428p PS=0.6u PD=1.52u rfmode=0
M$15660 \$2886 \$2861 \$2862 VSS|anode|cathode|vss sg13_lv_nmos L=0.13u W=0.42u
+ AS=0.12665p AD=0.1428p PS=1.145u PD=1.52u rfmode=0
M$15661 \$2860 \$2885 \$2886 VSS|anode|cathode|vss sg13_lv_nmos L=0.13u W=0.74u
+ AS=0.3473p AD=0.12665p PS=2.71u PD=1.145u rfmode=0
M$15662 \$2862 \$2863 VSS|anode|cathode|vss VSS|anode|cathode|vss sg13_lv_nmos
+ L=0.13u W=0.42u AS=0.1428p AD=0.0798p PS=1.52u PD=0.8u rfmode=0
M$15663 VSS|anode|cathode|vss \$2913 \$2901 VSS|anode|cathode|vss sg13_lv_nmos
+ L=0.13u W=0.42u AS=0.0798p AD=0.0378p PS=0.8u PD=0.6u rfmode=0
M$15664 \$2901 \$2886 \$2863 VSS|anode|cathode|vss sg13_lv_nmos L=0.13u W=0.42u
+ AS=0.0378p AD=0.1428p PS=0.6u PD=1.52u rfmode=0
M$15665 \$2864 \$2886 VSS|anode|cathode|vss VSS|anode|cathode|vss sg13_lv_nmos
+ L=0.13u W=0.74u AS=0.2516p AD=0.1406p PS=2.16u PD=1.12u rfmode=0
M$15666 VSS|anode|cathode|vss \$2864 \$2802 VSS|anode|cathode|vss sg13_lv_nmos
+ L=0.13u W=0.74u AS=0.1406p AD=0.2516p PS=1.12u PD=2.16u rfmode=0
M$15668 VSS|anode|cathode|vss \$2651 \$2865 VSS|anode|cathode|vss sg13_lv_nmos
+ L=0.13u W=0.74u AS=0.2516p AD=0.2516p PS=2.16u PD=2.16u rfmode=0
M$15669 \$2888 \$3322 \$2902 VSS|anode|cathode|vss sg13_lv_nmos L=0.13u W=0.42u
+ AS=0.1428p AD=0.0609p PS=1.52u PD=0.71u rfmode=0
M$15670 \$2902 \$2865 VSS|anode|cathode|vss VSS|anode|cathode|vss sg13_lv_nmos
+ L=0.13u W=0.42u AS=0.0609p AD=0.1626p PS=0.71u PD=1.415u rfmode=0
M$15671 VSS|anode|cathode|vss \$2916 \$2866 VSS|anode|cathode|vss sg13_lv_nmos
+ L=0.13u W=0.74u AS=0.1626p AD=0.2516p PS=1.415u PD=2.16u rfmode=0
M$15672 VSS|anode|cathode|vss \$2865 \$2903 VSS|anode|cathode|vss sg13_lv_nmos
+ L=0.13u W=0.42u AS=0.1701p AD=0.0378p PS=1.65u PD=0.6u rfmode=0
M$15673 \$2903 \$2866 \$2887 VSS|anode|cathode|vss sg13_lv_nmos L=0.13u W=0.42u
+ AS=0.0378p AD=0.1428p PS=0.6u PD=1.52u rfmode=0
M$15674 \$2890 \$2867 \$2868 VSS|anode|cathode|vss sg13_lv_nmos L=0.13u W=0.42u
+ AS=0.12665p AD=0.1428p PS=1.145u PD=1.52u rfmode=0
M$15675 \$2866 \$2889 \$2890 VSS|anode|cathode|vss sg13_lv_nmos L=0.13u W=0.74u
+ AS=0.3473p AD=0.12665p PS=2.71u PD=1.145u rfmode=0
M$15676 \$2868 \$2869 VSS|anode|cathode|vss VSS|anode|cathode|vss sg13_lv_nmos
+ L=0.13u W=0.42u AS=0.1428p AD=0.0798p PS=1.52u PD=0.8u rfmode=0
M$15677 VSS|anode|cathode|vss \$2865 \$2904 VSS|anode|cathode|vss sg13_lv_nmos
+ L=0.13u W=0.42u AS=0.0798p AD=0.0378p PS=0.8u PD=0.6u rfmode=0
M$15678 \$2904 \$2890 \$2869 VSS|anode|cathode|vss sg13_lv_nmos L=0.13u W=0.42u
+ AS=0.0378p AD=0.1428p PS=0.6u PD=1.52u rfmode=0
M$15679 \$2870 \$2890 VSS|anode|cathode|vss VSS|anode|cathode|vss sg13_lv_nmos
+ L=0.13u W=0.74u AS=0.2516p AD=0.1406p PS=2.16u PD=1.12u rfmode=0
M$15680 VSS|anode|cathode|vss \$2870 \$2871 VSS|anode|cathode|vss sg13_lv_nmos
+ L=0.13u W=0.74u AS=0.1406p AD=0.2516p PS=1.12u PD=2.16u rfmode=0
M$15686 \$2873 \$2838 \$2906 VSS|anode|cathode|vss sg13_lv_nmos L=0.13u W=0.42u
+ AS=0.1296p AD=0.0798p PS=1.52u PD=0.8u rfmode=0
M$15687 \$2906 \$2874 \$2872 VSS|anode|cathode|vss sg13_lv_nmos L=0.13u W=0.42u
+ AS=0.0798p AD=0.2373p PS=0.8u PD=1.97u rfmode=0
M$15688 VSS|anode|cathode|vss \$2838 \$2874 VSS|anode|cathode|vss sg13_lv_nmos
+ L=0.13u W=0.74u AS=0.317325p AD=0.2516p PS=1.805u PD=2.16u rfmode=0
M$15689 VSS|anode|cathode|vss \$2247 \$2838 VSS|anode|cathode|vss sg13_lv_nmos
+ L=0.13u W=0.74u AS=0.317325p AD=0.2516p PS=1.805u PD=2.16u rfmode=0
M$15690 \$2880 \$2855 \$2912 VSS|anode|cathode|vss sg13_lv_nmos L=0.13u W=0.42u
+ AS=0.1296p AD=0.0798p PS=1.52u PD=0.8u rfmode=0
M$15691 \$2912 \$2881 \$2879 VSS|anode|cathode|vss sg13_lv_nmos L=0.13u W=0.42u
+ AS=0.0798p AD=0.2373p PS=0.8u PD=1.97u rfmode=0
M$15692 VSS|anode|cathode|vss \$2855 \$2881 VSS|anode|cathode|vss sg13_lv_nmos
+ L=0.13u W=0.74u AS=0.317325p AD=0.2516p PS=1.805u PD=2.16u rfmode=0
M$15693 VSS|anode|cathode|vss \$2256 \$2855 VSS|anode|cathode|vss sg13_lv_nmos
+ L=0.13u W=0.74u AS=0.317325p AD=0.2516p PS=1.805u PD=2.16u rfmode=0
M$15694 \$2884 \$2861 \$2914 VSS|anode|cathode|vss sg13_lv_nmos L=0.13u W=0.42u
+ AS=0.1296p AD=0.0798p PS=1.52u PD=0.8u rfmode=0
M$15695 \$2914 \$2885 \$2883 VSS|anode|cathode|vss sg13_lv_nmos L=0.13u W=0.42u
+ AS=0.0798p AD=0.2373p PS=0.8u PD=1.97u rfmode=0
M$15696 VSS|anode|cathode|vss \$2861 \$2885 VSS|anode|cathode|vss sg13_lv_nmos
+ L=0.13u W=0.74u AS=0.317325p AD=0.2516p PS=1.805u PD=2.16u rfmode=0
M$15697 VSS|anode|cathode|vss \$2915 \$2861 VSS|anode|cathode|vss sg13_lv_nmos
+ L=0.13u W=0.74u AS=0.317325p AD=0.2516p PS=1.805u PD=2.16u rfmode=0
M$15698 \$2888 \$2867 \$2916 VSS|anode|cathode|vss sg13_lv_nmos L=0.13u W=0.42u
+ AS=0.1296p AD=0.0798p PS=1.52u PD=0.8u rfmode=0
M$15699 \$2916 \$2889 \$2887 VSS|anode|cathode|vss sg13_lv_nmos L=0.13u W=0.42u
+ AS=0.0798p AD=0.2373p PS=0.8u PD=1.97u rfmode=0
M$15700 VSS|anode|cathode|vss \$2867 \$2889 VSS|anode|cathode|vss sg13_lv_nmos
+ L=0.13u W=0.74u AS=0.317325p AD=0.2516p PS=1.805u PD=2.16u rfmode=0
M$15701 VSS|anode|cathode|vss \$2915 \$2867 VSS|anode|cathode|vss sg13_lv_nmos
+ L=0.13u W=0.74u AS=0.317325p AD=0.2516p PS=1.805u PD=2.16u rfmode=0
M$15702 \$2917 X10|dout[11] VSS|anode|cathode|vss VSS|anode|cathode|vss
+ sg13_lv_nmos L=0.13u W=0.64u AS=0.2176p AD=0.1371p PS=1.96u PD=1.12u rfmode=0
M$15703 VSS|anode|cathode|vss \$2917 \$2935 VSS|anode|cathode|vss sg13_lv_nmos
+ L=0.13u W=1.48u AS=0.2777p AD=0.3922p PS=2.24u PD=3.28u rfmode=0
M$15705 VSS|anode|cathode|vss \$3192 \$2962 VSS|anode|cathode|vss sg13_lv_nmos
+ L=0.13u W=0.55u AS=0.187p AD=0.1045p PS=1.78u PD=0.93u rfmode=0
M$15706 \$2962 \$3416 VSS|anode|cathode|vss VSS|anode|cathode|vss sg13_lv_nmos
+ L=0.13u W=0.55u AS=0.1045p AD=0.146425p PS=0.93u PD=1.155u rfmode=0
M$15707 VSS|anode|cathode|vss \$2962 \$2963 VSS|anode|cathode|vss sg13_lv_nmos
+ L=0.13u W=1.48u AS=0.312925p AD=0.4477p PS=2.345u PD=3.43u rfmode=0
M$15709 \$2965 \$3060 \$3092 VSS|anode|cathode|vss sg13_lv_nmos L=0.13u W=0.42u
+ AS=0.1428p AD=0.0609p PS=1.52u PD=0.71u rfmode=0
M$15710 \$3092 VDD VSS|anode|cathode|vss VSS|anode|cathode|vss sg13_lv_nmos
+ L=0.13u W=0.42u AS=0.0609p AD=0.1626p PS=0.71u PD=1.415u rfmode=0
M$15711 VSS|anode|cathode|vss \$3164 \$2942 VSS|anode|cathode|vss sg13_lv_nmos
+ L=0.13u W=0.74u AS=0.1626p AD=0.2516p PS=1.415u PD=2.16u rfmode=0
M$15712 \$2967 \$3165 VSS|anode|cathode|vss VSS|anode|cathode|vss sg13_lv_nmos
+ L=0.13u W=0.42u AS=0.1428p AD=0.0798p PS=1.52u PD=0.8u rfmode=0
M$15713 VSS|anode|cathode|vss VDD \$3096 VSS|anode|cathode|vss sg13_lv_nmos
+ L=0.13u W=0.42u AS=0.0798p AD=0.0378p PS=0.8u PD=0.6u rfmode=0
M$15714 \$3096 \$3062 \$3165 VSS|anode|cathode|vss sg13_lv_nmos L=0.13u W=0.42u
+ AS=0.0378p AD=0.1428p PS=0.6u PD=1.52u rfmode=0
M$15715 VSS|anode|cathode|vss \$3062 \$2969 VSS|anode|cathode|vss sg13_lv_nmos
+ L=0.13u W=0.64u AS=0.1331p AD=0.2176p PS=1.12u PD=1.96u rfmode=0
M$15716 VSS|anode|cathode|vss \$3062 \$2968 VSS|anode|cathode|vss sg13_lv_nmos
+ L=0.13u W=1.48u AS=0.3922p AD=0.2737p PS=3.28u PD=2.24u rfmode=0
M$15718 VSS|anode|cathode|vss \$2969 \$2970 VSS|anode|cathode|vss sg13_lv_nmos
+ L=0.13u W=1.48u AS=0.3922p AD=0.3922p PS=3.28u PD=3.28u rfmode=0
M$15720 VSS|anode|cathode|vss \$3193 \$2971 VSS|anode|cathode|vss sg13_lv_nmos
+ L=0.13u W=0.55u AS=0.187p AD=0.1045p PS=1.78u PD=0.93u rfmode=0
M$15721 \$2971 \$3416 VSS|anode|cathode|vss VSS|anode|cathode|vss sg13_lv_nmos
+ L=0.13u W=0.55u AS=0.1045p AD=0.146425p PS=0.93u PD=1.155u rfmode=0
M$15722 VSS|anode|cathode|vss \$2971 \$2972 VSS|anode|cathode|vss sg13_lv_nmos
+ L=0.13u W=1.48u AS=0.312925p AD=0.4477p PS=2.345u PD=3.43u rfmode=0
M$15724 \$2974 \$3064 \$3099 VSS|anode|cathode|vss sg13_lv_nmos L=0.13u W=0.42u
+ AS=0.1428p AD=0.0609p PS=1.52u PD=0.71u rfmode=0
M$15725 \$3099 VDD VSS|anode|cathode|vss VSS|anode|cathode|vss sg13_lv_nmos
+ L=0.13u W=0.42u AS=0.0609p AD=0.1626p PS=0.71u PD=1.415u rfmode=0
M$15726 VSS|anode|cathode|vss \$3166 \$2944 VSS|anode|cathode|vss sg13_lv_nmos
+ L=0.13u W=0.74u AS=0.1626p AD=0.2516p PS=1.415u PD=2.16u rfmode=0
M$15727 \$2976 \$3167 VSS|anode|cathode|vss VSS|anode|cathode|vss sg13_lv_nmos
+ L=0.13u W=0.42u AS=0.1428p AD=0.0798p PS=1.52u PD=0.8u rfmode=0
M$15728 VSS|anode|cathode|vss VDD \$3107 VSS|anode|cathode|vss sg13_lv_nmos
+ L=0.13u W=0.42u AS=0.0798p AD=0.0378p PS=0.8u PD=0.6u rfmode=0
M$15729 \$3107 \$3066 \$3167 VSS|anode|cathode|vss sg13_lv_nmos L=0.13u W=0.42u
+ AS=0.0378p AD=0.1428p PS=0.6u PD=1.52u rfmode=0
M$15730 VSS|anode|cathode|vss \$3066 \$2978 VSS|anode|cathode|vss sg13_lv_nmos
+ L=0.13u W=0.64u AS=0.1331p AD=0.2176p PS=1.12u PD=1.96u rfmode=0
M$15731 VSS|anode|cathode|vss \$3066 \$2977 VSS|anode|cathode|vss sg13_lv_nmos
+ L=0.13u W=1.48u AS=0.3922p AD=0.2737p PS=3.28u PD=2.24u rfmode=0
M$15733 VSS|anode|cathode|vss \$2978 \$2979 VSS|anode|cathode|vss sg13_lv_nmos
+ L=0.13u W=1.48u AS=0.3922p AD=0.3922p PS=3.28u PD=3.28u rfmode=0
M$15735 VSS|anode|cathode|vss \$3194 \$2980 VSS|anode|cathode|vss sg13_lv_nmos
+ L=0.13u W=0.55u AS=0.187p AD=0.1045p PS=1.78u PD=0.93u rfmode=0
M$15736 \$2980 \$3416 VSS|anode|cathode|vss VSS|anode|cathode|vss sg13_lv_nmos
+ L=0.13u W=0.55u AS=0.1045p AD=0.146425p PS=0.93u PD=1.155u rfmode=0
M$15737 VSS|anode|cathode|vss \$2980 \$2981 VSS|anode|cathode|vss sg13_lv_nmos
+ L=0.13u W=1.48u AS=0.312925p AD=0.4477p PS=2.345u PD=3.43u rfmode=0
M$15739 \$2983 \$3068 \$3113 VSS|anode|cathode|vss sg13_lv_nmos L=0.13u W=0.42u
+ AS=0.1428p AD=0.0609p PS=1.52u PD=0.71u rfmode=0
M$15740 \$3113 VDD VSS|anode|cathode|vss VSS|anode|cathode|vss sg13_lv_nmos
+ L=0.13u W=0.42u AS=0.0609p AD=0.1626p PS=0.71u PD=1.415u rfmode=0
M$15741 VSS|anode|cathode|vss \$3168 \$2946 VSS|anode|cathode|vss sg13_lv_nmos
+ L=0.13u W=0.74u AS=0.1626p AD=0.2516p PS=1.415u PD=2.16u rfmode=0
M$15742 \$2985 \$3169 VSS|anode|cathode|vss VSS|anode|cathode|vss sg13_lv_nmos
+ L=0.13u W=0.42u AS=0.1428p AD=0.0798p PS=1.52u PD=0.8u rfmode=0
M$15743 VSS|anode|cathode|vss VDD \$3121 VSS|anode|cathode|vss sg13_lv_nmos
+ L=0.13u W=0.42u AS=0.0798p AD=0.0378p PS=0.8u PD=0.6u rfmode=0
M$15744 \$3121 \$3070 \$3169 VSS|anode|cathode|vss sg13_lv_nmos L=0.13u W=0.42u
+ AS=0.0378p AD=0.1428p PS=0.6u PD=1.52u rfmode=0
M$15745 VSS|anode|cathode|vss \$3070 \$2987 VSS|anode|cathode|vss sg13_lv_nmos
+ L=0.13u W=0.64u AS=0.1331p AD=0.2176p PS=1.12u PD=1.96u rfmode=0
M$15746 VSS|anode|cathode|vss \$3070 \$2986 VSS|anode|cathode|vss sg13_lv_nmos
+ L=0.13u W=1.48u AS=0.3922p AD=0.2737p PS=3.28u PD=2.24u rfmode=0
M$15748 VSS|anode|cathode|vss \$2987 \$2988 VSS|anode|cathode|vss sg13_lv_nmos
+ L=0.13u W=1.48u AS=0.3922p AD=0.3922p PS=3.28u PD=3.28u rfmode=0
M$15750 VSS|anode|cathode|vss \$3195 \$2989 VSS|anode|cathode|vss sg13_lv_nmos
+ L=0.13u W=0.55u AS=0.187p AD=0.1045p PS=1.78u PD=0.93u rfmode=0
M$15751 \$2989 \$3416 VSS|anode|cathode|vss VSS|anode|cathode|vss sg13_lv_nmos
+ L=0.13u W=0.55u AS=0.1045p AD=0.146425p PS=0.93u PD=1.155u rfmode=0
M$15752 VSS|anode|cathode|vss \$2989 \$2990 VSS|anode|cathode|vss sg13_lv_nmos
+ L=0.13u W=1.48u AS=0.312925p AD=0.4477p PS=2.345u PD=3.43u rfmode=0
M$15754 \$2992 \$3072 \$3126 VSS|anode|cathode|vss sg13_lv_nmos L=0.13u W=0.42u
+ AS=0.1428p AD=0.0609p PS=1.52u PD=0.71u rfmode=0
M$15755 \$3126 VDD VSS|anode|cathode|vss VSS|anode|cathode|vss sg13_lv_nmos
+ L=0.13u W=0.42u AS=0.0609p AD=0.1626p PS=0.71u PD=1.415u rfmode=0
M$15756 VSS|anode|cathode|vss \$3170 \$2948 VSS|anode|cathode|vss sg13_lv_nmos
+ L=0.13u W=0.74u AS=0.1626p AD=0.2516p PS=1.415u PD=2.16u rfmode=0
M$15757 \$2994 \$3171 VSS|anode|cathode|vss VSS|anode|cathode|vss sg13_lv_nmos
+ L=0.13u W=0.42u AS=0.1428p AD=0.0798p PS=1.52u PD=0.8u rfmode=0
M$15758 VSS|anode|cathode|vss VDD \$3128 VSS|anode|cathode|vss sg13_lv_nmos
+ L=0.13u W=0.42u AS=0.0798p AD=0.0378p PS=0.8u PD=0.6u rfmode=0
M$15759 \$3128 \$3074 \$3171 VSS|anode|cathode|vss sg13_lv_nmos L=0.13u W=0.42u
+ AS=0.0378p AD=0.1428p PS=0.6u PD=1.52u rfmode=0
M$15760 VSS|anode|cathode|vss \$3074 \$2996 VSS|anode|cathode|vss sg13_lv_nmos
+ L=0.13u W=0.64u AS=0.1331p AD=0.2176p PS=1.12u PD=1.96u rfmode=0
M$15761 VSS|anode|cathode|vss \$3074 \$2995 VSS|anode|cathode|vss sg13_lv_nmos
+ L=0.13u W=1.48u AS=0.3922p AD=0.2737p PS=3.28u PD=2.24u rfmode=0
M$15763 VSS|anode|cathode|vss \$2996 \$2997 VSS|anode|cathode|vss sg13_lv_nmos
+ L=0.13u W=1.48u AS=0.3922p AD=0.3922p PS=3.28u PD=3.28u rfmode=0
M$15765 VSS|anode|cathode|vss \$3196 \$2998 VSS|anode|cathode|vss sg13_lv_nmos
+ L=0.13u W=0.55u AS=0.187p AD=0.1045p PS=1.78u PD=0.93u rfmode=0
M$15766 \$2998 \$3416 VSS|anode|cathode|vss VSS|anode|cathode|vss sg13_lv_nmos
+ L=0.13u W=0.55u AS=0.1045p AD=0.146425p PS=0.93u PD=1.155u rfmode=0
M$15767 VSS|anode|cathode|vss \$2998 \$2999 VSS|anode|cathode|vss sg13_lv_nmos
+ L=0.13u W=1.48u AS=0.312925p AD=0.4477p PS=2.345u PD=3.43u rfmode=0
M$15769 \$3001 \$3076 \$3138 VSS|anode|cathode|vss sg13_lv_nmos L=0.13u W=0.42u
+ AS=0.1428p AD=0.0609p PS=1.52u PD=0.71u rfmode=0
M$15770 \$3138 VDD VSS|anode|cathode|vss VSS|anode|cathode|vss sg13_lv_nmos
+ L=0.13u W=0.42u AS=0.0609p AD=0.1626p PS=0.71u PD=1.415u rfmode=0
M$15771 VSS|anode|cathode|vss \$3172 \$2950 VSS|anode|cathode|vss sg13_lv_nmos
+ L=0.13u W=0.74u AS=0.1626p AD=0.2516p PS=1.415u PD=2.16u rfmode=0
M$15772 \$3003 \$3173 VSS|anode|cathode|vss VSS|anode|cathode|vss sg13_lv_nmos
+ L=0.13u W=0.42u AS=0.1428p AD=0.0798p PS=1.52u PD=0.8u rfmode=0
M$15773 VSS|anode|cathode|vss VDD \$3136 VSS|anode|cathode|vss sg13_lv_nmos
+ L=0.13u W=0.42u AS=0.0798p AD=0.0378p PS=0.8u PD=0.6u rfmode=0
M$15774 \$3136 \$3078 \$3173 VSS|anode|cathode|vss sg13_lv_nmos L=0.13u W=0.42u
+ AS=0.0378p AD=0.1428p PS=0.6u PD=1.52u rfmode=0
M$15775 VSS|anode|cathode|vss \$3078 \$3005 VSS|anode|cathode|vss sg13_lv_nmos
+ L=0.13u W=0.64u AS=0.1331p AD=0.2176p PS=1.12u PD=1.96u rfmode=0
M$15776 VSS|anode|cathode|vss \$3078 \$3004 VSS|anode|cathode|vss sg13_lv_nmos
+ L=0.13u W=1.48u AS=0.3922p AD=0.2737p PS=3.28u PD=2.24u rfmode=0
M$15778 VSS|anode|cathode|vss \$3005 \$3006 VSS|anode|cathode|vss sg13_lv_nmos
+ L=0.13u W=1.48u AS=0.3922p AD=0.3922p PS=3.28u PD=3.28u rfmode=0
M$15780 VSS|anode|cathode|vss \$3197 \$3007 VSS|anode|cathode|vss sg13_lv_nmos
+ L=0.13u W=0.55u AS=0.187p AD=0.1045p PS=1.78u PD=0.93u rfmode=0
M$15781 \$3007 \$3416 VSS|anode|cathode|vss VSS|anode|cathode|vss sg13_lv_nmos
+ L=0.13u W=0.55u AS=0.1045p AD=0.146425p PS=0.93u PD=1.155u rfmode=0
M$15782 VSS|anode|cathode|vss \$3007 \$3008 VSS|anode|cathode|vss sg13_lv_nmos
+ L=0.13u W=1.48u AS=0.312925p AD=0.4477p PS=2.345u PD=3.43u rfmode=0
M$15784 \$3010 \$3080 \$3127 VSS|anode|cathode|vss sg13_lv_nmos L=0.13u W=0.42u
+ AS=0.1428p AD=0.0609p PS=1.52u PD=0.71u rfmode=0
M$15785 \$3127 VDD VSS|anode|cathode|vss VSS|anode|cathode|vss sg13_lv_nmos
+ L=0.13u W=0.42u AS=0.0609p AD=0.1626p PS=0.71u PD=1.415u rfmode=0
M$15786 VSS|anode|cathode|vss \$3174 \$2952 VSS|anode|cathode|vss sg13_lv_nmos
+ L=0.13u W=0.74u AS=0.1626p AD=0.2516p PS=1.415u PD=2.16u rfmode=0
M$15787 \$3012 \$3175 VSS|anode|cathode|vss VSS|anode|cathode|vss sg13_lv_nmos
+ L=0.13u W=0.42u AS=0.1428p AD=0.0798p PS=1.52u PD=0.8u rfmode=0
M$15788 VSS|anode|cathode|vss VDD \$3125 VSS|anode|cathode|vss sg13_lv_nmos
+ L=0.13u W=0.42u AS=0.0798p AD=0.0378p PS=0.8u PD=0.6u rfmode=0
M$15789 \$3125 \$3082 \$3175 VSS|anode|cathode|vss sg13_lv_nmos L=0.13u W=0.42u
+ AS=0.0378p AD=0.1428p PS=0.6u PD=1.52u rfmode=0
M$15790 VSS|anode|cathode|vss \$3082 \$3014 VSS|anode|cathode|vss sg13_lv_nmos
+ L=0.13u W=0.64u AS=0.1331p AD=0.2176p PS=1.12u PD=1.96u rfmode=0
M$15791 VSS|anode|cathode|vss \$3082 \$3013 VSS|anode|cathode|vss sg13_lv_nmos
+ L=0.13u W=1.48u AS=0.3922p AD=0.2737p PS=3.28u PD=2.24u rfmode=0
M$15793 VSS|anode|cathode|vss \$3014 \$3015 VSS|anode|cathode|vss sg13_lv_nmos
+ L=0.13u W=1.48u AS=0.3922p AD=0.3922p PS=3.28u PD=3.28u rfmode=0
M$15795 VSS|anode|cathode|vss \$3198 \$3016 VSS|anode|cathode|vss sg13_lv_nmos
+ L=0.13u W=0.55u AS=0.187p AD=0.1045p PS=1.78u PD=0.93u rfmode=0
M$15796 \$3016 \$3416 VSS|anode|cathode|vss VSS|anode|cathode|vss sg13_lv_nmos
+ L=0.13u W=0.55u AS=0.1045p AD=0.146425p PS=0.93u PD=1.155u rfmode=0
M$15797 VSS|anode|cathode|vss \$3016 \$3017 VSS|anode|cathode|vss sg13_lv_nmos
+ L=0.13u W=1.48u AS=0.312925p AD=0.4477p PS=2.345u PD=3.43u rfmode=0
M$15799 \$3019 \$3084 \$3115 VSS|anode|cathode|vss sg13_lv_nmos L=0.13u W=0.42u
+ AS=0.1428p AD=0.0609p PS=1.52u PD=0.71u rfmode=0
M$15800 \$3115 VDD VSS|anode|cathode|vss VSS|anode|cathode|vss sg13_lv_nmos
+ L=0.13u W=0.42u AS=0.0609p AD=0.1626p PS=0.71u PD=1.415u rfmode=0
M$15801 VSS|anode|cathode|vss \$3176 \$2954 VSS|anode|cathode|vss sg13_lv_nmos
+ L=0.13u W=0.74u AS=0.1626p AD=0.2516p PS=1.415u PD=2.16u rfmode=0
M$15802 \$3021 \$3177 VSS|anode|cathode|vss VSS|anode|cathode|vss sg13_lv_nmos
+ L=0.13u W=0.42u AS=0.1428p AD=0.0798p PS=1.52u PD=0.8u rfmode=0
M$15803 VSS|anode|cathode|vss VDD \$3114 VSS|anode|cathode|vss sg13_lv_nmos
+ L=0.13u W=0.42u AS=0.0798p AD=0.0378p PS=0.8u PD=0.6u rfmode=0
M$15804 \$3114 \$3086 \$3177 VSS|anode|cathode|vss sg13_lv_nmos L=0.13u W=0.42u
+ AS=0.0378p AD=0.1428p PS=0.6u PD=1.52u rfmode=0
M$15805 VSS|anode|cathode|vss \$3086 \$3023 VSS|anode|cathode|vss sg13_lv_nmos
+ L=0.13u W=0.64u AS=0.1331p AD=0.2176p PS=1.12u PD=1.96u rfmode=0
M$15806 VSS|anode|cathode|vss \$3086 \$3022 VSS|anode|cathode|vss sg13_lv_nmos
+ L=0.13u W=1.48u AS=0.3922p AD=0.2737p PS=3.28u PD=2.24u rfmode=0
M$15808 VSS|anode|cathode|vss \$3023 \$3024 VSS|anode|cathode|vss sg13_lv_nmos
+ L=0.13u W=1.48u AS=0.3922p AD=0.3922p PS=3.28u PD=3.28u rfmode=0
M$15810 VSS|anode|cathode|vss VSS|anode|cathode|vss \$3025
+ VSS|anode|cathode|vss sg13_lv_nmos L=0.13u W=0.55u AS=0.187p AD=0.1045p
+ PS=1.78u PD=0.93u rfmode=0
M$15811 \$3025 \$3416 VSS|anode|cathode|vss VSS|anode|cathode|vss sg13_lv_nmos
+ L=0.13u W=0.55u AS=0.1045p AD=0.146425p PS=0.93u PD=1.155u rfmode=0
M$15812 VSS|anode|cathode|vss \$3025 \$3026 VSS|anode|cathode|vss sg13_lv_nmos
+ L=0.13u W=1.48u AS=0.312925p AD=0.4477p PS=2.345u PD=3.43u rfmode=0
M$15814 \$3028 \$3088 \$3106 VSS|anode|cathode|vss sg13_lv_nmos L=0.13u W=0.42u
+ AS=0.1428p AD=0.0609p PS=1.52u PD=0.71u rfmode=0
M$15815 \$3106 VDD VSS|anode|cathode|vss VSS|anode|cathode|vss sg13_lv_nmos
+ L=0.13u W=0.42u AS=0.0609p AD=0.1626p PS=0.71u PD=1.415u rfmode=0
M$15816 VSS|anode|cathode|vss \$3178 \$2956 VSS|anode|cathode|vss sg13_lv_nmos
+ L=0.13u W=0.74u AS=0.1626p AD=0.2516p PS=1.415u PD=2.16u rfmode=0
M$15817 \$3030 \$3179 VSS|anode|cathode|vss VSS|anode|cathode|vss sg13_lv_nmos
+ L=0.13u W=0.42u AS=0.1428p AD=0.0798p PS=1.52u PD=0.8u rfmode=0
M$15818 VSS|anode|cathode|vss VDD \$3102 VSS|anode|cathode|vss sg13_lv_nmos
+ L=0.13u W=0.42u AS=0.0798p AD=0.0378p PS=0.8u PD=0.6u rfmode=0
M$15819 \$3102 \$3090 \$3179 VSS|anode|cathode|vss sg13_lv_nmos L=0.13u W=0.42u
+ AS=0.0378p AD=0.1428p PS=0.6u PD=1.52u rfmode=0
M$15820 VSS|anode|cathode|vss \$3090 \$3032 VSS|anode|cathode|vss sg13_lv_nmos
+ L=0.13u W=0.64u AS=0.1331p AD=0.2176p PS=1.12u PD=1.96u rfmode=0
M$15821 VSS|anode|cathode|vss \$3090 \$3031 VSS|anode|cathode|vss sg13_lv_nmos
+ L=0.13u W=1.48u AS=0.3922p AD=0.2737p PS=3.28u PD=2.24u rfmode=0
M$15823 VSS|anode|cathode|vss \$3032 \$3033 VSS|anode|cathode|vss sg13_lv_nmos
+ L=0.13u W=1.48u AS=0.3922p AD=0.3922p PS=3.28u PD=3.28u rfmode=0
M$15825 \$2964 \$2963 VSS|anode|cathode|vss VSS|anode|cathode|vss sg13_lv_nmos
+ L=0.13u W=1.44u AS=0.4068p AD=0.2772p PS=3.29u PD=2.21u rfmode=0
M$15827 \$2964 VDD \$3060 VSS|anode|cathode|vss sg13_lv_nmos L=0.13u W=1.44u
+ AS=0.2772p AD=0.3816p PS=2.21u PD=3.22u rfmode=0
M$15829 VSS|anode|cathode|vss VDD \$3093 VSS|anode|cathode|vss sg13_lv_nmos
+ L=0.13u W=0.42u AS=0.1701p AD=0.03885p PS=1.65u PD=0.605u rfmode=0
M$15830 \$3093 \$2942 \$2966 VSS|anode|cathode|vss sg13_lv_nmos L=0.13u W=0.42u
+ AS=0.03885p AD=0.1596p PS=0.605u PD=1.6u rfmode=0
M$15831 \$2965 \$2943 \$3164 VSS|anode|cathode|vss sg13_lv_nmos L=0.13u W=0.42u
+ AS=0.1296p AD=0.081p PS=1.52u PD=0.81u rfmode=0
M$15832 \$3164 \$3061 \$2966 VSS|anode|cathode|vss sg13_lv_nmos L=0.13u W=0.42u
+ AS=0.081p AD=0.2163p PS=0.81u PD=1.87u rfmode=0
M$15833 VSS|anode|cathode|vss \$2943 \$3061 VSS|anode|cathode|vss sg13_lv_nmos
+ L=0.13u W=0.74u AS=0.43315p AD=0.2516p PS=2.205u PD=2.16u rfmode=0
M$15834 VSS|anode|cathode|vss CLK|clk|core|fclk_in|p2c|ui_p2c[6] \$2943
+ VSS|anode|cathode|vss sg13_lv_nmos L=0.13u W=0.74u AS=0.43315p AD=0.2516p
+ PS=2.205u PD=2.16u rfmode=0
M$15835 \$3062 \$2943 \$2967 VSS|anode|cathode|vss sg13_lv_nmos L=0.13u W=0.42u
+ AS=0.12665p AD=0.1428p PS=1.145u PD=1.52u rfmode=0
M$15836 \$2942 \$3061 \$3062 VSS|anode|cathode|vss sg13_lv_nmos L=0.13u W=0.74u
+ AS=0.3473p AD=0.12665p PS=2.71u PD=1.145u rfmode=0
M$15837 \$2973 \$2972 VSS|anode|cathode|vss VSS|anode|cathode|vss sg13_lv_nmos
+ L=0.13u W=1.44u AS=0.4068p AD=0.2772p PS=3.29u PD=2.21u rfmode=0
M$15839 \$2973 VDD \$3064 VSS|anode|cathode|vss sg13_lv_nmos L=0.13u W=1.44u
+ AS=0.2772p AD=0.3816p PS=2.21u PD=3.22u rfmode=0
M$15841 VSS|anode|cathode|vss VDD \$3103 VSS|anode|cathode|vss sg13_lv_nmos
+ L=0.13u W=0.42u AS=0.1701p AD=0.03885p PS=1.65u PD=0.605u rfmode=0
M$15842 \$3103 \$2944 \$2975 VSS|anode|cathode|vss sg13_lv_nmos L=0.13u W=0.42u
+ AS=0.03885p AD=0.1596p PS=0.605u PD=1.6u rfmode=0
M$15843 \$2974 \$2945 \$3166 VSS|anode|cathode|vss sg13_lv_nmos L=0.13u W=0.42u
+ AS=0.1296p AD=0.081p PS=1.52u PD=0.81u rfmode=0
M$15844 \$3166 \$3065 \$2975 VSS|anode|cathode|vss sg13_lv_nmos L=0.13u W=0.42u
+ AS=0.081p AD=0.2163p PS=0.81u PD=1.87u rfmode=0
M$15845 VSS|anode|cathode|vss \$2945 \$3065 VSS|anode|cathode|vss sg13_lv_nmos
+ L=0.13u W=0.74u AS=0.43315p AD=0.2516p PS=2.205u PD=2.16u rfmode=0
M$15846 VSS|anode|cathode|vss CLK|clk|core|fclk_in|p2c|ui_p2c[6] \$2945
+ VSS|anode|cathode|vss sg13_lv_nmos L=0.13u W=0.74u AS=0.43315p AD=0.2516p
+ PS=2.205u PD=2.16u rfmode=0
M$15847 \$3066 \$2945 \$2976 VSS|anode|cathode|vss sg13_lv_nmos L=0.13u W=0.42u
+ AS=0.12665p AD=0.1428p PS=1.145u PD=1.52u rfmode=0
M$15848 \$2944 \$3065 \$3066 VSS|anode|cathode|vss sg13_lv_nmos L=0.13u W=0.74u
+ AS=0.3473p AD=0.12665p PS=2.71u PD=1.145u rfmode=0
M$15849 \$2982 \$2981 VSS|anode|cathode|vss VSS|anode|cathode|vss sg13_lv_nmos
+ L=0.13u W=1.44u AS=0.4068p AD=0.2772p PS=3.29u PD=2.21u rfmode=0
M$15851 \$2982 VDD \$3068 VSS|anode|cathode|vss sg13_lv_nmos L=0.13u W=1.44u
+ AS=0.2772p AD=0.3816p PS=2.21u PD=3.22u rfmode=0
M$15853 VSS|anode|cathode|vss VDD \$3117 VSS|anode|cathode|vss sg13_lv_nmos
+ L=0.13u W=0.42u AS=0.1701p AD=0.03885p PS=1.65u PD=0.605u rfmode=0
M$15854 \$3117 \$2946 \$2984 VSS|anode|cathode|vss sg13_lv_nmos L=0.13u W=0.42u
+ AS=0.03885p AD=0.1596p PS=0.605u PD=1.6u rfmode=0
M$15855 \$2983 \$2947 \$3168 VSS|anode|cathode|vss sg13_lv_nmos L=0.13u W=0.42u
+ AS=0.1296p AD=0.081p PS=1.52u PD=0.81u rfmode=0
M$15856 \$3168 \$3069 \$2984 VSS|anode|cathode|vss sg13_lv_nmos L=0.13u W=0.42u
+ AS=0.081p AD=0.2163p PS=0.81u PD=1.87u rfmode=0
M$15857 VSS|anode|cathode|vss \$2947 \$3069 VSS|anode|cathode|vss sg13_lv_nmos
+ L=0.13u W=0.74u AS=0.43315p AD=0.2516p PS=2.205u PD=2.16u rfmode=0
M$15858 VSS|anode|cathode|vss CLK|clk|core|fclk_in|p2c|ui_p2c[6] \$2947
+ VSS|anode|cathode|vss sg13_lv_nmos L=0.13u W=0.74u AS=0.43315p AD=0.2516p
+ PS=2.205u PD=2.16u rfmode=0
M$15859 \$3070 \$2947 \$2985 VSS|anode|cathode|vss sg13_lv_nmos L=0.13u W=0.42u
+ AS=0.12665p AD=0.1428p PS=1.145u PD=1.52u rfmode=0
M$15860 \$2946 \$3069 \$3070 VSS|anode|cathode|vss sg13_lv_nmos L=0.13u W=0.74u
+ AS=0.3473p AD=0.12665p PS=2.71u PD=1.145u rfmode=0
M$15861 \$2991 \$2990 VSS|anode|cathode|vss VSS|anode|cathode|vss sg13_lv_nmos
+ L=0.13u W=1.44u AS=0.4068p AD=0.2772p PS=3.29u PD=2.21u rfmode=0
M$15863 \$2991 VDD \$3072 VSS|anode|cathode|vss sg13_lv_nmos L=0.13u W=1.44u
+ AS=0.2772p AD=0.3816p PS=2.21u PD=3.22u rfmode=0
M$15865 VSS|anode|cathode|vss VDD \$3131 VSS|anode|cathode|vss sg13_lv_nmos
+ L=0.13u W=0.42u AS=0.1701p AD=0.03885p PS=1.65u PD=0.605u rfmode=0
M$15866 \$3131 \$2948 \$2993 VSS|anode|cathode|vss sg13_lv_nmos L=0.13u W=0.42u
+ AS=0.03885p AD=0.1596p PS=0.605u PD=1.6u rfmode=0
M$15867 \$2992 \$2949 \$3170 VSS|anode|cathode|vss sg13_lv_nmos L=0.13u W=0.42u
+ AS=0.1296p AD=0.081p PS=1.52u PD=0.81u rfmode=0
M$15868 \$3170 \$3073 \$2993 VSS|anode|cathode|vss sg13_lv_nmos L=0.13u W=0.42u
+ AS=0.081p AD=0.2163p PS=0.81u PD=1.87u rfmode=0
M$15869 VSS|anode|cathode|vss \$2949 \$3073 VSS|anode|cathode|vss sg13_lv_nmos
+ L=0.13u W=0.74u AS=0.43315p AD=0.2516p PS=2.205u PD=2.16u rfmode=0
M$15870 VSS|anode|cathode|vss CLK|clk|core|fclk_in|p2c|ui_p2c[6] \$2949
+ VSS|anode|cathode|vss sg13_lv_nmos L=0.13u W=0.74u AS=0.43315p AD=0.2516p
+ PS=2.205u PD=2.16u rfmode=0
M$15871 \$3074 \$2949 \$2994 VSS|anode|cathode|vss sg13_lv_nmos L=0.13u W=0.42u
+ AS=0.12665p AD=0.1428p PS=1.145u PD=1.52u rfmode=0
M$15872 \$2948 \$3073 \$3074 VSS|anode|cathode|vss sg13_lv_nmos L=0.13u W=0.74u
+ AS=0.3473p AD=0.12665p PS=2.71u PD=1.145u rfmode=0
M$15873 \$3000 \$2999 VSS|anode|cathode|vss VSS|anode|cathode|vss sg13_lv_nmos
+ L=0.13u W=1.44u AS=0.4068p AD=0.2772p PS=3.29u PD=2.21u rfmode=0
M$15875 \$3000 VDD \$3076 VSS|anode|cathode|vss sg13_lv_nmos L=0.13u W=1.44u
+ AS=0.2772p AD=0.3816p PS=2.21u PD=3.22u rfmode=0
M$15877 VSS|anode|cathode|vss VDD \$3139 VSS|anode|cathode|vss sg13_lv_nmos
+ L=0.13u W=0.42u AS=0.1701p AD=0.03885p PS=1.65u PD=0.605u rfmode=0
M$15878 \$3139 \$2950 \$3002 VSS|anode|cathode|vss sg13_lv_nmos L=0.13u W=0.42u
+ AS=0.03885p AD=0.1596p PS=0.605u PD=1.6u rfmode=0
M$15879 \$3001 \$2951 \$3172 VSS|anode|cathode|vss sg13_lv_nmos L=0.13u W=0.42u
+ AS=0.1296p AD=0.081p PS=1.52u PD=0.81u rfmode=0
M$15880 \$3172 \$3077 \$3002 VSS|anode|cathode|vss sg13_lv_nmos L=0.13u W=0.42u
+ AS=0.081p AD=0.2163p PS=0.81u PD=1.87u rfmode=0
M$15881 VSS|anode|cathode|vss \$2951 \$3077 VSS|anode|cathode|vss sg13_lv_nmos
+ L=0.13u W=0.74u AS=0.43315p AD=0.2516p PS=2.205u PD=2.16u rfmode=0
M$15882 VSS|anode|cathode|vss CLK|clk|core|fclk_in|p2c|ui_p2c[6] \$2951
+ VSS|anode|cathode|vss sg13_lv_nmos L=0.13u W=0.74u AS=0.43315p AD=0.2516p
+ PS=2.205u PD=2.16u rfmode=0
M$15883 \$3078 \$2951 \$3003 VSS|anode|cathode|vss sg13_lv_nmos L=0.13u W=0.42u
+ AS=0.12665p AD=0.1428p PS=1.145u PD=1.52u rfmode=0
M$15884 \$2950 \$3077 \$3078 VSS|anode|cathode|vss sg13_lv_nmos L=0.13u W=0.74u
+ AS=0.3473p AD=0.12665p PS=2.71u PD=1.145u rfmode=0
M$15885 \$3009 \$3008 VSS|anode|cathode|vss VSS|anode|cathode|vss sg13_lv_nmos
+ L=0.13u W=1.44u AS=0.4068p AD=0.2772p PS=3.29u PD=2.21u rfmode=0
M$15887 \$3009 VDD \$3080 VSS|anode|cathode|vss sg13_lv_nmos L=0.13u W=1.44u
+ AS=0.2772p AD=0.3816p PS=2.21u PD=3.22u rfmode=0
M$15889 VSS|anode|cathode|vss VDD \$3129 VSS|anode|cathode|vss sg13_lv_nmos
+ L=0.13u W=0.42u AS=0.1701p AD=0.03885p PS=1.65u PD=0.605u rfmode=0
M$15890 \$3129 \$2952 \$3011 VSS|anode|cathode|vss sg13_lv_nmos L=0.13u W=0.42u
+ AS=0.03885p AD=0.1596p PS=0.605u PD=1.6u rfmode=0
M$15891 \$3010 \$2953 \$3174 VSS|anode|cathode|vss sg13_lv_nmos L=0.13u W=0.42u
+ AS=0.1296p AD=0.081p PS=1.52u PD=0.81u rfmode=0
M$15892 \$3174 \$3081 \$3011 VSS|anode|cathode|vss sg13_lv_nmos L=0.13u W=0.42u
+ AS=0.081p AD=0.2163p PS=0.81u PD=1.87u rfmode=0
M$15893 VSS|anode|cathode|vss \$2953 \$3081 VSS|anode|cathode|vss sg13_lv_nmos
+ L=0.13u W=0.74u AS=0.43315p AD=0.2516p PS=2.205u PD=2.16u rfmode=0
M$15894 VSS|anode|cathode|vss CLK|clk|core|fclk_in|p2c|ui_p2c[6] \$2953
+ VSS|anode|cathode|vss sg13_lv_nmos L=0.13u W=0.74u AS=0.43315p AD=0.2516p
+ PS=2.205u PD=2.16u rfmode=0
M$15895 \$3082 \$2953 \$3012 VSS|anode|cathode|vss sg13_lv_nmos L=0.13u W=0.42u
+ AS=0.12665p AD=0.1428p PS=1.145u PD=1.52u rfmode=0
M$15896 \$2952 \$3081 \$3082 VSS|anode|cathode|vss sg13_lv_nmos L=0.13u W=0.74u
+ AS=0.3473p AD=0.12665p PS=2.71u PD=1.145u rfmode=0
M$15897 \$3018 \$3017 VSS|anode|cathode|vss VSS|anode|cathode|vss sg13_lv_nmos
+ L=0.13u W=1.44u AS=0.4068p AD=0.2772p PS=3.29u PD=2.21u rfmode=0
M$15899 \$3018 VDD \$3084 VSS|anode|cathode|vss sg13_lv_nmos L=0.13u W=1.44u
+ AS=0.2772p AD=0.3816p PS=2.21u PD=3.22u rfmode=0
M$15901 VSS|anode|cathode|vss VDD \$3116 VSS|anode|cathode|vss sg13_lv_nmos
+ L=0.13u W=0.42u AS=0.1701p AD=0.03885p PS=1.65u PD=0.605u rfmode=0
M$15902 \$3116 \$2954 \$3020 VSS|anode|cathode|vss sg13_lv_nmos L=0.13u W=0.42u
+ AS=0.03885p AD=0.1596p PS=0.605u PD=1.6u rfmode=0
M$15903 \$3019 \$2955 \$3176 VSS|anode|cathode|vss sg13_lv_nmos L=0.13u W=0.42u
+ AS=0.1296p AD=0.081p PS=1.52u PD=0.81u rfmode=0
M$15904 \$3176 \$3085 \$3020 VSS|anode|cathode|vss sg13_lv_nmos L=0.13u W=0.42u
+ AS=0.081p AD=0.2163p PS=0.81u PD=1.87u rfmode=0
M$15905 VSS|anode|cathode|vss \$2955 \$3085 VSS|anode|cathode|vss sg13_lv_nmos
+ L=0.13u W=0.74u AS=0.43315p AD=0.2516p PS=2.205u PD=2.16u rfmode=0
M$15906 VSS|anode|cathode|vss CLK|clk|core|fclk_in|p2c|ui_p2c[6] \$2955
+ VSS|anode|cathode|vss sg13_lv_nmos L=0.13u W=0.74u AS=0.43315p AD=0.2516p
+ PS=2.205u PD=2.16u rfmode=0
M$15907 \$3086 \$2955 \$3021 VSS|anode|cathode|vss sg13_lv_nmos L=0.13u W=0.42u
+ AS=0.12665p AD=0.1428p PS=1.145u PD=1.52u rfmode=0
M$15908 \$2954 \$3085 \$3086 VSS|anode|cathode|vss sg13_lv_nmos L=0.13u W=0.74u
+ AS=0.3473p AD=0.12665p PS=2.71u PD=1.145u rfmode=0
M$15909 \$3027 \$3026 VSS|anode|cathode|vss VSS|anode|cathode|vss sg13_lv_nmos
+ L=0.13u W=1.44u AS=0.4068p AD=0.2772p PS=3.29u PD=2.21u rfmode=0
M$15911 \$3027 VDD \$3088 VSS|anode|cathode|vss sg13_lv_nmos L=0.13u W=1.44u
+ AS=0.2772p AD=0.3816p PS=2.21u PD=3.22u rfmode=0
M$15913 VSS|anode|cathode|vss VDD \$3108 VSS|anode|cathode|vss sg13_lv_nmos
+ L=0.13u W=0.42u AS=0.1701p AD=0.03885p PS=1.65u PD=0.605u rfmode=0
M$15914 \$3108 \$2956 \$3029 VSS|anode|cathode|vss sg13_lv_nmos L=0.13u W=0.42u
+ AS=0.03885p AD=0.1596p PS=0.605u PD=1.6u rfmode=0
M$15915 \$3028 \$2957 \$3178 VSS|anode|cathode|vss sg13_lv_nmos L=0.13u W=0.42u
+ AS=0.1296p AD=0.081p PS=1.52u PD=0.81u rfmode=0
M$15916 \$3178 \$3089 \$3029 VSS|anode|cathode|vss sg13_lv_nmos L=0.13u W=0.42u
+ AS=0.081p AD=0.2163p PS=0.81u PD=1.87u rfmode=0
M$15917 VSS|anode|cathode|vss \$2957 \$3089 VSS|anode|cathode|vss sg13_lv_nmos
+ L=0.13u W=0.74u AS=0.43315p AD=0.2516p PS=2.205u PD=2.16u rfmode=0
M$15918 VSS|anode|cathode|vss CLK|clk|core|fclk_in|p2c|ui_p2c[6] \$2957
+ VSS|anode|cathode|vss sg13_lv_nmos L=0.13u W=0.74u AS=0.43315p AD=0.2516p
+ PS=2.205u PD=2.16u rfmode=0
M$15919 \$3090 \$2957 \$3030 VSS|anode|cathode|vss sg13_lv_nmos L=0.13u W=0.42u
+ AS=0.12665p AD=0.1428p PS=1.145u PD=1.52u rfmode=0
M$15920 \$2956 \$3089 \$3090 VSS|anode|cathode|vss sg13_lv_nmos L=0.13u W=0.74u
+ AS=0.3473p AD=0.12665p PS=2.71u PD=1.145u rfmode=0
M$15921 VSS|anode|cathode|vss \$2248 \$2907 VSS|anode|cathode|vss sg13_lv_nmos
+ L=0.13u W=0.74u AS=0.2516p AD=0.2516p PS=2.16u PD=2.16u rfmode=0
M$15922 VSS|anode|cathode|vss \$2690 \$2958 VSS|anode|cathode|vss sg13_lv_nmos
+ L=0.13u W=0.55u AS=0.18945p AD=0.187p PS=1.27u PD=1.78u rfmode=0
M$15923 \$2905 \$3211 VSS|anode|cathode|vss VSS|anode|cathode|vss sg13_lv_nmos
+ L=0.13u W=0.74u AS=0.4033p AD=0.148p PS=2.57u PD=1.14u rfmode=0
M$15924 VSS|anode|cathode|vss \$2958 \$3297 VSS|anode|cathode|vss sg13_lv_nmos
+ L=0.13u W=0.74u AS=0.148p AD=0.3367p PS=1.14u PD=1.65u rfmode=0
M$15925 \$3297 \$2842 \$3211 VSS|anode|cathode|vss sg13_lv_nmos L=0.13u W=0.74u
+ AS=0.3367p AD=0.1628p PS=1.65u PD=1.18u rfmode=0
M$15926 \$3211 \$2390 \$3296 VSS|anode|cathode|vss sg13_lv_nmos L=0.13u W=0.74u
+ AS=0.1628p AD=0.13135p PS=1.18u PD=1.095u rfmode=0
M$15927 \$3296 \$2690 VSS|anode|cathode|vss VSS|anode|cathode|vss sg13_lv_nmos
+ L=0.13u W=0.74u AS=0.13135p AD=0.18945p PS=1.095u PD=1.27u rfmode=0
M$15928 \$3034 \$3141 \$3035 VSS|anode|cathode|vss sg13_lv_nmos L=0.13u W=0.42u
+ AS=0.1296p AD=0.0798p PS=1.52u PD=0.8u rfmode=0
M$15929 \$3035 \$3140 \$3212 VSS|anode|cathode|vss sg13_lv_nmos L=0.13u W=0.42u
+ AS=0.0798p AD=0.2373p PS=0.8u PD=1.97u rfmode=0
M$15930 \$3140 \$3141 VSS|anode|cathode|vss VSS|anode|cathode|vss sg13_lv_nmos
+ L=0.13u W=0.74u AS=0.2516p AD=0.317325p PS=2.16u PD=1.805u rfmode=0
M$15931 VSS|anode|cathode|vss \$2247 \$3141 VSS|anode|cathode|vss sg13_lv_nmos
+ L=0.13u W=0.74u AS=0.317325p AD=0.2516p PS=1.805u PD=2.16u rfmode=0
M$15932 \$3262 \$3141 \$3142 VSS|anode|cathode|vss sg13_lv_nmos L=0.13u W=0.42u
+ AS=0.1428p AD=0.12665p PS=1.52u PD=1.145u rfmode=0
M$15933 \$3142 \$3140 \$3186 VSS|anode|cathode|vss sg13_lv_nmos L=0.13u W=0.74u
+ AS=0.12665p AD=0.3473p PS=1.145u PD=2.71u rfmode=0
M$15934 \$3037 \$3145 \$3038 VSS|anode|cathode|vss sg13_lv_nmos L=0.13u W=0.42u
+ AS=0.1296p AD=0.0798p PS=1.52u PD=0.8u rfmode=0
M$15935 \$3038 \$3144 \$3213 VSS|anode|cathode|vss sg13_lv_nmos L=0.13u W=0.42u
+ AS=0.0798p AD=0.2373p PS=0.8u PD=1.97u rfmode=0
M$15936 \$3144 \$3145 VSS|anode|cathode|vss VSS|anode|cathode|vss sg13_lv_nmos
+ L=0.13u W=0.74u AS=0.2516p AD=0.317325p PS=2.16u PD=1.805u rfmode=0
M$15937 VSS|anode|cathode|vss \$2530 \$3145 VSS|anode|cathode|vss sg13_lv_nmos
+ L=0.13u W=0.74u AS=0.317325p AD=0.2516p PS=1.805u PD=2.16u rfmode=0
M$15938 \$3263 \$3145 \$3146 VSS|anode|cathode|vss sg13_lv_nmos L=0.13u W=0.42u
+ AS=0.1428p AD=0.12665p PS=1.52u PD=1.145u rfmode=0
M$15939 \$3146 \$3144 \$3187 VSS|anode|cathode|vss sg13_lv_nmos L=0.13u W=0.74u
+ AS=0.12665p AD=0.3473p PS=1.145u PD=2.71u rfmode=0
M$15940 \$3040 \$3149 \$3041 VSS|anode|cathode|vss sg13_lv_nmos L=0.13u W=0.42u
+ AS=0.1296p AD=0.0798p PS=1.52u PD=0.8u rfmode=0
M$15941 \$3041 \$3148 \$3214 VSS|anode|cathode|vss sg13_lv_nmos L=0.13u W=0.42u
+ AS=0.0798p AD=0.2373p PS=0.8u PD=1.97u rfmode=0
M$15942 \$3148 \$3149 VSS|anode|cathode|vss VSS|anode|cathode|vss sg13_lv_nmos
+ L=0.13u W=0.74u AS=0.2516p AD=0.317325p PS=2.16u PD=1.805u rfmode=0
M$15943 VSS|anode|cathode|vss \$2530 \$3149 VSS|anode|cathode|vss sg13_lv_nmos
+ L=0.13u W=0.74u AS=0.317325p AD=0.2516p PS=1.805u PD=2.16u rfmode=0
M$15944 \$3264 \$3149 \$3150 VSS|anode|cathode|vss sg13_lv_nmos L=0.13u W=0.42u
+ AS=0.1428p AD=0.12665p PS=1.52u PD=1.145u rfmode=0
M$15945 \$3150 \$3148 \$3188 VSS|anode|cathode|vss sg13_lv_nmos L=0.13u W=0.74u
+ AS=0.12665p AD=0.3473p PS=1.145u PD=2.71u rfmode=0
M$15946 \$3043 \$3153 \$3044 VSS|anode|cathode|vss sg13_lv_nmos L=0.13u W=0.42u
+ AS=0.1296p AD=0.0798p PS=1.52u PD=0.8u rfmode=0
M$15947 \$3044 \$3152 \$3215 VSS|anode|cathode|vss sg13_lv_nmos L=0.13u W=0.42u
+ AS=0.0798p AD=0.2373p PS=0.8u PD=1.97u rfmode=0
M$15948 \$3152 \$3153 VSS|anode|cathode|vss VSS|anode|cathode|vss sg13_lv_nmos
+ L=0.13u W=0.74u AS=0.2516p AD=0.317325p PS=2.16u PD=1.805u rfmode=0
M$15949 VSS|anode|cathode|vss \$2256 \$3153 VSS|anode|cathode|vss sg13_lv_nmos
+ L=0.13u W=0.74u AS=0.317325p AD=0.2516p PS=1.805u PD=2.16u rfmode=0
M$15950 \$3265 \$3153 \$3154 VSS|anode|cathode|vss sg13_lv_nmos L=0.13u W=0.42u
+ AS=0.1428p AD=0.12665p PS=1.52u PD=1.145u rfmode=0
M$15951 \$3154 \$3152 \$3189 VSS|anode|cathode|vss sg13_lv_nmos L=0.13u W=0.74u
+ AS=0.12665p AD=0.3473p PS=1.145u PD=2.71u rfmode=0
M$15952 \$3047 \$2766 VSS|anode|cathode|vss VSS|anode|cathode|vss sg13_lv_nmos
+ L=0.13u W=0.55u AS=0.187p AD=0.18945p PS=1.78u PD=1.27u rfmode=0
M$15953 VSS|anode|cathode|vss \$2766 \$3310 VSS|anode|cathode|vss sg13_lv_nmos
+ L=0.13u W=0.74u AS=0.18945p AD=0.13135p PS=1.27u PD=1.095u rfmode=0
M$15954 \$3310 \$2384 \$3048 VSS|anode|cathode|vss sg13_lv_nmos L=0.13u W=0.74u
+ AS=0.13135p AD=0.1628p PS=1.095u PD=1.18u rfmode=0
M$15955 \$3048 \$3216 \$3309 VSS|anode|cathode|vss sg13_lv_nmos L=0.13u W=0.74u
+ AS=0.1628p AD=0.3367p PS=1.18u PD=1.65u rfmode=0
M$15956 \$3309 \$3047 VSS|anode|cathode|vss VSS|anode|cathode|vss sg13_lv_nmos
+ L=0.13u W=0.74u AS=0.3367p AD=0.148p PS=1.65u PD=1.14u rfmode=0
M$15957 VSS|anode|cathode|vss \$3048 \$3049 VSS|anode|cathode|vss sg13_lv_nmos
+ L=0.13u W=0.74u AS=0.148p AD=0.4033p PS=1.14u PD=2.57u rfmode=0
M$15958 \$3050 \$3157 \$3051 VSS|anode|cathode|vss sg13_lv_nmos L=0.13u W=0.42u
+ AS=0.1296p AD=0.0798p PS=1.52u PD=0.8u rfmode=0
M$15959 \$3051 \$3156 \$3217 VSS|anode|cathode|vss sg13_lv_nmos L=0.13u W=0.42u
+ AS=0.0798p AD=0.2373p PS=0.8u PD=1.97u rfmode=0
M$15960 \$3156 \$3157 VSS|anode|cathode|vss VSS|anode|cathode|vss sg13_lv_nmos
+ L=0.13u W=0.74u AS=0.2516p AD=0.317325p PS=2.16u PD=1.805u rfmode=0
M$15961 VSS|anode|cathode|vss \$2915 \$3157 VSS|anode|cathode|vss sg13_lv_nmos
+ L=0.13u W=0.74u AS=0.317325p AD=0.2516p PS=1.805u PD=2.16u rfmode=0
M$15962 \$3266 \$3157 \$3158 VSS|anode|cathode|vss sg13_lv_nmos L=0.13u W=0.42u
+ AS=0.1428p AD=0.12665p PS=1.52u PD=1.145u rfmode=0
M$15963 \$3158 \$3156 \$3190 VSS|anode|cathode|vss sg13_lv_nmos L=0.13u W=0.74u
+ AS=0.12665p AD=0.3473p PS=1.145u PD=2.71u rfmode=0
M$15964 \$3053 \$2849 VSS|anode|cathode|vss VSS|anode|cathode|vss sg13_lv_nmos
+ L=0.13u W=0.55u AS=0.187p AD=0.18945p PS=1.78u PD=1.27u rfmode=0
M$15965 VSS|anode|cathode|vss \$2849 \$3314 VSS|anode|cathode|vss sg13_lv_nmos
+ L=0.13u W=0.74u AS=0.18945p AD=0.13135p PS=1.27u PD=1.095u rfmode=0
M$15966 \$3314 \$2384 \$3054 VSS|anode|cathode|vss sg13_lv_nmos L=0.13u W=0.74u
+ AS=0.13135p AD=0.1628p PS=1.095u PD=1.18u rfmode=0
M$15967 \$3054 \$3059 \$3317 VSS|anode|cathode|vss sg13_lv_nmos L=0.13u W=0.74u
+ AS=0.1628p AD=0.3367p PS=1.18u PD=1.65u rfmode=0
M$15968 \$3317 \$3053 VSS|anode|cathode|vss VSS|anode|cathode|vss sg13_lv_nmos
+ L=0.13u W=0.74u AS=0.3367p AD=0.148p PS=1.65u PD=1.14u rfmode=0
M$15969 VSS|anode|cathode|vss \$3054 \$3055 VSS|anode|cathode|vss sg13_lv_nmos
+ L=0.13u W=0.74u AS=0.148p AD=0.4033p PS=1.14u PD=2.57u rfmode=0
M$15970 \$3056 \$3161 \$3057 VSS|anode|cathode|vss sg13_lv_nmos L=0.13u W=0.42u
+ AS=0.1296p AD=0.0798p PS=1.52u PD=0.8u rfmode=0
M$15971 \$3057 \$3160 \$3218 VSS|anode|cathode|vss sg13_lv_nmos L=0.13u W=0.42u
+ AS=0.0798p AD=0.2373p PS=0.8u PD=1.97u rfmode=0
M$15972 \$3160 \$3161 VSS|anode|cathode|vss VSS|anode|cathode|vss sg13_lv_nmos
+ L=0.13u W=0.74u AS=0.2516p AD=0.317325p PS=2.16u PD=1.805u rfmode=0
M$15973 VSS|anode|cathode|vss \$2915 \$3161 VSS|anode|cathode|vss sg13_lv_nmos
+ L=0.13u W=0.74u AS=0.317325p AD=0.2516p PS=1.805u PD=2.16u rfmode=0
M$15974 \$3267 \$3161 \$3162 VSS|anode|cathode|vss sg13_lv_nmos L=0.13u W=0.42u
+ AS=0.1428p AD=0.12665p PS=1.52u PD=1.145u rfmode=0
M$15975 \$3162 \$3160 \$3191 VSS|anode|cathode|vss sg13_lv_nmos L=0.13u W=0.74u
+ AS=0.12665p AD=0.3473p PS=1.145u PD=2.71u rfmode=0
M$15976 \$3268 X8|dout[9] \$3278 VSS|anode|cathode|vss sg13_lv_nmos L=0.13u
+ W=0.64u AS=0.2176p AD=0.1216p PS=1.96u PD=1.02u rfmode=0
M$15977 VSS|anode|cathode|vss X9|dout[10] \$3278 VSS|anode|cathode|vss
+ sg13_lv_nmos L=0.13u W=0.64u AS=0.1331p AD=0.1216p PS=1.12u PD=1.02u rfmode=0
M$15978 VSS|anode|cathode|vss \$3268 \$3269 VSS|anode|cathode|vss sg13_lv_nmos
+ L=0.13u W=1.48u AS=0.2737p AD=0.4218p PS=2.24u PD=3.36u rfmode=0
M$15980 VSS|anode|cathode|vss X10|dout[11] \$3220 VSS|anode|cathode|vss
+ sg13_lv_nmos L=0.13u W=0.55u AS=0.187p AD=0.1045p PS=1.78u PD=0.93u rfmode=0
M$15981 \$3220 \$3269 VSS|anode|cathode|vss VSS|anode|cathode|vss sg13_lv_nmos
+ L=0.13u W=0.55u AS=0.1045p AD=0.146425p PS=0.93u PD=1.155u rfmode=0
M$15982 VSS|anode|cathode|vss \$3220 \$3221 VSS|anode|cathode|vss sg13_lv_nmos
+ L=0.13u W=1.48u AS=0.312925p AD=0.4477p PS=2.345u PD=3.43u rfmode=0
M$15986 \$882 \$3323 VSS|anode|cathode|vss VSS|anode|cathode|vss sg13_lv_nmos
+ L=0.13u W=0.74u AS=0.2886p AD=0.14875p PS=2.26u PD=1.16u rfmode=0
M$15987 VSS|anode|cathode|vss \$2909 \$3323 VSS|anode|cathode|vss sg13_lv_nmos
+ L=0.13u W=0.55u AS=0.14875p AD=0.187p PS=1.16u PD=1.78u rfmode=0
M$15988 \$881 \$3324 VSS|anode|cathode|vss VSS|anode|cathode|vss sg13_lv_nmos
+ L=0.13u W=0.74u AS=0.2886p AD=0.14875p PS=2.26u PD=1.16u rfmode=0
M$15989 VSS|anode|cathode|vss \$3046 \$3324 VSS|anode|cathode|vss sg13_lv_nmos
+ L=0.13u W=0.55u AS=0.14875p AD=0.187p PS=1.16u PD=1.78u rfmode=0
M$15994 D0|c2p|core|i|uo_c2p[8] \$3325 VSS|anode|cathode|vss
+ VSS|anode|cathode|vss sg13_lv_nmos L=0.13u W=0.74u AS=0.2886p AD=0.14875p
+ PS=2.26u PD=1.16u rfmode=0
M$15995 VSS|anode|cathode|vss \$3392 \$3325 VSS|anode|cathode|vss sg13_lv_nmos
+ L=0.13u W=0.55u AS=0.14875p AD=0.187p PS=1.16u PD=1.78u rfmode=0
M$16006 D1|c2p|core|i|uo_c2p[7] \$3326 VSS|anode|cathode|vss
+ VSS|anode|cathode|vss sg13_lv_nmos L=0.13u W=0.74u AS=0.2886p AD=0.14875p
+ PS=2.26u PD=1.16u rfmode=0
M$16007 VSS|anode|cathode|vss \$2687 \$3326 VSS|anode|cathode|vss sg13_lv_nmos
+ L=0.13u W=0.55u AS=0.14875p AD=0.187p PS=1.16u PD=1.78u rfmode=0
M$16013 VSS|anode|cathode|vss \$3035 \$3186 VSS|anode|cathode|vss sg13_lv_nmos
+ L=0.13u W=0.74u AS=0.1626p AD=0.2516p PS=1.415u PD=2.16u rfmode=0
M$16014 \$3034 \$3319 \$3295 VSS|anode|cathode|vss sg13_lv_nmos L=0.13u W=0.42u
+ AS=0.1428p AD=0.0609p PS=1.52u PD=0.71u rfmode=0
M$16015 VSS|anode|cathode|vss \$2843 \$3295 VSS|anode|cathode|vss sg13_lv_nmos
+ L=0.13u W=0.42u AS=0.1626p AD=0.0609p PS=1.415u PD=0.71u rfmode=0
M$16016 D2|c2p|core|i|uo_c2p[6] \$3327 VSS|anode|cathode|vss
+ VSS|anode|cathode|vss sg13_lv_nmos L=0.13u W=0.74u AS=0.2886p AD=0.14875p
+ PS=2.26u PD=1.16u rfmode=0
M$16017 VSS|anode|cathode|vss \$2842 \$3327 VSS|anode|cathode|vss sg13_lv_nmos
+ L=0.13u W=0.55u AS=0.14875p AD=0.187p PS=1.16u PD=1.78u rfmode=0
M$16018 VSS|anode|cathode|vss \$2843 \$3298 VSS|anode|cathode|vss sg13_lv_nmos
+ L=0.13u W=0.42u AS=0.1701p AD=0.0378p PS=1.65u PD=0.6u rfmode=0
M$16019 \$3298 \$3186 \$3212 VSS|anode|cathode|vss sg13_lv_nmos L=0.13u W=0.42u
+ AS=0.0378p AD=0.1428p PS=0.6u PD=1.52u rfmode=0
M$16020 \$3262 \$3143 VSS|anode|cathode|vss VSS|anode|cathode|vss sg13_lv_nmos
+ L=0.13u W=0.42u AS=0.1428p AD=0.0798p PS=1.52u PD=0.8u rfmode=0
M$16021 VSS|anode|cathode|vss \$2843 \$3300 VSS|anode|cathode|vss sg13_lv_nmos
+ L=0.13u W=0.42u AS=0.0798p AD=0.0378p PS=0.8u PD=0.6u rfmode=0
M$16022 \$3300 \$3142 \$3143 VSS|anode|cathode|vss sg13_lv_nmos L=0.13u W=0.42u
+ AS=0.0378p AD=0.1428p PS=0.6u PD=1.52u rfmode=0
M$16023 \$3036 \$3142 VSS|anode|cathode|vss VSS|anode|cathode|vss sg13_lv_nmos
+ L=0.13u W=0.74u AS=0.2516p AD=0.1406p PS=2.16u PD=1.12u rfmode=0
M$16024 VSS|anode|cathode|vss \$3036 \$3392 VSS|anode|cathode|vss sg13_lv_nmos
+ L=0.13u W=0.74u AS=0.1406p AD=0.2516p PS=1.12u PD=2.16u rfmode=0
M$16025 VSS|anode|cathode|vss \$3038 \$3187 VSS|anode|cathode|vss sg13_lv_nmos
+ L=0.13u W=0.74u AS=0.1626p AD=0.2516p PS=1.415u PD=2.16u rfmode=0
M$16026 \$3037 \$2844 \$3299 VSS|anode|cathode|vss sg13_lv_nmos L=0.13u W=0.42u
+ AS=0.1428p AD=0.0609p PS=1.52u PD=0.71u rfmode=0
M$16027 VSS|anode|cathode|vss \$2959 \$3299 VSS|anode|cathode|vss sg13_lv_nmos
+ L=0.13u W=0.42u AS=0.1626p AD=0.0609p PS=1.415u PD=0.71u rfmode=0
M$16028 VSS|anode|cathode|vss \$2959 \$3301 VSS|anode|cathode|vss sg13_lv_nmos
+ L=0.13u W=0.42u AS=0.1701p AD=0.0378p PS=1.65u PD=0.6u rfmode=0
M$16029 \$3301 \$3187 \$3213 VSS|anode|cathode|vss sg13_lv_nmos L=0.13u W=0.42u
+ AS=0.0378p AD=0.1428p PS=0.6u PD=1.52u rfmode=0
M$16030 D3|c2p|core|i|uo_c2p[5] \$3329 VSS|anode|cathode|vss
+ VSS|anode|cathode|vss sg13_lv_nmos L=0.13u W=0.74u AS=0.2886p AD=0.14875p
+ PS=2.26u PD=1.16u rfmode=0
M$16031 VSS|anode|cathode|vss \$2908 \$3329 VSS|anode|cathode|vss sg13_lv_nmos
+ L=0.13u W=0.55u AS=0.14875p AD=0.187p PS=1.16u PD=1.78u rfmode=0
M$16032 \$3263 \$3147 VSS|anode|cathode|vss VSS|anode|cathode|vss sg13_lv_nmos
+ L=0.13u W=0.42u AS=0.1428p AD=0.0798p PS=1.52u PD=0.8u rfmode=0
M$16033 VSS|anode|cathode|vss \$2959 \$3303 VSS|anode|cathode|vss sg13_lv_nmos
+ L=0.13u W=0.42u AS=0.0798p AD=0.0378p PS=0.8u PD=0.6u rfmode=0
M$16034 \$3303 \$3146 \$3147 VSS|anode|cathode|vss sg13_lv_nmos L=0.13u W=0.42u
+ AS=0.0378p AD=0.1428p PS=0.6u PD=1.52u rfmode=0
M$16035 \$3039 \$3146 VSS|anode|cathode|vss VSS|anode|cathode|vss sg13_lv_nmos
+ L=0.13u W=0.74u AS=0.2516p AD=0.1406p PS=2.16u PD=1.12u rfmode=0
M$16036 VSS|anode|cathode|vss \$3039 \$2908 VSS|anode|cathode|vss sg13_lv_nmos
+ L=0.13u W=0.74u AS=0.1406p AD=0.2516p PS=1.12u PD=2.16u rfmode=0
M$16037 VSS|anode|cathode|vss \$3041 \$3188 VSS|anode|cathode|vss sg13_lv_nmos
+ L=0.13u W=0.74u AS=0.1626p AD=0.2516p PS=1.415u PD=2.16u rfmode=0
M$16038 \$3040 \$2877 \$3302 VSS|anode|cathode|vss sg13_lv_nmos L=0.13u W=0.42u
+ AS=0.1428p AD=0.0609p PS=1.52u PD=0.71u rfmode=0
M$16039 VSS|anode|cathode|vss \$2960 \$3302 VSS|anode|cathode|vss sg13_lv_nmos
+ L=0.13u W=0.42u AS=0.1626p AD=0.0609p PS=1.415u PD=0.71u rfmode=0
M$16040 VSS|anode|cathode|vss \$2960 \$3304 VSS|anode|cathode|vss sg13_lv_nmos
+ L=0.13u W=0.42u AS=0.1701p AD=0.0378p PS=1.65u PD=0.6u rfmode=0
M$16041 \$3304 \$3188 \$3214 VSS|anode|cathode|vss sg13_lv_nmos L=0.13u W=0.42u
+ AS=0.0378p AD=0.1428p PS=0.6u PD=1.52u rfmode=0
M$16042 \$3264 \$3151 VSS|anode|cathode|vss VSS|anode|cathode|vss sg13_lv_nmos
+ L=0.13u W=0.42u AS=0.1428p AD=0.0798p PS=1.52u PD=0.8u rfmode=0
M$16043 VSS|anode|cathode|vss \$2960 \$3305 VSS|anode|cathode|vss sg13_lv_nmos
+ L=0.13u W=0.42u AS=0.0798p AD=0.0378p PS=0.8u PD=0.6u rfmode=0
M$16044 \$3305 \$3150 \$3151 VSS|anode|cathode|vss sg13_lv_nmos L=0.13u W=0.42u
+ AS=0.0378p AD=0.1428p PS=0.6u PD=1.52u rfmode=0
M$16045 \$3042 \$3150 VSS|anode|cathode|vss VSS|anode|cathode|vss sg13_lv_nmos
+ L=0.13u W=0.74u AS=0.2516p AD=0.1406p PS=2.16u PD=1.12u rfmode=0
M$16046 VSS|anode|cathode|vss \$3042 \$2909 VSS|anode|cathode|vss sg13_lv_nmos
+ L=0.13u W=0.74u AS=0.1406p AD=0.2516p PS=1.12u PD=2.16u rfmode=0
M$16047 VSS|anode|cathode|vss \$3044 \$3189 VSS|anode|cathode|vss sg13_lv_nmos
+ L=0.13u W=0.74u AS=0.1626p AD=0.2516p PS=1.415u PD=2.16u rfmode=0
M$16048 \$3043 \$2851 \$3307 VSS|anode|cathode|vss sg13_lv_nmos L=0.13u W=0.42u
+ AS=0.1428p AD=0.0609p PS=1.52u PD=0.71u rfmode=0
M$16049 VSS|anode|cathode|vss \$2852 \$3307 VSS|anode|cathode|vss sg13_lv_nmos
+ L=0.13u W=0.42u AS=0.1626p AD=0.0609p PS=1.415u PD=0.71u rfmode=0
M$16050 D4|c2p|core|i|uo_c2p[4] \$3330 VSS|anode|cathode|vss
+ VSS|anode|cathode|vss sg13_lv_nmos L=0.13u W=0.74u AS=0.2886p AD=0.14875p
+ PS=2.26u PD=1.16u rfmode=0
M$16051 VSS|anode|cathode|vss \$2650 \$3330 VSS|anode|cathode|vss sg13_lv_nmos
+ L=0.13u W=0.55u AS=0.14875p AD=0.187p PS=1.16u PD=1.78u rfmode=0
M$16052 VSS|anode|cathode|vss \$2852 \$3306 VSS|anode|cathode|vss sg13_lv_nmos
+ L=0.13u W=0.42u AS=0.1701p AD=0.0378p PS=1.65u PD=0.6u rfmode=0
M$16053 \$3306 \$3189 \$3215 VSS|anode|cathode|vss sg13_lv_nmos L=0.13u W=0.42u
+ AS=0.0378p AD=0.1428p PS=0.6u PD=1.52u rfmode=0
M$16054 \$3265 \$3155 VSS|anode|cathode|vss VSS|anode|cathode|vss sg13_lv_nmos
+ L=0.13u W=0.42u AS=0.1428p AD=0.0798p PS=1.52u PD=0.8u rfmode=0
M$16055 VSS|anode|cathode|vss \$2852 \$3308 VSS|anode|cathode|vss sg13_lv_nmos
+ L=0.13u W=0.42u AS=0.0798p AD=0.0378p PS=0.8u PD=0.6u rfmode=0
M$16056 \$3308 \$3154 \$3155 VSS|anode|cathode|vss sg13_lv_nmos L=0.13u W=0.42u
+ AS=0.0378p AD=0.1428p PS=0.6u PD=1.52u rfmode=0
M$16057 \$3045 \$3154 VSS|anode|cathode|vss VSS|anode|cathode|vss sg13_lv_nmos
+ L=0.13u W=0.74u AS=0.2516p AD=0.1406p PS=2.16u PD=1.12u rfmode=0
M$16058 VSS|anode|cathode|vss \$3045 \$3046 VSS|anode|cathode|vss sg13_lv_nmos
+ L=0.13u W=0.74u AS=0.1406p AD=0.2516p PS=1.12u PD=2.16u rfmode=0
M$16061 D5|c2p|core|i|uo_c2p[3] \$3331 VSS|anode|cathode|vss
+ VSS|anode|cathode|vss sg13_lv_nmos L=0.13u W=0.74u AS=0.2886p AD=0.14875p
+ PS=2.26u PD=1.16u rfmode=0
M$16062 VSS|anode|cathode|vss \$2801 \$3331 VSS|anode|cathode|vss sg13_lv_nmos
+ L=0.13u W=0.55u AS=0.14875p AD=0.187p PS=1.16u PD=1.78u rfmode=0
M$16063 VSS|anode|cathode|vss \$3051 \$3190 VSS|anode|cathode|vss sg13_lv_nmos
+ L=0.13u W=0.74u AS=0.1626p AD=0.2516p PS=1.415u PD=2.16u rfmode=0
M$16064 \$3050 \$3049 \$3312 VSS|anode|cathode|vss sg13_lv_nmos L=0.13u W=0.42u
+ AS=0.1428p AD=0.0609p PS=1.52u PD=0.71u rfmode=0
M$16065 VSS|anode|cathode|vss \$2859 \$3312 VSS|anode|cathode|vss sg13_lv_nmos
+ L=0.13u W=0.42u AS=0.1626p AD=0.0609p PS=1.415u PD=0.71u rfmode=0
M$16066 VSS|anode|cathode|vss \$2859 \$3311 VSS|anode|cathode|vss sg13_lv_nmos
+ L=0.13u W=0.42u AS=0.1701p AD=0.0378p PS=1.65u PD=0.6u rfmode=0
M$16067 \$3311 \$3190 \$3217 VSS|anode|cathode|vss sg13_lv_nmos L=0.13u W=0.42u
+ AS=0.0378p AD=0.1428p PS=0.6u PD=1.52u rfmode=0
M$16068 \$2915 \$3332 VSS|anode|cathode|vss VSS|anode|cathode|vss sg13_lv_nmos
+ L=0.13u W=0.74u AS=0.2886p AD=0.14875p PS=2.26u PD=1.16u rfmode=0
M$16069 VSS|anode|cathode|vss \$2099 \$3332 VSS|anode|cathode|vss sg13_lv_nmos
+ L=0.13u W=0.55u AS=0.14875p AD=0.187p PS=1.16u PD=1.78u rfmode=0
M$16070 \$3266 \$3159 VSS|anode|cathode|vss VSS|anode|cathode|vss sg13_lv_nmos
+ L=0.13u W=0.42u AS=0.1428p AD=0.0798p PS=1.52u PD=0.8u rfmode=0
M$16071 VSS|anode|cathode|vss \$2859 \$3313 VSS|anode|cathode|vss sg13_lv_nmos
+ L=0.13u W=0.42u AS=0.0798p AD=0.0378p PS=0.8u PD=0.6u rfmode=0
M$16072 \$3313 \$3158 \$3159 VSS|anode|cathode|vss sg13_lv_nmos L=0.13u W=0.42u
+ AS=0.0378p AD=0.1428p PS=0.6u PD=1.52u rfmode=0
M$16073 \$3052 \$3158 VSS|anode|cathode|vss VSS|anode|cathode|vss sg13_lv_nmos
+ L=0.13u W=0.74u AS=0.2516p AD=0.1406p PS=2.16u PD=1.12u rfmode=0
M$16074 VSS|anode|cathode|vss \$3052 \$3216 VSS|anode|cathode|vss sg13_lv_nmos
+ L=0.13u W=0.74u AS=0.1406p AD=0.2516p PS=1.12u PD=2.16u rfmode=0
M$16077 VSS|anode|cathode|vss \$3216 \$3333 VSS|anode|cathode|vss sg13_lv_nmos
+ L=0.13u W=0.55u AS=0.14875p AD=0.187p PS=1.16u PD=1.78u rfmode=0
M$16078 VSS|anode|cathode|vss \$3333 D6|c2p|core|i|uo_c2p[2]
+ VSS|anode|cathode|vss sg13_lv_nmos L=0.13u W=0.74u AS=0.14875p AD=0.2886p
+ PS=1.16u PD=2.26u rfmode=0
M$16079 VSS|anode|cathode|vss \$3057 \$3191 VSS|anode|cathode|vss sg13_lv_nmos
+ L=0.13u W=0.74u AS=0.1626p AD=0.2516p PS=1.415u PD=2.16u rfmode=0
M$16080 \$3056 \$3055 \$3316 VSS|anode|cathode|vss sg13_lv_nmos L=0.13u W=0.42u
+ AS=0.1428p AD=0.0609p PS=1.52u PD=0.71u rfmode=0
M$16081 VSS|anode|cathode|vss \$2961 \$3316 VSS|anode|cathode|vss sg13_lv_nmos
+ L=0.13u W=0.42u AS=0.1626p AD=0.0609p PS=1.415u PD=0.71u rfmode=0
M$16082 VSS|anode|cathode|vss \$2961 \$3315 VSS|anode|cathode|vss sg13_lv_nmos
+ L=0.13u W=0.42u AS=0.1701p AD=0.0378p PS=1.65u PD=0.6u rfmode=0
M$16083 \$3315 \$3191 \$3218 VSS|anode|cathode|vss sg13_lv_nmos L=0.13u W=0.42u
+ AS=0.0378p AD=0.1428p PS=0.6u PD=1.52u rfmode=0
M$16084 \$3267 \$3163 VSS|anode|cathode|vss VSS|anode|cathode|vss sg13_lv_nmos
+ L=0.13u W=0.42u AS=0.1428p AD=0.0798p PS=1.52u PD=0.8u rfmode=0
M$16085 VSS|anode|cathode|vss \$2961 \$3318 VSS|anode|cathode|vss sg13_lv_nmos
+ L=0.13u W=0.42u AS=0.0798p AD=0.0378p PS=0.8u PD=0.6u rfmode=0
M$16086 \$3318 \$3162 \$3163 VSS|anode|cathode|vss sg13_lv_nmos L=0.13u W=0.42u
+ AS=0.0378p AD=0.1428p PS=0.6u PD=1.52u rfmode=0
M$16087 \$3058 \$3162 VSS|anode|cathode|vss VSS|anode|cathode|vss sg13_lv_nmos
+ L=0.13u W=0.74u AS=0.2516p AD=0.1406p PS=2.16u PD=1.12u rfmode=0
M$16088 VSS|anode|cathode|vss \$3058 \$3059 VSS|anode|cathode|vss sg13_lv_nmos
+ L=0.13u W=0.74u AS=0.1406p AD=0.2516p PS=1.12u PD=2.16u rfmode=0
M$16091 D7|c2p|core|i|uo_c2p[1] \$3335 VSS|anode|cathode|vss
+ VSS|anode|cathode|vss sg13_lv_nmos L=0.13u W=0.74u AS=0.2886p AD=0.14875p
+ PS=2.26u PD=1.16u rfmode=0
M$16092 VSS|anode|cathode|vss \$3059 \$3335 VSS|anode|cathode|vss sg13_lv_nmos
+ L=0.13u W=0.55u AS=0.14875p AD=0.187p PS=1.16u PD=1.78u rfmode=0
M$16095 VSS|anode|cathode|vss \$2871 \$3336 VSS|anode|cathode|vss sg13_lv_nmos
+ L=0.13u W=0.55u AS=0.14875p AD=0.187p PS=1.16u PD=1.78u rfmode=0
M$16096 VSS|anode|cathode|vss \$3336 \$893 VSS|anode|cathode|vss sg13_lv_nmos
+ L=0.13u W=0.74u AS=0.14875p AD=0.2886p PS=1.16u PD=2.26u rfmode=0
M$16098 VSS|anode|cathode|vss \$2802 \$3337 VSS|anode|cathode|vss sg13_lv_nmos
+ L=0.13u W=0.55u AS=0.14875p AD=0.187p PS=1.16u PD=1.78u rfmode=0
M$16099 VSS|anode|cathode|vss \$3337 \$892 VSS|anode|cathode|vss sg13_lv_nmos
+ L=0.13u W=0.74u AS=0.14875p AD=0.2886p PS=1.16u PD=2.26u rfmode=0
M$16101 \$3319 \$3320 VSS|anode|cathode|vss VSS|anode|cathode|vss sg13_lv_nmos
+ L=0.13u W=0.74u AS=0.4033p AD=0.148p PS=2.57u PD=1.14u rfmode=0
M$16102 VSS|anode|cathode|vss \$3328 \$3339 VSS|anode|cathode|vss sg13_lv_nmos
+ L=0.13u W=0.74u AS=0.148p AD=0.3367p PS=1.14u PD=1.65u rfmode=0
M$16103 \$3339 \$3392 \$3320 VSS|anode|cathode|vss sg13_lv_nmos L=0.13u W=0.74u
+ AS=0.3367p AD=0.1628p PS=1.65u PD=1.18u rfmode=0
M$16104 \$3320 \$2390 \$3340 VSS|anode|cathode|vss sg13_lv_nmos L=0.13u W=0.74u
+ AS=0.1628p AD=0.13135p PS=1.18u PD=1.095u rfmode=0
M$16105 \$3340 \$2556 VSS|anode|cathode|vss VSS|anode|cathode|vss sg13_lv_nmos
+ L=0.13u W=0.74u AS=0.13135p AD=0.18945p PS=1.095u PD=1.27u rfmode=0
M$16106 VSS|anode|cathode|vss \$2556 \$3328 VSS|anode|cathode|vss sg13_lv_nmos
+ L=0.13u W=0.55u AS=0.18945p AD=0.187p PS=1.27u PD=1.78u rfmode=0
M$16108 VSS|anode|cathode|vss \$2248 \$2959 VSS|anode|cathode|vss sg13_lv_nmos
+ L=0.13u W=0.74u AS=0.2516p AD=0.2516p PS=2.16u PD=2.16u rfmode=0
M$16110 VSS|anode|cathode|vss \$2248 \$2960 VSS|anode|cathode|vss sg13_lv_nmos
+ L=0.13u W=0.74u AS=0.2516p AD=0.2516p PS=2.16u PD=2.16u rfmode=0
M$16111 VSS|anode|cathode|vss \$3046 \$2911 VSS|anode|cathode|vss sg13_lv_nmos
+ L=0.13u W=0.74u AS=0.2516p AD=0.2516p PS=2.16u PD=2.16u rfmode=0
M$16113 VSS|anode|cathode|vss \$2849 \$3334 VSS|anode|cathode|vss sg13_lv_nmos
+ L=0.13u W=0.55u AS=0.18945p AD=0.187p PS=1.27u PD=1.78u rfmode=0
M$16114 VSS|anode|cathode|vss \$2849 \$3342 VSS|anode|cathode|vss sg13_lv_nmos
+ L=0.13u W=0.74u AS=0.18945p AD=0.13135p PS=1.27u PD=1.095u rfmode=0
M$16115 \$3342 \$2384 \$3321 VSS|anode|cathode|vss sg13_lv_nmos L=0.13u W=0.74u
+ AS=0.13135p AD=0.1628p PS=1.095u PD=1.18u rfmode=0
M$16116 \$3321 \$2871 \$3341 VSS|anode|cathode|vss sg13_lv_nmos L=0.13u W=0.74u
+ AS=0.1628p AD=0.3367p PS=1.18u PD=1.65u rfmode=0
M$16117 \$3341 \$3334 VSS|anode|cathode|vss VSS|anode|cathode|vss sg13_lv_nmos
+ L=0.13u W=0.74u AS=0.3367p AD=0.148p PS=1.65u PD=1.14u rfmode=0
M$16118 VSS|anode|cathode|vss \$3321 \$3322 VSS|anode|cathode|vss sg13_lv_nmos
+ L=0.13u W=0.74u AS=0.148p AD=0.4033p PS=1.14u PD=2.57u rfmode=0
M$16119 VSS|anode|cathode|vss \$2651 \$2961 VSS|anode|cathode|vss sg13_lv_nmos
+ L=0.13u W=0.74u AS=0.2516p AD=0.2516p PS=2.16u PD=2.16u rfmode=0
M$16176 VSS|anode|cathode|vss X9|dout[10] \$3413 VSS|anode|cathode|vss
+ sg13_lv_nmos L=0.13u W=0.55u AS=0.187p AD=0.1045p PS=1.78u PD=0.93u rfmode=0
M$16177 \$3413 X10|dout[11] VSS|anode|cathode|vss VSS|anode|cathode|vss
+ sg13_lv_nmos L=0.13u W=0.55u AS=0.1045p AD=0.146425p PS=0.93u PD=1.155u
+ rfmode=0
M$16178 VSS|anode|cathode|vss \$3413 \$3414 VSS|anode|cathode|vss sg13_lv_nmos
+ L=0.13u W=1.48u AS=0.312925p AD=0.4477p PS=2.345u PD=3.43u rfmode=0
M$16180 VSS|anode|cathode|vss X9|dout[10] \$3393 VSS|anode|cathode|vss
+ sg13_lv_nmos L=0.13u W=0.55u AS=0.187p AD=0.1045p PS=1.78u PD=0.93u rfmode=0
M$16181 VSS|anode|cathode|vss X8|dout[9] \$3393 VSS|anode|cathode|vss
+ sg13_lv_nmos L=0.13u W=0.55u AS=0.146425p AD=0.1045p PS=1.155u PD=0.93u
+ rfmode=0
M$16182 VSS|anode|cathode|vss \$3393 \$3394 VSS|anode|cathode|vss sg13_lv_nmos
+ L=0.13u W=1.48u AS=0.312925p AD=0.4477p PS=2.345u PD=3.43u rfmode=0
M$16184 VSS|anode|cathode|vss X8|dout[9] \$3415 VSS|anode|cathode|vss
+ sg13_lv_nmos L=0.13u W=0.55u AS=0.187p AD=0.1045p PS=1.78u PD=0.93u rfmode=0
M$16185 \$3415 \$3414 VSS|anode|cathode|vss VSS|anode|cathode|vss sg13_lv_nmos
+ L=0.13u W=0.55u AS=0.1045p AD=0.146425p PS=0.93u PD=1.155u rfmode=0
M$16186 VSS|anode|cathode|vss \$3415 \$3416 VSS|anode|cathode|vss sg13_lv_nmos
+ L=0.13u W=1.48u AS=0.312925p AD=0.4477p PS=2.345u PD=3.43u rfmode=0
M$16188 \$3395 X10|dout[11] \$3412 VSS|anode|cathode|vss sg13_lv_nmos L=0.13u
+ W=0.64u AS=0.2176p AD=0.1216p PS=1.96u PD=1.02u rfmode=0
M$16189 \$3412 \$3394 VSS|anode|cathode|vss VSS|anode|cathode|vss sg13_lv_nmos
+ L=0.13u W=0.64u AS=0.1216p AD=0.1331p PS=1.02u PD=1.12u rfmode=0
M$16190 VSS|anode|cathode|vss \$3395 \$3396 VSS|anode|cathode|vss sg13_lv_nmos
+ L=0.13u W=1.48u AS=0.2737p AD=0.4218p PS=2.24u PD=3.36u rfmode=0
M$16192 VSS|anode|cathode|vss VSS|anode|cathode|vss \$3222
+ VSS|anode|cathode|vss sg13_lv_nmos L=0.13u W=1u AS=0.265p AD=0.265p PS=2.56u
+ PD=2.56u rfmode=0
M$16193 \$3222 \$2968 OUTP|analog_io_padres[16]|core|padres
+ VSS|anode|cathode|vss sg13_lv_nmos L=0.13u W=2u AS=0.38p AD=0.38p PS=3.52u
+ PD=3.52u rfmode=0
M$16195 \$3222 \$2970 OUTN|analog_io_padres[15]|core|padres
+ VSS|anode|cathode|vss sg13_lv_nmos L=0.13u W=2u AS=0.38p AD=0.38p PS=3.52u
+ PD=3.52u rfmode=0
M$16202 VSS|anode|cathode|vss VSS|anode|cathode|vss \$3223
+ VSS|anode|cathode|vss sg13_lv_nmos L=0.13u W=1u AS=0.265p AD=0.265p PS=2.56u
+ PD=2.56u rfmode=0
M$16203 \$3223 \$2977 OUTP|analog_io_padres[16]|core|padres
+ VSS|anode|cathode|vss sg13_lv_nmos L=0.13u W=2u AS=0.38p AD=0.38p PS=3.52u
+ PD=3.52u rfmode=0
M$16205 \$3223 \$2979 OUTN|analog_io_padres[15]|core|padres
+ VSS|anode|cathode|vss sg13_lv_nmos L=0.13u W=2u AS=0.38p AD=0.38p PS=3.52u
+ PD=3.52u rfmode=0
M$16212 VSS|anode|cathode|vss VSS|anode|cathode|vss \$3224
+ VSS|anode|cathode|vss sg13_lv_nmos L=0.13u W=1u AS=0.265p AD=0.265p PS=2.56u
+ PD=2.56u rfmode=0
M$16213 \$3224 \$2986 OUTP|analog_io_padres[16]|core|padres
+ VSS|anode|cathode|vss sg13_lv_nmos L=0.13u W=2u AS=0.38p AD=0.38p PS=3.52u
+ PD=3.52u rfmode=0
M$16215 \$3224 \$2988 OUTN|analog_io_padres[15]|core|padres
+ VSS|anode|cathode|vss sg13_lv_nmos L=0.13u W=2u AS=0.38p AD=0.38p PS=3.52u
+ PD=3.52u rfmode=0
M$16222 VSS|anode|cathode|vss VSS|anode|cathode|vss \$3225
+ VSS|anode|cathode|vss sg13_lv_nmos L=0.13u W=1u AS=0.265p AD=0.265p PS=2.56u
+ PD=2.56u rfmode=0
M$16223 \$3225 \$2995 OUTP|analog_io_padres[16]|core|padres
+ VSS|anode|cathode|vss sg13_lv_nmos L=0.13u W=2u AS=0.38p AD=0.38p PS=3.52u
+ PD=3.52u rfmode=0
M$16225 \$3225 \$2997 OUTN|analog_io_padres[15]|core|padres
+ VSS|anode|cathode|vss sg13_lv_nmos L=0.13u W=2u AS=0.38p AD=0.38p PS=3.52u
+ PD=3.52u rfmode=0
M$16232 VSS|anode|cathode|vss VSS|anode|cathode|vss \$3226
+ VSS|anode|cathode|vss sg13_lv_nmos L=0.13u W=1u AS=0.265p AD=0.265p PS=2.56u
+ PD=2.56u rfmode=0
M$16233 \$3226 \$3004 OUTP|analog_io_padres[16]|core|padres
+ VSS|anode|cathode|vss sg13_lv_nmos L=0.13u W=2u AS=0.38p AD=0.38p PS=3.52u
+ PD=3.52u rfmode=0
M$16235 \$3226 \$3006 OUTN|analog_io_padres[15]|core|padres
+ VSS|anode|cathode|vss sg13_lv_nmos L=0.13u W=2u AS=0.38p AD=0.38p PS=3.52u
+ PD=3.52u rfmode=0
M$16242 VSS|anode|cathode|vss VSS|anode|cathode|vss \$3227
+ VSS|anode|cathode|vss sg13_lv_nmos L=0.13u W=1u AS=0.265p AD=0.265p PS=2.56u
+ PD=2.56u rfmode=0
M$16243 \$3227 \$3013 OUTP|analog_io_padres[16]|core|padres
+ VSS|anode|cathode|vss sg13_lv_nmos L=0.13u W=2u AS=0.38p AD=0.38p PS=3.52u
+ PD=3.52u rfmode=0
M$16245 \$3227 \$3015 OUTN|analog_io_padres[15]|core|padres
+ VSS|anode|cathode|vss sg13_lv_nmos L=0.13u W=2u AS=0.38p AD=0.38p PS=3.52u
+ PD=3.52u rfmode=0
M$16252 VSS|anode|cathode|vss VSS|anode|cathode|vss \$3228
+ VSS|anode|cathode|vss sg13_lv_nmos L=0.13u W=1u AS=0.265p AD=0.265p PS=2.56u
+ PD=2.56u rfmode=0
M$16253 \$3228 \$3022 OUTP|analog_io_padres[16]|core|padres
+ VSS|anode|cathode|vss sg13_lv_nmos L=0.13u W=2u AS=0.38p AD=0.38p PS=3.52u
+ PD=3.52u rfmode=0
M$16255 \$3228 \$3024 OUTN|analog_io_padres[15]|core|padres
+ VSS|anode|cathode|vss sg13_lv_nmos L=0.13u W=2u AS=0.38p AD=0.38p PS=3.52u
+ PD=3.52u rfmode=0
M$16262 VSS|anode|cathode|vss VSS|anode|cathode|vss \$3229
+ VSS|anode|cathode|vss sg13_lv_nmos L=0.13u W=1u AS=0.265p AD=0.265p PS=2.56u
+ PD=2.56u rfmode=0
M$16263 \$3229 \$3031 OUTP|analog_io_padres[16]|core|padres
+ VSS|anode|cathode|vss sg13_lv_nmos L=0.13u W=2u AS=0.38p AD=0.38p PS=3.52u
+ PD=3.52u rfmode=0
M$16265 \$3229 \$3033 OUTN|analog_io_padres[15]|core|padres
+ VSS|anode|cathode|vss sg13_lv_nmos L=0.13u W=2u AS=0.38p AD=0.38p PS=3.52u
+ PD=3.52u rfmode=0
M$16272 VSS|anode|cathode|vss \$3192 \$3448 VSS|anode|cathode|vss sg13_lv_nmos
+ L=0.13u W=0.55u AS=0.187p AD=0.1045p PS=1.78u PD=0.93u rfmode=0
M$16273 \$3448 \$3414 VSS|anode|cathode|vss VSS|anode|cathode|vss sg13_lv_nmos
+ L=0.13u W=0.55u AS=0.1045p AD=0.146425p PS=0.93u PD=1.155u rfmode=0
M$16274 VSS|anode|cathode|vss \$3448 \$3449 VSS|anode|cathode|vss sg13_lv_nmos
+ L=0.13u W=1.48u AS=0.312925p AD=0.4477p PS=2.345u PD=3.43u rfmode=0
M$16276 VSS|anode|cathode|vss \$3193 \$3455 VSS|anode|cathode|vss sg13_lv_nmos
+ L=0.13u W=0.55u AS=0.187p AD=0.1045p PS=1.78u PD=0.93u rfmode=0
M$16277 \$3455 \$3414 VSS|anode|cathode|vss VSS|anode|cathode|vss sg13_lv_nmos
+ L=0.13u W=0.55u AS=0.1045p AD=0.146425p PS=0.93u PD=1.155u rfmode=0
M$16278 VSS|anode|cathode|vss \$3455 \$3456 VSS|anode|cathode|vss sg13_lv_nmos
+ L=0.13u W=1.48u AS=0.312925p AD=0.4477p PS=2.345u PD=3.43u rfmode=0
M$16280 VSS|anode|cathode|vss \$3194 \$3462 VSS|anode|cathode|vss sg13_lv_nmos
+ L=0.13u W=0.55u AS=0.187p AD=0.1045p PS=1.78u PD=0.93u rfmode=0
M$16281 \$3462 \$3414 VSS|anode|cathode|vss VSS|anode|cathode|vss sg13_lv_nmos
+ L=0.13u W=0.55u AS=0.1045p AD=0.146425p PS=0.93u PD=1.155u rfmode=0
M$16282 VSS|anode|cathode|vss \$3462 \$3463 VSS|anode|cathode|vss sg13_lv_nmos
+ L=0.13u W=1.48u AS=0.312925p AD=0.4477p PS=2.345u PD=3.43u rfmode=0
M$16284 VSS|anode|cathode|vss \$3195 \$3469 VSS|anode|cathode|vss sg13_lv_nmos
+ L=0.13u W=0.55u AS=0.187p AD=0.1045p PS=1.78u PD=0.93u rfmode=0
M$16285 \$3469 \$3414 VSS|anode|cathode|vss VSS|anode|cathode|vss sg13_lv_nmos
+ L=0.13u W=0.55u AS=0.1045p AD=0.146425p PS=0.93u PD=1.155u rfmode=0
M$16286 VSS|anode|cathode|vss \$3469 \$3470 VSS|anode|cathode|vss sg13_lv_nmos
+ L=0.13u W=1.48u AS=0.312925p AD=0.4477p PS=2.345u PD=3.43u rfmode=0
M$16288 VSS|anode|cathode|vss \$3196 \$3476 VSS|anode|cathode|vss sg13_lv_nmos
+ L=0.13u W=0.55u AS=0.187p AD=0.1045p PS=1.78u PD=0.93u rfmode=0
M$16289 \$3476 \$3414 VSS|anode|cathode|vss VSS|anode|cathode|vss sg13_lv_nmos
+ L=0.13u W=0.55u AS=0.1045p AD=0.146425p PS=0.93u PD=1.155u rfmode=0
M$16290 VSS|anode|cathode|vss \$3476 \$3477 VSS|anode|cathode|vss sg13_lv_nmos
+ L=0.13u W=1.48u AS=0.312925p AD=0.4477p PS=2.345u PD=3.43u rfmode=0
M$16292 VSS|anode|cathode|vss \$3197 \$3483 VSS|anode|cathode|vss sg13_lv_nmos
+ L=0.13u W=0.55u AS=0.187p AD=0.1045p PS=1.78u PD=0.93u rfmode=0
M$16293 \$3483 \$3414 VSS|anode|cathode|vss VSS|anode|cathode|vss sg13_lv_nmos
+ L=0.13u W=0.55u AS=0.1045p AD=0.146425p PS=0.93u PD=1.155u rfmode=0
M$16294 VSS|anode|cathode|vss \$3483 \$3484 VSS|anode|cathode|vss sg13_lv_nmos
+ L=0.13u W=1.48u AS=0.312925p AD=0.4477p PS=2.345u PD=3.43u rfmode=0
M$16296 VSS|anode|cathode|vss \$3198 \$3490 VSS|anode|cathode|vss sg13_lv_nmos
+ L=0.13u W=0.55u AS=0.187p AD=0.1045p PS=1.78u PD=0.93u rfmode=0
M$16297 \$3490 \$3414 VSS|anode|cathode|vss VSS|anode|cathode|vss sg13_lv_nmos
+ L=0.13u W=0.55u AS=0.1045p AD=0.146425p PS=0.93u PD=1.155u rfmode=0
M$16298 VSS|anode|cathode|vss \$3490 \$3491 VSS|anode|cathode|vss sg13_lv_nmos
+ L=0.13u W=1.48u AS=0.312925p AD=0.4477p PS=2.345u PD=3.43u rfmode=0
M$16300 VSS|anode|cathode|vss VSS|anode|cathode|vss \$3497
+ VSS|anode|cathode|vss sg13_lv_nmos L=0.13u W=0.55u AS=0.187p AD=0.1045p
+ PS=1.78u PD=0.93u rfmode=0
M$16301 \$3497 \$3414 VSS|anode|cathode|vss VSS|anode|cathode|vss sg13_lv_nmos
+ L=0.13u W=0.55u AS=0.1045p AD=0.146425p PS=0.93u PD=1.155u rfmode=0
M$16302 VSS|anode|cathode|vss \$3497 \$3498 VSS|anode|cathode|vss sg13_lv_nmos
+ L=0.13u W=1.48u AS=0.312925p AD=0.4477p PS=2.345u PD=3.43u rfmode=0
M$16304 \$3505 \$3504 \$3559 VSS|anode|cathode|vss sg13_lv_nmos L=0.13u W=0.42u
+ AS=0.1428p AD=0.0609p PS=1.52u PD=0.71u rfmode=0
M$16305 \$3559 VDD VSS|anode|cathode|vss VSS|anode|cathode|vss sg13_lv_nmos
+ L=0.13u W=0.42u AS=0.0609p AD=0.1626p PS=0.71u PD=1.415u rfmode=0
M$16306 VSS|anode|cathode|vss \$3610 \$3440 VSS|anode|cathode|vss sg13_lv_nmos
+ L=0.13u W=0.74u AS=0.1626p AD=0.2516p PS=1.415u PD=2.16u rfmode=0
M$16307 \$3507 \$3576 VSS|anode|cathode|vss VSS|anode|cathode|vss sg13_lv_nmos
+ L=0.13u W=0.42u AS=0.1428p AD=0.0798p PS=1.52u PD=0.8u rfmode=0
M$16308 VSS|anode|cathode|vss VDD \$3561 VSS|anode|cathode|vss sg13_lv_nmos
+ L=0.13u W=0.42u AS=0.0798p AD=0.0378p PS=0.8u PD=0.6u rfmode=0
M$16309 \$3561 \$3508 \$3576 VSS|anode|cathode|vss sg13_lv_nmos L=0.13u W=0.42u
+ AS=0.0378p AD=0.1428p PS=0.6u PD=1.52u rfmode=0
M$16310 VSS|anode|cathode|vss \$3508 \$3453 VSS|anode|cathode|vss sg13_lv_nmos
+ L=0.13u W=0.64u AS=0.1331p AD=0.2176p PS=1.12u PD=1.96u rfmode=0
M$16311 VSS|anode|cathode|vss \$3508 \$3452 VSS|anode|cathode|vss sg13_lv_nmos
+ L=0.13u W=1.48u AS=0.3922p AD=0.2737p PS=3.28u PD=2.24u rfmode=0
M$16313 VSS|anode|cathode|vss \$3453 \$3454 VSS|anode|cathode|vss sg13_lv_nmos
+ L=0.13u W=1.48u AS=0.3922p AD=0.3922p PS=3.28u PD=3.28u rfmode=0
M$16315 \$3511 \$3510 \$3567 VSS|anode|cathode|vss sg13_lv_nmos L=0.13u W=0.42u
+ AS=0.1428p AD=0.0609p PS=1.52u PD=0.71u rfmode=0
M$16316 \$3567 VDD VSS|anode|cathode|vss VSS|anode|cathode|vss sg13_lv_nmos
+ L=0.13u W=0.42u AS=0.0609p AD=0.1626p PS=0.71u PD=1.415u rfmode=0
M$16317 VSS|anode|cathode|vss \$3611 \$3441 VSS|anode|cathode|vss sg13_lv_nmos
+ L=0.13u W=0.74u AS=0.1626p AD=0.2516p PS=1.415u PD=2.16u rfmode=0
M$16318 \$3513 \$3577 VSS|anode|cathode|vss VSS|anode|cathode|vss sg13_lv_nmos
+ L=0.13u W=0.42u AS=0.1428p AD=0.0798p PS=1.52u PD=0.8u rfmode=0
M$16319 VSS|anode|cathode|vss VDD \$3569 VSS|anode|cathode|vss sg13_lv_nmos
+ L=0.13u W=0.42u AS=0.0798p AD=0.0378p PS=0.8u PD=0.6u rfmode=0
M$16320 \$3569 \$3514 \$3577 VSS|anode|cathode|vss sg13_lv_nmos L=0.13u W=0.42u
+ AS=0.0378p AD=0.1428p PS=0.6u PD=1.52u rfmode=0
M$16321 VSS|anode|cathode|vss \$3514 \$3460 VSS|anode|cathode|vss sg13_lv_nmos
+ L=0.13u W=0.64u AS=0.1331p AD=0.2176p PS=1.12u PD=1.96u rfmode=0
M$16322 VSS|anode|cathode|vss \$3514 \$3459 VSS|anode|cathode|vss sg13_lv_nmos
+ L=0.13u W=1.48u AS=0.3922p AD=0.2737p PS=3.28u PD=2.24u rfmode=0
M$16324 VSS|anode|cathode|vss \$3460 \$3461 VSS|anode|cathode|vss sg13_lv_nmos
+ L=0.13u W=1.48u AS=0.3922p AD=0.3922p PS=3.28u PD=3.28u rfmode=0
M$16326 \$3517 \$3516 \$3574 VSS|anode|cathode|vss sg13_lv_nmos L=0.13u W=0.42u
+ AS=0.1428p AD=0.0609p PS=1.52u PD=0.71u rfmode=0
M$16327 \$3574 VDD VSS|anode|cathode|vss VSS|anode|cathode|vss sg13_lv_nmos
+ L=0.13u W=0.42u AS=0.0609p AD=0.1626p PS=0.71u PD=1.415u rfmode=0
M$16328 VSS|anode|cathode|vss \$3612 \$3442 VSS|anode|cathode|vss sg13_lv_nmos
+ L=0.13u W=0.74u AS=0.1626p AD=0.2516p PS=1.415u PD=2.16u rfmode=0
M$16329 \$3519 \$3578 VSS|anode|cathode|vss VSS|anode|cathode|vss sg13_lv_nmos
+ L=0.13u W=0.42u AS=0.1428p AD=0.0798p PS=1.52u PD=0.8u rfmode=0
M$16330 VSS|anode|cathode|vss VDD \$3575 VSS|anode|cathode|vss sg13_lv_nmos
+ L=0.13u W=0.42u AS=0.0798p AD=0.0378p PS=0.8u PD=0.6u rfmode=0
M$16331 \$3575 \$3520 \$3578 VSS|anode|cathode|vss sg13_lv_nmos L=0.13u W=0.42u
+ AS=0.0378p AD=0.1428p PS=0.6u PD=1.52u rfmode=0
M$16332 VSS|anode|cathode|vss \$3520 \$3467 VSS|anode|cathode|vss sg13_lv_nmos
+ L=0.13u W=0.64u AS=0.1331p AD=0.2176p PS=1.12u PD=1.96u rfmode=0
M$16333 VSS|anode|cathode|vss \$3520 \$3466 VSS|anode|cathode|vss sg13_lv_nmos
+ L=0.13u W=1.48u AS=0.3922p AD=0.2737p PS=3.28u PD=2.24u rfmode=0
M$16335 VSS|anode|cathode|vss \$3467 \$3468 VSS|anode|cathode|vss sg13_lv_nmos
+ L=0.13u W=1.48u AS=0.3922p AD=0.3922p PS=3.28u PD=3.28u rfmode=0
M$16337 \$3523 \$3522 \$3572 VSS|anode|cathode|vss sg13_lv_nmos L=0.13u W=0.42u
+ AS=0.1428p AD=0.0609p PS=1.52u PD=0.71u rfmode=0
M$16338 \$3572 VDD VSS|anode|cathode|vss VSS|anode|cathode|vss sg13_lv_nmos
+ L=0.13u W=0.42u AS=0.0609p AD=0.1626p PS=0.71u PD=1.415u rfmode=0
M$16339 VSS|anode|cathode|vss \$3613 \$3443 VSS|anode|cathode|vss sg13_lv_nmos
+ L=0.13u W=0.74u AS=0.1626p AD=0.2516p PS=1.415u PD=2.16u rfmode=0
M$16340 \$3525 \$3579 VSS|anode|cathode|vss VSS|anode|cathode|vss sg13_lv_nmos
+ L=0.13u W=0.42u AS=0.1428p AD=0.0798p PS=1.52u PD=0.8u rfmode=0
M$16341 VSS|anode|cathode|vss VDD \$3571 VSS|anode|cathode|vss sg13_lv_nmos
+ L=0.13u W=0.42u AS=0.0798p AD=0.0378p PS=0.8u PD=0.6u rfmode=0
M$16342 \$3571 \$3526 \$3579 VSS|anode|cathode|vss sg13_lv_nmos L=0.13u W=0.42u
+ AS=0.0378p AD=0.1428p PS=0.6u PD=1.52u rfmode=0
M$16343 VSS|anode|cathode|vss \$3526 \$3474 VSS|anode|cathode|vss sg13_lv_nmos
+ L=0.13u W=0.64u AS=0.1331p AD=0.2176p PS=1.12u PD=1.96u rfmode=0
M$16344 VSS|anode|cathode|vss \$3526 \$3473 VSS|anode|cathode|vss sg13_lv_nmos
+ L=0.13u W=1.48u AS=0.3922p AD=0.2737p PS=3.28u PD=2.24u rfmode=0
M$16346 VSS|anode|cathode|vss \$3474 \$3475 VSS|anode|cathode|vss sg13_lv_nmos
+ L=0.13u W=1.48u AS=0.3922p AD=0.3922p PS=3.28u PD=3.28u rfmode=0
M$16348 \$3529 \$3528 \$3566 VSS|anode|cathode|vss sg13_lv_nmos L=0.13u W=0.42u
+ AS=0.1428p AD=0.0609p PS=1.52u PD=0.71u rfmode=0
M$16349 \$3566 VDD VSS|anode|cathode|vss VSS|anode|cathode|vss sg13_lv_nmos
+ L=0.13u W=0.42u AS=0.0609p AD=0.1626p PS=0.71u PD=1.415u rfmode=0
M$16350 VSS|anode|cathode|vss \$3614 \$3444 VSS|anode|cathode|vss sg13_lv_nmos
+ L=0.13u W=0.74u AS=0.1626p AD=0.2516p PS=1.415u PD=2.16u rfmode=0
M$16351 \$3531 \$3580 VSS|anode|cathode|vss VSS|anode|cathode|vss sg13_lv_nmos
+ L=0.13u W=0.42u AS=0.1428p AD=0.0798p PS=1.52u PD=0.8u rfmode=0
M$16352 VSS|anode|cathode|vss VDD \$3564 VSS|anode|cathode|vss sg13_lv_nmos
+ L=0.13u W=0.42u AS=0.0798p AD=0.0378p PS=0.8u PD=0.6u rfmode=0
M$16353 \$3564 \$3532 \$3580 VSS|anode|cathode|vss sg13_lv_nmos L=0.13u W=0.42u
+ AS=0.0378p AD=0.1428p PS=0.6u PD=1.52u rfmode=0
M$16354 VSS|anode|cathode|vss \$3532 \$3481 VSS|anode|cathode|vss sg13_lv_nmos
+ L=0.13u W=0.64u AS=0.1331p AD=0.2176p PS=1.12u PD=1.96u rfmode=0
M$16355 VSS|anode|cathode|vss \$3532 \$3480 VSS|anode|cathode|vss sg13_lv_nmos
+ L=0.13u W=1.48u AS=0.3922p AD=0.2737p PS=3.28u PD=2.24u rfmode=0
M$16357 VSS|anode|cathode|vss \$3481 \$3482 VSS|anode|cathode|vss sg13_lv_nmos
+ L=0.13u W=1.48u AS=0.3922p AD=0.3922p PS=3.28u PD=3.28u rfmode=0
M$16359 \$3535 \$3534 \$3562 VSS|anode|cathode|vss sg13_lv_nmos L=0.13u W=0.42u
+ AS=0.1428p AD=0.0609p PS=1.52u PD=0.71u rfmode=0
M$16360 \$3562 VDD VSS|anode|cathode|vss VSS|anode|cathode|vss sg13_lv_nmos
+ L=0.13u W=0.42u AS=0.0609p AD=0.1626p PS=0.71u PD=1.415u rfmode=0
M$16361 VSS|anode|cathode|vss \$3615 \$3445 VSS|anode|cathode|vss sg13_lv_nmos
+ L=0.13u W=0.74u AS=0.1626p AD=0.2516p PS=1.415u PD=2.16u rfmode=0
M$16362 \$3537 \$3581 VSS|anode|cathode|vss VSS|anode|cathode|vss sg13_lv_nmos
+ L=0.13u W=0.42u AS=0.1428p AD=0.0798p PS=1.52u PD=0.8u rfmode=0
M$16363 VSS|anode|cathode|vss VDD \$3560 VSS|anode|cathode|vss sg13_lv_nmos
+ L=0.13u W=0.42u AS=0.0798p AD=0.0378p PS=0.8u PD=0.6u rfmode=0
M$16364 \$3560 \$3538 \$3581 VSS|anode|cathode|vss sg13_lv_nmos L=0.13u W=0.42u
+ AS=0.0378p AD=0.1428p PS=0.6u PD=1.52u rfmode=0
M$16365 VSS|anode|cathode|vss \$3538 \$3488 VSS|anode|cathode|vss sg13_lv_nmos
+ L=0.13u W=0.64u AS=0.1331p AD=0.2176p PS=1.12u PD=1.96u rfmode=0
M$16366 VSS|anode|cathode|vss \$3538 \$3487 VSS|anode|cathode|vss sg13_lv_nmos
+ L=0.13u W=1.48u AS=0.3922p AD=0.2737p PS=3.28u PD=2.24u rfmode=0
M$16368 VSS|anode|cathode|vss \$3488 \$3489 VSS|anode|cathode|vss sg13_lv_nmos
+ L=0.13u W=1.48u AS=0.3922p AD=0.3922p PS=3.28u PD=3.28u rfmode=0
M$16370 \$3541 \$3540 \$3556 VSS|anode|cathode|vss sg13_lv_nmos L=0.13u W=0.42u
+ AS=0.1428p AD=0.0609p PS=1.52u PD=0.71u rfmode=0
M$16371 \$3556 VDD VSS|anode|cathode|vss VSS|anode|cathode|vss sg13_lv_nmos
+ L=0.13u W=0.42u AS=0.0609p AD=0.1626p PS=0.71u PD=1.415u rfmode=0
M$16372 VSS|anode|cathode|vss \$3616 \$3446 VSS|anode|cathode|vss sg13_lv_nmos
+ L=0.13u W=0.74u AS=0.1626p AD=0.2516p PS=1.415u PD=2.16u rfmode=0
M$16373 \$3543 \$3582 VSS|anode|cathode|vss VSS|anode|cathode|vss sg13_lv_nmos
+ L=0.13u W=0.42u AS=0.1428p AD=0.0798p PS=1.52u PD=0.8u rfmode=0
M$16374 VSS|anode|cathode|vss VDD \$3555 VSS|anode|cathode|vss sg13_lv_nmos
+ L=0.13u W=0.42u AS=0.0798p AD=0.0378p PS=0.8u PD=0.6u rfmode=0
M$16375 \$3555 \$3544 \$3582 VSS|anode|cathode|vss sg13_lv_nmos L=0.13u W=0.42u
+ AS=0.0378p AD=0.1428p PS=0.6u PD=1.52u rfmode=0
M$16376 VSS|anode|cathode|vss \$3544 \$3495 VSS|anode|cathode|vss sg13_lv_nmos
+ L=0.13u W=0.64u AS=0.1331p AD=0.2176p PS=1.12u PD=1.96u rfmode=0
M$16377 VSS|anode|cathode|vss \$3544 \$3494 VSS|anode|cathode|vss sg13_lv_nmos
+ L=0.13u W=1.48u AS=0.3922p AD=0.2737p PS=3.28u PD=2.24u rfmode=0
M$16379 VSS|anode|cathode|vss \$3495 \$3496 VSS|anode|cathode|vss sg13_lv_nmos
+ L=0.13u W=1.48u AS=0.3922p AD=0.3922p PS=3.28u PD=3.28u rfmode=0
M$16381 \$3547 \$3546 \$3553 VSS|anode|cathode|vss sg13_lv_nmos L=0.13u W=0.42u
+ AS=0.1428p AD=0.0609p PS=1.52u PD=0.71u rfmode=0
M$16382 \$3553 VDD VSS|anode|cathode|vss VSS|anode|cathode|vss sg13_lv_nmos
+ L=0.13u W=0.42u AS=0.0609p AD=0.1626p PS=0.71u PD=1.415u rfmode=0
M$16383 VSS|anode|cathode|vss \$3617 \$3447 VSS|anode|cathode|vss sg13_lv_nmos
+ L=0.13u W=0.74u AS=0.1626p AD=0.2516p PS=1.415u PD=2.16u rfmode=0
M$16384 \$3549 \$3583 VSS|anode|cathode|vss VSS|anode|cathode|vss sg13_lv_nmos
+ L=0.13u W=0.42u AS=0.1428p AD=0.0798p PS=1.52u PD=0.8u rfmode=0
M$16385 VSS|anode|cathode|vss VDD \$3552 VSS|anode|cathode|vss sg13_lv_nmos
+ L=0.13u W=0.42u AS=0.0798p AD=0.0378p PS=0.8u PD=0.6u rfmode=0
M$16386 \$3552 \$3550 \$3583 VSS|anode|cathode|vss sg13_lv_nmos L=0.13u W=0.42u
+ AS=0.0378p AD=0.1428p PS=0.6u PD=1.52u rfmode=0
M$16387 VSS|anode|cathode|vss \$3550 \$3502 VSS|anode|cathode|vss sg13_lv_nmos
+ L=0.13u W=0.64u AS=0.1331p AD=0.2176p PS=1.12u PD=1.96u rfmode=0
M$16388 VSS|anode|cathode|vss \$3550 \$3501 VSS|anode|cathode|vss sg13_lv_nmos
+ L=0.13u W=1.48u AS=0.3922p AD=0.2737p PS=3.28u PD=2.24u rfmode=0
M$16390 VSS|anode|cathode|vss \$3502 \$3503 VSS|anode|cathode|vss sg13_lv_nmos
+ L=0.13u W=1.48u AS=0.3922p AD=0.3922p PS=3.28u PD=3.28u rfmode=0
M$16392 \$3450 \$3449 VSS|anode|cathode|vss VSS|anode|cathode|vss sg13_lv_nmos
+ L=0.13u W=1.44u AS=0.4068p AD=0.2772p PS=3.29u PD=2.21u rfmode=0
M$16394 \$3450 \$3416 \$3504 VSS|anode|cathode|vss sg13_lv_nmos L=0.13u W=1.44u
+ AS=0.2772p AD=0.3816p PS=2.21u PD=3.22u rfmode=0
M$16396 VSS|anode|cathode|vss VDD \$3558 VSS|anode|cathode|vss sg13_lv_nmos
+ L=0.13u W=0.42u AS=0.1701p AD=0.03885p PS=1.65u PD=0.605u rfmode=0
M$16397 \$3558 \$3440 \$3506 VSS|anode|cathode|vss sg13_lv_nmos L=0.13u W=0.42u
+ AS=0.03885p AD=0.1596p PS=0.605u PD=1.6u rfmode=0
M$16398 VSS|anode|cathode|vss \$3451 \$3618 VSS|anode|cathode|vss sg13_lv_nmos
+ L=0.13u W=0.74u AS=0.43315p AD=0.2516p PS=2.205u PD=2.16u rfmode=0
M$16399 VSS|anode|cathode|vss CLK|clk|core|fclk_in|p2c|ui_p2c[6] \$3451
+ VSS|anode|cathode|vss sg13_lv_nmos L=0.13u W=0.74u AS=0.43315p AD=0.2516p
+ PS=2.205u PD=2.16u rfmode=0
M$16400 \$3508 \$3451 \$3507 VSS|anode|cathode|vss sg13_lv_nmos L=0.13u W=0.42u
+ AS=0.12665p AD=0.1428p PS=1.145u PD=1.52u rfmode=0
M$16401 \$3440 \$3618 \$3508 VSS|anode|cathode|vss sg13_lv_nmos L=0.13u W=0.74u
+ AS=0.3473p AD=0.12665p PS=2.71u PD=1.145u rfmode=0
M$16402 \$3457 \$3456 VSS|anode|cathode|vss VSS|anode|cathode|vss sg13_lv_nmos
+ L=0.13u W=1.44u AS=0.4068p AD=0.2772p PS=3.29u PD=2.21u rfmode=0
M$16404 \$3457 \$3416 \$3510 VSS|anode|cathode|vss sg13_lv_nmos L=0.13u W=1.44u
+ AS=0.2772p AD=0.3816p PS=2.21u PD=3.22u rfmode=0
M$16406 VSS|anode|cathode|vss VDD \$3565 VSS|anode|cathode|vss sg13_lv_nmos
+ L=0.13u W=0.42u AS=0.1701p AD=0.03885p PS=1.65u PD=0.605u rfmode=0
M$16407 \$3565 \$3441 \$3512 VSS|anode|cathode|vss sg13_lv_nmos L=0.13u W=0.42u
+ AS=0.03885p AD=0.1596p PS=0.605u PD=1.6u rfmode=0
M$16408 VSS|anode|cathode|vss \$3458 \$3620 VSS|anode|cathode|vss sg13_lv_nmos
+ L=0.13u W=0.74u AS=0.43315p AD=0.2516p PS=2.205u PD=2.16u rfmode=0
M$16409 VSS|anode|cathode|vss CLK|clk|core|fclk_in|p2c|ui_p2c[6] \$3458
+ VSS|anode|cathode|vss sg13_lv_nmos L=0.13u W=0.74u AS=0.43315p AD=0.2516p
+ PS=2.205u PD=2.16u rfmode=0
M$16410 \$3514 \$3458 \$3513 VSS|anode|cathode|vss sg13_lv_nmos L=0.13u W=0.42u
+ AS=0.12665p AD=0.1428p PS=1.145u PD=1.52u rfmode=0
M$16411 \$3441 \$3620 \$3514 VSS|anode|cathode|vss sg13_lv_nmos L=0.13u W=0.74u
+ AS=0.3473p AD=0.12665p PS=2.71u PD=1.145u rfmode=0
M$16412 \$3464 \$3463 VSS|anode|cathode|vss VSS|anode|cathode|vss sg13_lv_nmos
+ L=0.13u W=1.44u AS=0.4068p AD=0.2772p PS=3.29u PD=2.21u rfmode=0
M$16414 \$3464 \$3416 \$3516 VSS|anode|cathode|vss sg13_lv_nmos L=0.13u W=1.44u
+ AS=0.2772p AD=0.3816p PS=2.21u PD=3.22u rfmode=0
M$16416 VSS|anode|cathode|vss VDD \$3573 VSS|anode|cathode|vss sg13_lv_nmos
+ L=0.13u W=0.42u AS=0.1701p AD=0.03885p PS=1.65u PD=0.605u rfmode=0
M$16417 \$3573 \$3442 \$3518 VSS|anode|cathode|vss sg13_lv_nmos L=0.13u W=0.42u
+ AS=0.03885p AD=0.1596p PS=0.605u PD=1.6u rfmode=0
M$16418 VSS|anode|cathode|vss \$3465 \$3622 VSS|anode|cathode|vss sg13_lv_nmos
+ L=0.13u W=0.74u AS=0.43315p AD=0.2516p PS=2.205u PD=2.16u rfmode=0
M$16419 VSS|anode|cathode|vss CLK|clk|core|fclk_in|p2c|ui_p2c[6] \$3465
+ VSS|anode|cathode|vss sg13_lv_nmos L=0.13u W=0.74u AS=0.43315p AD=0.2516p
+ PS=2.205u PD=2.16u rfmode=0
M$16420 \$3520 \$3465 \$3519 VSS|anode|cathode|vss sg13_lv_nmos L=0.13u W=0.42u
+ AS=0.12665p AD=0.1428p PS=1.145u PD=1.52u rfmode=0
M$16421 \$3442 \$3622 \$3520 VSS|anode|cathode|vss sg13_lv_nmos L=0.13u W=0.74u
+ AS=0.3473p AD=0.12665p PS=2.71u PD=1.145u rfmode=0
M$16422 \$3471 \$3470 VSS|anode|cathode|vss VSS|anode|cathode|vss sg13_lv_nmos
+ L=0.13u W=1.44u AS=0.4068p AD=0.2772p PS=3.29u PD=2.21u rfmode=0
M$16424 \$3471 \$3416 \$3522 VSS|anode|cathode|vss sg13_lv_nmos L=0.13u W=1.44u
+ AS=0.2772p AD=0.3816p PS=2.21u PD=3.22u rfmode=0
M$16426 VSS|anode|cathode|vss VDD \$3570 VSS|anode|cathode|vss sg13_lv_nmos
+ L=0.13u W=0.42u AS=0.1701p AD=0.03885p PS=1.65u PD=0.605u rfmode=0
M$16427 \$3570 \$3443 \$3524 VSS|anode|cathode|vss sg13_lv_nmos L=0.13u W=0.42u
+ AS=0.03885p AD=0.1596p PS=0.605u PD=1.6u rfmode=0
M$16428 VSS|anode|cathode|vss \$3472 \$3624 VSS|anode|cathode|vss sg13_lv_nmos
+ L=0.13u W=0.74u AS=0.43315p AD=0.2516p PS=2.205u PD=2.16u rfmode=0
M$16429 VSS|anode|cathode|vss CLK|clk|core|fclk_in|p2c|ui_p2c[6] \$3472
+ VSS|anode|cathode|vss sg13_lv_nmos L=0.13u W=0.74u AS=0.43315p AD=0.2516p
+ PS=2.205u PD=2.16u rfmode=0
M$16430 \$3526 \$3472 \$3525 VSS|anode|cathode|vss sg13_lv_nmos L=0.13u W=0.42u
+ AS=0.12665p AD=0.1428p PS=1.145u PD=1.52u rfmode=0
M$16431 \$3443 \$3624 \$3526 VSS|anode|cathode|vss sg13_lv_nmos L=0.13u W=0.74u
+ AS=0.3473p AD=0.12665p PS=2.71u PD=1.145u rfmode=0
M$16432 \$3478 \$3477 VSS|anode|cathode|vss VSS|anode|cathode|vss sg13_lv_nmos
+ L=0.13u W=1.44u AS=0.4068p AD=0.2772p PS=3.29u PD=2.21u rfmode=0
M$16434 \$3478 \$3416 \$3528 VSS|anode|cathode|vss sg13_lv_nmos L=0.13u W=1.44u
+ AS=0.2772p AD=0.3816p PS=2.21u PD=3.22u rfmode=0
M$16436 VSS|anode|cathode|vss VDD \$3568 VSS|anode|cathode|vss sg13_lv_nmos
+ L=0.13u W=0.42u AS=0.1701p AD=0.03885p PS=1.65u PD=0.605u rfmode=0
M$16437 \$3568 \$3444 \$3530 VSS|anode|cathode|vss sg13_lv_nmos L=0.13u W=0.42u
+ AS=0.03885p AD=0.1596p PS=0.605u PD=1.6u rfmode=0
M$16438 VSS|anode|cathode|vss \$3479 \$3626 VSS|anode|cathode|vss sg13_lv_nmos
+ L=0.13u W=0.74u AS=0.43315p AD=0.2516p PS=2.205u PD=2.16u rfmode=0
M$16439 VSS|anode|cathode|vss CLK|clk|core|fclk_in|p2c|ui_p2c[6] \$3479
+ VSS|anode|cathode|vss sg13_lv_nmos L=0.13u W=0.74u AS=0.43315p AD=0.2516p
+ PS=2.205u PD=2.16u rfmode=0
M$16440 \$3532 \$3479 \$3531 VSS|anode|cathode|vss sg13_lv_nmos L=0.13u W=0.42u
+ AS=0.12665p AD=0.1428p PS=1.145u PD=1.52u rfmode=0
M$16441 \$3444 \$3626 \$3532 VSS|anode|cathode|vss sg13_lv_nmos L=0.13u W=0.74u
+ AS=0.3473p AD=0.12665p PS=2.71u PD=1.145u rfmode=0
M$16442 \$3485 \$3484 VSS|anode|cathode|vss VSS|anode|cathode|vss sg13_lv_nmos
+ L=0.13u W=1.44u AS=0.4068p AD=0.2772p PS=3.29u PD=2.21u rfmode=0
M$16444 \$3485 \$3416 \$3534 VSS|anode|cathode|vss sg13_lv_nmos L=0.13u W=1.44u
+ AS=0.2772p AD=0.3816p PS=2.21u PD=3.22u rfmode=0
M$16446 VSS|anode|cathode|vss VDD \$3563 VSS|anode|cathode|vss sg13_lv_nmos
+ L=0.13u W=0.42u AS=0.1701p AD=0.03885p PS=1.65u PD=0.605u rfmode=0
M$16447 \$3563 \$3445 \$3536 VSS|anode|cathode|vss sg13_lv_nmos L=0.13u W=0.42u
+ AS=0.03885p AD=0.1596p PS=0.605u PD=1.6u rfmode=0
M$16448 VSS|anode|cathode|vss \$3486 \$3628 VSS|anode|cathode|vss sg13_lv_nmos
+ L=0.13u W=0.74u AS=0.43315p AD=0.2516p PS=2.205u PD=2.16u rfmode=0
M$16449 VSS|anode|cathode|vss CLK|clk|core|fclk_in|p2c|ui_p2c[6] \$3486
+ VSS|anode|cathode|vss sg13_lv_nmos L=0.13u W=0.74u AS=0.43315p AD=0.2516p
+ PS=2.205u PD=2.16u rfmode=0
M$16450 \$3538 \$3486 \$3537 VSS|anode|cathode|vss sg13_lv_nmos L=0.13u W=0.42u
+ AS=0.12665p AD=0.1428p PS=1.145u PD=1.52u rfmode=0
M$16451 \$3445 \$3628 \$3538 VSS|anode|cathode|vss sg13_lv_nmos L=0.13u W=0.74u
+ AS=0.3473p AD=0.12665p PS=2.71u PD=1.145u rfmode=0
M$16452 \$3492 \$3491 VSS|anode|cathode|vss VSS|anode|cathode|vss sg13_lv_nmos
+ L=0.13u W=1.44u AS=0.4068p AD=0.2772p PS=3.29u PD=2.21u rfmode=0
M$16454 \$3492 \$3416 \$3540 VSS|anode|cathode|vss sg13_lv_nmos L=0.13u W=1.44u
+ AS=0.2772p AD=0.3816p PS=2.21u PD=3.22u rfmode=0
M$16456 VSS|anode|cathode|vss VDD \$3557 VSS|anode|cathode|vss sg13_lv_nmos
+ L=0.13u W=0.42u AS=0.1701p AD=0.03885p PS=1.65u PD=0.605u rfmode=0
M$16457 \$3557 \$3446 \$3542 VSS|anode|cathode|vss sg13_lv_nmos L=0.13u W=0.42u
+ AS=0.03885p AD=0.1596p PS=0.605u PD=1.6u rfmode=0
M$16458 VSS|anode|cathode|vss \$3493 \$3630 VSS|anode|cathode|vss sg13_lv_nmos
+ L=0.13u W=0.74u AS=0.43315p AD=0.2516p PS=2.205u PD=2.16u rfmode=0
M$16459 VSS|anode|cathode|vss CLK|clk|core|fclk_in|p2c|ui_p2c[6] \$3493
+ VSS|anode|cathode|vss sg13_lv_nmos L=0.13u W=0.74u AS=0.43315p AD=0.2516p
+ PS=2.205u PD=2.16u rfmode=0
M$16460 \$3544 \$3493 \$3543 VSS|anode|cathode|vss sg13_lv_nmos L=0.13u W=0.42u
+ AS=0.12665p AD=0.1428p PS=1.145u PD=1.52u rfmode=0
M$16461 \$3446 \$3630 \$3544 VSS|anode|cathode|vss sg13_lv_nmos L=0.13u W=0.74u
+ AS=0.3473p AD=0.12665p PS=2.71u PD=1.145u rfmode=0
M$16462 \$3499 \$3498 VSS|anode|cathode|vss VSS|anode|cathode|vss sg13_lv_nmos
+ L=0.13u W=1.44u AS=0.4068p AD=0.2772p PS=3.29u PD=2.21u rfmode=0
M$16464 \$3499 \$3416 \$3546 VSS|anode|cathode|vss sg13_lv_nmos L=0.13u W=1.44u
+ AS=0.2772p AD=0.3816p PS=2.21u PD=3.22u rfmode=0
M$16466 VSS|anode|cathode|vss VDD \$3554 VSS|anode|cathode|vss sg13_lv_nmos
+ L=0.13u W=0.42u AS=0.1701p AD=0.03885p PS=1.65u PD=0.605u rfmode=0
M$16467 \$3554 \$3447 \$3548 VSS|anode|cathode|vss sg13_lv_nmos L=0.13u W=0.42u
+ AS=0.03885p AD=0.1596p PS=0.605u PD=1.6u rfmode=0
M$16468 VSS|anode|cathode|vss \$3500 \$3632 VSS|anode|cathode|vss sg13_lv_nmos
+ L=0.13u W=0.74u AS=0.43315p AD=0.2516p PS=2.205u PD=2.16u rfmode=0
M$16469 VSS|anode|cathode|vss CLK|clk|core|fclk_in|p2c|ui_p2c[6] \$3500
+ VSS|anode|cathode|vss sg13_lv_nmos L=0.13u W=0.74u AS=0.43315p AD=0.2516p
+ PS=2.205u PD=2.16u rfmode=0
M$16470 \$3550 \$3500 \$3549 VSS|anode|cathode|vss sg13_lv_nmos L=0.13u W=0.42u
+ AS=0.12665p AD=0.1428p PS=1.145u PD=1.52u rfmode=0
M$16471 \$3447 \$3632 \$3550 VSS|anode|cathode|vss sg13_lv_nmos L=0.13u W=0.74u
+ AS=0.3473p AD=0.12665p PS=2.71u PD=1.145u rfmode=0
M$16472 \$3438 X9|dout[10] \$3634 VSS|anode|cathode|vss sg13_lv_nmos L=0.13u
+ W=0.64u AS=0.2176p AD=0.1216p PS=1.96u PD=1.02u rfmode=0
M$16473 \$3634 X10|dout[11] VSS|anode|cathode|vss VSS|anode|cathode|vss
+ sg13_lv_nmos L=0.13u W=0.64u AS=0.1216p AD=0.1331p PS=1.02u PD=1.12u rfmode=0
M$16474 VSS|anode|cathode|vss \$3438 \$3439 VSS|anode|cathode|vss sg13_lv_nmos
+ L=0.13u W=1.48u AS=0.2737p AD=0.4218p PS=2.24u PD=3.36u rfmode=0
M$16476 \$3688 X8|dout[9] \$3691 VSS|anode|cathode|vss sg13_lv_nmos L=0.13u
+ W=0.64u AS=0.2176p AD=0.1216p PS=1.96u PD=1.02u rfmode=0
M$16477 VSS|anode|cathode|vss X9|dout[10] \$3691 VSS|anode|cathode|vss
+ sg13_lv_nmos L=0.13u W=0.64u AS=0.1331p AD=0.1216p PS=1.12u PD=1.02u rfmode=0
M$16478 VSS|anode|cathode|vss \$3688 \$3684 VSS|anode|cathode|vss sg13_lv_nmos
+ L=0.13u W=1.48u AS=0.2737p AD=0.4218p PS=2.24u PD=3.36u rfmode=0
M$16480 \$3689 X10|dout[11] \$3692 VSS|anode|cathode|vss sg13_lv_nmos L=0.13u
+ W=0.64u AS=0.2176p AD=0.1216p PS=1.96u PD=1.02u rfmode=0
M$16481 VSS|anode|cathode|vss \$3684 \$3692 VSS|anode|cathode|vss sg13_lv_nmos
+ L=0.13u W=0.64u AS=0.1331p AD=0.1216p PS=1.12u PD=1.02u rfmode=0
M$16482 VSS|anode|cathode|vss \$3689 \$3685 VSS|anode|cathode|vss sg13_lv_nmos
+ L=0.13u W=1.48u AS=0.2737p AD=0.4218p PS=2.24u PD=3.36u rfmode=0
M$16484 VSS|anode|cathode|vss \$3192 \$3751 VSS|anode|cathode|vss sg13_lv_nmos
+ L=0.13u W=0.55u AS=0.187p AD=0.1045p PS=1.78u PD=0.93u rfmode=0
M$16485 \$3751 \$3221 VSS|anode|cathode|vss VSS|anode|cathode|vss sg13_lv_nmos
+ L=0.13u W=0.55u AS=0.1045p AD=0.146425p PS=0.93u PD=1.155u rfmode=0
M$16486 VSS|anode|cathode|vss \$3751 \$3752 VSS|anode|cathode|vss sg13_lv_nmos
+ L=0.13u W=1.48u AS=0.312925p AD=0.4477p PS=2.345u PD=3.43u rfmode=0
M$16488 \$3803 \$3802 \$3857 VSS|anode|cathode|vss sg13_lv_nmos L=0.13u W=0.42u
+ AS=0.1428p AD=0.0609p PS=1.52u PD=0.71u rfmode=0
M$16489 \$3857 VDD VSS|anode|cathode|vss VSS|anode|cathode|vss sg13_lv_nmos
+ L=0.13u W=0.42u AS=0.0609p AD=0.1626p PS=0.71u PD=1.415u rfmode=0
M$16490 VSS|anode|cathode|vss \$3913 \$3753 VSS|anode|cathode|vss sg13_lv_nmos
+ L=0.13u W=0.74u AS=0.1626p AD=0.2516p PS=1.415u PD=2.16u rfmode=0
M$16491 \$3505 \$3451 \$3610 VSS|anode|cathode|vss sg13_lv_nmos L=0.13u W=0.42u
+ AS=0.1296p AD=0.081p PS=1.52u PD=0.81u rfmode=0
M$16492 \$3610 \$3618 \$3506 VSS|anode|cathode|vss sg13_lv_nmos L=0.13u W=0.42u
+ AS=0.081p AD=0.2163p PS=0.81u PD=1.87u rfmode=0
M$16493 \$3805 \$3914 VSS|anode|cathode|vss VSS|anode|cathode|vss sg13_lv_nmos
+ L=0.13u W=0.42u AS=0.1428p AD=0.0798p PS=1.52u PD=0.8u rfmode=0
M$16494 VSS|anode|cathode|vss VDD \$3858 VSS|anode|cathode|vss sg13_lv_nmos
+ L=0.13u W=0.42u AS=0.0798p AD=0.0378p PS=0.8u PD=0.6u rfmode=0
M$16495 \$3858 \$3873 \$3914 VSS|anode|cathode|vss sg13_lv_nmos L=0.13u W=0.42u
+ AS=0.0378p AD=0.1428p PS=0.6u PD=1.52u rfmode=0
M$16496 VSS|anode|cathode|vss \$3873 \$3756 VSS|anode|cathode|vss sg13_lv_nmos
+ L=0.13u W=0.64u AS=0.1331p AD=0.2176p PS=1.12u PD=1.96u rfmode=0
M$16497 VSS|anode|cathode|vss \$3873 \$3755 VSS|anode|cathode|vss sg13_lv_nmos
+ L=0.13u W=1.48u AS=0.3922p AD=0.2737p PS=3.28u PD=2.24u rfmode=0
M$16499 VSS|anode|cathode|vss \$3756 \$3806 VSS|anode|cathode|vss sg13_lv_nmos
+ L=0.13u W=1.48u AS=0.3922p AD=0.3922p PS=3.28u PD=3.28u rfmode=0
M$16501 VSS|anode|cathode|vss VSS|anode|cathode|vss \$3619
+ VSS|anode|cathode|vss sg13_lv_nmos L=0.13u W=1u AS=0.265p AD=0.265p PS=2.56u
+ PD=2.56u rfmode=0
M$16502 \$3619 \$3452 OUTP|analog_io_padres[16]|core|padres
+ VSS|anode|cathode|vss sg13_lv_nmos L=0.13u W=2u AS=0.38p AD=0.38p PS=3.52u
+ PD=3.52u rfmode=0
M$16504 \$3619 \$3454 OUTN|analog_io_padres[15]|core|padres
+ VSS|anode|cathode|vss sg13_lv_nmos L=0.13u W=2u AS=0.38p AD=0.38p PS=3.52u
+ PD=3.52u rfmode=0
M$16511 VSS|anode|cathode|vss \$3193 \$3757 VSS|anode|cathode|vss sg13_lv_nmos
+ L=0.13u W=0.55u AS=0.187p AD=0.1045p PS=1.78u PD=0.93u rfmode=0
M$16512 \$3757 \$3221 VSS|anode|cathode|vss VSS|anode|cathode|vss sg13_lv_nmos
+ L=0.13u W=0.55u AS=0.1045p AD=0.146425p PS=0.93u PD=1.155u rfmode=0
M$16513 VSS|anode|cathode|vss \$3757 \$3758 VSS|anode|cathode|vss sg13_lv_nmos
+ L=0.13u W=1.48u AS=0.312925p AD=0.4477p PS=2.345u PD=3.43u rfmode=0
M$16515 \$3810 \$3809 \$3859 VSS|anode|cathode|vss sg13_lv_nmos L=0.13u W=0.42u
+ AS=0.1428p AD=0.0609p PS=1.52u PD=0.71u rfmode=0
M$16516 \$3859 VDD VSS|anode|cathode|vss VSS|anode|cathode|vss sg13_lv_nmos
+ L=0.13u W=0.42u AS=0.0609p AD=0.1626p PS=0.71u PD=1.415u rfmode=0
M$16517 VSS|anode|cathode|vss \$3915 \$3759 VSS|anode|cathode|vss sg13_lv_nmos
+ L=0.13u W=0.74u AS=0.1626p AD=0.2516p PS=1.415u PD=2.16u rfmode=0
M$16518 \$3511 \$3458 \$3611 VSS|anode|cathode|vss sg13_lv_nmos L=0.13u W=0.42u
+ AS=0.1296p AD=0.081p PS=1.52u PD=0.81u rfmode=0
M$16519 \$3611 \$3620 \$3512 VSS|anode|cathode|vss sg13_lv_nmos L=0.13u W=0.42u
+ AS=0.081p AD=0.2163p PS=0.81u PD=1.87u rfmode=0
M$16520 \$3812 \$3916 VSS|anode|cathode|vss VSS|anode|cathode|vss sg13_lv_nmos
+ L=0.13u W=0.42u AS=0.1428p AD=0.0798p PS=1.52u PD=0.8u rfmode=0
M$16521 VSS|anode|cathode|vss VDD \$3860 VSS|anode|cathode|vss sg13_lv_nmos
+ L=0.13u W=0.42u AS=0.0798p AD=0.0378p PS=0.8u PD=0.6u rfmode=0
M$16522 \$3860 \$3874 \$3916 VSS|anode|cathode|vss sg13_lv_nmos L=0.13u W=0.42u
+ AS=0.0378p AD=0.1428p PS=0.6u PD=1.52u rfmode=0
M$16523 VSS|anode|cathode|vss \$3874 \$3762 VSS|anode|cathode|vss sg13_lv_nmos
+ L=0.13u W=0.64u AS=0.1331p AD=0.2176p PS=1.12u PD=1.96u rfmode=0
M$16524 VSS|anode|cathode|vss \$3874 \$3761 VSS|anode|cathode|vss sg13_lv_nmos
+ L=0.13u W=1.48u AS=0.3922p AD=0.2737p PS=3.28u PD=2.24u rfmode=0
M$16526 VSS|anode|cathode|vss \$3762 \$3813 VSS|anode|cathode|vss sg13_lv_nmos
+ L=0.13u W=1.48u AS=0.3922p AD=0.3922p PS=3.28u PD=3.28u rfmode=0
M$16528 VSS|anode|cathode|vss VSS|anode|cathode|vss \$3621
+ VSS|anode|cathode|vss sg13_lv_nmos L=0.13u W=1u AS=0.265p AD=0.265p PS=2.56u
+ PD=2.56u rfmode=0
M$16529 \$3621 \$3459 OUTP|analog_io_padres[16]|core|padres
+ VSS|anode|cathode|vss sg13_lv_nmos L=0.13u W=2u AS=0.38p AD=0.38p PS=3.52u
+ PD=3.52u rfmode=0
M$16531 \$3621 \$3461 OUTN|analog_io_padres[15]|core|padres
+ VSS|anode|cathode|vss sg13_lv_nmos L=0.13u W=2u AS=0.38p AD=0.38p PS=3.52u
+ PD=3.52u rfmode=0
M$16538 VSS|anode|cathode|vss \$3194 \$3763 VSS|anode|cathode|vss sg13_lv_nmos
+ L=0.13u W=0.55u AS=0.187p AD=0.1045p PS=1.78u PD=0.93u rfmode=0
M$16539 \$3763 \$3221 VSS|anode|cathode|vss VSS|anode|cathode|vss sg13_lv_nmos
+ L=0.13u W=0.55u AS=0.1045p AD=0.146425p PS=0.93u PD=1.155u rfmode=0
M$16540 VSS|anode|cathode|vss \$3763 \$3764 VSS|anode|cathode|vss sg13_lv_nmos
+ L=0.13u W=1.48u AS=0.312925p AD=0.4477p PS=2.345u PD=3.43u rfmode=0
M$16542 \$3817 \$3816 \$3861 VSS|anode|cathode|vss sg13_lv_nmos L=0.13u W=0.42u
+ AS=0.1428p AD=0.0609p PS=1.52u PD=0.71u rfmode=0
M$16543 \$3861 VDD VSS|anode|cathode|vss VSS|anode|cathode|vss sg13_lv_nmos
+ L=0.13u W=0.42u AS=0.0609p AD=0.1626p PS=0.71u PD=1.415u rfmode=0
M$16544 VSS|anode|cathode|vss \$3917 \$3765 VSS|anode|cathode|vss sg13_lv_nmos
+ L=0.13u W=0.74u AS=0.1626p AD=0.2516p PS=1.415u PD=2.16u rfmode=0
M$16545 \$3517 \$3465 \$3612 VSS|anode|cathode|vss sg13_lv_nmos L=0.13u W=0.42u
+ AS=0.1296p AD=0.081p PS=1.52u PD=0.81u rfmode=0
M$16546 \$3612 \$3622 \$3518 VSS|anode|cathode|vss sg13_lv_nmos L=0.13u W=0.42u
+ AS=0.081p AD=0.2163p PS=0.81u PD=1.87u rfmode=0
M$16547 \$3819 \$3918 VSS|anode|cathode|vss VSS|anode|cathode|vss sg13_lv_nmos
+ L=0.13u W=0.42u AS=0.1428p AD=0.0798p PS=1.52u PD=0.8u rfmode=0
M$16548 VSS|anode|cathode|vss VDD \$3863 VSS|anode|cathode|vss sg13_lv_nmos
+ L=0.13u W=0.42u AS=0.0798p AD=0.0378p PS=0.8u PD=0.6u rfmode=0
M$16549 \$3863 \$3875 \$3918 VSS|anode|cathode|vss sg13_lv_nmos L=0.13u W=0.42u
+ AS=0.0378p AD=0.1428p PS=0.6u PD=1.52u rfmode=0
M$16550 VSS|anode|cathode|vss \$3875 \$3768 VSS|anode|cathode|vss sg13_lv_nmos
+ L=0.13u W=0.64u AS=0.1331p AD=0.2176p PS=1.12u PD=1.96u rfmode=0
M$16551 VSS|anode|cathode|vss \$3875 \$3767 VSS|anode|cathode|vss sg13_lv_nmos
+ L=0.13u W=1.48u AS=0.3922p AD=0.2737p PS=3.28u PD=2.24u rfmode=0
M$16553 VSS|anode|cathode|vss \$3768 \$3820 VSS|anode|cathode|vss sg13_lv_nmos
+ L=0.13u W=1.48u AS=0.3922p AD=0.3922p PS=3.28u PD=3.28u rfmode=0
M$16555 VSS|anode|cathode|vss VSS|anode|cathode|vss \$3623
+ VSS|anode|cathode|vss sg13_lv_nmos L=0.13u W=1u AS=0.265p AD=0.265p PS=2.56u
+ PD=2.56u rfmode=0
M$16556 \$3623 \$3466 OUTP|analog_io_padres[16]|core|padres
+ VSS|anode|cathode|vss sg13_lv_nmos L=0.13u W=2u AS=0.38p AD=0.38p PS=3.52u
+ PD=3.52u rfmode=0
M$16558 \$3623 \$3468 OUTN|analog_io_padres[15]|core|padres
+ VSS|anode|cathode|vss sg13_lv_nmos L=0.13u W=2u AS=0.38p AD=0.38p PS=3.52u
+ PD=3.52u rfmode=0
M$16565 VSS|anode|cathode|vss \$3195 \$3769 VSS|anode|cathode|vss sg13_lv_nmos
+ L=0.13u W=0.55u AS=0.187p AD=0.1045p PS=1.78u PD=0.93u rfmode=0
M$16566 \$3769 \$3221 VSS|anode|cathode|vss VSS|anode|cathode|vss sg13_lv_nmos
+ L=0.13u W=0.55u AS=0.1045p AD=0.146425p PS=0.93u PD=1.155u rfmode=0
M$16567 VSS|anode|cathode|vss \$3769 \$3770 VSS|anode|cathode|vss sg13_lv_nmos
+ L=0.13u W=1.48u AS=0.312925p AD=0.4477p PS=2.345u PD=3.43u rfmode=0
M$16569 \$3824 \$3823 \$3867 VSS|anode|cathode|vss sg13_lv_nmos L=0.13u W=0.42u
+ AS=0.1428p AD=0.0609p PS=1.52u PD=0.71u rfmode=0
M$16570 \$3867 VDD VSS|anode|cathode|vss VSS|anode|cathode|vss sg13_lv_nmos
+ L=0.13u W=0.42u AS=0.0609p AD=0.1626p PS=0.71u PD=1.415u rfmode=0
M$16571 VSS|anode|cathode|vss \$3919 \$3771 VSS|anode|cathode|vss sg13_lv_nmos
+ L=0.13u W=0.74u AS=0.1626p AD=0.2516p PS=1.415u PD=2.16u rfmode=0
M$16572 \$3523 \$3472 \$3613 VSS|anode|cathode|vss sg13_lv_nmos L=0.13u W=0.42u
+ AS=0.1296p AD=0.081p PS=1.52u PD=0.81u rfmode=0
M$16573 \$3613 \$3624 \$3524 VSS|anode|cathode|vss sg13_lv_nmos L=0.13u W=0.42u
+ AS=0.081p AD=0.2163p PS=0.81u PD=1.87u rfmode=0
M$16574 \$3826 \$3920 VSS|anode|cathode|vss VSS|anode|cathode|vss sg13_lv_nmos
+ L=0.13u W=0.42u AS=0.1428p AD=0.0798p PS=1.52u PD=0.8u rfmode=0
M$16575 VSS|anode|cathode|vss VDD \$3869 VSS|anode|cathode|vss sg13_lv_nmos
+ L=0.13u W=0.42u AS=0.0798p AD=0.0378p PS=0.8u PD=0.6u rfmode=0
M$16576 \$3869 \$3876 \$3920 VSS|anode|cathode|vss sg13_lv_nmos L=0.13u W=0.42u
+ AS=0.0378p AD=0.1428p PS=0.6u PD=1.52u rfmode=0
M$16577 VSS|anode|cathode|vss \$3876 \$3774 VSS|anode|cathode|vss sg13_lv_nmos
+ L=0.13u W=0.64u AS=0.1331p AD=0.2176p PS=1.12u PD=1.96u rfmode=0
M$16578 VSS|anode|cathode|vss \$3876 \$3773 VSS|anode|cathode|vss sg13_lv_nmos
+ L=0.13u W=1.48u AS=0.3922p AD=0.2737p PS=3.28u PD=2.24u rfmode=0
M$16580 VSS|anode|cathode|vss \$3774 \$3827 VSS|anode|cathode|vss sg13_lv_nmos
+ L=0.13u W=1.48u AS=0.3922p AD=0.3922p PS=3.28u PD=3.28u rfmode=0
M$16582 VSS|anode|cathode|vss VSS|anode|cathode|vss \$3625
+ VSS|anode|cathode|vss sg13_lv_nmos L=0.13u W=1u AS=0.265p AD=0.265p PS=2.56u
+ PD=2.56u rfmode=0
M$16583 \$3625 \$3473 OUTP|analog_io_padres[16]|core|padres
+ VSS|anode|cathode|vss sg13_lv_nmos L=0.13u W=2u AS=0.38p AD=0.38p PS=3.52u
+ PD=3.52u rfmode=0
M$16585 \$3625 \$3475 OUTN|analog_io_padres[15]|core|padres
+ VSS|anode|cathode|vss sg13_lv_nmos L=0.13u W=2u AS=0.38p AD=0.38p PS=3.52u
+ PD=3.52u rfmode=0
M$16592 VSS|anode|cathode|vss \$3196 \$3775 VSS|anode|cathode|vss sg13_lv_nmos
+ L=0.13u W=0.55u AS=0.187p AD=0.1045p PS=1.78u PD=0.93u rfmode=0
M$16593 \$3775 \$3221 VSS|anode|cathode|vss VSS|anode|cathode|vss sg13_lv_nmos
+ L=0.13u W=0.55u AS=0.1045p AD=0.146425p PS=0.93u PD=1.155u rfmode=0
M$16594 VSS|anode|cathode|vss \$3775 \$3776 VSS|anode|cathode|vss sg13_lv_nmos
+ L=0.13u W=1.48u AS=0.312925p AD=0.4477p PS=2.345u PD=3.43u rfmode=0
M$16596 \$3831 \$3830 \$3872 VSS|anode|cathode|vss sg13_lv_nmos L=0.13u W=0.42u
+ AS=0.1428p AD=0.0609p PS=1.52u PD=0.71u rfmode=0
M$16597 \$3872 VDD VSS|anode|cathode|vss VSS|anode|cathode|vss sg13_lv_nmos
+ L=0.13u W=0.42u AS=0.0609p AD=0.1626p PS=0.71u PD=1.415u rfmode=0
M$16598 VSS|anode|cathode|vss \$3921 \$3777 VSS|anode|cathode|vss sg13_lv_nmos
+ L=0.13u W=0.74u AS=0.1626p AD=0.2516p PS=1.415u PD=2.16u rfmode=0
M$16599 \$3529 \$3479 \$3614 VSS|anode|cathode|vss sg13_lv_nmos L=0.13u W=0.42u
+ AS=0.1296p AD=0.081p PS=1.52u PD=0.81u rfmode=0
M$16600 \$3614 \$3626 \$3530 VSS|anode|cathode|vss sg13_lv_nmos L=0.13u W=0.42u
+ AS=0.081p AD=0.2163p PS=0.81u PD=1.87u rfmode=0
M$16601 \$3833 \$3922 VSS|anode|cathode|vss VSS|anode|cathode|vss sg13_lv_nmos
+ L=0.13u W=0.42u AS=0.1428p AD=0.0798p PS=1.52u PD=0.8u rfmode=0
M$16602 VSS|anode|cathode|vss VDD \$3871 VSS|anode|cathode|vss sg13_lv_nmos
+ L=0.13u W=0.42u AS=0.0798p AD=0.0378p PS=0.8u PD=0.6u rfmode=0
M$16603 \$3871 \$3877 \$3922 VSS|anode|cathode|vss sg13_lv_nmos L=0.13u W=0.42u
+ AS=0.0378p AD=0.1428p PS=0.6u PD=1.52u rfmode=0
M$16604 VSS|anode|cathode|vss \$3877 \$3780 VSS|anode|cathode|vss sg13_lv_nmos
+ L=0.13u W=0.64u AS=0.1331p AD=0.2176p PS=1.12u PD=1.96u rfmode=0
M$16605 VSS|anode|cathode|vss \$3877 \$3779 VSS|anode|cathode|vss sg13_lv_nmos
+ L=0.13u W=1.48u AS=0.3922p AD=0.2737p PS=3.28u PD=2.24u rfmode=0
M$16607 VSS|anode|cathode|vss \$3780 \$3834 VSS|anode|cathode|vss sg13_lv_nmos
+ L=0.13u W=1.48u AS=0.3922p AD=0.3922p PS=3.28u PD=3.28u rfmode=0
M$16609 VSS|anode|cathode|vss VSS|anode|cathode|vss \$3627
+ VSS|anode|cathode|vss sg13_lv_nmos L=0.13u W=1u AS=0.265p AD=0.265p PS=2.56u
+ PD=2.56u rfmode=0
M$16610 \$3627 \$3480 OUTP|analog_io_padres[16]|core|padres
+ VSS|anode|cathode|vss sg13_lv_nmos L=0.13u W=2u AS=0.38p AD=0.38p PS=3.52u
+ PD=3.52u rfmode=0
M$16612 \$3627 \$3482 OUTN|analog_io_padres[15]|core|padres
+ VSS|anode|cathode|vss sg13_lv_nmos L=0.13u W=2u AS=0.38p AD=0.38p PS=3.52u
+ PD=3.52u rfmode=0
M$16619 VSS|anode|cathode|vss \$3197 \$3781 VSS|anode|cathode|vss sg13_lv_nmos
+ L=0.13u W=0.55u AS=0.187p AD=0.1045p PS=1.78u PD=0.93u rfmode=0
M$16620 \$3781 \$3221 VSS|anode|cathode|vss VSS|anode|cathode|vss sg13_lv_nmos
+ L=0.13u W=0.55u AS=0.1045p AD=0.146425p PS=0.93u PD=1.155u rfmode=0
M$16621 VSS|anode|cathode|vss \$3781 \$3782 VSS|anode|cathode|vss sg13_lv_nmos
+ L=0.13u W=1.48u AS=0.312925p AD=0.4477p PS=2.345u PD=3.43u rfmode=0
M$16623 \$3838 \$3837 \$3870 VSS|anode|cathode|vss sg13_lv_nmos L=0.13u W=0.42u
+ AS=0.1428p AD=0.0609p PS=1.52u PD=0.71u rfmode=0
M$16624 \$3870 VDD VSS|anode|cathode|vss VSS|anode|cathode|vss sg13_lv_nmos
+ L=0.13u W=0.42u AS=0.0609p AD=0.1626p PS=0.71u PD=1.415u rfmode=0
M$16625 VSS|anode|cathode|vss \$3923 \$3783 VSS|anode|cathode|vss sg13_lv_nmos
+ L=0.13u W=0.74u AS=0.1626p AD=0.2516p PS=1.415u PD=2.16u rfmode=0
M$16626 \$3535 \$3486 \$3615 VSS|anode|cathode|vss sg13_lv_nmos L=0.13u W=0.42u
+ AS=0.1296p AD=0.081p PS=1.52u PD=0.81u rfmode=0
M$16627 \$3615 \$3628 \$3536 VSS|anode|cathode|vss sg13_lv_nmos L=0.13u W=0.42u
+ AS=0.081p AD=0.2163p PS=0.81u PD=1.87u rfmode=0
M$16628 \$3840 \$3924 VSS|anode|cathode|vss VSS|anode|cathode|vss sg13_lv_nmos
+ L=0.13u W=0.42u AS=0.1428p AD=0.0798p PS=1.52u PD=0.8u rfmode=0
M$16629 VSS|anode|cathode|vss VDD \$3868 VSS|anode|cathode|vss sg13_lv_nmos
+ L=0.13u W=0.42u AS=0.0798p AD=0.0378p PS=0.8u PD=0.6u rfmode=0
M$16630 \$3868 \$3878 \$3924 VSS|anode|cathode|vss sg13_lv_nmos L=0.13u W=0.42u
+ AS=0.0378p AD=0.1428p PS=0.6u PD=1.52u rfmode=0
M$16631 VSS|anode|cathode|vss \$3878 \$3786 VSS|anode|cathode|vss sg13_lv_nmos
+ L=0.13u W=0.64u AS=0.1331p AD=0.2176p PS=1.12u PD=1.96u rfmode=0
M$16632 VSS|anode|cathode|vss \$3878 \$3785 VSS|anode|cathode|vss sg13_lv_nmos
+ L=0.13u W=1.48u AS=0.3922p AD=0.2737p PS=3.28u PD=2.24u rfmode=0
M$16634 VSS|anode|cathode|vss \$3786 \$3841 VSS|anode|cathode|vss sg13_lv_nmos
+ L=0.13u W=1.48u AS=0.3922p AD=0.3922p PS=3.28u PD=3.28u rfmode=0
M$16636 VSS|anode|cathode|vss VSS|anode|cathode|vss \$3629
+ VSS|anode|cathode|vss sg13_lv_nmos L=0.13u W=1u AS=0.265p AD=0.265p PS=2.56u
+ PD=2.56u rfmode=0
M$16637 \$3629 \$3487 OUTP|analog_io_padres[16]|core|padres
+ VSS|anode|cathode|vss sg13_lv_nmos L=0.13u W=2u AS=0.38p AD=0.38p PS=3.52u
+ PD=3.52u rfmode=0
M$16639 \$3629 \$3489 OUTN|analog_io_padres[15]|core|padres
+ VSS|anode|cathode|vss sg13_lv_nmos L=0.13u W=2u AS=0.38p AD=0.38p PS=3.52u
+ PD=3.52u rfmode=0
M$16646 VSS|anode|cathode|vss \$3198 \$3787 VSS|anode|cathode|vss sg13_lv_nmos
+ L=0.13u W=0.55u AS=0.187p AD=0.1045p PS=1.78u PD=0.93u rfmode=0
M$16647 \$3787 \$3221 VSS|anode|cathode|vss VSS|anode|cathode|vss sg13_lv_nmos
+ L=0.13u W=0.55u AS=0.1045p AD=0.146425p PS=0.93u PD=1.155u rfmode=0
M$16648 VSS|anode|cathode|vss \$3787 \$3788 VSS|anode|cathode|vss sg13_lv_nmos
+ L=0.13u W=1.48u AS=0.312925p AD=0.4477p PS=2.345u PD=3.43u rfmode=0
M$16650 \$3845 \$3844 \$3866 VSS|anode|cathode|vss sg13_lv_nmos L=0.13u W=0.42u
+ AS=0.1428p AD=0.0609p PS=1.52u PD=0.71u rfmode=0
M$16651 \$3866 VDD VSS|anode|cathode|vss VSS|anode|cathode|vss sg13_lv_nmos
+ L=0.13u W=0.42u AS=0.0609p AD=0.1626p PS=0.71u PD=1.415u rfmode=0
M$16652 VSS|anode|cathode|vss \$3925 \$3789 VSS|anode|cathode|vss sg13_lv_nmos
+ L=0.13u W=0.74u AS=0.1626p AD=0.2516p PS=1.415u PD=2.16u rfmode=0
M$16653 \$3541 \$3493 \$3616 VSS|anode|cathode|vss sg13_lv_nmos L=0.13u W=0.42u
+ AS=0.1296p AD=0.081p PS=1.52u PD=0.81u rfmode=0
M$16654 \$3616 \$3630 \$3542 VSS|anode|cathode|vss sg13_lv_nmos L=0.13u W=0.42u
+ AS=0.081p AD=0.2163p PS=0.81u PD=1.87u rfmode=0
M$16655 \$3847 \$3926 VSS|anode|cathode|vss VSS|anode|cathode|vss sg13_lv_nmos
+ L=0.13u W=0.42u AS=0.1428p AD=0.0798p PS=1.52u PD=0.8u rfmode=0
M$16656 VSS|anode|cathode|vss VDD \$3865 VSS|anode|cathode|vss sg13_lv_nmos
+ L=0.13u W=0.42u AS=0.0798p AD=0.0378p PS=0.8u PD=0.6u rfmode=0
M$16657 \$3865 \$3879 \$3926 VSS|anode|cathode|vss sg13_lv_nmos L=0.13u W=0.42u
+ AS=0.0378p AD=0.1428p PS=0.6u PD=1.52u rfmode=0
M$16658 VSS|anode|cathode|vss \$3879 \$3792 VSS|anode|cathode|vss sg13_lv_nmos
+ L=0.13u W=0.64u AS=0.1331p AD=0.2176p PS=1.12u PD=1.96u rfmode=0
M$16659 VSS|anode|cathode|vss \$3879 \$3791 VSS|anode|cathode|vss sg13_lv_nmos
+ L=0.13u W=1.48u AS=0.3922p AD=0.2737p PS=3.28u PD=2.24u rfmode=0
M$16661 VSS|anode|cathode|vss \$3792 \$3848 VSS|anode|cathode|vss sg13_lv_nmos
+ L=0.13u W=1.48u AS=0.3922p AD=0.3922p PS=3.28u PD=3.28u rfmode=0
M$16663 VSS|anode|cathode|vss VSS|anode|cathode|vss \$3631
+ VSS|anode|cathode|vss sg13_lv_nmos L=0.13u W=1u AS=0.265p AD=0.265p PS=2.56u
+ PD=2.56u rfmode=0
M$16664 \$3631 \$3494 OUTP|analog_io_padres[16]|core|padres
+ VSS|anode|cathode|vss sg13_lv_nmos L=0.13u W=2u AS=0.38p AD=0.38p PS=3.52u
+ PD=3.52u rfmode=0
M$16666 \$3631 \$3496 OUTN|analog_io_padres[15]|core|padres
+ VSS|anode|cathode|vss sg13_lv_nmos L=0.13u W=2u AS=0.38p AD=0.38p PS=3.52u
+ PD=3.52u rfmode=0
M$16673 VSS|anode|cathode|vss VSS|anode|cathode|vss \$3793
+ VSS|anode|cathode|vss sg13_lv_nmos L=0.13u W=0.55u AS=0.187p AD=0.1045p
+ PS=1.78u PD=0.93u rfmode=0
M$16674 \$3793 \$3221 VSS|anode|cathode|vss VSS|anode|cathode|vss sg13_lv_nmos
+ L=0.13u W=0.55u AS=0.1045p AD=0.146425p PS=0.93u PD=1.155u rfmode=0
M$16675 VSS|anode|cathode|vss \$3793 \$3794 VSS|anode|cathode|vss sg13_lv_nmos
+ L=0.13u W=1.48u AS=0.312925p AD=0.4477p PS=2.345u PD=3.43u rfmode=0
M$16677 \$3852 \$3851 \$3864 VSS|anode|cathode|vss sg13_lv_nmos L=0.13u W=0.42u
+ AS=0.1428p AD=0.0609p PS=1.52u PD=0.71u rfmode=0
M$16678 \$3864 VDD VSS|anode|cathode|vss VSS|anode|cathode|vss sg13_lv_nmos
+ L=0.13u W=0.42u AS=0.0609p AD=0.1626p PS=0.71u PD=1.415u rfmode=0
M$16679 VSS|anode|cathode|vss \$3927 \$3795 VSS|anode|cathode|vss sg13_lv_nmos
+ L=0.13u W=0.74u AS=0.1626p AD=0.2516p PS=1.415u PD=2.16u rfmode=0
M$16680 \$3547 \$3500 \$3617 VSS|anode|cathode|vss sg13_lv_nmos L=0.13u W=0.42u
+ AS=0.1296p AD=0.081p PS=1.52u PD=0.81u rfmode=0
M$16681 \$3617 \$3632 \$3548 VSS|anode|cathode|vss sg13_lv_nmos L=0.13u W=0.42u
+ AS=0.081p AD=0.2163p PS=0.81u PD=1.87u rfmode=0
M$16682 \$3854 \$3928 VSS|anode|cathode|vss VSS|anode|cathode|vss sg13_lv_nmos
+ L=0.13u W=0.42u AS=0.1428p AD=0.0798p PS=1.52u PD=0.8u rfmode=0
M$16683 VSS|anode|cathode|vss VDD \$3862 VSS|anode|cathode|vss sg13_lv_nmos
+ L=0.13u W=0.42u AS=0.0798p AD=0.0378p PS=0.8u PD=0.6u rfmode=0
M$16684 \$3862 \$3880 \$3928 VSS|anode|cathode|vss sg13_lv_nmos L=0.13u W=0.42u
+ AS=0.0378p AD=0.1428p PS=0.6u PD=1.52u rfmode=0
M$16685 VSS|anode|cathode|vss \$3880 \$3798 VSS|anode|cathode|vss sg13_lv_nmos
+ L=0.13u W=0.64u AS=0.1331p AD=0.2176p PS=1.12u PD=1.96u rfmode=0
M$16686 VSS|anode|cathode|vss \$3880 \$3797 VSS|anode|cathode|vss sg13_lv_nmos
+ L=0.13u W=1.48u AS=0.3922p AD=0.2737p PS=3.28u PD=2.24u rfmode=0
M$16688 VSS|anode|cathode|vss \$3798 \$3855 VSS|anode|cathode|vss sg13_lv_nmos
+ L=0.13u W=1.48u AS=0.3922p AD=0.3922p PS=3.28u PD=3.28u rfmode=0
M$16690 VSS|anode|cathode|vss VSS|anode|cathode|vss \$3633
+ VSS|anode|cathode|vss sg13_lv_nmos L=0.13u W=1u AS=0.265p AD=0.265p PS=2.56u
+ PD=2.56u rfmode=0
M$16691 \$3633 \$3501 OUTP|analog_io_padres[16]|core|padres
+ VSS|anode|cathode|vss sg13_lv_nmos L=0.13u W=2u AS=0.38p AD=0.38p PS=3.52u
+ PD=3.52u rfmode=0
M$16693 \$3633 \$3503 OUTN|analog_io_padres[15]|core|padres
+ VSS|anode|cathode|vss sg13_lv_nmos L=0.13u W=2u AS=0.38p AD=0.38p PS=3.52u
+ PD=3.52u rfmode=0
M$16700 \$3801 \$3752 VSS|anode|cathode|vss VSS|anode|cathode|vss sg13_lv_nmos
+ L=0.13u W=1.44u AS=0.4068p AD=0.2772p PS=3.29u PD=2.21u rfmode=0
M$16702 \$3801 \$3414 \$3802 VSS|anode|cathode|vss sg13_lv_nmos L=0.13u W=1.44u
+ AS=0.2772p AD=0.3816p PS=2.21u PD=3.22u rfmode=0
M$16704 VSS|anode|cathode|vss VDD \$3881 VSS|anode|cathode|vss sg13_lv_nmos
+ L=0.13u W=0.42u AS=0.1701p AD=0.03885p PS=1.65u PD=0.605u rfmode=0
M$16705 \$3881 \$3753 \$3804 VSS|anode|cathode|vss sg13_lv_nmos L=0.13u W=0.42u
+ AS=0.03885p AD=0.1596p PS=0.605u PD=1.6u rfmode=0
M$16706 VSS|anode|cathode|vss \$3754 \$3929 VSS|anode|cathode|vss sg13_lv_nmos
+ L=0.13u W=0.74u AS=0.43315p AD=0.2516p PS=2.205u PD=2.16u rfmode=0
M$16707 VSS|anode|cathode|vss CLK|clk|core|fclk_in|p2c|ui_p2c[6] \$3754
+ VSS|anode|cathode|vss sg13_lv_nmos L=0.13u W=0.74u AS=0.43315p AD=0.2516p
+ PS=2.205u PD=2.16u rfmode=0
M$16708 \$3873 \$3754 \$3805 VSS|anode|cathode|vss sg13_lv_nmos L=0.13u W=0.42u
+ AS=0.12665p AD=0.1428p PS=1.145u PD=1.52u rfmode=0
M$16709 \$3753 \$3929 \$3873 VSS|anode|cathode|vss sg13_lv_nmos L=0.13u W=0.74u
+ AS=0.3473p AD=0.12665p PS=2.71u PD=1.145u rfmode=0
M$16710 \$3808 \$3758 VSS|anode|cathode|vss VSS|anode|cathode|vss sg13_lv_nmos
+ L=0.13u W=1.44u AS=0.4068p AD=0.2772p PS=3.29u PD=2.21u rfmode=0
M$16712 \$3808 \$3414 \$3809 VSS|anode|cathode|vss sg13_lv_nmos L=0.13u W=1.44u
+ AS=0.2772p AD=0.3816p PS=2.21u PD=3.22u rfmode=0
M$16714 VSS|anode|cathode|vss VDD \$3885 VSS|anode|cathode|vss sg13_lv_nmos
+ L=0.13u W=0.42u AS=0.1701p AD=0.03885p PS=1.65u PD=0.605u rfmode=0
M$16715 \$3885 \$3759 \$3811 VSS|anode|cathode|vss sg13_lv_nmos L=0.13u W=0.42u
+ AS=0.03885p AD=0.1596p PS=0.605u PD=1.6u rfmode=0
M$16716 VSS|anode|cathode|vss \$3760 \$3931 VSS|anode|cathode|vss sg13_lv_nmos
+ L=0.13u W=0.74u AS=0.43315p AD=0.2516p PS=2.205u PD=2.16u rfmode=0
M$16717 VSS|anode|cathode|vss CLK|clk|core|fclk_in|p2c|ui_p2c[6] \$3760
+ VSS|anode|cathode|vss sg13_lv_nmos L=0.13u W=0.74u AS=0.43315p AD=0.2516p
+ PS=2.205u PD=2.16u rfmode=0
M$16718 \$3874 \$3760 \$3812 VSS|anode|cathode|vss sg13_lv_nmos L=0.13u W=0.42u
+ AS=0.12665p AD=0.1428p PS=1.145u PD=1.52u rfmode=0
M$16719 \$3759 \$3931 \$3874 VSS|anode|cathode|vss sg13_lv_nmos L=0.13u W=0.74u
+ AS=0.3473p AD=0.12665p PS=2.71u PD=1.145u rfmode=0
M$16720 \$3815 \$3764 VSS|anode|cathode|vss VSS|anode|cathode|vss sg13_lv_nmos
+ L=0.13u W=1.44u AS=0.4068p AD=0.2772p PS=3.29u PD=2.21u rfmode=0
M$16722 \$3815 \$3414 \$3816 VSS|anode|cathode|vss sg13_lv_nmos L=0.13u W=1.44u
+ AS=0.2772p AD=0.3816p PS=2.21u PD=3.22u rfmode=0
M$16724 VSS|anode|cathode|vss VDD \$3893 VSS|anode|cathode|vss sg13_lv_nmos
+ L=0.13u W=0.42u AS=0.1701p AD=0.03885p PS=1.65u PD=0.605u rfmode=0
M$16725 \$3893 \$3765 \$3818 VSS|anode|cathode|vss sg13_lv_nmos L=0.13u W=0.42u
+ AS=0.03885p AD=0.1596p PS=0.605u PD=1.6u rfmode=0
M$16726 VSS|anode|cathode|vss \$3766 \$3933 VSS|anode|cathode|vss sg13_lv_nmos
+ L=0.13u W=0.74u AS=0.43315p AD=0.2516p PS=2.205u PD=2.16u rfmode=0
M$16727 VSS|anode|cathode|vss CLK|clk|core|fclk_in|p2c|ui_p2c[6] \$3766
+ VSS|anode|cathode|vss sg13_lv_nmos L=0.13u W=0.74u AS=0.43315p AD=0.2516p
+ PS=2.205u PD=2.16u rfmode=0
M$16728 \$3875 \$3766 \$3819 VSS|anode|cathode|vss sg13_lv_nmos L=0.13u W=0.42u
+ AS=0.12665p AD=0.1428p PS=1.145u PD=1.52u rfmode=0
M$16729 \$3765 \$3933 \$3875 VSS|anode|cathode|vss sg13_lv_nmos L=0.13u W=0.74u
+ AS=0.3473p AD=0.12665p PS=2.71u PD=1.145u rfmode=0
M$16730 \$3822 \$3770 VSS|anode|cathode|vss VSS|anode|cathode|vss sg13_lv_nmos
+ L=0.13u W=1.44u AS=0.4068p AD=0.2772p PS=3.29u PD=2.21u rfmode=0
M$16732 \$3822 \$3414 \$3823 VSS|anode|cathode|vss sg13_lv_nmos L=0.13u W=1.44u
+ AS=0.2772p AD=0.3816p PS=2.21u PD=3.22u rfmode=0
M$16734 VSS|anode|cathode|vss VDD \$3900 VSS|anode|cathode|vss sg13_lv_nmos
+ L=0.13u W=0.42u AS=0.1701p AD=0.03885p PS=1.65u PD=0.605u rfmode=0
M$16735 \$3900 \$3771 \$3825 VSS|anode|cathode|vss sg13_lv_nmos L=0.13u W=0.42u
+ AS=0.03885p AD=0.1596p PS=0.605u PD=1.6u rfmode=0
M$16736 VSS|anode|cathode|vss \$3772 \$3935 VSS|anode|cathode|vss sg13_lv_nmos
+ L=0.13u W=0.74u AS=0.43315p AD=0.2516p PS=2.205u PD=2.16u rfmode=0
M$16737 VSS|anode|cathode|vss CLK|clk|core|fclk_in|p2c|ui_p2c[6] \$3772
+ VSS|anode|cathode|vss sg13_lv_nmos L=0.13u W=0.74u AS=0.43315p AD=0.2516p
+ PS=2.205u PD=2.16u rfmode=0
M$16738 \$3876 \$3772 \$3826 VSS|anode|cathode|vss sg13_lv_nmos L=0.13u W=0.42u
+ AS=0.12665p AD=0.1428p PS=1.145u PD=1.52u rfmode=0
M$16739 \$3771 \$3935 \$3876 VSS|anode|cathode|vss sg13_lv_nmos L=0.13u W=0.74u
+ AS=0.3473p AD=0.12665p PS=2.71u PD=1.145u rfmode=0
M$16740 \$3829 \$3776 VSS|anode|cathode|vss VSS|anode|cathode|vss sg13_lv_nmos
+ L=0.13u W=1.44u AS=0.4068p AD=0.2772p PS=3.29u PD=2.21u rfmode=0
M$16742 \$3829 \$3414 \$3830 VSS|anode|cathode|vss sg13_lv_nmos L=0.13u W=1.44u
+ AS=0.2772p AD=0.3816p PS=2.21u PD=3.22u rfmode=0
M$16744 VSS|anode|cathode|vss VDD \$3912 VSS|anode|cathode|vss sg13_lv_nmos
+ L=0.13u W=0.42u AS=0.1701p AD=0.03885p PS=1.65u PD=0.605u rfmode=0
M$16745 \$3912 \$3777 \$3832 VSS|anode|cathode|vss sg13_lv_nmos L=0.13u W=0.42u
+ AS=0.03885p AD=0.1596p PS=0.605u PD=1.6u rfmode=0
M$16746 VSS|anode|cathode|vss \$3778 \$3937 VSS|anode|cathode|vss sg13_lv_nmos
+ L=0.13u W=0.74u AS=0.43315p AD=0.2516p PS=2.205u PD=2.16u rfmode=0
M$16747 VSS|anode|cathode|vss CLK|clk|core|fclk_in|p2c|ui_p2c[6] \$3778
+ VSS|anode|cathode|vss sg13_lv_nmos L=0.13u W=0.74u AS=0.43315p AD=0.2516p
+ PS=2.205u PD=2.16u rfmode=0
M$16748 \$3877 \$3778 \$3833 VSS|anode|cathode|vss sg13_lv_nmos L=0.13u W=0.42u
+ AS=0.12665p AD=0.1428p PS=1.145u PD=1.52u rfmode=0
M$16749 \$3777 \$3937 \$3877 VSS|anode|cathode|vss sg13_lv_nmos L=0.13u W=0.74u
+ AS=0.3473p AD=0.12665p PS=2.71u PD=1.145u rfmode=0
M$16750 \$3836 \$3782 VSS|anode|cathode|vss VSS|anode|cathode|vss sg13_lv_nmos
+ L=0.13u W=1.44u AS=0.4068p AD=0.2772p PS=3.29u PD=2.21u rfmode=0
M$16752 \$3836 \$3414 \$3837 VSS|anode|cathode|vss sg13_lv_nmos L=0.13u W=1.44u
+ AS=0.2772p AD=0.3816p PS=2.21u PD=3.22u rfmode=0
M$16754 VSS|anode|cathode|vss VDD \$3905 VSS|anode|cathode|vss sg13_lv_nmos
+ L=0.13u W=0.42u AS=0.1701p AD=0.03885p PS=1.65u PD=0.605u rfmode=0
M$16755 \$3905 \$3783 \$3839 VSS|anode|cathode|vss sg13_lv_nmos L=0.13u W=0.42u
+ AS=0.03885p AD=0.1596p PS=0.605u PD=1.6u rfmode=0
M$16756 VSS|anode|cathode|vss \$3784 \$3939 VSS|anode|cathode|vss sg13_lv_nmos
+ L=0.13u W=0.74u AS=0.43315p AD=0.2516p PS=2.205u PD=2.16u rfmode=0
M$16757 VSS|anode|cathode|vss CLK|clk|core|fclk_in|p2c|ui_p2c[6] \$3784
+ VSS|anode|cathode|vss sg13_lv_nmos L=0.13u W=0.74u AS=0.43315p AD=0.2516p
+ PS=2.205u PD=2.16u rfmode=0
M$16758 \$3878 \$3784 \$3840 VSS|anode|cathode|vss sg13_lv_nmos L=0.13u W=0.42u
+ AS=0.12665p AD=0.1428p PS=1.145u PD=1.52u rfmode=0
M$16759 \$3783 \$3939 \$3878 VSS|anode|cathode|vss sg13_lv_nmos L=0.13u W=0.74u
+ AS=0.3473p AD=0.12665p PS=2.71u PD=1.145u rfmode=0
M$16760 \$3843 \$3788 VSS|anode|cathode|vss VSS|anode|cathode|vss sg13_lv_nmos
+ L=0.13u W=1.44u AS=0.4068p AD=0.2772p PS=3.29u PD=2.21u rfmode=0
M$16762 \$3843 \$3414 \$3844 VSS|anode|cathode|vss sg13_lv_nmos L=0.13u W=1.44u
+ AS=0.2772p AD=0.3816p PS=2.21u PD=3.22u rfmode=0
M$16764 VSS|anode|cathode|vss VDD \$3901 VSS|anode|cathode|vss sg13_lv_nmos
+ L=0.13u W=0.42u AS=0.1701p AD=0.03885p PS=1.65u PD=0.605u rfmode=0
M$16765 \$3901 \$3789 \$3846 VSS|anode|cathode|vss sg13_lv_nmos L=0.13u W=0.42u
+ AS=0.03885p AD=0.1596p PS=0.605u PD=1.6u rfmode=0
M$16766 VSS|anode|cathode|vss \$3790 \$3941 VSS|anode|cathode|vss sg13_lv_nmos
+ L=0.13u W=0.74u AS=0.43315p AD=0.2516p PS=2.205u PD=2.16u rfmode=0
M$16767 VSS|anode|cathode|vss CLK|clk|core|fclk_in|p2c|ui_p2c[6] \$3790
+ VSS|anode|cathode|vss sg13_lv_nmos L=0.13u W=0.74u AS=0.43315p AD=0.2516p
+ PS=2.205u PD=2.16u rfmode=0
M$16768 \$3879 \$3790 \$3847 VSS|anode|cathode|vss sg13_lv_nmos L=0.13u W=0.42u
+ AS=0.12665p AD=0.1428p PS=1.145u PD=1.52u rfmode=0
M$16769 \$3789 \$3941 \$3879 VSS|anode|cathode|vss sg13_lv_nmos L=0.13u W=0.74u
+ AS=0.3473p AD=0.12665p PS=2.71u PD=1.145u rfmode=0
M$16770 \$3850 \$3794 VSS|anode|cathode|vss VSS|anode|cathode|vss sg13_lv_nmos
+ L=0.13u W=1.44u AS=0.4068p AD=0.2772p PS=3.29u PD=2.21u rfmode=0
M$16772 \$3850 \$3414 \$3851 VSS|anode|cathode|vss sg13_lv_nmos L=0.13u W=1.44u
+ AS=0.2772p AD=0.3816p PS=2.21u PD=3.22u rfmode=0
M$16774 VSS|anode|cathode|vss VDD \$3892 VSS|anode|cathode|vss sg13_lv_nmos
+ L=0.13u W=0.42u AS=0.1701p AD=0.03885p PS=1.65u PD=0.605u rfmode=0
M$16775 \$3892 \$3795 \$3853 VSS|anode|cathode|vss sg13_lv_nmos L=0.13u W=0.42u
+ AS=0.03885p AD=0.1596p PS=0.605u PD=1.6u rfmode=0
M$16776 VSS|anode|cathode|vss \$3796 \$3943 VSS|anode|cathode|vss sg13_lv_nmos
+ L=0.13u W=0.74u AS=0.43315p AD=0.2516p PS=2.205u PD=2.16u rfmode=0
M$16777 VSS|anode|cathode|vss CLK|clk|core|fclk_in|p2c|ui_p2c[6] \$3796
+ VSS|anode|cathode|vss sg13_lv_nmos L=0.13u W=0.74u AS=0.43315p AD=0.2516p
+ PS=2.205u PD=2.16u rfmode=0
M$16778 \$3880 \$3796 \$3854 VSS|anode|cathode|vss sg13_lv_nmos L=0.13u W=0.42u
+ AS=0.12665p AD=0.1428p PS=1.145u PD=1.52u rfmode=0
M$16779 \$3795 \$3943 \$3880 VSS|anode|cathode|vss sg13_lv_nmos L=0.13u W=0.74u
+ AS=0.3473p AD=0.12665p PS=2.71u PD=1.145u rfmode=0
M$16780 VSS|anode|cathode|vss \$3192 \$4045 VSS|anode|cathode|vss sg13_lv_nmos
+ L=0.13u W=0.55u AS=0.187p AD=0.1045p PS=1.78u PD=0.93u rfmode=0
M$16781 \$4045 \$2935 VSS|anode|cathode|vss VSS|anode|cathode|vss sg13_lv_nmos
+ L=0.13u W=0.55u AS=0.1045p AD=0.146425p PS=0.93u PD=1.155u rfmode=0
M$16782 VSS|anode|cathode|vss \$4045 \$4046 VSS|anode|cathode|vss sg13_lv_nmos
+ L=0.13u W=1.48u AS=0.312925p AD=0.4477p PS=2.345u PD=3.43u rfmode=0
M$16784 \$4078 \$4133 \$4166 VSS|anode|cathode|vss sg13_lv_nmos L=0.13u W=0.42u
+ AS=0.1428p AD=0.0609p PS=1.52u PD=0.71u rfmode=0
M$16785 \$4166 VDD VSS|anode|cathode|vss VSS|anode|cathode|vss sg13_lv_nmos
+ L=0.13u W=0.42u AS=0.0609p AD=0.1626p PS=0.71u PD=1.415u rfmode=0
M$16786 VSS|anode|cathode|vss \$4213 \$4047 VSS|anode|cathode|vss sg13_lv_nmos
+ L=0.13u W=0.74u AS=0.1626p AD=0.2516p PS=1.415u PD=2.16u rfmode=0
M$16787 \$3803 \$3754 \$3913 VSS|anode|cathode|vss sg13_lv_nmos L=0.13u W=0.42u
+ AS=0.1296p AD=0.081p PS=1.52u PD=0.81u rfmode=0
M$16788 \$3913 \$3929 \$3804 VSS|anode|cathode|vss sg13_lv_nmos L=0.13u W=0.42u
+ AS=0.081p AD=0.2163p PS=0.81u PD=1.87u rfmode=0
M$16789 \$4080 \$4214 VSS|anode|cathode|vss VSS|anode|cathode|vss sg13_lv_nmos
+ L=0.13u W=0.42u AS=0.1428p AD=0.0798p PS=1.52u PD=0.8u rfmode=0
M$16790 VSS|anode|cathode|vss VDD \$4167 VSS|anode|cathode|vss sg13_lv_nmos
+ L=0.13u W=0.42u AS=0.0798p AD=0.0378p PS=0.8u PD=0.6u rfmode=0
M$16791 \$4167 \$4135 \$4214 VSS|anode|cathode|vss sg13_lv_nmos L=0.13u W=0.42u
+ AS=0.0378p AD=0.1428p PS=0.6u PD=1.52u rfmode=0
M$16792 VSS|anode|cathode|vss \$4135 \$4082 VSS|anode|cathode|vss sg13_lv_nmos
+ L=0.13u W=0.64u AS=0.1331p AD=0.2176p PS=1.12u PD=1.96u rfmode=0
M$16793 VSS|anode|cathode|vss \$4135 \$4081 VSS|anode|cathode|vss sg13_lv_nmos
+ L=0.13u W=1.48u AS=0.3922p AD=0.2737p PS=3.28u PD=2.24u rfmode=0
M$16795 VSS|anode|cathode|vss \$4082 \$4083 VSS|anode|cathode|vss sg13_lv_nmos
+ L=0.13u W=1.48u AS=0.3922p AD=0.3922p PS=3.28u PD=3.28u rfmode=0
M$16797 VSS|anode|cathode|vss VSS|anode|cathode|vss \$3930
+ VSS|anode|cathode|vss sg13_lv_nmos L=0.13u W=1u AS=0.265p AD=0.265p PS=2.56u
+ PD=2.56u rfmode=0
M$16798 \$3930 \$3755 OUTP|analog_io_padres[16]|core|padres
+ VSS|anode|cathode|vss sg13_lv_nmos L=0.13u W=2u AS=0.38p AD=0.38p PS=3.52u
+ PD=3.52u rfmode=0
M$16800 \$3930 \$3806 OUTN|analog_io_padres[15]|core|padres
+ VSS|anode|cathode|vss sg13_lv_nmos L=0.13u W=2u AS=0.38p AD=0.38p PS=3.52u
+ PD=3.52u rfmode=0
M$16807 VSS|anode|cathode|vss \$3193 \$4049 VSS|anode|cathode|vss sg13_lv_nmos
+ L=0.13u W=0.55u AS=0.187p AD=0.1045p PS=1.78u PD=0.93u rfmode=0
M$16808 \$4049 \$2935 VSS|anode|cathode|vss VSS|anode|cathode|vss sg13_lv_nmos
+ L=0.13u W=0.55u AS=0.1045p AD=0.146425p PS=0.93u PD=1.155u rfmode=0
M$16809 VSS|anode|cathode|vss \$4049 \$4050 VSS|anode|cathode|vss sg13_lv_nmos
+ L=0.13u W=1.48u AS=0.312925p AD=0.4477p PS=2.345u PD=3.43u rfmode=0
M$16811 \$4085 \$4137 \$4172 VSS|anode|cathode|vss sg13_lv_nmos L=0.13u W=0.42u
+ AS=0.1428p AD=0.0609p PS=1.52u PD=0.71u rfmode=0
M$16812 \$4172 VDD VSS|anode|cathode|vss VSS|anode|cathode|vss sg13_lv_nmos
+ L=0.13u W=0.42u AS=0.0609p AD=0.1626p PS=0.71u PD=1.415u rfmode=0
M$16813 VSS|anode|cathode|vss \$4215 \$4051 VSS|anode|cathode|vss sg13_lv_nmos
+ L=0.13u W=0.74u AS=0.1626p AD=0.2516p PS=1.415u PD=2.16u rfmode=0
M$16814 \$3810 \$3760 \$3915 VSS|anode|cathode|vss sg13_lv_nmos L=0.13u W=0.42u
+ AS=0.1296p AD=0.081p PS=1.52u PD=0.81u rfmode=0
M$16815 \$3915 \$3931 \$3811 VSS|anode|cathode|vss sg13_lv_nmos L=0.13u W=0.42u
+ AS=0.081p AD=0.2163p PS=0.81u PD=1.87u rfmode=0
M$16816 \$4087 \$4216 VSS|anode|cathode|vss VSS|anode|cathode|vss sg13_lv_nmos
+ L=0.13u W=0.42u AS=0.1428p AD=0.0798p PS=1.52u PD=0.8u rfmode=0
M$16817 VSS|anode|cathode|vss VDD \$4173 VSS|anode|cathode|vss sg13_lv_nmos
+ L=0.13u W=0.42u AS=0.0798p AD=0.0378p PS=0.8u PD=0.6u rfmode=0
M$16818 \$4173 \$4139 \$4216 VSS|anode|cathode|vss sg13_lv_nmos L=0.13u W=0.42u
+ AS=0.0378p AD=0.1428p PS=0.6u PD=1.52u rfmode=0
M$16819 VSS|anode|cathode|vss \$4139 \$4089 VSS|anode|cathode|vss sg13_lv_nmos
+ L=0.13u W=0.64u AS=0.1331p AD=0.2176p PS=1.12u PD=1.96u rfmode=0
M$16820 VSS|anode|cathode|vss \$4139 \$4088 VSS|anode|cathode|vss sg13_lv_nmos
+ L=0.13u W=1.48u AS=0.3922p AD=0.2737p PS=3.28u PD=2.24u rfmode=0
M$16822 VSS|anode|cathode|vss \$4089 \$4090 VSS|anode|cathode|vss sg13_lv_nmos
+ L=0.13u W=1.48u AS=0.3922p AD=0.3922p PS=3.28u PD=3.28u rfmode=0
M$16824 VSS|anode|cathode|vss VSS|anode|cathode|vss \$3932
+ VSS|anode|cathode|vss sg13_lv_nmos L=0.13u W=1u AS=0.265p AD=0.265p PS=2.56u
+ PD=2.56u rfmode=0
M$16825 \$3932 \$3761 OUTP|analog_io_padres[16]|core|padres
+ VSS|anode|cathode|vss sg13_lv_nmos L=0.13u W=2u AS=0.38p AD=0.38p PS=3.52u
+ PD=3.52u rfmode=0
M$16827 \$3932 \$3813 OUTN|analog_io_padres[15]|core|padres
+ VSS|anode|cathode|vss sg13_lv_nmos L=0.13u W=2u AS=0.38p AD=0.38p PS=3.52u
+ PD=3.52u rfmode=0
M$16834 VSS|anode|cathode|vss \$3194 \$4053 VSS|anode|cathode|vss sg13_lv_nmos
+ L=0.13u W=0.55u AS=0.187p AD=0.1045p PS=1.78u PD=0.93u rfmode=0
M$16835 \$4053 \$2935 VSS|anode|cathode|vss VSS|anode|cathode|vss sg13_lv_nmos
+ L=0.13u W=0.55u AS=0.1045p AD=0.146425p PS=0.93u PD=1.155u rfmode=0
M$16836 VSS|anode|cathode|vss \$4053 \$4054 VSS|anode|cathode|vss sg13_lv_nmos
+ L=0.13u W=1.48u AS=0.312925p AD=0.4477p PS=2.345u PD=3.43u rfmode=0
M$16838 \$4092 \$4141 \$4178 VSS|anode|cathode|vss sg13_lv_nmos L=0.13u W=0.42u
+ AS=0.1428p AD=0.0609p PS=1.52u PD=0.71u rfmode=0
M$16839 \$4178 VDD VSS|anode|cathode|vss VSS|anode|cathode|vss sg13_lv_nmos
+ L=0.13u W=0.42u AS=0.0609p AD=0.1626p PS=0.71u PD=1.415u rfmode=0
M$16840 VSS|anode|cathode|vss \$4217 \$4055 VSS|anode|cathode|vss sg13_lv_nmos
+ L=0.13u W=0.74u AS=0.1626p AD=0.2516p PS=1.415u PD=2.16u rfmode=0
M$16841 \$3817 \$3766 \$3917 VSS|anode|cathode|vss sg13_lv_nmos L=0.13u W=0.42u
+ AS=0.1296p AD=0.081p PS=1.52u PD=0.81u rfmode=0
M$16842 \$3917 \$3933 \$3818 VSS|anode|cathode|vss sg13_lv_nmos L=0.13u W=0.42u
+ AS=0.081p AD=0.2163p PS=0.81u PD=1.87u rfmode=0
M$16843 \$4094 \$4218 VSS|anode|cathode|vss VSS|anode|cathode|vss sg13_lv_nmos
+ L=0.13u W=0.42u AS=0.1428p AD=0.0798p PS=1.52u PD=0.8u rfmode=0
M$16844 VSS|anode|cathode|vss VDD \$4179 VSS|anode|cathode|vss sg13_lv_nmos
+ L=0.13u W=0.42u AS=0.0798p AD=0.0378p PS=0.8u PD=0.6u rfmode=0
M$16845 \$4179 \$4143 \$4218 VSS|anode|cathode|vss sg13_lv_nmos L=0.13u W=0.42u
+ AS=0.0378p AD=0.1428p PS=0.6u PD=1.52u rfmode=0
M$16846 VSS|anode|cathode|vss \$4143 \$4096 VSS|anode|cathode|vss sg13_lv_nmos
+ L=0.13u W=0.64u AS=0.1331p AD=0.2176p PS=1.12u PD=1.96u rfmode=0
M$16847 VSS|anode|cathode|vss \$4143 \$4095 VSS|anode|cathode|vss sg13_lv_nmos
+ L=0.13u W=1.48u AS=0.3922p AD=0.2737p PS=3.28u PD=2.24u rfmode=0
M$16849 VSS|anode|cathode|vss \$4096 \$4097 VSS|anode|cathode|vss sg13_lv_nmos
+ L=0.13u W=1.48u AS=0.3922p AD=0.3922p PS=3.28u PD=3.28u rfmode=0
M$16851 VSS|anode|cathode|vss VSS|anode|cathode|vss \$3934
+ VSS|anode|cathode|vss sg13_lv_nmos L=0.13u W=1u AS=0.265p AD=0.265p PS=2.56u
+ PD=2.56u rfmode=0
M$16852 \$3934 \$3767 OUTP|analog_io_padres[16]|core|padres
+ VSS|anode|cathode|vss sg13_lv_nmos L=0.13u W=2u AS=0.38p AD=0.38p PS=3.52u
+ PD=3.52u rfmode=0
M$16854 \$3934 \$3820 OUTN|analog_io_padres[15]|core|padres
+ VSS|anode|cathode|vss sg13_lv_nmos L=0.13u W=2u AS=0.38p AD=0.38p PS=3.52u
+ PD=3.52u rfmode=0
M$16861 VSS|anode|cathode|vss \$3195 \$4057 VSS|anode|cathode|vss sg13_lv_nmos
+ L=0.13u W=0.55u AS=0.187p AD=0.1045p PS=1.78u PD=0.93u rfmode=0
M$16862 \$4057 \$2935 VSS|anode|cathode|vss VSS|anode|cathode|vss sg13_lv_nmos
+ L=0.13u W=0.55u AS=0.1045p AD=0.146425p PS=0.93u PD=1.155u rfmode=0
M$16863 VSS|anode|cathode|vss \$4057 \$4058 VSS|anode|cathode|vss sg13_lv_nmos
+ L=0.13u W=1.48u AS=0.312925p AD=0.4477p PS=2.345u PD=3.43u rfmode=0
M$16865 \$4099 \$4145 \$4184 VSS|anode|cathode|vss sg13_lv_nmos L=0.13u W=0.42u
+ AS=0.1428p AD=0.0609p PS=1.52u PD=0.71u rfmode=0
M$16866 \$4184 VDD VSS|anode|cathode|vss VSS|anode|cathode|vss sg13_lv_nmos
+ L=0.13u W=0.42u AS=0.0609p AD=0.1626p PS=0.71u PD=1.415u rfmode=0
M$16867 VSS|anode|cathode|vss \$4219 \$4059 VSS|anode|cathode|vss sg13_lv_nmos
+ L=0.13u W=0.74u AS=0.1626p AD=0.2516p PS=1.415u PD=2.16u rfmode=0
M$16868 \$3824 \$3772 \$3919 VSS|anode|cathode|vss sg13_lv_nmos L=0.13u W=0.42u
+ AS=0.1296p AD=0.081p PS=1.52u PD=0.81u rfmode=0
M$16869 \$3919 \$3935 \$3825 VSS|anode|cathode|vss sg13_lv_nmos L=0.13u W=0.42u
+ AS=0.081p AD=0.2163p PS=0.81u PD=1.87u rfmode=0
M$16870 \$4101 \$4220 VSS|anode|cathode|vss VSS|anode|cathode|vss sg13_lv_nmos
+ L=0.13u W=0.42u AS=0.1428p AD=0.0798p PS=1.52u PD=0.8u rfmode=0
M$16871 VSS|anode|cathode|vss VDD \$4185 VSS|anode|cathode|vss sg13_lv_nmos
+ L=0.13u W=0.42u AS=0.0798p AD=0.0378p PS=0.8u PD=0.6u rfmode=0
M$16872 \$4185 \$4147 \$4220 VSS|anode|cathode|vss sg13_lv_nmos L=0.13u W=0.42u
+ AS=0.0378p AD=0.1428p PS=0.6u PD=1.52u rfmode=0
M$16873 VSS|anode|cathode|vss \$4147 \$4103 VSS|anode|cathode|vss sg13_lv_nmos
+ L=0.13u W=0.64u AS=0.1331p AD=0.2176p PS=1.12u PD=1.96u rfmode=0
M$16874 VSS|anode|cathode|vss \$4147 \$4102 VSS|anode|cathode|vss sg13_lv_nmos
+ L=0.13u W=1.48u AS=0.3922p AD=0.2737p PS=3.28u PD=2.24u rfmode=0
M$16876 VSS|anode|cathode|vss \$4103 \$4104 VSS|anode|cathode|vss sg13_lv_nmos
+ L=0.13u W=1.48u AS=0.3922p AD=0.3922p PS=3.28u PD=3.28u rfmode=0
M$16878 VSS|anode|cathode|vss VSS|anode|cathode|vss \$3936
+ VSS|anode|cathode|vss sg13_lv_nmos L=0.13u W=1u AS=0.265p AD=0.265p PS=2.56u
+ PD=2.56u rfmode=0
M$16879 \$3936 \$3773 OUTP|analog_io_padres[16]|core|padres
+ VSS|anode|cathode|vss sg13_lv_nmos L=0.13u W=2u AS=0.38p AD=0.38p PS=3.52u
+ PD=3.52u rfmode=0
M$16881 \$3936 \$3827 OUTN|analog_io_padres[15]|core|padres
+ VSS|anode|cathode|vss sg13_lv_nmos L=0.13u W=2u AS=0.38p AD=0.38p PS=3.52u
+ PD=3.52u rfmode=0
M$16888 VSS|anode|cathode|vss \$3196 \$4061 VSS|anode|cathode|vss sg13_lv_nmos
+ L=0.13u W=0.55u AS=0.187p AD=0.1045p PS=1.78u PD=0.93u rfmode=0
M$16889 \$4061 \$2935 VSS|anode|cathode|vss VSS|anode|cathode|vss sg13_lv_nmos
+ L=0.13u W=0.55u AS=0.1045p AD=0.146425p PS=0.93u PD=1.155u rfmode=0
M$16890 VSS|anode|cathode|vss \$4061 \$4062 VSS|anode|cathode|vss sg13_lv_nmos
+ L=0.13u W=1.48u AS=0.312925p AD=0.4477p PS=2.345u PD=3.43u rfmode=0
M$16892 \$4106 \$4149 \$4190 VSS|anode|cathode|vss sg13_lv_nmos L=0.13u W=0.42u
+ AS=0.1428p AD=0.0609p PS=1.52u PD=0.71u rfmode=0
M$16893 \$4190 VDD VSS|anode|cathode|vss VSS|anode|cathode|vss sg13_lv_nmos
+ L=0.13u W=0.42u AS=0.0609p AD=0.1626p PS=0.71u PD=1.415u rfmode=0
M$16894 VSS|anode|cathode|vss \$4221 \$4063 VSS|anode|cathode|vss sg13_lv_nmos
+ L=0.13u W=0.74u AS=0.1626p AD=0.2516p PS=1.415u PD=2.16u rfmode=0
M$16895 \$3831 \$3778 \$3921 VSS|anode|cathode|vss sg13_lv_nmos L=0.13u W=0.42u
+ AS=0.1296p AD=0.081p PS=1.52u PD=0.81u rfmode=0
M$16896 \$3921 \$3937 \$3832 VSS|anode|cathode|vss sg13_lv_nmos L=0.13u W=0.42u
+ AS=0.081p AD=0.2163p PS=0.81u PD=1.87u rfmode=0
M$16897 \$4108 \$4222 VSS|anode|cathode|vss VSS|anode|cathode|vss sg13_lv_nmos
+ L=0.13u W=0.42u AS=0.1428p AD=0.0798p PS=1.52u PD=0.8u rfmode=0
M$16898 VSS|anode|cathode|vss VDD \$4191 VSS|anode|cathode|vss sg13_lv_nmos
+ L=0.13u W=0.42u AS=0.0798p AD=0.0378p PS=0.8u PD=0.6u rfmode=0
M$16899 \$4191 \$4151 \$4222 VSS|anode|cathode|vss sg13_lv_nmos L=0.13u W=0.42u
+ AS=0.0378p AD=0.1428p PS=0.6u PD=1.52u rfmode=0
M$16900 VSS|anode|cathode|vss \$4151 \$4110 VSS|anode|cathode|vss sg13_lv_nmos
+ L=0.13u W=0.64u AS=0.1331p AD=0.2176p PS=1.12u PD=1.96u rfmode=0
M$16901 VSS|anode|cathode|vss \$4151 \$4109 VSS|anode|cathode|vss sg13_lv_nmos
+ L=0.13u W=1.48u AS=0.3922p AD=0.2737p PS=3.28u PD=2.24u rfmode=0
M$16903 VSS|anode|cathode|vss \$4110 \$4111 VSS|anode|cathode|vss sg13_lv_nmos
+ L=0.13u W=1.48u AS=0.3922p AD=0.3922p PS=3.28u PD=3.28u rfmode=0
M$16905 VSS|anode|cathode|vss VSS|anode|cathode|vss \$3938
+ VSS|anode|cathode|vss sg13_lv_nmos L=0.13u W=1u AS=0.265p AD=0.265p PS=2.56u
+ PD=2.56u rfmode=0
M$16906 \$3938 \$3779 OUTP|analog_io_padres[16]|core|padres
+ VSS|anode|cathode|vss sg13_lv_nmos L=0.13u W=2u AS=0.38p AD=0.38p PS=3.52u
+ PD=3.52u rfmode=0
M$16908 \$3938 \$3834 OUTN|analog_io_padres[15]|core|padres
+ VSS|anode|cathode|vss sg13_lv_nmos L=0.13u W=2u AS=0.38p AD=0.38p PS=3.52u
+ PD=3.52u rfmode=0
M$16915 VSS|anode|cathode|vss \$3197 \$4065 VSS|anode|cathode|vss sg13_lv_nmos
+ L=0.13u W=0.55u AS=0.187p AD=0.1045p PS=1.78u PD=0.93u rfmode=0
M$16916 \$4065 \$2935 VSS|anode|cathode|vss VSS|anode|cathode|vss sg13_lv_nmos
+ L=0.13u W=0.55u AS=0.1045p AD=0.146425p PS=0.93u PD=1.155u rfmode=0
M$16917 VSS|anode|cathode|vss \$4065 \$4066 VSS|anode|cathode|vss sg13_lv_nmos
+ L=0.13u W=1.48u AS=0.312925p AD=0.4477p PS=2.345u PD=3.43u rfmode=0
M$16919 \$4113 \$4153 \$4205 VSS|anode|cathode|vss sg13_lv_nmos L=0.13u W=0.42u
+ AS=0.1428p AD=0.0609p PS=1.52u PD=0.71u rfmode=0
M$16920 \$4205 VDD VSS|anode|cathode|vss VSS|anode|cathode|vss sg13_lv_nmos
+ L=0.13u W=0.42u AS=0.0609p AD=0.1626p PS=0.71u PD=1.415u rfmode=0
M$16921 VSS|anode|cathode|vss \$4223 \$4067 VSS|anode|cathode|vss sg13_lv_nmos
+ L=0.13u W=0.74u AS=0.1626p AD=0.2516p PS=1.415u PD=2.16u rfmode=0
M$16922 \$3838 \$3784 \$3923 VSS|anode|cathode|vss sg13_lv_nmos L=0.13u W=0.42u
+ AS=0.1296p AD=0.081p PS=1.52u PD=0.81u rfmode=0
M$16923 \$3923 \$3939 \$3839 VSS|anode|cathode|vss sg13_lv_nmos L=0.13u W=0.42u
+ AS=0.081p AD=0.2163p PS=0.81u PD=1.87u rfmode=0
M$16924 \$4115 \$4224 VSS|anode|cathode|vss VSS|anode|cathode|vss sg13_lv_nmos
+ L=0.13u W=0.42u AS=0.1428p AD=0.0798p PS=1.52u PD=0.8u rfmode=0
M$16925 VSS|anode|cathode|vss VDD \$4207 VSS|anode|cathode|vss sg13_lv_nmos
+ L=0.13u W=0.42u AS=0.0798p AD=0.0378p PS=0.8u PD=0.6u rfmode=0
M$16926 \$4207 \$4155 \$4224 VSS|anode|cathode|vss sg13_lv_nmos L=0.13u W=0.42u
+ AS=0.0378p AD=0.1428p PS=0.6u PD=1.52u rfmode=0
M$16927 VSS|anode|cathode|vss \$4155 \$4117 VSS|anode|cathode|vss sg13_lv_nmos
+ L=0.13u W=0.64u AS=0.1331p AD=0.2176p PS=1.12u PD=1.96u rfmode=0
M$16928 VSS|anode|cathode|vss \$4155 \$4116 VSS|anode|cathode|vss sg13_lv_nmos
+ L=0.13u W=1.48u AS=0.3922p AD=0.2737p PS=3.28u PD=2.24u rfmode=0
M$16930 VSS|anode|cathode|vss \$4117 \$4118 VSS|anode|cathode|vss sg13_lv_nmos
+ L=0.13u W=1.48u AS=0.3922p AD=0.3922p PS=3.28u PD=3.28u rfmode=0
M$16932 VSS|anode|cathode|vss VSS|anode|cathode|vss \$3940
+ VSS|anode|cathode|vss sg13_lv_nmos L=0.13u W=1u AS=0.265p AD=0.265p PS=2.56u
+ PD=2.56u rfmode=0
M$16933 \$3940 \$3785 OUTP|analog_io_padres[16]|core|padres
+ VSS|anode|cathode|vss sg13_lv_nmos L=0.13u W=2u AS=0.38p AD=0.38p PS=3.52u
+ PD=3.52u rfmode=0
M$16935 \$3940 \$3841 OUTN|analog_io_padres[15]|core|padres
+ VSS|anode|cathode|vss sg13_lv_nmos L=0.13u W=2u AS=0.38p AD=0.38p PS=3.52u
+ PD=3.52u rfmode=0
M$16942 VSS|anode|cathode|vss \$3198 \$4069 VSS|anode|cathode|vss sg13_lv_nmos
+ L=0.13u W=0.55u AS=0.187p AD=0.1045p PS=1.78u PD=0.93u rfmode=0
M$16943 \$4069 \$2935 VSS|anode|cathode|vss VSS|anode|cathode|vss sg13_lv_nmos
+ L=0.13u W=0.55u AS=0.1045p AD=0.146425p PS=0.93u PD=1.155u rfmode=0
M$16944 VSS|anode|cathode|vss \$4069 \$4070 VSS|anode|cathode|vss sg13_lv_nmos
+ L=0.13u W=1.48u AS=0.312925p AD=0.4477p PS=2.345u PD=3.43u rfmode=0
M$16946 \$4120 \$4157 \$4208 VSS|anode|cathode|vss sg13_lv_nmos L=0.13u W=0.42u
+ AS=0.1428p AD=0.0609p PS=1.52u PD=0.71u rfmode=0
M$16947 \$4208 VDD VSS|anode|cathode|vss VSS|anode|cathode|vss sg13_lv_nmos
+ L=0.13u W=0.42u AS=0.0609p AD=0.1626p PS=0.71u PD=1.415u rfmode=0
M$16948 VSS|anode|cathode|vss \$4225 \$4071 VSS|anode|cathode|vss sg13_lv_nmos
+ L=0.13u W=0.74u AS=0.1626p AD=0.2516p PS=1.415u PD=2.16u rfmode=0
M$16949 \$3845 \$3790 \$3925 VSS|anode|cathode|vss sg13_lv_nmos L=0.13u W=0.42u
+ AS=0.1296p AD=0.081p PS=1.52u PD=0.81u rfmode=0
M$16950 \$3925 \$3941 \$3846 VSS|anode|cathode|vss sg13_lv_nmos L=0.13u W=0.42u
+ AS=0.081p AD=0.2163p PS=0.81u PD=1.87u rfmode=0
M$16951 \$4122 \$4226 VSS|anode|cathode|vss VSS|anode|cathode|vss sg13_lv_nmos
+ L=0.13u W=0.42u AS=0.1428p AD=0.0798p PS=1.52u PD=0.8u rfmode=0
M$16952 VSS|anode|cathode|vss VDD \$4206 VSS|anode|cathode|vss sg13_lv_nmos
+ L=0.13u W=0.42u AS=0.0798p AD=0.0378p PS=0.8u PD=0.6u rfmode=0
M$16953 \$4206 \$4159 \$4226 VSS|anode|cathode|vss sg13_lv_nmos L=0.13u W=0.42u
+ AS=0.0378p AD=0.1428p PS=0.6u PD=1.52u rfmode=0
M$16954 VSS|anode|cathode|vss \$4159 \$4124 VSS|anode|cathode|vss sg13_lv_nmos
+ L=0.13u W=0.64u AS=0.1331p AD=0.2176p PS=1.12u PD=1.96u rfmode=0
M$16955 VSS|anode|cathode|vss \$4159 \$4123 VSS|anode|cathode|vss sg13_lv_nmos
+ L=0.13u W=1.48u AS=0.3922p AD=0.2737p PS=3.28u PD=2.24u rfmode=0
M$16957 VSS|anode|cathode|vss \$4124 \$4125 VSS|anode|cathode|vss sg13_lv_nmos
+ L=0.13u W=1.48u AS=0.3922p AD=0.3922p PS=3.28u PD=3.28u rfmode=0
M$16959 VSS|anode|cathode|vss VSS|anode|cathode|vss \$3942
+ VSS|anode|cathode|vss sg13_lv_nmos L=0.13u W=1u AS=0.265p AD=0.265p PS=2.56u
+ PD=2.56u rfmode=0
M$16960 \$3942 \$3791 OUTP|analog_io_padres[16]|core|padres
+ VSS|anode|cathode|vss sg13_lv_nmos L=0.13u W=2u AS=0.38p AD=0.38p PS=3.52u
+ PD=3.52u rfmode=0
M$16962 \$3942 \$3848 OUTN|analog_io_padres[15]|core|padres
+ VSS|anode|cathode|vss sg13_lv_nmos L=0.13u W=2u AS=0.38p AD=0.38p PS=3.52u
+ PD=3.52u rfmode=0
M$16969 VSS|anode|cathode|vss VSS|anode|cathode|vss \$4073
+ VSS|anode|cathode|vss sg13_lv_nmos L=0.13u W=0.55u AS=0.187p AD=0.1045p
+ PS=1.78u PD=0.93u rfmode=0
M$16970 \$4073 \$2935 VSS|anode|cathode|vss VSS|anode|cathode|vss sg13_lv_nmos
+ L=0.13u W=0.55u AS=0.1045p AD=0.146425p PS=0.93u PD=1.155u rfmode=0
M$16971 VSS|anode|cathode|vss \$4073 \$4074 VSS|anode|cathode|vss sg13_lv_nmos
+ L=0.13u W=1.48u AS=0.312925p AD=0.4477p PS=2.345u PD=3.43u rfmode=0
M$16973 \$4127 \$4161 \$4198 VSS|anode|cathode|vss sg13_lv_nmos L=0.13u W=0.42u
+ AS=0.1428p AD=0.0609p PS=1.52u PD=0.71u rfmode=0
M$16974 \$4198 VDD VSS|anode|cathode|vss VSS|anode|cathode|vss sg13_lv_nmos
+ L=0.13u W=0.42u AS=0.0609p AD=0.1626p PS=0.71u PD=1.415u rfmode=0
M$16975 VSS|anode|cathode|vss \$4227 \$4075 VSS|anode|cathode|vss sg13_lv_nmos
+ L=0.13u W=0.74u AS=0.1626p AD=0.2516p PS=1.415u PD=2.16u rfmode=0
M$16976 \$3852 \$3796 \$3927 VSS|anode|cathode|vss sg13_lv_nmos L=0.13u W=0.42u
+ AS=0.1296p AD=0.081p PS=1.52u PD=0.81u rfmode=0
M$16977 \$3927 \$3943 \$3853 VSS|anode|cathode|vss sg13_lv_nmos L=0.13u W=0.42u
+ AS=0.081p AD=0.2163p PS=0.81u PD=1.87u rfmode=0
M$16978 \$4129 \$4228 VSS|anode|cathode|vss VSS|anode|cathode|vss sg13_lv_nmos
+ L=0.13u W=0.42u AS=0.1428p AD=0.0798p PS=1.52u PD=0.8u rfmode=0
M$16979 VSS|anode|cathode|vss VDD \$4195 VSS|anode|cathode|vss sg13_lv_nmos
+ L=0.13u W=0.42u AS=0.0798p AD=0.0378p PS=0.8u PD=0.6u rfmode=0
M$16980 \$4195 \$4163 \$4228 VSS|anode|cathode|vss sg13_lv_nmos L=0.13u W=0.42u
+ AS=0.0378p AD=0.1428p PS=0.6u PD=1.52u rfmode=0
M$16981 VSS|anode|cathode|vss \$4163 \$4131 VSS|anode|cathode|vss sg13_lv_nmos
+ L=0.13u W=0.64u AS=0.1331p AD=0.2176p PS=1.12u PD=1.96u rfmode=0
M$16982 VSS|anode|cathode|vss \$4163 \$4130 VSS|anode|cathode|vss sg13_lv_nmos
+ L=0.13u W=1.48u AS=0.3922p AD=0.2737p PS=3.28u PD=2.24u rfmode=0
M$16984 VSS|anode|cathode|vss \$4131 \$4132 VSS|anode|cathode|vss sg13_lv_nmos
+ L=0.13u W=1.48u AS=0.3922p AD=0.3922p PS=3.28u PD=3.28u rfmode=0
M$16986 VSS|anode|cathode|vss VSS|anode|cathode|vss \$3944
+ VSS|anode|cathode|vss sg13_lv_nmos L=0.13u W=1u AS=0.265p AD=0.265p PS=2.56u
+ PD=2.56u rfmode=0
M$16987 \$3944 \$3797 OUTP|analog_io_padres[16]|core|padres
+ VSS|anode|cathode|vss sg13_lv_nmos L=0.13u W=2u AS=0.38p AD=0.38p PS=3.52u
+ PD=3.52u rfmode=0
M$16989 \$3944 \$3855 OUTN|analog_io_padres[15]|core|padres
+ VSS|anode|cathode|vss sg13_lv_nmos L=0.13u W=2u AS=0.38p AD=0.38p PS=3.52u
+ PD=3.52u rfmode=0
M$16996 \$4077 \$4046 VSS|anode|cathode|vss VSS|anode|cathode|vss sg13_lv_nmos
+ L=0.13u W=1.44u AS=0.4068p AD=0.2772p PS=3.29u PD=2.21u rfmode=0
M$16998 \$4077 \$3221 \$4133 VSS|anode|cathode|vss sg13_lv_nmos L=0.13u W=1.44u
+ AS=0.2772p AD=0.3816p PS=2.21u PD=3.22u rfmode=0
M$17000 VSS|anode|cathode|vss VDD \$4165 VSS|anode|cathode|vss sg13_lv_nmos
+ L=0.13u W=0.42u AS=0.1701p AD=0.03885p PS=1.65u PD=0.605u rfmode=0
M$17001 \$4165 \$4047 \$4079 VSS|anode|cathode|vss sg13_lv_nmos L=0.13u W=0.42u
+ AS=0.03885p AD=0.1596p PS=0.605u PD=1.6u rfmode=0
M$17002 VSS|anode|cathode|vss \$4048 \$4134 VSS|anode|cathode|vss sg13_lv_nmos
+ L=0.13u W=0.74u AS=0.43315p AD=0.2516p PS=2.205u PD=2.16u rfmode=0
M$17003 VSS|anode|cathode|vss CLK|clk|core|fclk_in|p2c|ui_p2c[6] \$4048
+ VSS|anode|cathode|vss sg13_lv_nmos L=0.13u W=0.74u AS=0.43315p AD=0.2516p
+ PS=2.205u PD=2.16u rfmode=0
M$17004 \$4135 \$4048 \$4080 VSS|anode|cathode|vss sg13_lv_nmos L=0.13u W=0.42u
+ AS=0.12665p AD=0.1428p PS=1.145u PD=1.52u rfmode=0
M$17005 \$4047 \$4134 \$4135 VSS|anode|cathode|vss sg13_lv_nmos L=0.13u W=0.74u
+ AS=0.3473p AD=0.12665p PS=2.71u PD=1.145u rfmode=0
M$17006 \$4084 \$4050 VSS|anode|cathode|vss VSS|anode|cathode|vss sg13_lv_nmos
+ L=0.13u W=1.44u AS=0.4068p AD=0.2772p PS=3.29u PD=2.21u rfmode=0
M$17008 \$4084 \$3221 \$4137 VSS|anode|cathode|vss sg13_lv_nmos L=0.13u W=1.44u
+ AS=0.2772p AD=0.3816p PS=2.21u PD=3.22u rfmode=0
M$17010 VSS|anode|cathode|vss VDD \$4171 VSS|anode|cathode|vss sg13_lv_nmos
+ L=0.13u W=0.42u AS=0.1701p AD=0.03885p PS=1.65u PD=0.605u rfmode=0
M$17011 \$4171 \$4051 \$4086 VSS|anode|cathode|vss sg13_lv_nmos L=0.13u W=0.42u
+ AS=0.03885p AD=0.1596p PS=0.605u PD=1.6u rfmode=0
M$17012 VSS|anode|cathode|vss \$4052 \$4138 VSS|anode|cathode|vss sg13_lv_nmos
+ L=0.13u W=0.74u AS=0.43315p AD=0.2516p PS=2.205u PD=2.16u rfmode=0
M$17013 VSS|anode|cathode|vss CLK|clk|core|fclk_in|p2c|ui_p2c[6] \$4052
+ VSS|anode|cathode|vss sg13_lv_nmos L=0.13u W=0.74u AS=0.43315p AD=0.2516p
+ PS=2.205u PD=2.16u rfmode=0
M$17014 \$4139 \$4052 \$4087 VSS|anode|cathode|vss sg13_lv_nmos L=0.13u W=0.42u
+ AS=0.12665p AD=0.1428p PS=1.145u PD=1.52u rfmode=0
M$17015 \$4051 \$4138 \$4139 VSS|anode|cathode|vss sg13_lv_nmos L=0.13u W=0.74u
+ AS=0.3473p AD=0.12665p PS=2.71u PD=1.145u rfmode=0
M$17016 \$4091 \$4054 VSS|anode|cathode|vss VSS|anode|cathode|vss sg13_lv_nmos
+ L=0.13u W=1.44u AS=0.4068p AD=0.2772p PS=3.29u PD=2.21u rfmode=0
M$17018 \$4091 \$3221 \$4141 VSS|anode|cathode|vss sg13_lv_nmos L=0.13u W=1.44u
+ AS=0.2772p AD=0.3816p PS=2.21u PD=3.22u rfmode=0
M$17020 VSS|anode|cathode|vss VDD \$4177 VSS|anode|cathode|vss sg13_lv_nmos
+ L=0.13u W=0.42u AS=0.1701p AD=0.03885p PS=1.65u PD=0.605u rfmode=0
M$17021 \$4177 \$4055 \$4093 VSS|anode|cathode|vss sg13_lv_nmos L=0.13u W=0.42u
+ AS=0.03885p AD=0.1596p PS=0.605u PD=1.6u rfmode=0
M$17022 VSS|anode|cathode|vss \$4056 \$4142 VSS|anode|cathode|vss sg13_lv_nmos
+ L=0.13u W=0.74u AS=0.43315p AD=0.2516p PS=2.205u PD=2.16u rfmode=0
M$17023 VSS|anode|cathode|vss CLK|clk|core|fclk_in|p2c|ui_p2c[6] \$4056
+ VSS|anode|cathode|vss sg13_lv_nmos L=0.13u W=0.74u AS=0.43315p AD=0.2516p
+ PS=2.205u PD=2.16u rfmode=0
M$17024 \$4143 \$4056 \$4094 VSS|anode|cathode|vss sg13_lv_nmos L=0.13u W=0.42u
+ AS=0.12665p AD=0.1428p PS=1.145u PD=1.52u rfmode=0
M$17025 \$4055 \$4142 \$4143 VSS|anode|cathode|vss sg13_lv_nmos L=0.13u W=0.74u
+ AS=0.3473p AD=0.12665p PS=2.71u PD=1.145u rfmode=0
M$17026 \$4098 \$4058 VSS|anode|cathode|vss VSS|anode|cathode|vss sg13_lv_nmos
+ L=0.13u W=1.44u AS=0.4068p AD=0.2772p PS=3.29u PD=2.21u rfmode=0
M$17028 \$4098 \$3221 \$4145 VSS|anode|cathode|vss sg13_lv_nmos L=0.13u W=1.44u
+ AS=0.2772p AD=0.3816p PS=2.21u PD=3.22u rfmode=0
M$17030 VSS|anode|cathode|vss VDD \$4183 VSS|anode|cathode|vss sg13_lv_nmos
+ L=0.13u W=0.42u AS=0.1701p AD=0.03885p PS=1.65u PD=0.605u rfmode=0
M$17031 \$4183 \$4059 \$4100 VSS|anode|cathode|vss sg13_lv_nmos L=0.13u W=0.42u
+ AS=0.03885p AD=0.1596p PS=0.605u PD=1.6u rfmode=0
M$17032 VSS|anode|cathode|vss \$4060 \$4146 VSS|anode|cathode|vss sg13_lv_nmos
+ L=0.13u W=0.74u AS=0.43315p AD=0.2516p PS=2.205u PD=2.16u rfmode=0
M$17033 VSS|anode|cathode|vss CLK|clk|core|fclk_in|p2c|ui_p2c[6] \$4060
+ VSS|anode|cathode|vss sg13_lv_nmos L=0.13u W=0.74u AS=0.43315p AD=0.2516p
+ PS=2.205u PD=2.16u rfmode=0
M$17034 \$4147 \$4060 \$4101 VSS|anode|cathode|vss sg13_lv_nmos L=0.13u W=0.42u
+ AS=0.12665p AD=0.1428p PS=1.145u PD=1.52u rfmode=0
M$17035 \$4059 \$4146 \$4147 VSS|anode|cathode|vss sg13_lv_nmos L=0.13u W=0.74u
+ AS=0.3473p AD=0.12665p PS=2.71u PD=1.145u rfmode=0
M$17036 \$4105 \$4062 VSS|anode|cathode|vss VSS|anode|cathode|vss sg13_lv_nmos
+ L=0.13u W=1.44u AS=0.4068p AD=0.2772p PS=3.29u PD=2.21u rfmode=0
M$17038 \$4105 \$3221 \$4149 VSS|anode|cathode|vss sg13_lv_nmos L=0.13u W=1.44u
+ AS=0.2772p AD=0.3816p PS=2.21u PD=3.22u rfmode=0
M$17040 VSS|anode|cathode|vss VDD \$4189 VSS|anode|cathode|vss sg13_lv_nmos
+ L=0.13u W=0.42u AS=0.1701p AD=0.03885p PS=1.65u PD=0.605u rfmode=0
M$17041 \$4189 \$4063 \$4107 VSS|anode|cathode|vss sg13_lv_nmos L=0.13u W=0.42u
+ AS=0.03885p AD=0.1596p PS=0.605u PD=1.6u rfmode=0
M$17042 VSS|anode|cathode|vss \$4064 \$4150 VSS|anode|cathode|vss sg13_lv_nmos
+ L=0.13u W=0.74u AS=0.43315p AD=0.2516p PS=2.205u PD=2.16u rfmode=0
M$17043 VSS|anode|cathode|vss CLK|clk|core|fclk_in|p2c|ui_p2c[6] \$4064
+ VSS|anode|cathode|vss sg13_lv_nmos L=0.13u W=0.74u AS=0.43315p AD=0.2516p
+ PS=2.205u PD=2.16u rfmode=0
M$17044 \$4151 \$4064 \$4108 VSS|anode|cathode|vss sg13_lv_nmos L=0.13u W=0.42u
+ AS=0.12665p AD=0.1428p PS=1.145u PD=1.52u rfmode=0
M$17045 \$4063 \$4150 \$4151 VSS|anode|cathode|vss sg13_lv_nmos L=0.13u W=0.74u
+ AS=0.3473p AD=0.12665p PS=2.71u PD=1.145u rfmode=0
M$17046 \$4112 \$4066 VSS|anode|cathode|vss VSS|anode|cathode|vss sg13_lv_nmos
+ L=0.13u W=1.44u AS=0.4068p AD=0.2772p PS=3.29u PD=2.21u rfmode=0
M$17048 \$4112 \$3221 \$4153 VSS|anode|cathode|vss sg13_lv_nmos L=0.13u W=1.44u
+ AS=0.2772p AD=0.3816p PS=2.21u PD=3.22u rfmode=0
M$17050 VSS|anode|cathode|vss VDD \$4203 VSS|anode|cathode|vss sg13_lv_nmos
+ L=0.13u W=0.42u AS=0.1701p AD=0.03885p PS=1.65u PD=0.605u rfmode=0
M$17051 \$4203 \$4067 \$4114 VSS|anode|cathode|vss sg13_lv_nmos L=0.13u W=0.42u
+ AS=0.03885p AD=0.1596p PS=0.605u PD=1.6u rfmode=0
M$17052 VSS|anode|cathode|vss \$4068 \$4154 VSS|anode|cathode|vss sg13_lv_nmos
+ L=0.13u W=0.74u AS=0.43315p AD=0.2516p PS=2.205u PD=2.16u rfmode=0
M$17053 VSS|anode|cathode|vss CLK|clk|core|fclk_in|p2c|ui_p2c[6] \$4068
+ VSS|anode|cathode|vss sg13_lv_nmos L=0.13u W=0.74u AS=0.43315p AD=0.2516p
+ PS=2.205u PD=2.16u rfmode=0
M$17054 \$4155 \$4068 \$4115 VSS|anode|cathode|vss sg13_lv_nmos L=0.13u W=0.42u
+ AS=0.12665p AD=0.1428p PS=1.145u PD=1.52u rfmode=0
M$17055 \$4067 \$4154 \$4155 VSS|anode|cathode|vss sg13_lv_nmos L=0.13u W=0.74u
+ AS=0.3473p AD=0.12665p PS=2.71u PD=1.145u rfmode=0
M$17056 \$4119 \$4070 VSS|anode|cathode|vss VSS|anode|cathode|vss sg13_lv_nmos
+ L=0.13u W=1.44u AS=0.4068p AD=0.2772p PS=3.29u PD=2.21u rfmode=0
M$17058 \$4119 \$3221 \$4157 VSS|anode|cathode|vss sg13_lv_nmos L=0.13u W=1.44u
+ AS=0.2772p AD=0.3816p PS=2.21u PD=3.22u rfmode=0
M$17060 VSS|anode|cathode|vss VDD \$4209 VSS|anode|cathode|vss sg13_lv_nmos
+ L=0.13u W=0.42u AS=0.1701p AD=0.03885p PS=1.65u PD=0.605u rfmode=0
M$17061 \$4209 \$4071 \$4121 VSS|anode|cathode|vss sg13_lv_nmos L=0.13u W=0.42u
+ AS=0.03885p AD=0.1596p PS=0.605u PD=1.6u rfmode=0
M$17062 VSS|anode|cathode|vss \$4072 \$4158 VSS|anode|cathode|vss sg13_lv_nmos
+ L=0.13u W=0.74u AS=0.43315p AD=0.2516p PS=2.205u PD=2.16u rfmode=0
M$17063 VSS|anode|cathode|vss CLK|clk|core|fclk_in|p2c|ui_p2c[6] \$4072
+ VSS|anode|cathode|vss sg13_lv_nmos L=0.13u W=0.74u AS=0.43315p AD=0.2516p
+ PS=2.205u PD=2.16u rfmode=0
M$17064 \$4159 \$4072 \$4122 VSS|anode|cathode|vss sg13_lv_nmos L=0.13u W=0.42u
+ AS=0.12665p AD=0.1428p PS=1.145u PD=1.52u rfmode=0
M$17065 \$4071 \$4158 \$4159 VSS|anode|cathode|vss sg13_lv_nmos L=0.13u W=0.74u
+ AS=0.3473p AD=0.12665p PS=2.71u PD=1.145u rfmode=0
M$17066 \$4126 \$4074 VSS|anode|cathode|vss VSS|anode|cathode|vss sg13_lv_nmos
+ L=0.13u W=1.44u AS=0.4068p AD=0.2772p PS=3.29u PD=2.21u rfmode=0
M$17068 \$4126 \$3221 \$4161 VSS|anode|cathode|vss sg13_lv_nmos L=0.13u W=1.44u
+ AS=0.2772p AD=0.3816p PS=2.21u PD=3.22u rfmode=0
M$17070 VSS|anode|cathode|vss VDD \$4199 VSS|anode|cathode|vss sg13_lv_nmos
+ L=0.13u W=0.42u AS=0.1701p AD=0.03885p PS=1.65u PD=0.605u rfmode=0
M$17071 \$4199 \$4075 \$4128 VSS|anode|cathode|vss sg13_lv_nmos L=0.13u W=0.42u
+ AS=0.03885p AD=0.1596p PS=0.605u PD=1.6u rfmode=0
M$17072 VSS|anode|cathode|vss \$4076 \$4162 VSS|anode|cathode|vss sg13_lv_nmos
+ L=0.13u W=0.74u AS=0.43315p AD=0.2516p PS=2.205u PD=2.16u rfmode=0
M$17073 VSS|anode|cathode|vss CLK|clk|core|fclk_in|p2c|ui_p2c[6] \$4076
+ VSS|anode|cathode|vss sg13_lv_nmos L=0.13u W=0.74u AS=0.43315p AD=0.2516p
+ PS=2.205u PD=2.16u rfmode=0
M$17074 \$4163 \$4076 \$4129 VSS|anode|cathode|vss sg13_lv_nmos L=0.13u W=0.42u
+ AS=0.12665p AD=0.1428p PS=1.145u PD=1.52u rfmode=0
M$17075 \$4075 \$4162 \$4163 VSS|anode|cathode|vss sg13_lv_nmos L=0.13u W=0.74u
+ AS=0.3473p AD=0.12665p PS=2.71u PD=1.145u rfmode=0
M$17076 \$4347 D3|c2p|core|i|uo_c2p[5] VSS|anode|cathode|vss
+ VSS|anode|cathode|vss sg13_lv_nmos L=0.13u W=2.75u AS=0.935p AD=0.935p
+ PS=6.18u PD=6.18u rfmode=0
M$17077 \$4336 D3|c2p|core|i|uo_c2p[5] VSS|anode|cathode|vss
+ VSS|anode|cathode|vss sg13_lv_nmos L=0.13u W=2.75u AS=0.935p AD=0.935p
+ PS=6.18u PD=6.18u rfmode=0
M$17078 VSS|anode|cathode|vss \$3192 \$4362 VSS|anode|cathode|vss sg13_lv_nmos
+ L=0.13u W=0.55u AS=0.187p AD=0.1045p PS=1.78u PD=0.93u rfmode=0
M$17079 \$4362 \$3396 VSS|anode|cathode|vss VSS|anode|cathode|vss sg13_lv_nmos
+ L=0.13u W=0.55u AS=0.1045p AD=0.146425p PS=0.93u PD=1.155u rfmode=0
M$17080 VSS|anode|cathode|vss \$4362 \$4363 VSS|anode|cathode|vss sg13_lv_nmos
+ L=0.13u W=1.48u AS=0.312925p AD=0.4477p PS=2.345u PD=3.43u rfmode=0
M$17082 \$4365 \$4434 \$4473 VSS|anode|cathode|vss sg13_lv_nmos L=0.13u W=0.42u
+ AS=0.1428p AD=0.0609p PS=1.52u PD=0.71u rfmode=0
M$17083 \$4473 VDD VSS|anode|cathode|vss VSS|anode|cathode|vss sg13_lv_nmos
+ L=0.13u W=0.42u AS=0.0609p AD=0.1626p PS=0.71u PD=1.415u rfmode=0
M$17084 VSS|anode|cathode|vss \$4492 \$4353 VSS|anode|cathode|vss sg13_lv_nmos
+ L=0.13u W=0.74u AS=0.1626p AD=0.2516p PS=1.415u PD=2.16u rfmode=0
M$17085 \$4078 \$4048 \$4213 VSS|anode|cathode|vss sg13_lv_nmos L=0.13u W=0.42u
+ AS=0.1296p AD=0.081p PS=1.52u PD=0.81u rfmode=0
M$17086 \$4213 \$4134 \$4079 VSS|anode|cathode|vss sg13_lv_nmos L=0.13u W=0.42u
+ AS=0.081p AD=0.2163p PS=0.81u PD=1.87u rfmode=0
M$17087 \$4367 \$4494 VSS|anode|cathode|vss VSS|anode|cathode|vss sg13_lv_nmos
+ L=0.13u W=0.42u AS=0.1428p AD=0.0798p PS=1.52u PD=0.8u rfmode=0
M$17088 VSS|anode|cathode|vss VDD \$4475 VSS|anode|cathode|vss sg13_lv_nmos
+ L=0.13u W=0.42u AS=0.0798p AD=0.0378p PS=0.8u PD=0.6u rfmode=0
M$17089 \$4475 \$4436 \$4494 VSS|anode|cathode|vss sg13_lv_nmos L=0.13u W=0.42u
+ AS=0.0378p AD=0.1428p PS=0.6u PD=1.52u rfmode=0
M$17090 VSS|anode|cathode|vss \$4436 \$4369 VSS|anode|cathode|vss sg13_lv_nmos
+ L=0.13u W=0.64u AS=0.1331p AD=0.2176p PS=1.12u PD=1.96u rfmode=0
M$17091 VSS|anode|cathode|vss \$4436 \$4368 VSS|anode|cathode|vss sg13_lv_nmos
+ L=0.13u W=1.48u AS=0.3922p AD=0.2737p PS=3.28u PD=2.24u rfmode=0
M$17093 VSS|anode|cathode|vss \$4369 \$4370 VSS|anode|cathode|vss sg13_lv_nmos
+ L=0.13u W=1.48u AS=0.3922p AD=0.3922p PS=3.28u PD=3.28u rfmode=0
M$17095 VSS|anode|cathode|vss VSS|anode|cathode|vss \$4231
+ VSS|anode|cathode|vss sg13_lv_nmos L=0.13u W=1u AS=0.265p AD=0.265p PS=2.56u
+ PD=2.56u rfmode=0
M$17096 \$4231 \$4081 OUTP|analog_io_padres[16]|core|padres
+ VSS|anode|cathode|vss sg13_lv_nmos L=0.13u W=2u AS=0.38p AD=0.38p PS=3.52u
+ PD=3.52u rfmode=0
M$17098 \$4231 \$4083 OUTN|analog_io_padres[15]|core|padres
+ VSS|anode|cathode|vss sg13_lv_nmos L=0.13u W=2u AS=0.38p AD=0.38p PS=3.52u
+ PD=3.52u rfmode=0
M$17105 VSS|anode|cathode|vss \$3193 \$4371 VSS|anode|cathode|vss sg13_lv_nmos
+ L=0.13u W=0.55u AS=0.187p AD=0.1045p PS=1.78u PD=0.93u rfmode=0
M$17106 \$4371 \$3396 VSS|anode|cathode|vss VSS|anode|cathode|vss sg13_lv_nmos
+ L=0.13u W=0.55u AS=0.1045p AD=0.146425p PS=0.93u PD=1.155u rfmode=0
M$17107 VSS|anode|cathode|vss \$4371 \$4372 VSS|anode|cathode|vss sg13_lv_nmos
+ L=0.13u W=1.48u AS=0.312925p AD=0.4477p PS=2.345u PD=3.43u rfmode=0
M$17109 \$4374 \$4438 \$4484 VSS|anode|cathode|vss sg13_lv_nmos L=0.13u W=0.42u
+ AS=0.1428p AD=0.0609p PS=1.52u PD=0.71u rfmode=0
M$17110 \$4484 VDD VSS|anode|cathode|vss VSS|anode|cathode|vss sg13_lv_nmos
+ L=0.13u W=0.42u AS=0.0609p AD=0.1626p PS=0.71u PD=1.415u rfmode=0
M$17111 VSS|anode|cathode|vss \$4495 \$4354 VSS|anode|cathode|vss sg13_lv_nmos
+ L=0.13u W=0.74u AS=0.1626p AD=0.2516p PS=1.415u PD=2.16u rfmode=0
M$17112 \$4085 \$4052 \$4215 VSS|anode|cathode|vss sg13_lv_nmos L=0.13u W=0.42u
+ AS=0.1296p AD=0.081p PS=1.52u PD=0.81u rfmode=0
M$17113 \$4215 \$4138 \$4086 VSS|anode|cathode|vss sg13_lv_nmos L=0.13u W=0.42u
+ AS=0.081p AD=0.2163p PS=0.81u PD=1.87u rfmode=0
M$17114 \$4376 \$4497 VSS|anode|cathode|vss VSS|anode|cathode|vss sg13_lv_nmos
+ L=0.13u W=0.42u AS=0.1428p AD=0.0798p PS=1.52u PD=0.8u rfmode=0
M$17115 VSS|anode|cathode|vss VDD \$4486 VSS|anode|cathode|vss sg13_lv_nmos
+ L=0.13u W=0.42u AS=0.0798p AD=0.0378p PS=0.8u PD=0.6u rfmode=0
M$17116 \$4486 \$4440 \$4497 VSS|anode|cathode|vss sg13_lv_nmos L=0.13u W=0.42u
+ AS=0.0378p AD=0.1428p PS=0.6u PD=1.52u rfmode=0
M$17117 VSS|anode|cathode|vss \$4440 \$4378 VSS|anode|cathode|vss sg13_lv_nmos
+ L=0.13u W=0.64u AS=0.1331p AD=0.2176p PS=1.12u PD=1.96u rfmode=0
M$17118 VSS|anode|cathode|vss \$4440 \$4377 VSS|anode|cathode|vss sg13_lv_nmos
+ L=0.13u W=1.48u AS=0.3922p AD=0.2737p PS=3.28u PD=2.24u rfmode=0
M$17120 VSS|anode|cathode|vss \$4378 \$4379 VSS|anode|cathode|vss sg13_lv_nmos
+ L=0.13u W=1.48u AS=0.3922p AD=0.3922p PS=3.28u PD=3.28u rfmode=0
M$17122 VSS|anode|cathode|vss VSS|anode|cathode|vss \$4232
+ VSS|anode|cathode|vss sg13_lv_nmos L=0.13u W=1u AS=0.265p AD=0.265p PS=2.56u
+ PD=2.56u rfmode=0
M$17123 \$4232 \$4088 OUTP|analog_io_padres[16]|core|padres
+ VSS|anode|cathode|vss sg13_lv_nmos L=0.13u W=2u AS=0.38p AD=0.38p PS=3.52u
+ PD=3.52u rfmode=0
M$17125 \$4232 \$4090 OUTN|analog_io_padres[15]|core|padres
+ VSS|anode|cathode|vss sg13_lv_nmos L=0.13u W=2u AS=0.38p AD=0.38p PS=3.52u
+ PD=3.52u rfmode=0
M$17132 VSS|anode|cathode|vss \$3194 \$4380 VSS|anode|cathode|vss sg13_lv_nmos
+ L=0.13u W=0.55u AS=0.187p AD=0.1045p PS=1.78u PD=0.93u rfmode=0
M$17133 \$4380 \$3396 VSS|anode|cathode|vss VSS|anode|cathode|vss sg13_lv_nmos
+ L=0.13u W=0.55u AS=0.1045p AD=0.146425p PS=0.93u PD=1.155u rfmode=0
M$17134 VSS|anode|cathode|vss \$4380 \$4381 VSS|anode|cathode|vss sg13_lv_nmos
+ L=0.13u W=1.48u AS=0.312925p AD=0.4477p PS=2.345u PD=3.43u rfmode=0
M$17136 \$4383 \$4442 \$4491 VSS|anode|cathode|vss sg13_lv_nmos L=0.13u W=0.42u
+ AS=0.1428p AD=0.0609p PS=1.52u PD=0.71u rfmode=0
M$17137 \$4491 VDD VSS|anode|cathode|vss VSS|anode|cathode|vss sg13_lv_nmos
+ L=0.13u W=0.42u AS=0.0609p AD=0.1626p PS=0.71u PD=1.415u rfmode=0
M$17138 VSS|anode|cathode|vss \$4498 \$4355 VSS|anode|cathode|vss sg13_lv_nmos
+ L=0.13u W=0.74u AS=0.1626p AD=0.2516p PS=1.415u PD=2.16u rfmode=0
M$17139 \$4092 \$4056 \$4217 VSS|anode|cathode|vss sg13_lv_nmos L=0.13u W=0.42u
+ AS=0.1296p AD=0.081p PS=1.52u PD=0.81u rfmode=0
M$17140 \$4217 \$4142 \$4093 VSS|anode|cathode|vss sg13_lv_nmos L=0.13u W=0.42u
+ AS=0.081p AD=0.2163p PS=0.81u PD=1.87u rfmode=0
M$17141 \$4385 \$4500 VSS|anode|cathode|vss VSS|anode|cathode|vss sg13_lv_nmos
+ L=0.13u W=0.42u AS=0.1428p AD=0.0798p PS=1.52u PD=0.8u rfmode=0
M$17142 VSS|anode|cathode|vss VDD \$4490 VSS|anode|cathode|vss sg13_lv_nmos
+ L=0.13u W=0.42u AS=0.0798p AD=0.0378p PS=0.8u PD=0.6u rfmode=0
M$17143 \$4490 \$4444 \$4500 VSS|anode|cathode|vss sg13_lv_nmos L=0.13u W=0.42u
+ AS=0.0378p AD=0.1428p PS=0.6u PD=1.52u rfmode=0
M$17144 VSS|anode|cathode|vss \$4444 \$4387 VSS|anode|cathode|vss sg13_lv_nmos
+ L=0.13u W=0.64u AS=0.1331p AD=0.2176p PS=1.12u PD=1.96u rfmode=0
M$17145 VSS|anode|cathode|vss \$4444 \$4386 VSS|anode|cathode|vss sg13_lv_nmos
+ L=0.13u W=1.48u AS=0.3922p AD=0.2737p PS=3.28u PD=2.24u rfmode=0
M$17147 VSS|anode|cathode|vss \$4387 \$4388 VSS|anode|cathode|vss sg13_lv_nmos
+ L=0.13u W=1.48u AS=0.3922p AD=0.3922p PS=3.28u PD=3.28u rfmode=0
M$17149 VSS|anode|cathode|vss VSS|anode|cathode|vss \$4233
+ VSS|anode|cathode|vss sg13_lv_nmos L=0.13u W=1u AS=0.265p AD=0.265p PS=2.56u
+ PD=2.56u rfmode=0
M$17150 \$4233 \$4095 OUTP|analog_io_padres[16]|core|padres
+ VSS|anode|cathode|vss sg13_lv_nmos L=0.13u W=2u AS=0.38p AD=0.38p PS=3.52u
+ PD=3.52u rfmode=0
M$17152 \$4233 \$4097 OUTN|analog_io_padres[15]|core|padres
+ VSS|anode|cathode|vss sg13_lv_nmos L=0.13u W=2u AS=0.38p AD=0.38p PS=3.52u
+ PD=3.52u rfmode=0
M$17159 VSS|anode|cathode|vss \$3195 \$4389 VSS|anode|cathode|vss sg13_lv_nmos
+ L=0.13u W=0.55u AS=0.187p AD=0.1045p PS=1.78u PD=0.93u rfmode=0
M$17160 \$4389 \$3396 VSS|anode|cathode|vss VSS|anode|cathode|vss sg13_lv_nmos
+ L=0.13u W=0.55u AS=0.1045p AD=0.146425p PS=0.93u PD=1.155u rfmode=0
M$17161 VSS|anode|cathode|vss \$4389 \$4390 VSS|anode|cathode|vss sg13_lv_nmos
+ L=0.13u W=1.48u AS=0.312925p AD=0.4477p PS=2.345u PD=3.43u rfmode=0
M$17163 \$4392 \$4446 \$4487 VSS|anode|cathode|vss sg13_lv_nmos L=0.13u W=0.42u
+ AS=0.1428p AD=0.0609p PS=1.52u PD=0.71u rfmode=0
M$17164 \$4487 VDD VSS|anode|cathode|vss VSS|anode|cathode|vss sg13_lv_nmos
+ L=0.13u W=0.42u AS=0.0609p AD=0.1626p PS=0.71u PD=1.415u rfmode=0
M$17165 VSS|anode|cathode|vss \$4501 \$4356 VSS|anode|cathode|vss sg13_lv_nmos
+ L=0.13u W=0.74u AS=0.1626p AD=0.2516p PS=1.415u PD=2.16u rfmode=0
M$17166 \$4099 \$4060 \$4219 VSS|anode|cathode|vss sg13_lv_nmos L=0.13u W=0.42u
+ AS=0.1296p AD=0.081p PS=1.52u PD=0.81u rfmode=0
M$17167 \$4219 \$4146 \$4100 VSS|anode|cathode|vss sg13_lv_nmos L=0.13u W=0.42u
+ AS=0.081p AD=0.2163p PS=0.81u PD=1.87u rfmode=0
M$17168 \$4394 \$4503 VSS|anode|cathode|vss VSS|anode|cathode|vss sg13_lv_nmos
+ L=0.13u W=0.42u AS=0.1428p AD=0.0798p PS=1.52u PD=0.8u rfmode=0
M$17169 VSS|anode|cathode|vss VDD \$4485 VSS|anode|cathode|vss sg13_lv_nmos
+ L=0.13u W=0.42u AS=0.0798p AD=0.0378p PS=0.8u PD=0.6u rfmode=0
M$17170 \$4485 \$4448 \$4503 VSS|anode|cathode|vss sg13_lv_nmos L=0.13u W=0.42u
+ AS=0.0378p AD=0.1428p PS=0.6u PD=1.52u rfmode=0
M$17171 VSS|anode|cathode|vss \$4448 \$4396 VSS|anode|cathode|vss sg13_lv_nmos
+ L=0.13u W=0.64u AS=0.1331p AD=0.2176p PS=1.12u PD=1.96u rfmode=0
M$17172 VSS|anode|cathode|vss \$4448 \$4395 VSS|anode|cathode|vss sg13_lv_nmos
+ L=0.13u W=1.48u AS=0.3922p AD=0.2737p PS=3.28u PD=2.24u rfmode=0
M$17174 VSS|anode|cathode|vss \$4396 \$4397 VSS|anode|cathode|vss sg13_lv_nmos
+ L=0.13u W=1.48u AS=0.3922p AD=0.3922p PS=3.28u PD=3.28u rfmode=0
M$17176 VSS|anode|cathode|vss VSS|anode|cathode|vss \$4234
+ VSS|anode|cathode|vss sg13_lv_nmos L=0.13u W=1u AS=0.265p AD=0.265p PS=2.56u
+ PD=2.56u rfmode=0
M$17177 \$4234 \$4102 OUTP|analog_io_padres[16]|core|padres
+ VSS|anode|cathode|vss sg13_lv_nmos L=0.13u W=2u AS=0.38p AD=0.38p PS=3.52u
+ PD=3.52u rfmode=0
M$17179 \$4234 \$4104 OUTN|analog_io_padres[15]|core|padres
+ VSS|anode|cathode|vss sg13_lv_nmos L=0.13u W=2u AS=0.38p AD=0.38p PS=3.52u
+ PD=3.52u rfmode=0
M$17186 VSS|anode|cathode|vss \$3196 \$4398 VSS|anode|cathode|vss sg13_lv_nmos
+ L=0.13u W=0.55u AS=0.187p AD=0.1045p PS=1.78u PD=0.93u rfmode=0
M$17187 \$4398 \$3396 VSS|anode|cathode|vss VSS|anode|cathode|vss sg13_lv_nmos
+ L=0.13u W=0.55u AS=0.1045p AD=0.146425p PS=0.93u PD=1.155u rfmode=0
M$17188 VSS|anode|cathode|vss \$4398 \$4399 VSS|anode|cathode|vss sg13_lv_nmos
+ L=0.13u W=1.48u AS=0.312925p AD=0.4477p PS=2.345u PD=3.43u rfmode=0
M$17190 \$4401 \$4450 \$4481 VSS|anode|cathode|vss sg13_lv_nmos L=0.13u W=0.42u
+ AS=0.1428p AD=0.0609p PS=1.52u PD=0.71u rfmode=0
M$17191 \$4481 VDD VSS|anode|cathode|vss VSS|anode|cathode|vss sg13_lv_nmos
+ L=0.13u W=0.42u AS=0.0609p AD=0.1626p PS=0.71u PD=1.415u rfmode=0
M$17192 VSS|anode|cathode|vss \$4504 \$4357 VSS|anode|cathode|vss sg13_lv_nmos
+ L=0.13u W=0.74u AS=0.1626p AD=0.2516p PS=1.415u PD=2.16u rfmode=0
M$17193 \$4106 \$4064 \$4221 VSS|anode|cathode|vss sg13_lv_nmos L=0.13u W=0.42u
+ AS=0.1296p AD=0.081p PS=1.52u PD=0.81u rfmode=0
M$17194 \$4221 \$4150 \$4107 VSS|anode|cathode|vss sg13_lv_nmos L=0.13u W=0.42u
+ AS=0.081p AD=0.2163p PS=0.81u PD=1.87u rfmode=0
M$17195 \$4403 \$4506 VSS|anode|cathode|vss VSS|anode|cathode|vss sg13_lv_nmos
+ L=0.13u W=0.42u AS=0.1428p AD=0.0798p PS=1.52u PD=0.8u rfmode=0
M$17196 VSS|anode|cathode|vss VDD \$4480 VSS|anode|cathode|vss sg13_lv_nmos
+ L=0.13u W=0.42u AS=0.0798p AD=0.0378p PS=0.8u PD=0.6u rfmode=0
M$17197 \$4480 \$4452 \$4506 VSS|anode|cathode|vss sg13_lv_nmos L=0.13u W=0.42u
+ AS=0.0378p AD=0.1428p PS=0.6u PD=1.52u rfmode=0
M$17198 VSS|anode|cathode|vss \$4452 \$4405 VSS|anode|cathode|vss sg13_lv_nmos
+ L=0.13u W=0.64u AS=0.1331p AD=0.2176p PS=1.12u PD=1.96u rfmode=0
M$17199 VSS|anode|cathode|vss \$4452 \$4404 VSS|anode|cathode|vss sg13_lv_nmos
+ L=0.13u W=1.48u AS=0.3922p AD=0.2737p PS=3.28u PD=2.24u rfmode=0
M$17201 VSS|anode|cathode|vss \$4405 \$4406 VSS|anode|cathode|vss sg13_lv_nmos
+ L=0.13u W=1.48u AS=0.3922p AD=0.3922p PS=3.28u PD=3.28u rfmode=0
M$17203 VSS|anode|cathode|vss VSS|anode|cathode|vss \$4235
+ VSS|anode|cathode|vss sg13_lv_nmos L=0.13u W=1u AS=0.265p AD=0.265p PS=2.56u
+ PD=2.56u rfmode=0
M$17204 \$4235 \$4109 OUTP|analog_io_padres[16]|core|padres
+ VSS|anode|cathode|vss sg13_lv_nmos L=0.13u W=2u AS=0.38p AD=0.38p PS=3.52u
+ PD=3.52u rfmode=0
M$17206 \$4235 \$4111 OUTN|analog_io_padres[15]|core|padres
+ VSS|anode|cathode|vss sg13_lv_nmos L=0.13u W=2u AS=0.38p AD=0.38p PS=3.52u
+ PD=3.52u rfmode=0
M$17213 VSS|anode|cathode|vss \$3197 \$4407 VSS|anode|cathode|vss sg13_lv_nmos
+ L=0.13u W=0.55u AS=0.187p AD=0.1045p PS=1.78u PD=0.93u rfmode=0
M$17214 \$4407 \$3396 VSS|anode|cathode|vss VSS|anode|cathode|vss sg13_lv_nmos
+ L=0.13u W=0.55u AS=0.1045p AD=0.146425p PS=0.93u PD=1.155u rfmode=0
M$17215 VSS|anode|cathode|vss \$4407 \$4408 VSS|anode|cathode|vss sg13_lv_nmos
+ L=0.13u W=1.48u AS=0.312925p AD=0.4477p PS=2.345u PD=3.43u rfmode=0
M$17217 \$4410 \$4454 \$4478 VSS|anode|cathode|vss sg13_lv_nmos L=0.13u W=0.42u
+ AS=0.1428p AD=0.0609p PS=1.52u PD=0.71u rfmode=0
M$17218 \$4478 VDD VSS|anode|cathode|vss VSS|anode|cathode|vss sg13_lv_nmos
+ L=0.13u W=0.42u AS=0.0609p AD=0.1626p PS=0.71u PD=1.415u rfmode=0
M$17219 VSS|anode|cathode|vss \$4507 \$4358 VSS|anode|cathode|vss sg13_lv_nmos
+ L=0.13u W=0.74u AS=0.1626p AD=0.2516p PS=1.415u PD=2.16u rfmode=0
M$17220 \$4113 \$4068 \$4223 VSS|anode|cathode|vss sg13_lv_nmos L=0.13u W=0.42u
+ AS=0.1296p AD=0.081p PS=1.52u PD=0.81u rfmode=0
M$17221 \$4223 \$4154 \$4114 VSS|anode|cathode|vss sg13_lv_nmos L=0.13u W=0.42u
+ AS=0.081p AD=0.2163p PS=0.81u PD=1.87u rfmode=0
M$17222 \$4412 \$4509 VSS|anode|cathode|vss VSS|anode|cathode|vss sg13_lv_nmos
+ L=0.13u W=0.42u AS=0.1428p AD=0.0798p PS=1.52u PD=0.8u rfmode=0
M$17223 VSS|anode|cathode|vss VDD \$4477 VSS|anode|cathode|vss sg13_lv_nmos
+ L=0.13u W=0.42u AS=0.0798p AD=0.0378p PS=0.8u PD=0.6u rfmode=0
M$17224 \$4477 \$4456 \$4509 VSS|anode|cathode|vss sg13_lv_nmos L=0.13u W=0.42u
+ AS=0.0378p AD=0.1428p PS=0.6u PD=1.52u rfmode=0
M$17225 VSS|anode|cathode|vss \$4456 \$4414 VSS|anode|cathode|vss sg13_lv_nmos
+ L=0.13u W=0.64u AS=0.1331p AD=0.2176p PS=1.12u PD=1.96u rfmode=0
M$17226 VSS|anode|cathode|vss \$4456 \$4413 VSS|anode|cathode|vss sg13_lv_nmos
+ L=0.13u W=1.48u AS=0.3922p AD=0.2737p PS=3.28u PD=2.24u rfmode=0
M$17228 VSS|anode|cathode|vss \$4414 \$4415 VSS|anode|cathode|vss sg13_lv_nmos
+ L=0.13u W=1.48u AS=0.3922p AD=0.3922p PS=3.28u PD=3.28u rfmode=0
M$17230 VSS|anode|cathode|vss VSS|anode|cathode|vss \$4236
+ VSS|anode|cathode|vss sg13_lv_nmos L=0.13u W=1u AS=0.265p AD=0.265p PS=2.56u
+ PD=2.56u rfmode=0
M$17231 \$4236 \$4116 OUTP|analog_io_padres[16]|core|padres
+ VSS|anode|cathode|vss sg13_lv_nmos L=0.13u W=2u AS=0.38p AD=0.38p PS=3.52u
+ PD=3.52u rfmode=0
M$17233 \$4236 \$4118 OUTN|analog_io_padres[15]|core|padres
+ VSS|anode|cathode|vss sg13_lv_nmos L=0.13u W=2u AS=0.38p AD=0.38p PS=3.52u
+ PD=3.52u rfmode=0
M$17240 VSS|anode|cathode|vss \$3198 \$4416 VSS|anode|cathode|vss sg13_lv_nmos
+ L=0.13u W=0.55u AS=0.187p AD=0.1045p PS=1.78u PD=0.93u rfmode=0
M$17241 \$4416 \$3396 VSS|anode|cathode|vss VSS|anode|cathode|vss sg13_lv_nmos
+ L=0.13u W=0.55u AS=0.1045p AD=0.146425p PS=0.93u PD=1.155u rfmode=0
M$17242 VSS|anode|cathode|vss \$4416 \$4417 VSS|anode|cathode|vss sg13_lv_nmos
+ L=0.13u W=1.48u AS=0.312925p AD=0.4477p PS=2.345u PD=3.43u rfmode=0
M$17244 \$4419 \$4458 \$4476 VSS|anode|cathode|vss sg13_lv_nmos L=0.13u W=0.42u
+ AS=0.1428p AD=0.0609p PS=1.52u PD=0.71u rfmode=0
M$17245 \$4476 VDD VSS|anode|cathode|vss VSS|anode|cathode|vss sg13_lv_nmos
+ L=0.13u W=0.42u AS=0.0609p AD=0.1626p PS=0.71u PD=1.415u rfmode=0
M$17246 VSS|anode|cathode|vss \$4510 \$4359 VSS|anode|cathode|vss sg13_lv_nmos
+ L=0.13u W=0.74u AS=0.1626p AD=0.2516p PS=1.415u PD=2.16u rfmode=0
M$17247 \$4120 \$4072 \$4225 VSS|anode|cathode|vss sg13_lv_nmos L=0.13u W=0.42u
+ AS=0.1296p AD=0.081p PS=1.52u PD=0.81u rfmode=0
M$17248 \$4225 \$4158 \$4121 VSS|anode|cathode|vss sg13_lv_nmos L=0.13u W=0.42u
+ AS=0.081p AD=0.2163p PS=0.81u PD=1.87u rfmode=0
M$17249 \$4421 \$4512 VSS|anode|cathode|vss VSS|anode|cathode|vss sg13_lv_nmos
+ L=0.13u W=0.42u AS=0.1428p AD=0.0798p PS=1.52u PD=0.8u rfmode=0
M$17250 VSS|anode|cathode|vss VDD \$4474 VSS|anode|cathode|vss sg13_lv_nmos
+ L=0.13u W=0.42u AS=0.0798p AD=0.0378p PS=0.8u PD=0.6u rfmode=0
M$17251 \$4474 \$4460 \$4512 VSS|anode|cathode|vss sg13_lv_nmos L=0.13u W=0.42u
+ AS=0.0378p AD=0.1428p PS=0.6u PD=1.52u rfmode=0
M$17252 VSS|anode|cathode|vss \$4460 \$4423 VSS|anode|cathode|vss sg13_lv_nmos
+ L=0.13u W=0.64u AS=0.1331p AD=0.2176p PS=1.12u PD=1.96u rfmode=0
M$17253 VSS|anode|cathode|vss \$4460 \$4422 VSS|anode|cathode|vss sg13_lv_nmos
+ L=0.13u W=1.48u AS=0.3922p AD=0.2737p PS=3.28u PD=2.24u rfmode=0
M$17255 VSS|anode|cathode|vss \$4423 \$4424 VSS|anode|cathode|vss sg13_lv_nmos
+ L=0.13u W=1.48u AS=0.3922p AD=0.3922p PS=3.28u PD=3.28u rfmode=0
M$17257 VSS|anode|cathode|vss VSS|anode|cathode|vss \$4237
+ VSS|anode|cathode|vss sg13_lv_nmos L=0.13u W=1u AS=0.265p AD=0.265p PS=2.56u
+ PD=2.56u rfmode=0
M$17258 \$4237 \$4123 OUTP|analog_io_padres[16]|core|padres
+ VSS|anode|cathode|vss sg13_lv_nmos L=0.13u W=2u AS=0.38p AD=0.38p PS=3.52u
+ PD=3.52u rfmode=0
M$17260 \$4237 \$4125 OUTN|analog_io_padres[15]|core|padres
+ VSS|anode|cathode|vss sg13_lv_nmos L=0.13u W=2u AS=0.38p AD=0.38p PS=3.52u
+ PD=3.52u rfmode=0
M$17267 VSS|anode|cathode|vss VSS|anode|cathode|vss \$4425
+ VSS|anode|cathode|vss sg13_lv_nmos L=0.13u W=0.55u AS=0.187p AD=0.1045p
+ PS=1.78u PD=0.93u rfmode=0
M$17268 \$4425 \$3396 VSS|anode|cathode|vss VSS|anode|cathode|vss sg13_lv_nmos
+ L=0.13u W=0.55u AS=0.1045p AD=0.146425p PS=0.93u PD=1.155u rfmode=0
M$17269 VSS|anode|cathode|vss \$4425 \$4426 VSS|anode|cathode|vss sg13_lv_nmos
+ L=0.13u W=1.48u AS=0.312925p AD=0.4477p PS=2.345u PD=3.43u rfmode=0
M$17271 \$4428 \$4462 \$4469 VSS|anode|cathode|vss sg13_lv_nmos L=0.13u W=0.42u
+ AS=0.1428p AD=0.0609p PS=1.52u PD=0.71u rfmode=0
M$17272 \$4469 VDD VSS|anode|cathode|vss VSS|anode|cathode|vss sg13_lv_nmos
+ L=0.13u W=0.42u AS=0.0609p AD=0.1626p PS=0.71u PD=1.415u rfmode=0
M$17273 VSS|anode|cathode|vss \$4513 \$4360 VSS|anode|cathode|vss sg13_lv_nmos
+ L=0.13u W=0.74u AS=0.1626p AD=0.2516p PS=1.415u PD=2.16u rfmode=0
M$17274 \$4127 \$4076 \$4227 VSS|anode|cathode|vss sg13_lv_nmos L=0.13u W=0.42u
+ AS=0.1296p AD=0.081p PS=1.52u PD=0.81u rfmode=0
M$17275 \$4227 \$4162 \$4128 VSS|anode|cathode|vss sg13_lv_nmos L=0.13u W=0.42u
+ AS=0.081p AD=0.2163p PS=0.81u PD=1.87u rfmode=0
M$17276 \$4430 \$4515 VSS|anode|cathode|vss VSS|anode|cathode|vss sg13_lv_nmos
+ L=0.13u W=0.42u AS=0.1428p AD=0.0798p PS=1.52u PD=0.8u rfmode=0
M$17277 VSS|anode|cathode|vss VDD \$4468 VSS|anode|cathode|vss sg13_lv_nmos
+ L=0.13u W=0.42u AS=0.0798p AD=0.0378p PS=0.8u PD=0.6u rfmode=0
M$17278 \$4468 \$4464 \$4515 VSS|anode|cathode|vss sg13_lv_nmos L=0.13u W=0.42u
+ AS=0.0378p AD=0.1428p PS=0.6u PD=1.52u rfmode=0
M$17279 VSS|anode|cathode|vss \$4464 \$4432 VSS|anode|cathode|vss sg13_lv_nmos
+ L=0.13u W=0.64u AS=0.1331p AD=0.2176p PS=1.12u PD=1.96u rfmode=0
M$17280 VSS|anode|cathode|vss \$4464 \$4431 VSS|anode|cathode|vss sg13_lv_nmos
+ L=0.13u W=1.48u AS=0.3922p AD=0.2737p PS=3.28u PD=2.24u rfmode=0
M$17282 VSS|anode|cathode|vss \$4432 \$4433 VSS|anode|cathode|vss sg13_lv_nmos
+ L=0.13u W=1.48u AS=0.3922p AD=0.3922p PS=3.28u PD=3.28u rfmode=0
M$17284 VSS|anode|cathode|vss VSS|anode|cathode|vss \$4238
+ VSS|anode|cathode|vss sg13_lv_nmos L=0.13u W=1u AS=0.265p AD=0.265p PS=2.56u
+ PD=2.56u rfmode=0
M$17285 \$4238 \$4130 OUTP|analog_io_padres[16]|core|padres
+ VSS|anode|cathode|vss sg13_lv_nmos L=0.13u W=2u AS=0.38p AD=0.38p PS=3.52u
+ PD=3.52u rfmode=0
M$17287 \$4238 \$4132 OUTN|analog_io_padres[15]|core|padres
+ VSS|anode|cathode|vss sg13_lv_nmos L=0.13u W=2u AS=0.38p AD=0.38p PS=3.52u
+ PD=3.52u rfmode=0
M$17294 core|p2c|shift_in|ui_p2c[3] \$4341 VSS|anode|cathode|vss
+ VSS|anode|cathode|vss sg13_lv_nmos L=0.13u W=2.75u AS=0.935p AD=0.935p
+ PS=6.18u PD=6.18u rfmode=0
M$17295 \$4364 \$4363 VSS|anode|cathode|vss VSS|anode|cathode|vss sg13_lv_nmos
+ L=0.13u W=1.44u AS=0.4068p AD=0.2772p PS=3.29u PD=2.21u rfmode=0
M$17297 \$4364 \$2935 \$4434 VSS|anode|cathode|vss sg13_lv_nmos L=0.13u W=1.44u
+ AS=0.2772p AD=0.3816p PS=2.21u PD=3.22u rfmode=0
M$17299 VSS|anode|cathode|vss VDD \$4471 VSS|anode|cathode|vss sg13_lv_nmos
+ L=0.13u W=0.42u AS=0.1701p AD=0.03885p PS=1.65u PD=0.605u rfmode=0
M$17300 \$4471 \$4353 \$4435 VSS|anode|cathode|vss sg13_lv_nmos L=0.13u W=0.42u
+ AS=0.03885p AD=0.1596p PS=0.605u PD=1.6u rfmode=0
M$17301 VSS|anode|cathode|vss \$4366 \$4493 VSS|anode|cathode|vss sg13_lv_nmos
+ L=0.13u W=0.74u AS=0.43315p AD=0.2516p PS=2.205u PD=2.16u rfmode=0
M$17302 VSS|anode|cathode|vss CLK|clk|core|fclk_in|p2c|ui_p2c[6] \$4366
+ VSS|anode|cathode|vss sg13_lv_nmos L=0.13u W=0.74u AS=0.43315p AD=0.2516p
+ PS=2.205u PD=2.16u rfmode=0
M$17303 \$4436 \$4366 \$4367 VSS|anode|cathode|vss sg13_lv_nmos L=0.13u W=0.42u
+ AS=0.12665p AD=0.1428p PS=1.145u PD=1.52u rfmode=0
M$17304 \$4353 \$4493 \$4436 VSS|anode|cathode|vss sg13_lv_nmos L=0.13u W=0.74u
+ AS=0.3473p AD=0.12665p PS=2.71u PD=1.145u rfmode=0
M$17305 \$4373 \$4372 VSS|anode|cathode|vss VSS|anode|cathode|vss sg13_lv_nmos
+ L=0.13u W=1.44u AS=0.4068p AD=0.2772p PS=3.29u PD=2.21u rfmode=0
M$17307 \$4373 \$2935 \$4438 VSS|anode|cathode|vss sg13_lv_nmos L=0.13u W=1.44u
+ AS=0.2772p AD=0.3816p PS=2.21u PD=3.22u rfmode=0
M$17309 VSS|anode|cathode|vss VDD \$4483 VSS|anode|cathode|vss sg13_lv_nmos
+ L=0.13u W=0.42u AS=0.1701p AD=0.03885p PS=1.65u PD=0.605u rfmode=0
M$17310 \$4483 \$4354 \$4439 VSS|anode|cathode|vss sg13_lv_nmos L=0.13u W=0.42u
+ AS=0.03885p AD=0.1596p PS=0.605u PD=1.6u rfmode=0
M$17311 VSS|anode|cathode|vss \$4375 \$4496 VSS|anode|cathode|vss sg13_lv_nmos
+ L=0.13u W=0.74u AS=0.43315p AD=0.2516p PS=2.205u PD=2.16u rfmode=0
M$17312 VSS|anode|cathode|vss CLK|clk|core|fclk_in|p2c|ui_p2c[6] \$4375
+ VSS|anode|cathode|vss sg13_lv_nmos L=0.13u W=0.74u AS=0.43315p AD=0.2516p
+ PS=2.205u PD=2.16u rfmode=0
M$17313 \$4440 \$4375 \$4376 VSS|anode|cathode|vss sg13_lv_nmos L=0.13u W=0.42u
+ AS=0.12665p AD=0.1428p PS=1.145u PD=1.52u rfmode=0
M$17314 \$4354 \$4496 \$4440 VSS|anode|cathode|vss sg13_lv_nmos L=0.13u W=0.74u
+ AS=0.3473p AD=0.12665p PS=2.71u PD=1.145u rfmode=0
M$17315 \$4382 \$4381 VSS|anode|cathode|vss VSS|anode|cathode|vss sg13_lv_nmos
+ L=0.13u W=1.44u AS=0.4068p AD=0.2772p PS=3.29u PD=2.21u rfmode=0
M$17317 \$4382 \$2935 \$4442 VSS|anode|cathode|vss sg13_lv_nmos L=0.13u W=1.44u
+ AS=0.2772p AD=0.3816p PS=2.21u PD=3.22u rfmode=0
M$17319 VSS|anode|cathode|vss VDD \$4489 VSS|anode|cathode|vss sg13_lv_nmos
+ L=0.13u W=0.42u AS=0.1701p AD=0.03885p PS=1.65u PD=0.605u rfmode=0
M$17320 \$4489 \$4355 \$4443 VSS|anode|cathode|vss sg13_lv_nmos L=0.13u W=0.42u
+ AS=0.03885p AD=0.1596p PS=0.605u PD=1.6u rfmode=0
M$17321 VSS|anode|cathode|vss \$4384 \$4499 VSS|anode|cathode|vss sg13_lv_nmos
+ L=0.13u W=0.74u AS=0.43315p AD=0.2516p PS=2.205u PD=2.16u rfmode=0
M$17322 VSS|anode|cathode|vss CLK|clk|core|fclk_in|p2c|ui_p2c[6] \$4384
+ VSS|anode|cathode|vss sg13_lv_nmos L=0.13u W=0.74u AS=0.43315p AD=0.2516p
+ PS=2.205u PD=2.16u rfmode=0
M$17323 \$4444 \$4384 \$4385 VSS|anode|cathode|vss sg13_lv_nmos L=0.13u W=0.42u
+ AS=0.12665p AD=0.1428p PS=1.145u PD=1.52u rfmode=0
M$17324 \$4355 \$4499 \$4444 VSS|anode|cathode|vss sg13_lv_nmos L=0.13u W=0.74u
+ AS=0.3473p AD=0.12665p PS=2.71u PD=1.145u rfmode=0
M$17325 \$4391 \$4390 VSS|anode|cathode|vss VSS|anode|cathode|vss sg13_lv_nmos
+ L=0.13u W=1.44u AS=0.4068p AD=0.2772p PS=3.29u PD=2.21u rfmode=0
M$17327 \$4391 \$2935 \$4446 VSS|anode|cathode|vss sg13_lv_nmos L=0.13u W=1.44u
+ AS=0.2772p AD=0.3816p PS=2.21u PD=3.22u rfmode=0
M$17329 VSS|anode|cathode|vss VDD \$4488 VSS|anode|cathode|vss sg13_lv_nmos
+ L=0.13u W=0.42u AS=0.1701p AD=0.03885p PS=1.65u PD=0.605u rfmode=0
M$17330 \$4488 \$4356 \$4447 VSS|anode|cathode|vss sg13_lv_nmos L=0.13u W=0.42u
+ AS=0.03885p AD=0.1596p PS=0.605u PD=1.6u rfmode=0
M$17331 VSS|anode|cathode|vss \$4393 \$4502 VSS|anode|cathode|vss sg13_lv_nmos
+ L=0.13u W=0.74u AS=0.43315p AD=0.2516p PS=2.205u PD=2.16u rfmode=0
M$17332 VSS|anode|cathode|vss CLK|clk|core|fclk_in|p2c|ui_p2c[6] \$4393
+ VSS|anode|cathode|vss sg13_lv_nmos L=0.13u W=0.74u AS=0.43315p AD=0.2516p
+ PS=2.205u PD=2.16u rfmode=0
M$17333 \$4448 \$4393 \$4394 VSS|anode|cathode|vss sg13_lv_nmos L=0.13u W=0.42u
+ AS=0.12665p AD=0.1428p PS=1.145u PD=1.52u rfmode=0
M$17334 \$4356 \$4502 \$4448 VSS|anode|cathode|vss sg13_lv_nmos L=0.13u W=0.74u
+ AS=0.3473p AD=0.12665p PS=2.71u PD=1.145u rfmode=0
M$17335 \$4400 \$4399 VSS|anode|cathode|vss VSS|anode|cathode|vss sg13_lv_nmos
+ L=0.13u W=1.44u AS=0.4068p AD=0.2772p PS=3.29u PD=2.21u rfmode=0
M$17337 \$4400 \$2935 \$4450 VSS|anode|cathode|vss sg13_lv_nmos L=0.13u W=1.44u
+ AS=0.2772p AD=0.3816p PS=2.21u PD=3.22u rfmode=0
M$17339 VSS|anode|cathode|vss VDD \$4482 VSS|anode|cathode|vss sg13_lv_nmos
+ L=0.13u W=0.42u AS=0.1701p AD=0.03885p PS=1.65u PD=0.605u rfmode=0
M$17340 \$4482 \$4357 \$4451 VSS|anode|cathode|vss sg13_lv_nmos L=0.13u W=0.42u
+ AS=0.03885p AD=0.1596p PS=0.605u PD=1.6u rfmode=0
M$17341 VSS|anode|cathode|vss \$4402 \$4505 VSS|anode|cathode|vss sg13_lv_nmos
+ L=0.13u W=0.74u AS=0.43315p AD=0.2516p PS=2.205u PD=2.16u rfmode=0
M$17342 VSS|anode|cathode|vss CLK|clk|core|fclk_in|p2c|ui_p2c[6] \$4402
+ VSS|anode|cathode|vss sg13_lv_nmos L=0.13u W=0.74u AS=0.43315p AD=0.2516p
+ PS=2.205u PD=2.16u rfmode=0
M$17343 \$4452 \$4402 \$4403 VSS|anode|cathode|vss sg13_lv_nmos L=0.13u W=0.42u
+ AS=0.12665p AD=0.1428p PS=1.145u PD=1.52u rfmode=0
M$17344 \$4357 \$4505 \$4452 VSS|anode|cathode|vss sg13_lv_nmos L=0.13u W=0.74u
+ AS=0.3473p AD=0.12665p PS=2.71u PD=1.145u rfmode=0
M$17345 \$4409 \$4408 VSS|anode|cathode|vss VSS|anode|cathode|vss sg13_lv_nmos
+ L=0.13u W=1.44u AS=0.4068p AD=0.2772p PS=3.29u PD=2.21u rfmode=0
M$17347 \$4409 \$2935 \$4454 VSS|anode|cathode|vss sg13_lv_nmos L=0.13u W=1.44u
+ AS=0.2772p AD=0.3816p PS=2.21u PD=3.22u rfmode=0
M$17349 VSS|anode|cathode|vss VDD \$4479 VSS|anode|cathode|vss sg13_lv_nmos
+ L=0.13u W=0.42u AS=0.1701p AD=0.03885p PS=1.65u PD=0.605u rfmode=0
M$17350 \$4479 \$4358 \$4455 VSS|anode|cathode|vss sg13_lv_nmos L=0.13u W=0.42u
+ AS=0.03885p AD=0.1596p PS=0.605u PD=1.6u rfmode=0
M$17351 VSS|anode|cathode|vss \$4411 \$4508 VSS|anode|cathode|vss sg13_lv_nmos
+ L=0.13u W=0.74u AS=0.43315p AD=0.2516p PS=2.205u PD=2.16u rfmode=0
M$17352 VSS|anode|cathode|vss CLK|clk|core|fclk_in|p2c|ui_p2c[6] \$4411
+ VSS|anode|cathode|vss sg13_lv_nmos L=0.13u W=0.74u AS=0.43315p AD=0.2516p
+ PS=2.205u PD=2.16u rfmode=0
M$17353 \$4456 \$4411 \$4412 VSS|anode|cathode|vss sg13_lv_nmos L=0.13u W=0.42u
+ AS=0.12665p AD=0.1428p PS=1.145u PD=1.52u rfmode=0
M$17354 \$4358 \$4508 \$4456 VSS|anode|cathode|vss sg13_lv_nmos L=0.13u W=0.74u
+ AS=0.3473p AD=0.12665p PS=2.71u PD=1.145u rfmode=0
M$17355 \$4418 \$4417 VSS|anode|cathode|vss VSS|anode|cathode|vss sg13_lv_nmos
+ L=0.13u W=1.44u AS=0.4068p AD=0.2772p PS=3.29u PD=2.21u rfmode=0
M$17357 \$4418 \$2935 \$4458 VSS|anode|cathode|vss sg13_lv_nmos L=0.13u W=1.44u
+ AS=0.2772p AD=0.3816p PS=2.21u PD=3.22u rfmode=0
M$17359 VSS|anode|cathode|vss VDD \$4472 VSS|anode|cathode|vss sg13_lv_nmos
+ L=0.13u W=0.42u AS=0.1701p AD=0.03885p PS=1.65u PD=0.605u rfmode=0
M$17360 \$4472 \$4359 \$4459 VSS|anode|cathode|vss sg13_lv_nmos L=0.13u W=0.42u
+ AS=0.03885p AD=0.1596p PS=0.605u PD=1.6u rfmode=0
M$17361 VSS|anode|cathode|vss \$4420 \$4511 VSS|anode|cathode|vss sg13_lv_nmos
+ L=0.13u W=0.74u AS=0.43315p AD=0.2516p PS=2.205u PD=2.16u rfmode=0
M$17362 VSS|anode|cathode|vss CLK|clk|core|fclk_in|p2c|ui_p2c[6] \$4420
+ VSS|anode|cathode|vss sg13_lv_nmos L=0.13u W=0.74u AS=0.43315p AD=0.2516p
+ PS=2.205u PD=2.16u rfmode=0
M$17363 \$4460 \$4420 \$4421 VSS|anode|cathode|vss sg13_lv_nmos L=0.13u W=0.42u
+ AS=0.12665p AD=0.1428p PS=1.145u PD=1.52u rfmode=0
M$17364 \$4359 \$4511 \$4460 VSS|anode|cathode|vss sg13_lv_nmos L=0.13u W=0.74u
+ AS=0.3473p AD=0.12665p PS=2.71u PD=1.145u rfmode=0
M$17365 \$4427 \$4426 VSS|anode|cathode|vss VSS|anode|cathode|vss sg13_lv_nmos
+ L=0.13u W=1.44u AS=0.4068p AD=0.2772p PS=3.29u PD=2.21u rfmode=0
M$17367 \$4427 \$2935 \$4462 VSS|anode|cathode|vss sg13_lv_nmos L=0.13u W=1.44u
+ AS=0.2772p AD=0.3816p PS=2.21u PD=3.22u rfmode=0
M$17369 VSS|anode|cathode|vss VDD \$4470 VSS|anode|cathode|vss sg13_lv_nmos
+ L=0.13u W=0.42u AS=0.1701p AD=0.03885p PS=1.65u PD=0.605u rfmode=0
M$17370 \$4470 \$4360 \$4463 VSS|anode|cathode|vss sg13_lv_nmos L=0.13u W=0.42u
+ AS=0.03885p AD=0.1596p PS=0.605u PD=1.6u rfmode=0
M$17371 VSS|anode|cathode|vss \$4429 \$4514 VSS|anode|cathode|vss sg13_lv_nmos
+ L=0.13u W=0.74u AS=0.43315p AD=0.2516p PS=2.205u PD=2.16u rfmode=0
M$17372 VSS|anode|cathode|vss CLK|clk|core|fclk_in|p2c|ui_p2c[6] \$4429
+ VSS|anode|cathode|vss sg13_lv_nmos L=0.13u W=0.74u AS=0.43315p AD=0.2516p
+ PS=2.205u PD=2.16u rfmode=0
M$17373 \$4464 \$4429 \$4430 VSS|anode|cathode|vss sg13_lv_nmos L=0.13u W=0.42u
+ AS=0.12665p AD=0.1428p PS=1.145u PD=1.52u rfmode=0
M$17374 \$4360 \$4514 \$4464 VSS|anode|cathode|vss sg13_lv_nmos L=0.13u W=0.74u
+ AS=0.3473p AD=0.12665p PS=2.71u PD=1.145u rfmode=0
M$17375 VSS|anode|cathode|vss \$3192 \$4673 VSS|anode|cathode|vss sg13_lv_nmos
+ L=0.13u W=0.55u AS=0.187p AD=0.1045p PS=1.78u PD=0.93u rfmode=0
M$17376 \$4673 \$3439 VSS|anode|cathode|vss VSS|anode|cathode|vss sg13_lv_nmos
+ L=0.13u W=0.55u AS=0.1045p AD=0.146425p PS=0.93u PD=1.155u rfmode=0
M$17377 VSS|anode|cathode|vss \$4673 \$4674 VSS|anode|cathode|vss sg13_lv_nmos
+ L=0.13u W=1.48u AS=0.312925p AD=0.4477p PS=2.345u PD=3.43u rfmode=0
M$17379 \$4676 \$4745 \$4784 VSS|anode|cathode|vss sg13_lv_nmos L=0.13u W=0.42u
+ AS=0.1428p AD=0.0609p PS=1.52u PD=0.71u rfmode=0
M$17380 \$4784 VDD VSS|anode|cathode|vss VSS|anode|cathode|vss sg13_lv_nmos
+ L=0.13u W=0.42u AS=0.0609p AD=0.1626p PS=0.71u PD=1.415u rfmode=0
M$17381 VSS|anode|cathode|vss \$4801 \$4657 VSS|anode|cathode|vss sg13_lv_nmos
+ L=0.13u W=0.74u AS=0.1626p AD=0.2516p PS=1.415u PD=2.16u rfmode=0
M$17382 \$4365 \$4366 \$4492 VSS|anode|cathode|vss sg13_lv_nmos L=0.13u W=0.42u
+ AS=0.1296p AD=0.081p PS=1.52u PD=0.81u rfmode=0
M$17383 \$4492 \$4493 \$4435 VSS|anode|cathode|vss sg13_lv_nmos L=0.13u W=0.42u
+ AS=0.081p AD=0.2163p PS=0.81u PD=1.87u rfmode=0
M$17384 \$4678 \$4802 VSS|anode|cathode|vss VSS|anode|cathode|vss sg13_lv_nmos
+ L=0.13u W=0.42u AS=0.1428p AD=0.0798p PS=1.52u PD=0.8u rfmode=0
M$17385 VSS|anode|cathode|vss VDD \$4786 VSS|anode|cathode|vss sg13_lv_nmos
+ L=0.13u W=0.42u AS=0.0798p AD=0.0378p PS=0.8u PD=0.6u rfmode=0
M$17386 \$4786 \$4747 \$4802 VSS|anode|cathode|vss sg13_lv_nmos L=0.13u W=0.42u
+ AS=0.0378p AD=0.1428p PS=0.6u PD=1.52u rfmode=0
M$17387 VSS|anode|cathode|vss \$4747 \$4680 VSS|anode|cathode|vss sg13_lv_nmos
+ L=0.13u W=0.64u AS=0.1331p AD=0.2176p PS=1.12u PD=1.96u rfmode=0
M$17388 VSS|anode|cathode|vss \$4747 \$4679 VSS|anode|cathode|vss sg13_lv_nmos
+ L=0.13u W=1.48u AS=0.3922p AD=0.2737p PS=3.28u PD=2.24u rfmode=0
M$17390 VSS|anode|cathode|vss \$4680 \$4681 VSS|anode|cathode|vss sg13_lv_nmos
+ L=0.13u W=1.48u AS=0.3922p AD=0.3922p PS=3.28u PD=3.28u rfmode=0
M$17392 VSS|anode|cathode|vss VSS|anode|cathode|vss \$4542
+ VSS|anode|cathode|vss sg13_lv_nmos L=0.13u W=1u AS=0.265p AD=0.265p PS=2.56u
+ PD=2.56u rfmode=0
M$17393 \$4542 \$4368 OUTP|analog_io_padres[16]|core|padres
+ VSS|anode|cathode|vss sg13_lv_nmos L=0.13u W=2u AS=0.38p AD=0.38p PS=3.52u
+ PD=3.52u rfmode=0
M$17395 \$4542 \$4370 OUTN|analog_io_padres[15]|core|padres
+ VSS|anode|cathode|vss sg13_lv_nmos L=0.13u W=2u AS=0.38p AD=0.38p PS=3.52u
+ PD=3.52u rfmode=0
M$17402 VSS|anode|cathode|vss \$3193 \$4682 VSS|anode|cathode|vss sg13_lv_nmos
+ L=0.13u W=0.55u AS=0.187p AD=0.1045p PS=1.78u PD=0.93u rfmode=0
M$17403 \$4682 \$3439 VSS|anode|cathode|vss VSS|anode|cathode|vss sg13_lv_nmos
+ L=0.13u W=0.55u AS=0.1045p AD=0.146425p PS=0.93u PD=1.155u rfmode=0
M$17404 VSS|anode|cathode|vss \$4682 \$4683 VSS|anode|cathode|vss sg13_lv_nmos
+ L=0.13u W=1.48u AS=0.312925p AD=0.4477p PS=2.345u PD=3.43u rfmode=0
M$17406 \$4685 \$4749 \$4790 VSS|anode|cathode|vss sg13_lv_nmos L=0.13u W=0.42u
+ AS=0.1428p AD=0.0609p PS=1.52u PD=0.71u rfmode=0
M$17407 \$4790 VDD VSS|anode|cathode|vss VSS|anode|cathode|vss sg13_lv_nmos
+ L=0.13u W=0.42u AS=0.0609p AD=0.1626p PS=0.71u PD=1.415u rfmode=0
M$17408 VSS|anode|cathode|vss \$4803 \$4659 VSS|anode|cathode|vss sg13_lv_nmos
+ L=0.13u W=0.74u AS=0.1626p AD=0.2516p PS=1.415u PD=2.16u rfmode=0
M$17409 \$4374 \$4375 \$4495 VSS|anode|cathode|vss sg13_lv_nmos L=0.13u W=0.42u
+ AS=0.1296p AD=0.081p PS=1.52u PD=0.81u rfmode=0
M$17410 \$4495 \$4496 \$4439 VSS|anode|cathode|vss sg13_lv_nmos L=0.13u W=0.42u
+ AS=0.081p AD=0.2163p PS=0.81u PD=1.87u rfmode=0
M$17411 \$4687 \$4804 VSS|anode|cathode|vss VSS|anode|cathode|vss sg13_lv_nmos
+ L=0.13u W=0.42u AS=0.1428p AD=0.0798p PS=1.52u PD=0.8u rfmode=0
M$17412 VSS|anode|cathode|vss VDD \$4793 VSS|anode|cathode|vss sg13_lv_nmos
+ L=0.13u W=0.42u AS=0.0798p AD=0.0378p PS=0.8u PD=0.6u rfmode=0
M$17413 \$4793 \$4751 \$4804 VSS|anode|cathode|vss sg13_lv_nmos L=0.13u W=0.42u
+ AS=0.0378p AD=0.1428p PS=0.6u PD=1.52u rfmode=0
M$17414 VSS|anode|cathode|vss \$4751 \$4689 VSS|anode|cathode|vss sg13_lv_nmos
+ L=0.13u W=0.64u AS=0.1331p AD=0.2176p PS=1.12u PD=1.96u rfmode=0
M$17415 VSS|anode|cathode|vss \$4751 \$4688 VSS|anode|cathode|vss sg13_lv_nmos
+ L=0.13u W=1.48u AS=0.3922p AD=0.2737p PS=3.28u PD=2.24u rfmode=0
M$17417 VSS|anode|cathode|vss \$4689 \$4690 VSS|anode|cathode|vss sg13_lv_nmos
+ L=0.13u W=1.48u AS=0.3922p AD=0.3922p PS=3.28u PD=3.28u rfmode=0
M$17419 VSS|anode|cathode|vss VSS|anode|cathode|vss \$4543
+ VSS|anode|cathode|vss sg13_lv_nmos L=0.13u W=1u AS=0.265p AD=0.265p PS=2.56u
+ PD=2.56u rfmode=0
M$17420 \$4543 \$4377 OUTP|analog_io_padres[16]|core|padres
+ VSS|anode|cathode|vss sg13_lv_nmos L=0.13u W=2u AS=0.38p AD=0.38p PS=3.52u
+ PD=3.52u rfmode=0
M$17422 \$4543 \$4379 OUTN|analog_io_padres[15]|core|padres
+ VSS|anode|cathode|vss sg13_lv_nmos L=0.13u W=2u AS=0.38p AD=0.38p PS=3.52u
+ PD=3.52u rfmode=0
M$17429 VSS|anode|cathode|vss \$3194 \$4691 VSS|anode|cathode|vss sg13_lv_nmos
+ L=0.13u W=0.55u AS=0.187p AD=0.1045p PS=1.78u PD=0.93u rfmode=0
M$17430 \$4691 \$3439 VSS|anode|cathode|vss VSS|anode|cathode|vss sg13_lv_nmos
+ L=0.13u W=0.55u AS=0.1045p AD=0.146425p PS=0.93u PD=1.155u rfmode=0
M$17431 VSS|anode|cathode|vss \$4691 \$4692 VSS|anode|cathode|vss sg13_lv_nmos
+ L=0.13u W=1.48u AS=0.312925p AD=0.4477p PS=2.345u PD=3.43u rfmode=0
M$17433 \$4694 \$4753 \$4799 VSS|anode|cathode|vss sg13_lv_nmos L=0.13u W=0.42u
+ AS=0.1428p AD=0.0609p PS=1.52u PD=0.71u rfmode=0
M$17434 \$4799 VDD VSS|anode|cathode|vss VSS|anode|cathode|vss sg13_lv_nmos
+ L=0.13u W=0.42u AS=0.0609p AD=0.1626p PS=0.71u PD=1.415u rfmode=0
M$17435 VSS|anode|cathode|vss \$4805 \$4661 VSS|anode|cathode|vss sg13_lv_nmos
+ L=0.13u W=0.74u AS=0.1626p AD=0.2516p PS=1.415u PD=2.16u rfmode=0
M$17436 \$4383 \$4384 \$4498 VSS|anode|cathode|vss sg13_lv_nmos L=0.13u W=0.42u
+ AS=0.1296p AD=0.081p PS=1.52u PD=0.81u rfmode=0
M$17437 \$4498 \$4499 \$4443 VSS|anode|cathode|vss sg13_lv_nmos L=0.13u W=0.42u
+ AS=0.081p AD=0.2163p PS=0.81u PD=1.87u rfmode=0
M$17438 \$4696 \$4806 VSS|anode|cathode|vss VSS|anode|cathode|vss sg13_lv_nmos
+ L=0.13u W=0.42u AS=0.1428p AD=0.0798p PS=1.52u PD=0.8u rfmode=0
M$17439 VSS|anode|cathode|vss VDD \$4798 VSS|anode|cathode|vss sg13_lv_nmos
+ L=0.13u W=0.42u AS=0.0798p AD=0.0378p PS=0.8u PD=0.6u rfmode=0
M$17440 \$4798 \$4755 \$4806 VSS|anode|cathode|vss sg13_lv_nmos L=0.13u W=0.42u
+ AS=0.0378p AD=0.1428p PS=0.6u PD=1.52u rfmode=0
M$17441 VSS|anode|cathode|vss \$4755 \$4698 VSS|anode|cathode|vss sg13_lv_nmos
+ L=0.13u W=0.64u AS=0.1331p AD=0.2176p PS=1.12u PD=1.96u rfmode=0
M$17442 VSS|anode|cathode|vss \$4755 \$4697 VSS|anode|cathode|vss sg13_lv_nmos
+ L=0.13u W=1.48u AS=0.3922p AD=0.2737p PS=3.28u PD=2.24u rfmode=0
M$17444 VSS|anode|cathode|vss \$4698 \$4699 VSS|anode|cathode|vss sg13_lv_nmos
+ L=0.13u W=1.48u AS=0.3922p AD=0.3922p PS=3.28u PD=3.28u rfmode=0
M$17446 VSS|anode|cathode|vss VSS|anode|cathode|vss \$4544
+ VSS|anode|cathode|vss sg13_lv_nmos L=0.13u W=1u AS=0.265p AD=0.265p PS=2.56u
+ PD=2.56u rfmode=0
M$17447 \$4544 \$4386 OUTP|analog_io_padres[16]|core|padres
+ VSS|anode|cathode|vss sg13_lv_nmos L=0.13u W=2u AS=0.38p AD=0.38p PS=3.52u
+ PD=3.52u rfmode=0
M$17449 \$4544 \$4388 OUTN|analog_io_padres[15]|core|padres
+ VSS|anode|cathode|vss sg13_lv_nmos L=0.13u W=2u AS=0.38p AD=0.38p PS=3.52u
+ PD=3.52u rfmode=0
M$17456 VSS|anode|cathode|vss \$3195 \$4700 VSS|anode|cathode|vss sg13_lv_nmos
+ L=0.13u W=0.55u AS=0.187p AD=0.1045p PS=1.78u PD=0.93u rfmode=0
M$17457 \$4700 \$3439 VSS|anode|cathode|vss VSS|anode|cathode|vss sg13_lv_nmos
+ L=0.13u W=0.55u AS=0.1045p AD=0.146425p PS=0.93u PD=1.155u rfmode=0
M$17458 VSS|anode|cathode|vss \$4700 \$4701 VSS|anode|cathode|vss sg13_lv_nmos
+ L=0.13u W=1.48u AS=0.312925p AD=0.4477p PS=2.345u PD=3.43u rfmode=0
M$17460 \$4703 \$4757 \$4797 VSS|anode|cathode|vss sg13_lv_nmos L=0.13u W=0.42u
+ AS=0.1428p AD=0.0609p PS=1.52u PD=0.71u rfmode=0
M$17461 \$4797 VDD VSS|anode|cathode|vss VSS|anode|cathode|vss sg13_lv_nmos
+ L=0.13u W=0.42u AS=0.0609p AD=0.1626p PS=0.71u PD=1.415u rfmode=0
M$17462 VSS|anode|cathode|vss \$4807 \$4663 VSS|anode|cathode|vss sg13_lv_nmos
+ L=0.13u W=0.74u AS=0.1626p AD=0.2516p PS=1.415u PD=2.16u rfmode=0
M$17463 \$4392 \$4393 \$4501 VSS|anode|cathode|vss sg13_lv_nmos L=0.13u W=0.42u
+ AS=0.1296p AD=0.081p PS=1.52u PD=0.81u rfmode=0
M$17464 \$4501 \$4502 \$4447 VSS|anode|cathode|vss sg13_lv_nmos L=0.13u W=0.42u
+ AS=0.081p AD=0.2163p PS=0.81u PD=1.87u rfmode=0
M$17465 \$4705 \$4808 VSS|anode|cathode|vss VSS|anode|cathode|vss sg13_lv_nmos
+ L=0.13u W=0.42u AS=0.1428p AD=0.0798p PS=1.52u PD=0.8u rfmode=0
M$17466 VSS|anode|cathode|vss VDD \$4796 VSS|anode|cathode|vss sg13_lv_nmos
+ L=0.13u W=0.42u AS=0.0798p AD=0.0378p PS=0.8u PD=0.6u rfmode=0
M$17467 \$4796 \$4759 \$4808 VSS|anode|cathode|vss sg13_lv_nmos L=0.13u W=0.42u
+ AS=0.0378p AD=0.1428p PS=0.6u PD=1.52u rfmode=0
M$17468 VSS|anode|cathode|vss \$4759 \$4707 VSS|anode|cathode|vss sg13_lv_nmos
+ L=0.13u W=0.64u AS=0.1331p AD=0.2176p PS=1.12u PD=1.96u rfmode=0
M$17469 VSS|anode|cathode|vss \$4759 \$4706 VSS|anode|cathode|vss sg13_lv_nmos
+ L=0.13u W=1.48u AS=0.3922p AD=0.2737p PS=3.28u PD=2.24u rfmode=0
M$17471 VSS|anode|cathode|vss \$4707 \$4708 VSS|anode|cathode|vss sg13_lv_nmos
+ L=0.13u W=1.48u AS=0.3922p AD=0.3922p PS=3.28u PD=3.28u rfmode=0
M$17473 VSS|anode|cathode|vss VSS|anode|cathode|vss \$4545
+ VSS|anode|cathode|vss sg13_lv_nmos L=0.13u W=1u AS=0.265p AD=0.265p PS=2.56u
+ PD=2.56u rfmode=0
M$17474 \$4545 \$4395 OUTP|analog_io_padres[16]|core|padres
+ VSS|anode|cathode|vss sg13_lv_nmos L=0.13u W=2u AS=0.38p AD=0.38p PS=3.52u
+ PD=3.52u rfmode=0
M$17476 \$4545 \$4397 OUTN|analog_io_padres[15]|core|padres
+ VSS|anode|cathode|vss sg13_lv_nmos L=0.13u W=2u AS=0.38p AD=0.38p PS=3.52u
+ PD=3.52u rfmode=0
M$17483 VSS|anode|cathode|vss \$3196 \$4709 VSS|anode|cathode|vss sg13_lv_nmos
+ L=0.13u W=0.55u AS=0.187p AD=0.1045p PS=1.78u PD=0.93u rfmode=0
M$17484 \$4709 \$3439 VSS|anode|cathode|vss VSS|anode|cathode|vss sg13_lv_nmos
+ L=0.13u W=0.55u AS=0.1045p AD=0.146425p PS=0.93u PD=1.155u rfmode=0
M$17485 VSS|anode|cathode|vss \$4709 \$4710 VSS|anode|cathode|vss sg13_lv_nmos
+ L=0.13u W=1.48u AS=0.312925p AD=0.4477p PS=2.345u PD=3.43u rfmode=0
M$17487 \$4712 \$4761 \$4791 VSS|anode|cathode|vss sg13_lv_nmos L=0.13u W=0.42u
+ AS=0.1428p AD=0.0609p PS=1.52u PD=0.71u rfmode=0
M$17488 \$4791 VDD VSS|anode|cathode|vss VSS|anode|cathode|vss sg13_lv_nmos
+ L=0.13u W=0.42u AS=0.0609p AD=0.1626p PS=0.71u PD=1.415u rfmode=0
M$17489 VSS|anode|cathode|vss \$4809 \$4665 VSS|anode|cathode|vss sg13_lv_nmos
+ L=0.13u W=0.74u AS=0.1626p AD=0.2516p PS=1.415u PD=2.16u rfmode=0
M$17490 \$4401 \$4402 \$4504 VSS|anode|cathode|vss sg13_lv_nmos L=0.13u W=0.42u
+ AS=0.1296p AD=0.081p PS=1.52u PD=0.81u rfmode=0
M$17491 \$4504 \$4505 \$4451 VSS|anode|cathode|vss sg13_lv_nmos L=0.13u W=0.42u
+ AS=0.081p AD=0.2163p PS=0.81u PD=1.87u rfmode=0
M$17492 \$4714 \$4810 VSS|anode|cathode|vss VSS|anode|cathode|vss sg13_lv_nmos
+ L=0.13u W=0.42u AS=0.1428p AD=0.0798p PS=1.52u PD=0.8u rfmode=0
M$17493 VSS|anode|cathode|vss VDD \$4789 VSS|anode|cathode|vss sg13_lv_nmos
+ L=0.13u W=0.42u AS=0.0798p AD=0.0378p PS=0.8u PD=0.6u rfmode=0
M$17494 \$4789 \$4763 \$4810 VSS|anode|cathode|vss sg13_lv_nmos L=0.13u W=0.42u
+ AS=0.0378p AD=0.1428p PS=0.6u PD=1.52u rfmode=0
M$17495 VSS|anode|cathode|vss \$4763 \$4716 VSS|anode|cathode|vss sg13_lv_nmos
+ L=0.13u W=0.64u AS=0.1331p AD=0.2176p PS=1.12u PD=1.96u rfmode=0
M$17496 VSS|anode|cathode|vss \$4763 \$4715 VSS|anode|cathode|vss sg13_lv_nmos
+ L=0.13u W=1.48u AS=0.3922p AD=0.2737p PS=3.28u PD=2.24u rfmode=0
M$17498 VSS|anode|cathode|vss \$4716 \$4717 VSS|anode|cathode|vss sg13_lv_nmos
+ L=0.13u W=1.48u AS=0.3922p AD=0.3922p PS=3.28u PD=3.28u rfmode=0
M$17500 VSS|anode|cathode|vss VSS|anode|cathode|vss \$4546
+ VSS|anode|cathode|vss sg13_lv_nmos L=0.13u W=1u AS=0.265p AD=0.265p PS=2.56u
+ PD=2.56u rfmode=0
M$17501 \$4546 \$4404 OUTP|analog_io_padres[16]|core|padres
+ VSS|anode|cathode|vss sg13_lv_nmos L=0.13u W=2u AS=0.38p AD=0.38p PS=3.52u
+ PD=3.52u rfmode=0
M$17503 \$4546 \$4406 OUTN|analog_io_padres[15]|core|padres
+ VSS|anode|cathode|vss sg13_lv_nmos L=0.13u W=2u AS=0.38p AD=0.38p PS=3.52u
+ PD=3.52u rfmode=0
M$17510 VSS|anode|cathode|vss \$3197 \$4718 VSS|anode|cathode|vss sg13_lv_nmos
+ L=0.13u W=0.55u AS=0.187p AD=0.1045p PS=1.78u PD=0.93u rfmode=0
M$17511 \$4718 \$3439 VSS|anode|cathode|vss VSS|anode|cathode|vss sg13_lv_nmos
+ L=0.13u W=0.55u AS=0.1045p AD=0.146425p PS=0.93u PD=1.155u rfmode=0
M$17512 VSS|anode|cathode|vss \$4718 \$4719 VSS|anode|cathode|vss sg13_lv_nmos
+ L=0.13u W=1.48u AS=0.312925p AD=0.4477p PS=2.345u PD=3.43u rfmode=0
M$17514 \$4721 \$4765 \$4788 VSS|anode|cathode|vss sg13_lv_nmos L=0.13u W=0.42u
+ AS=0.1428p AD=0.0609p PS=1.52u PD=0.71u rfmode=0
M$17515 \$4788 VDD VSS|anode|cathode|vss VSS|anode|cathode|vss sg13_lv_nmos
+ L=0.13u W=0.42u AS=0.0609p AD=0.1626p PS=0.71u PD=1.415u rfmode=0
M$17516 VSS|anode|cathode|vss \$4811 \$4667 VSS|anode|cathode|vss sg13_lv_nmos
+ L=0.13u W=0.74u AS=0.1626p AD=0.2516p PS=1.415u PD=2.16u rfmode=0
M$17517 \$4410 \$4411 \$4507 VSS|anode|cathode|vss sg13_lv_nmos L=0.13u W=0.42u
+ AS=0.1296p AD=0.081p PS=1.52u PD=0.81u rfmode=0
M$17518 \$4507 \$4508 \$4455 VSS|anode|cathode|vss sg13_lv_nmos L=0.13u W=0.42u
+ AS=0.081p AD=0.2163p PS=0.81u PD=1.87u rfmode=0
M$17519 \$4723 \$4812 VSS|anode|cathode|vss VSS|anode|cathode|vss sg13_lv_nmos
+ L=0.13u W=0.42u AS=0.1428p AD=0.0798p PS=1.52u PD=0.8u rfmode=0
M$17520 VSS|anode|cathode|vss VDD \$4787 VSS|anode|cathode|vss sg13_lv_nmos
+ L=0.13u W=0.42u AS=0.0798p AD=0.0378p PS=0.8u PD=0.6u rfmode=0
M$17521 \$4787 \$4767 \$4812 VSS|anode|cathode|vss sg13_lv_nmos L=0.13u W=0.42u
+ AS=0.0378p AD=0.1428p PS=0.6u PD=1.52u rfmode=0
M$17522 VSS|anode|cathode|vss \$4767 \$4725 VSS|anode|cathode|vss sg13_lv_nmos
+ L=0.13u W=0.64u AS=0.1331p AD=0.2176p PS=1.12u PD=1.96u rfmode=0
M$17523 VSS|anode|cathode|vss \$4767 \$4724 VSS|anode|cathode|vss sg13_lv_nmos
+ L=0.13u W=1.48u AS=0.3922p AD=0.2737p PS=3.28u PD=2.24u rfmode=0
M$17525 VSS|anode|cathode|vss \$4725 \$4726 VSS|anode|cathode|vss sg13_lv_nmos
+ L=0.13u W=1.48u AS=0.3922p AD=0.3922p PS=3.28u PD=3.28u rfmode=0
M$17527 VSS|anode|cathode|vss VSS|anode|cathode|vss \$4547
+ VSS|anode|cathode|vss sg13_lv_nmos L=0.13u W=1u AS=0.265p AD=0.265p PS=2.56u
+ PD=2.56u rfmode=0
M$17528 \$4547 \$4413 OUTP|analog_io_padres[16]|core|padres
+ VSS|anode|cathode|vss sg13_lv_nmos L=0.13u W=2u AS=0.38p AD=0.38p PS=3.52u
+ PD=3.52u rfmode=0
M$17530 \$4547 \$4415 OUTN|analog_io_padres[15]|core|padres
+ VSS|anode|cathode|vss sg13_lv_nmos L=0.13u W=2u AS=0.38p AD=0.38p PS=3.52u
+ PD=3.52u rfmode=0
M$17537 VSS|anode|cathode|vss \$3198 \$4727 VSS|anode|cathode|vss sg13_lv_nmos
+ L=0.13u W=0.55u AS=0.187p AD=0.1045p PS=1.78u PD=0.93u rfmode=0
M$17538 \$4727 \$3439 VSS|anode|cathode|vss VSS|anode|cathode|vss sg13_lv_nmos
+ L=0.13u W=0.55u AS=0.1045p AD=0.146425p PS=0.93u PD=1.155u rfmode=0
M$17539 VSS|anode|cathode|vss \$4727 \$4728 VSS|anode|cathode|vss sg13_lv_nmos
+ L=0.13u W=1.48u AS=0.312925p AD=0.4477p PS=2.345u PD=3.43u rfmode=0
M$17541 \$4730 \$4769 \$4781 VSS|anode|cathode|vss sg13_lv_nmos L=0.13u W=0.42u
+ AS=0.1428p AD=0.0609p PS=1.52u PD=0.71u rfmode=0
M$17542 \$4781 VDD VSS|anode|cathode|vss VSS|anode|cathode|vss sg13_lv_nmos
+ L=0.13u W=0.42u AS=0.0609p AD=0.1626p PS=0.71u PD=1.415u rfmode=0
M$17543 VSS|anode|cathode|vss \$4813 \$4669 VSS|anode|cathode|vss sg13_lv_nmos
+ L=0.13u W=0.74u AS=0.1626p AD=0.2516p PS=1.415u PD=2.16u rfmode=0
M$17544 \$4419 \$4420 \$4510 VSS|anode|cathode|vss sg13_lv_nmos L=0.13u W=0.42u
+ AS=0.1296p AD=0.081p PS=1.52u PD=0.81u rfmode=0
M$17545 \$4510 \$4511 \$4459 VSS|anode|cathode|vss sg13_lv_nmos L=0.13u W=0.42u
+ AS=0.081p AD=0.2163p PS=0.81u PD=1.87u rfmode=0
M$17546 \$4732 \$4814 VSS|anode|cathode|vss VSS|anode|cathode|vss sg13_lv_nmos
+ L=0.13u W=0.42u AS=0.1428p AD=0.0798p PS=1.52u PD=0.8u rfmode=0
M$17547 VSS|anode|cathode|vss VDD \$4780 VSS|anode|cathode|vss sg13_lv_nmos
+ L=0.13u W=0.42u AS=0.0798p AD=0.0378p PS=0.8u PD=0.6u rfmode=0
M$17548 \$4780 \$4771 \$4814 VSS|anode|cathode|vss sg13_lv_nmos L=0.13u W=0.42u
+ AS=0.0378p AD=0.1428p PS=0.6u PD=1.52u rfmode=0
M$17549 VSS|anode|cathode|vss \$4771 \$4734 VSS|anode|cathode|vss sg13_lv_nmos
+ L=0.13u W=0.64u AS=0.1331p AD=0.2176p PS=1.12u PD=1.96u rfmode=0
M$17550 VSS|anode|cathode|vss \$4771 \$4733 VSS|anode|cathode|vss sg13_lv_nmos
+ L=0.13u W=1.48u AS=0.3922p AD=0.2737p PS=3.28u PD=2.24u rfmode=0
M$17552 VSS|anode|cathode|vss \$4734 \$4735 VSS|anode|cathode|vss sg13_lv_nmos
+ L=0.13u W=1.48u AS=0.3922p AD=0.3922p PS=3.28u PD=3.28u rfmode=0
M$17554 VSS|anode|cathode|vss VSS|anode|cathode|vss \$4548
+ VSS|anode|cathode|vss sg13_lv_nmos L=0.13u W=1u AS=0.265p AD=0.265p PS=2.56u
+ PD=2.56u rfmode=0
M$17555 \$4548 \$4422 OUTP|analog_io_padres[16]|core|padres
+ VSS|anode|cathode|vss sg13_lv_nmos L=0.13u W=2u AS=0.38p AD=0.38p PS=3.52u
+ PD=3.52u rfmode=0
M$17557 \$4548 \$4424 OUTN|analog_io_padres[15]|core|padres
+ VSS|anode|cathode|vss sg13_lv_nmos L=0.13u W=2u AS=0.38p AD=0.38p PS=3.52u
+ PD=3.52u rfmode=0
M$17564 VSS|anode|cathode|vss VSS|anode|cathode|vss \$4736
+ VSS|anode|cathode|vss sg13_lv_nmos L=0.13u W=0.55u AS=0.187p AD=0.1045p
+ PS=1.78u PD=0.93u rfmode=0
M$17565 \$4736 \$3439 VSS|anode|cathode|vss VSS|anode|cathode|vss sg13_lv_nmos
+ L=0.13u W=0.55u AS=0.1045p AD=0.146425p PS=0.93u PD=1.155u rfmode=0
M$17566 VSS|anode|cathode|vss \$4736 \$4737 VSS|anode|cathode|vss sg13_lv_nmos
+ L=0.13u W=1.48u AS=0.312925p AD=0.4477p PS=2.345u PD=3.43u rfmode=0
M$17568 \$4739 \$4773 \$4779 VSS|anode|cathode|vss sg13_lv_nmos L=0.13u W=0.42u
+ AS=0.1428p AD=0.0609p PS=1.52u PD=0.71u rfmode=0
M$17569 \$4779 VDD VSS|anode|cathode|vss VSS|anode|cathode|vss sg13_lv_nmos
+ L=0.13u W=0.42u AS=0.0609p AD=0.1626p PS=0.71u PD=1.415u rfmode=0
M$17570 VSS|anode|cathode|vss \$4815 \$4671 VSS|anode|cathode|vss sg13_lv_nmos
+ L=0.13u W=0.74u AS=0.1626p AD=0.2516p PS=1.415u PD=2.16u rfmode=0
M$17571 \$4428 \$4429 \$4513 VSS|anode|cathode|vss sg13_lv_nmos L=0.13u W=0.42u
+ AS=0.1296p AD=0.081p PS=1.52u PD=0.81u rfmode=0
M$17572 \$4513 \$4514 \$4463 VSS|anode|cathode|vss sg13_lv_nmos L=0.13u W=0.42u
+ AS=0.081p AD=0.2163p PS=0.81u PD=1.87u rfmode=0
M$17573 \$4741 \$4816 VSS|anode|cathode|vss VSS|anode|cathode|vss sg13_lv_nmos
+ L=0.13u W=0.42u AS=0.1428p AD=0.0798p PS=1.52u PD=0.8u rfmode=0
M$17574 VSS|anode|cathode|vss VDD \$4778 VSS|anode|cathode|vss sg13_lv_nmos
+ L=0.13u W=0.42u AS=0.0798p AD=0.0378p PS=0.8u PD=0.6u rfmode=0
M$17575 \$4778 \$4775 \$4816 VSS|anode|cathode|vss sg13_lv_nmos L=0.13u W=0.42u
+ AS=0.0378p AD=0.1428p PS=0.6u PD=1.52u rfmode=0
M$17576 VSS|anode|cathode|vss \$4775 \$4743 VSS|anode|cathode|vss sg13_lv_nmos
+ L=0.13u W=0.64u AS=0.1331p AD=0.2176p PS=1.12u PD=1.96u rfmode=0
M$17577 VSS|anode|cathode|vss \$4775 \$4742 VSS|anode|cathode|vss sg13_lv_nmos
+ L=0.13u W=1.48u AS=0.3922p AD=0.2737p PS=3.28u PD=2.24u rfmode=0
M$17579 VSS|anode|cathode|vss \$4743 \$4744 VSS|anode|cathode|vss sg13_lv_nmos
+ L=0.13u W=1.48u AS=0.3922p AD=0.3922p PS=3.28u PD=3.28u rfmode=0
M$17581 VSS|anode|cathode|vss VSS|anode|cathode|vss \$4549
+ VSS|anode|cathode|vss sg13_lv_nmos L=0.13u W=1u AS=0.265p AD=0.265p PS=2.56u
+ PD=2.56u rfmode=0
M$17582 \$4549 \$4431 OUTP|analog_io_padres[16]|core|padres
+ VSS|anode|cathode|vss sg13_lv_nmos L=0.13u W=2u AS=0.38p AD=0.38p PS=3.52u
+ PD=3.52u rfmode=0
M$17584 \$4549 \$4433 OUTN|analog_io_padres[15]|core|padres
+ VSS|anode|cathode|vss sg13_lv_nmos L=0.13u W=2u AS=0.38p AD=0.38p PS=3.52u
+ PD=3.52u rfmode=0
M$17591 \$4675 \$4674 VSS|anode|cathode|vss VSS|anode|cathode|vss sg13_lv_nmos
+ L=0.13u W=1.44u AS=0.4068p AD=0.2772p PS=3.29u PD=2.21u rfmode=0
M$17593 \$4675 \$3396 \$4745 VSS|anode|cathode|vss sg13_lv_nmos L=0.13u W=1.44u
+ AS=0.2772p AD=0.3816p PS=2.21u PD=3.22u rfmode=0
M$17595 VSS|anode|cathode|vss VDD \$4783 VSS|anode|cathode|vss sg13_lv_nmos
+ L=0.13u W=0.42u AS=0.1701p AD=0.03885p PS=1.65u PD=0.605u rfmode=0
M$17596 \$4783 \$4657 \$4677 VSS|anode|cathode|vss sg13_lv_nmos L=0.13u W=0.42u
+ AS=0.03885p AD=0.1596p PS=0.605u PD=1.6u rfmode=0
M$17597 VSS|anode|cathode|vss \$4658 \$4746 VSS|anode|cathode|vss sg13_lv_nmos
+ L=0.13u W=0.74u AS=0.43315p AD=0.2516p PS=2.205u PD=2.16u rfmode=0
M$17598 VSS|anode|cathode|vss CLK|clk|core|fclk_in|p2c|ui_p2c[6] \$4658
+ VSS|anode|cathode|vss sg13_lv_nmos L=0.13u W=0.74u AS=0.43315p AD=0.2516p
+ PS=2.205u PD=2.16u rfmode=0
M$17599 \$4747 \$4658 \$4678 VSS|anode|cathode|vss sg13_lv_nmos L=0.13u W=0.42u
+ AS=0.12665p AD=0.1428p PS=1.145u PD=1.52u rfmode=0
M$17600 \$4657 \$4746 \$4747 VSS|anode|cathode|vss sg13_lv_nmos L=0.13u W=0.74u
+ AS=0.3473p AD=0.12665p PS=2.71u PD=1.145u rfmode=0
M$17601 \$4684 \$4683 VSS|anode|cathode|vss VSS|anode|cathode|vss sg13_lv_nmos
+ L=0.13u W=1.44u AS=0.4068p AD=0.2772p PS=3.29u PD=2.21u rfmode=0
M$17603 \$4684 \$3396 \$4749 VSS|anode|cathode|vss sg13_lv_nmos L=0.13u W=1.44u
+ AS=0.2772p AD=0.3816p PS=2.21u PD=3.22u rfmode=0
M$17605 VSS|anode|cathode|vss VDD \$4795 VSS|anode|cathode|vss sg13_lv_nmos
+ L=0.13u W=0.42u AS=0.1701p AD=0.03885p PS=1.65u PD=0.605u rfmode=0
M$17606 \$4795 \$4659 \$4686 VSS|anode|cathode|vss sg13_lv_nmos L=0.13u W=0.42u
+ AS=0.03885p AD=0.1596p PS=0.605u PD=1.6u rfmode=0
M$17607 VSS|anode|cathode|vss \$4660 \$4750 VSS|anode|cathode|vss sg13_lv_nmos
+ L=0.13u W=0.74u AS=0.43315p AD=0.2516p PS=2.205u PD=2.16u rfmode=0
M$17608 VSS|anode|cathode|vss CLK|clk|core|fclk_in|p2c|ui_p2c[6] \$4660
+ VSS|anode|cathode|vss sg13_lv_nmos L=0.13u W=0.74u AS=0.43315p AD=0.2516p
+ PS=2.205u PD=2.16u rfmode=0
M$17609 \$4751 \$4660 \$4687 VSS|anode|cathode|vss sg13_lv_nmos L=0.13u W=0.42u
+ AS=0.12665p AD=0.1428p PS=1.145u PD=1.52u rfmode=0
M$17610 \$4659 \$4750 \$4751 VSS|anode|cathode|vss sg13_lv_nmos L=0.13u W=0.74u
+ AS=0.3473p AD=0.12665p PS=2.71u PD=1.145u rfmode=0
M$17611 \$4693 \$4692 VSS|anode|cathode|vss VSS|anode|cathode|vss sg13_lv_nmos
+ L=0.13u W=1.44u AS=0.4068p AD=0.2772p PS=3.29u PD=2.21u rfmode=0
M$17613 \$4693 \$3396 \$4753 VSS|anode|cathode|vss sg13_lv_nmos L=0.13u W=1.44u
+ AS=0.2772p AD=0.3816p PS=2.21u PD=3.22u rfmode=0
M$17615 VSS|anode|cathode|vss VDD \$4800 VSS|anode|cathode|vss sg13_lv_nmos
+ L=0.13u W=0.42u AS=0.1701p AD=0.03885p PS=1.65u PD=0.605u rfmode=0
M$17616 \$4800 \$4661 \$4695 VSS|anode|cathode|vss sg13_lv_nmos L=0.13u W=0.42u
+ AS=0.03885p AD=0.1596p PS=0.605u PD=1.6u rfmode=0
M$17617 VSS|anode|cathode|vss \$4662 \$4754 VSS|anode|cathode|vss sg13_lv_nmos
+ L=0.13u W=0.74u AS=0.43315p AD=0.2516p PS=2.205u PD=2.16u rfmode=0
M$17618 VSS|anode|cathode|vss CLK|clk|core|fclk_in|p2c|ui_p2c[6] \$4662
+ VSS|anode|cathode|vss sg13_lv_nmos L=0.13u W=0.74u AS=0.43315p AD=0.2516p
+ PS=2.205u PD=2.16u rfmode=0
M$17619 \$4755 \$4662 \$4696 VSS|anode|cathode|vss sg13_lv_nmos L=0.13u W=0.42u
+ AS=0.12665p AD=0.1428p PS=1.145u PD=1.52u rfmode=0
M$17620 \$4661 \$4754 \$4755 VSS|anode|cathode|vss sg13_lv_nmos L=0.13u W=0.74u
+ AS=0.3473p AD=0.12665p PS=2.71u PD=1.145u rfmode=0
M$17621 \$4702 \$4701 VSS|anode|cathode|vss VSS|anode|cathode|vss sg13_lv_nmos
+ L=0.13u W=1.44u AS=0.4068p AD=0.2772p PS=3.29u PD=2.21u rfmode=0
M$17623 \$4702 \$3396 \$4757 VSS|anode|cathode|vss sg13_lv_nmos L=0.13u W=1.44u
+ AS=0.2772p AD=0.3816p PS=2.21u PD=3.22u rfmode=0
M$17625 VSS|anode|cathode|vss VDD \$4794 VSS|anode|cathode|vss sg13_lv_nmos
+ L=0.13u W=0.42u AS=0.1701p AD=0.03885p PS=1.65u PD=0.605u rfmode=0
M$17626 \$4794 \$4663 \$4704 VSS|anode|cathode|vss sg13_lv_nmos L=0.13u W=0.42u
+ AS=0.03885p AD=0.1596p PS=0.605u PD=1.6u rfmode=0
M$17627 VSS|anode|cathode|vss \$4664 \$4758 VSS|anode|cathode|vss sg13_lv_nmos
+ L=0.13u W=0.74u AS=0.43315p AD=0.2516p PS=2.205u PD=2.16u rfmode=0
M$17628 VSS|anode|cathode|vss CLK|clk|core|fclk_in|p2c|ui_p2c[6] \$4664
+ VSS|anode|cathode|vss sg13_lv_nmos L=0.13u W=0.74u AS=0.43315p AD=0.2516p
+ PS=2.205u PD=2.16u rfmode=0
M$17629 \$4759 \$4664 \$4705 VSS|anode|cathode|vss sg13_lv_nmos L=0.13u W=0.42u
+ AS=0.12665p AD=0.1428p PS=1.145u PD=1.52u rfmode=0
M$17630 \$4663 \$4758 \$4759 VSS|anode|cathode|vss sg13_lv_nmos L=0.13u W=0.74u
+ AS=0.3473p AD=0.12665p PS=2.71u PD=1.145u rfmode=0
M$17631 \$4711 \$4710 VSS|anode|cathode|vss VSS|anode|cathode|vss sg13_lv_nmos
+ L=0.13u W=1.44u AS=0.4068p AD=0.2772p PS=3.29u PD=2.21u rfmode=0
M$17633 \$4711 \$3396 \$4761 VSS|anode|cathode|vss sg13_lv_nmos L=0.13u W=1.44u
+ AS=0.2772p AD=0.3816p PS=2.21u PD=3.22u rfmode=0
M$17635 VSS|anode|cathode|vss VDD \$4792 VSS|anode|cathode|vss sg13_lv_nmos
+ L=0.13u W=0.42u AS=0.1701p AD=0.03885p PS=1.65u PD=0.605u rfmode=0
M$17636 \$4792 \$4665 \$4713 VSS|anode|cathode|vss sg13_lv_nmos L=0.13u W=0.42u
+ AS=0.03885p AD=0.1596p PS=0.605u PD=1.6u rfmode=0
M$17637 VSS|anode|cathode|vss \$4666 \$4762 VSS|anode|cathode|vss sg13_lv_nmos
+ L=0.13u W=0.74u AS=0.43315p AD=0.2516p PS=2.205u PD=2.16u rfmode=0
M$17638 VSS|anode|cathode|vss CLK|clk|core|fclk_in|p2c|ui_p2c[6] \$4666
+ VSS|anode|cathode|vss sg13_lv_nmos L=0.13u W=0.74u AS=0.43315p AD=0.2516p
+ PS=2.205u PD=2.16u rfmode=0
M$17639 \$4763 \$4666 \$4714 VSS|anode|cathode|vss sg13_lv_nmos L=0.13u W=0.42u
+ AS=0.12665p AD=0.1428p PS=1.145u PD=1.52u rfmode=0
M$17640 \$4665 \$4762 \$4763 VSS|anode|cathode|vss sg13_lv_nmos L=0.13u W=0.74u
+ AS=0.3473p AD=0.12665p PS=2.71u PD=1.145u rfmode=0
M$17641 \$4720 \$4719 VSS|anode|cathode|vss VSS|anode|cathode|vss sg13_lv_nmos
+ L=0.13u W=1.44u AS=0.4068p AD=0.2772p PS=3.29u PD=2.21u rfmode=0
M$17643 \$4720 \$3396 \$4765 VSS|anode|cathode|vss sg13_lv_nmos L=0.13u W=1.44u
+ AS=0.2772p AD=0.3816p PS=2.21u PD=3.22u rfmode=0
M$17645 VSS|anode|cathode|vss VDD \$4785 VSS|anode|cathode|vss sg13_lv_nmos
+ L=0.13u W=0.42u AS=0.1701p AD=0.03885p PS=1.65u PD=0.605u rfmode=0
M$17646 \$4785 \$4667 \$4722 VSS|anode|cathode|vss sg13_lv_nmos L=0.13u W=0.42u
+ AS=0.03885p AD=0.1596p PS=0.605u PD=1.6u rfmode=0
M$17647 VSS|anode|cathode|vss \$4668 \$4766 VSS|anode|cathode|vss sg13_lv_nmos
+ L=0.13u W=0.74u AS=0.43315p AD=0.2516p PS=2.205u PD=2.16u rfmode=0
M$17648 VSS|anode|cathode|vss CLK|clk|core|fclk_in|p2c|ui_p2c[6] \$4668
+ VSS|anode|cathode|vss sg13_lv_nmos L=0.13u W=0.74u AS=0.43315p AD=0.2516p
+ PS=2.205u PD=2.16u rfmode=0
M$17649 \$4767 \$4668 \$4723 VSS|anode|cathode|vss sg13_lv_nmos L=0.13u W=0.42u
+ AS=0.12665p AD=0.1428p PS=1.145u PD=1.52u rfmode=0
M$17650 \$4667 \$4766 \$4767 VSS|anode|cathode|vss sg13_lv_nmos L=0.13u W=0.74u
+ AS=0.3473p AD=0.12665p PS=2.71u PD=1.145u rfmode=0
M$17651 \$4729 \$4728 VSS|anode|cathode|vss VSS|anode|cathode|vss sg13_lv_nmos
+ L=0.13u W=1.44u AS=0.4068p AD=0.2772p PS=3.29u PD=2.21u rfmode=0
M$17653 \$4729 \$3396 \$4769 VSS|anode|cathode|vss sg13_lv_nmos L=0.13u W=1.44u
+ AS=0.2772p AD=0.3816p PS=2.21u PD=3.22u rfmode=0
M$17655 VSS|anode|cathode|vss VDD \$4782 VSS|anode|cathode|vss sg13_lv_nmos
+ L=0.13u W=0.42u AS=0.1701p AD=0.03885p PS=1.65u PD=0.605u rfmode=0
M$17656 \$4782 \$4669 \$4731 VSS|anode|cathode|vss sg13_lv_nmos L=0.13u W=0.42u
+ AS=0.03885p AD=0.1596p PS=0.605u PD=1.6u rfmode=0
M$17657 VSS|anode|cathode|vss \$4670 \$4770 VSS|anode|cathode|vss sg13_lv_nmos
+ L=0.13u W=0.74u AS=0.43315p AD=0.2516p PS=2.205u PD=2.16u rfmode=0
M$17658 VSS|anode|cathode|vss CLK|clk|core|fclk_in|p2c|ui_p2c[6] \$4670
+ VSS|anode|cathode|vss sg13_lv_nmos L=0.13u W=0.74u AS=0.43315p AD=0.2516p
+ PS=2.205u PD=2.16u rfmode=0
M$17659 \$4771 \$4670 \$4732 VSS|anode|cathode|vss sg13_lv_nmos L=0.13u W=0.42u
+ AS=0.12665p AD=0.1428p PS=1.145u PD=1.52u rfmode=0
M$17660 \$4669 \$4770 \$4771 VSS|anode|cathode|vss sg13_lv_nmos L=0.13u W=0.74u
+ AS=0.3473p AD=0.12665p PS=2.71u PD=1.145u rfmode=0
M$17661 \$4738 \$4737 VSS|anode|cathode|vss VSS|anode|cathode|vss sg13_lv_nmos
+ L=0.13u W=1.44u AS=0.4068p AD=0.2772p PS=3.29u PD=2.21u rfmode=0
M$17663 \$4738 \$3396 \$4773 VSS|anode|cathode|vss sg13_lv_nmos L=0.13u W=1.44u
+ AS=0.2772p AD=0.3816p PS=2.21u PD=3.22u rfmode=0
M$17665 VSS|anode|cathode|vss VDD \$4777 VSS|anode|cathode|vss sg13_lv_nmos
+ L=0.13u W=0.42u AS=0.1701p AD=0.03885p PS=1.65u PD=0.605u rfmode=0
M$17666 \$4777 \$4671 \$4740 VSS|anode|cathode|vss sg13_lv_nmos L=0.13u W=0.42u
+ AS=0.03885p AD=0.1596p PS=0.605u PD=1.6u rfmode=0
M$17667 VSS|anode|cathode|vss \$4672 \$4774 VSS|anode|cathode|vss sg13_lv_nmos
+ L=0.13u W=0.74u AS=0.43315p AD=0.2516p PS=2.205u PD=2.16u rfmode=0
M$17668 VSS|anode|cathode|vss CLK|clk|core|fclk_in|p2c|ui_p2c[6] \$4672
+ VSS|anode|cathode|vss sg13_lv_nmos L=0.13u W=0.74u AS=0.43315p AD=0.2516p
+ PS=2.205u PD=2.16u rfmode=0
M$17669 \$4775 \$4672 \$4741 VSS|anode|cathode|vss sg13_lv_nmos L=0.13u W=0.42u
+ AS=0.12665p AD=0.1428p PS=1.145u PD=1.52u rfmode=0
M$17670 \$4671 \$4774 \$4775 VSS|anode|cathode|vss sg13_lv_nmos L=0.13u W=0.74u
+ AS=0.3473p AD=0.12665p PS=2.71u PD=1.145u rfmode=0
M$17671 VSS|anode|cathode|vss \$3192 \$4961 VSS|anode|cathode|vss sg13_lv_nmos
+ L=0.13u W=0.55u AS=0.187p AD=0.1045p PS=1.78u PD=0.93u rfmode=0
M$17672 \$4961 \$3685 VSS|anode|cathode|vss VSS|anode|cathode|vss sg13_lv_nmos
+ L=0.13u W=0.55u AS=0.1045p AD=0.146425p PS=0.93u PD=1.155u rfmode=0
M$17673 VSS|anode|cathode|vss \$4961 \$4962 VSS|anode|cathode|vss sg13_lv_nmos
+ L=0.13u W=1.48u AS=0.312925p AD=0.4477p PS=2.345u PD=3.43u rfmode=0
M$17675 \$4964 \$5030 \$5055 VSS|anode|cathode|vss sg13_lv_nmos L=0.13u W=0.42u
+ AS=0.1428p AD=0.0609p PS=1.52u PD=0.71u rfmode=0
M$17676 \$5055 VDD VSS|anode|cathode|vss VSS|anode|cathode|vss sg13_lv_nmos
+ L=0.13u W=0.42u AS=0.0609p AD=0.1626p PS=0.71u PD=1.415u rfmode=0
M$17677 VSS|anode|cathode|vss \$5078 \$4945 VSS|anode|cathode|vss sg13_lv_nmos
+ L=0.13u W=0.74u AS=0.1626p AD=0.2516p PS=1.415u PD=2.16u rfmode=0
M$17678 \$4676 \$4658 \$4801 VSS|anode|cathode|vss sg13_lv_nmos L=0.13u W=0.42u
+ AS=0.1296p AD=0.081p PS=1.52u PD=0.81u rfmode=0
M$17679 \$4801 \$4746 \$4677 VSS|anode|cathode|vss sg13_lv_nmos L=0.13u W=0.42u
+ AS=0.081p AD=0.2163p PS=0.81u PD=1.87u rfmode=0
M$17680 \$4966 \$5079 VSS|anode|cathode|vss VSS|anode|cathode|vss sg13_lv_nmos
+ L=0.13u W=0.42u AS=0.1428p AD=0.0798p PS=1.52u PD=0.8u rfmode=0
M$17681 VSS|anode|cathode|vss VDD \$5057 VSS|anode|cathode|vss sg13_lv_nmos
+ L=0.13u W=0.42u AS=0.0798p AD=0.0378p PS=0.8u PD=0.6u rfmode=0
M$17682 \$5057 \$5031 \$5079 VSS|anode|cathode|vss sg13_lv_nmos L=0.13u W=0.42u
+ AS=0.0378p AD=0.1428p PS=0.6u PD=1.52u rfmode=0
M$17683 VSS|anode|cathode|vss \$5031 \$4968 VSS|anode|cathode|vss sg13_lv_nmos
+ L=0.13u W=0.64u AS=0.1331p AD=0.2176p PS=1.12u PD=1.96u rfmode=0
M$17684 VSS|anode|cathode|vss \$5031 \$4967 VSS|anode|cathode|vss sg13_lv_nmos
+ L=0.13u W=1.48u AS=0.3922p AD=0.2737p PS=3.28u PD=2.24u rfmode=0
M$17686 VSS|anode|cathode|vss \$4968 \$4969 VSS|anode|cathode|vss sg13_lv_nmos
+ L=0.13u W=1.48u AS=0.3922p AD=0.3922p PS=3.28u PD=3.28u rfmode=0
M$17688 VSS|anode|cathode|vss VSS|anode|cathode|vss \$4841
+ VSS|anode|cathode|vss sg13_lv_nmos L=0.13u W=1u AS=0.265p AD=0.265p PS=2.56u
+ PD=2.56u rfmode=0
M$17689 \$4841 \$4679 OUTP|analog_io_padres[16]|core|padres
+ VSS|anode|cathode|vss sg13_lv_nmos L=0.13u W=2u AS=0.38p AD=0.38p PS=3.52u
+ PD=3.52u rfmode=0
M$17691 \$4841 \$4681 OUTN|analog_io_padres[15]|core|padres
+ VSS|anode|cathode|vss sg13_lv_nmos L=0.13u W=2u AS=0.38p AD=0.38p PS=3.52u
+ PD=3.52u rfmode=0
M$17698 VSS|anode|cathode|vss \$3193 \$4970 VSS|anode|cathode|vss sg13_lv_nmos
+ L=0.13u W=0.55u AS=0.187p AD=0.1045p PS=1.78u PD=0.93u rfmode=0
M$17699 \$4970 \$3685 VSS|anode|cathode|vss VSS|anode|cathode|vss sg13_lv_nmos
+ L=0.13u W=0.55u AS=0.1045p AD=0.146425p PS=0.93u PD=1.155u rfmode=0
M$17700 VSS|anode|cathode|vss \$4970 \$4971 VSS|anode|cathode|vss sg13_lv_nmos
+ L=0.13u W=1.48u AS=0.312925p AD=0.4477p PS=2.345u PD=3.43u rfmode=0
M$17702 \$4973 \$5033 \$5062 VSS|anode|cathode|vss sg13_lv_nmos L=0.13u W=0.42u
+ AS=0.1428p AD=0.0609p PS=1.52u PD=0.71u rfmode=0
M$17703 \$5062 VDD VSS|anode|cathode|vss VSS|anode|cathode|vss sg13_lv_nmos
+ L=0.13u W=0.42u AS=0.0609p AD=0.1626p PS=0.71u PD=1.415u rfmode=0
M$17704 VSS|anode|cathode|vss \$5080 \$4947 VSS|anode|cathode|vss sg13_lv_nmos
+ L=0.13u W=0.74u AS=0.1626p AD=0.2516p PS=1.415u PD=2.16u rfmode=0
M$17705 \$4685 \$4660 \$4803 VSS|anode|cathode|vss sg13_lv_nmos L=0.13u W=0.42u
+ AS=0.1296p AD=0.081p PS=1.52u PD=0.81u rfmode=0
M$17706 \$4803 \$4750 \$4686 VSS|anode|cathode|vss sg13_lv_nmos L=0.13u W=0.42u
+ AS=0.081p AD=0.2163p PS=0.81u PD=1.87u rfmode=0
M$17707 \$4975 \$5081 VSS|anode|cathode|vss VSS|anode|cathode|vss sg13_lv_nmos
+ L=0.13u W=0.42u AS=0.1428p AD=0.0798p PS=1.52u PD=0.8u rfmode=0
M$17708 VSS|anode|cathode|vss VDD \$5065 VSS|anode|cathode|vss sg13_lv_nmos
+ L=0.13u W=0.42u AS=0.0798p AD=0.0378p PS=0.8u PD=0.6u rfmode=0
M$17709 \$5065 \$5034 \$5081 VSS|anode|cathode|vss sg13_lv_nmos L=0.13u W=0.42u
+ AS=0.0378p AD=0.1428p PS=0.6u PD=1.52u rfmode=0
M$17710 VSS|anode|cathode|vss \$5034 \$4977 VSS|anode|cathode|vss sg13_lv_nmos
+ L=0.13u W=0.64u AS=0.1331p AD=0.2176p PS=1.12u PD=1.96u rfmode=0
M$17711 VSS|anode|cathode|vss \$5034 \$4976 VSS|anode|cathode|vss sg13_lv_nmos
+ L=0.13u W=1.48u AS=0.3922p AD=0.2737p PS=3.28u PD=2.24u rfmode=0
M$17713 VSS|anode|cathode|vss \$4977 \$4978 VSS|anode|cathode|vss sg13_lv_nmos
+ L=0.13u W=1.48u AS=0.3922p AD=0.3922p PS=3.28u PD=3.28u rfmode=0
M$17715 VSS|anode|cathode|vss VSS|anode|cathode|vss \$4842
+ VSS|anode|cathode|vss sg13_lv_nmos L=0.13u W=1u AS=0.265p AD=0.265p PS=2.56u
+ PD=2.56u rfmode=0
M$17716 \$4842 \$4688 OUTP|analog_io_padres[16]|core|padres
+ VSS|anode|cathode|vss sg13_lv_nmos L=0.13u W=2u AS=0.38p AD=0.38p PS=3.52u
+ PD=3.52u rfmode=0
M$17718 \$4842 \$4690 OUTN|analog_io_padres[15]|core|padres
+ VSS|anode|cathode|vss sg13_lv_nmos L=0.13u W=2u AS=0.38p AD=0.38p PS=3.52u
+ PD=3.52u rfmode=0
M$17725 VSS|anode|cathode|vss \$3194 \$4979 VSS|anode|cathode|vss sg13_lv_nmos
+ L=0.13u W=0.55u AS=0.187p AD=0.1045p PS=1.78u PD=0.93u rfmode=0
M$17726 \$4979 \$3685 VSS|anode|cathode|vss VSS|anode|cathode|vss sg13_lv_nmos
+ L=0.13u W=0.55u AS=0.1045p AD=0.146425p PS=0.93u PD=1.155u rfmode=0
M$17727 VSS|anode|cathode|vss \$4979 \$4980 VSS|anode|cathode|vss sg13_lv_nmos
+ L=0.13u W=1.48u AS=0.312925p AD=0.4477p PS=2.345u PD=3.43u rfmode=0
M$17729 \$5122 \$5036 \$5069 VSS|anode|cathode|vss sg13_lv_nmos L=0.13u W=0.42u
+ AS=0.1428p AD=0.0609p PS=1.52u PD=0.71u rfmode=0
M$17730 \$5069 VDD VSS|anode|cathode|vss VSS|anode|cathode|vss sg13_lv_nmos
+ L=0.13u W=0.42u AS=0.0609p AD=0.1626p PS=0.71u PD=1.415u rfmode=0
M$17731 VSS|anode|cathode|vss \$5082 \$4949 VSS|anode|cathode|vss sg13_lv_nmos
+ L=0.13u W=0.74u AS=0.1626p AD=0.2516p PS=1.415u PD=2.16u rfmode=0
M$17732 \$4694 \$4662 \$4805 VSS|anode|cathode|vss sg13_lv_nmos L=0.13u W=0.42u
+ AS=0.1296p AD=0.081p PS=1.52u PD=0.81u rfmode=0
M$17733 \$4805 \$4754 \$4695 VSS|anode|cathode|vss sg13_lv_nmos L=0.13u W=0.42u
+ AS=0.081p AD=0.2163p PS=0.81u PD=1.87u rfmode=0
M$17734 \$4983 \$5083 VSS|anode|cathode|vss VSS|anode|cathode|vss sg13_lv_nmos
+ L=0.13u W=0.42u AS=0.1428p AD=0.0798p PS=1.52u PD=0.8u rfmode=0
M$17735 VSS|anode|cathode|vss VDD \$5077 VSS|anode|cathode|vss sg13_lv_nmos
+ L=0.13u W=0.42u AS=0.0798p AD=0.0378p PS=0.8u PD=0.6u rfmode=0
M$17736 \$5077 \$5037 \$5083 VSS|anode|cathode|vss sg13_lv_nmos L=0.13u W=0.42u
+ AS=0.0378p AD=0.1428p PS=0.6u PD=1.52u rfmode=0
M$17737 VSS|anode|cathode|vss \$5037 \$4985 VSS|anode|cathode|vss sg13_lv_nmos
+ L=0.13u W=0.64u AS=0.1331p AD=0.2176p PS=1.12u PD=1.96u rfmode=0
M$17738 VSS|anode|cathode|vss \$5037 \$4984 VSS|anode|cathode|vss sg13_lv_nmos
+ L=0.13u W=1.48u AS=0.3922p AD=0.2737p PS=3.28u PD=2.24u rfmode=0
M$17740 VSS|anode|cathode|vss \$4985 \$4986 VSS|anode|cathode|vss sg13_lv_nmos
+ L=0.13u W=1.48u AS=0.3922p AD=0.3922p PS=3.28u PD=3.28u rfmode=0
M$17742 VSS|anode|cathode|vss VSS|anode|cathode|vss \$4843
+ VSS|anode|cathode|vss sg13_lv_nmos L=0.13u W=1u AS=0.265p AD=0.265p PS=2.56u
+ PD=2.56u rfmode=0
M$17743 \$4843 \$4697 OUTP|analog_io_padres[16]|core|padres
+ VSS|anode|cathode|vss sg13_lv_nmos L=0.13u W=2u AS=0.38p AD=0.38p PS=3.52u
+ PD=3.52u rfmode=0
M$17745 \$4843 \$4699 OUTN|analog_io_padres[15]|core|padres
+ VSS|anode|cathode|vss sg13_lv_nmos L=0.13u W=2u AS=0.38p AD=0.38p PS=3.52u
+ PD=3.52u rfmode=0
M$17752 VSS|anode|cathode|vss \$3195 \$4987 VSS|anode|cathode|vss sg13_lv_nmos
+ L=0.13u W=0.55u AS=0.187p AD=0.1045p PS=1.78u PD=0.93u rfmode=0
M$17753 \$4987 \$3685 VSS|anode|cathode|vss VSS|anode|cathode|vss sg13_lv_nmos
+ L=0.13u W=0.55u AS=0.1045p AD=0.146425p PS=0.93u PD=1.155u rfmode=0
M$17754 VSS|anode|cathode|vss \$4987 \$4988 VSS|anode|cathode|vss sg13_lv_nmos
+ L=0.13u W=1.48u AS=0.312925p AD=0.4477p PS=2.345u PD=3.43u rfmode=0
M$17756 \$4990 \$5039 \$5075 VSS|anode|cathode|vss sg13_lv_nmos L=0.13u W=0.42u
+ AS=0.1428p AD=0.0609p PS=1.52u PD=0.71u rfmode=0
M$17757 \$5075 VDD VSS|anode|cathode|vss VSS|anode|cathode|vss sg13_lv_nmos
+ L=0.13u W=0.42u AS=0.0609p AD=0.1626p PS=0.71u PD=1.415u rfmode=0
M$17758 VSS|anode|cathode|vss \$5084 \$4951 VSS|anode|cathode|vss sg13_lv_nmos
+ L=0.13u W=0.74u AS=0.1626p AD=0.2516p PS=1.415u PD=2.16u rfmode=0
M$17759 \$4703 \$4664 \$4807 VSS|anode|cathode|vss sg13_lv_nmos L=0.13u W=0.42u
+ AS=0.1296p AD=0.081p PS=1.52u PD=0.81u rfmode=0
M$17760 \$4807 \$4758 \$4704 VSS|anode|cathode|vss sg13_lv_nmos L=0.13u W=0.42u
+ AS=0.081p AD=0.2163p PS=0.81u PD=1.87u rfmode=0
M$17761 \$4992 \$5085 VSS|anode|cathode|vss VSS|anode|cathode|vss sg13_lv_nmos
+ L=0.13u W=0.42u AS=0.1428p AD=0.0798p PS=1.52u PD=0.8u rfmode=0
M$17762 VSS|anode|cathode|vss VDD \$5073 VSS|anode|cathode|vss sg13_lv_nmos
+ L=0.13u W=0.42u AS=0.0798p AD=0.0378p PS=0.8u PD=0.6u rfmode=0
M$17763 \$5073 \$5040 \$5085 VSS|anode|cathode|vss sg13_lv_nmos L=0.13u W=0.42u
+ AS=0.0378p AD=0.1428p PS=0.6u PD=1.52u rfmode=0
M$17764 VSS|anode|cathode|vss \$5040 \$4994 VSS|anode|cathode|vss sg13_lv_nmos
+ L=0.13u W=0.64u AS=0.1331p AD=0.2176p PS=1.12u PD=1.96u rfmode=0
M$17765 VSS|anode|cathode|vss \$5040 \$4993 VSS|anode|cathode|vss sg13_lv_nmos
+ L=0.13u W=1.48u AS=0.3922p AD=0.2737p PS=3.28u PD=2.24u rfmode=0
M$17767 VSS|anode|cathode|vss \$4994 \$4995 VSS|anode|cathode|vss sg13_lv_nmos
+ L=0.13u W=1.48u AS=0.3922p AD=0.3922p PS=3.28u PD=3.28u rfmode=0
M$17769 VSS|anode|cathode|vss VSS|anode|cathode|vss \$4844
+ VSS|anode|cathode|vss sg13_lv_nmos L=0.13u W=1u AS=0.265p AD=0.265p PS=2.56u
+ PD=2.56u rfmode=0
M$17770 \$4844 \$4706 OUTP|analog_io_padres[16]|core|padres
+ VSS|anode|cathode|vss sg13_lv_nmos L=0.13u W=2u AS=0.38p AD=0.38p PS=3.52u
+ PD=3.52u rfmode=0
M$17772 \$4844 \$4708 OUTN|analog_io_padres[15]|core|padres
+ VSS|anode|cathode|vss sg13_lv_nmos L=0.13u W=2u AS=0.38p AD=0.38p PS=3.52u
+ PD=3.52u rfmode=0
M$17779 VSS|anode|cathode|vss \$3196 \$4996 VSS|anode|cathode|vss sg13_lv_nmos
+ L=0.13u W=0.55u AS=0.187p AD=0.1045p PS=1.78u PD=0.93u rfmode=0
M$17780 \$4996 \$3685 VSS|anode|cathode|vss VSS|anode|cathode|vss sg13_lv_nmos
+ L=0.13u W=0.55u AS=0.1045p AD=0.146425p PS=0.93u PD=1.155u rfmode=0
M$17781 VSS|anode|cathode|vss \$4996 \$4997 VSS|anode|cathode|vss sg13_lv_nmos
+ L=0.13u W=1.48u AS=0.312925p AD=0.4477p PS=2.345u PD=3.43u rfmode=0
M$17783 \$4999 \$5042 \$5071 VSS|anode|cathode|vss sg13_lv_nmos L=0.13u W=0.42u
+ AS=0.1428p AD=0.0609p PS=1.52u PD=0.71u rfmode=0
M$17784 \$5071 VDD VSS|anode|cathode|vss VSS|anode|cathode|vss sg13_lv_nmos
+ L=0.13u W=0.42u AS=0.0609p AD=0.1626p PS=0.71u PD=1.415u rfmode=0
M$17785 VSS|anode|cathode|vss \$5086 \$4953 VSS|anode|cathode|vss sg13_lv_nmos
+ L=0.13u W=0.74u AS=0.1626p AD=0.2516p PS=1.415u PD=2.16u rfmode=0
M$17786 \$4712 \$4666 \$4809 VSS|anode|cathode|vss sg13_lv_nmos L=0.13u W=0.42u
+ AS=0.1296p AD=0.081p PS=1.52u PD=0.81u rfmode=0
M$17787 \$4809 \$4762 \$4713 VSS|anode|cathode|vss sg13_lv_nmos L=0.13u W=0.42u
+ AS=0.081p AD=0.2163p PS=0.81u PD=1.87u rfmode=0
M$17788 \$5001 \$5087 VSS|anode|cathode|vss VSS|anode|cathode|vss sg13_lv_nmos
+ L=0.13u W=0.42u AS=0.1428p AD=0.0798p PS=1.52u PD=0.8u rfmode=0
M$17789 VSS|anode|cathode|vss VDD \$5070 VSS|anode|cathode|vss sg13_lv_nmos
+ L=0.13u W=0.42u AS=0.0798p AD=0.0378p PS=0.8u PD=0.6u rfmode=0
M$17790 \$5070 \$5043 \$5087 VSS|anode|cathode|vss sg13_lv_nmos L=0.13u W=0.42u
+ AS=0.0378p AD=0.1428p PS=0.6u PD=1.52u rfmode=0
M$17791 VSS|anode|cathode|vss \$5043 \$5003 VSS|anode|cathode|vss sg13_lv_nmos
+ L=0.13u W=0.64u AS=0.1331p AD=0.2176p PS=1.12u PD=1.96u rfmode=0
M$17792 VSS|anode|cathode|vss \$5043 \$5002 VSS|anode|cathode|vss sg13_lv_nmos
+ L=0.13u W=1.48u AS=0.3922p AD=0.2737p PS=3.28u PD=2.24u rfmode=0
M$17794 VSS|anode|cathode|vss \$5003 \$5004 VSS|anode|cathode|vss sg13_lv_nmos
+ L=0.13u W=1.48u AS=0.3922p AD=0.3922p PS=3.28u PD=3.28u rfmode=0
M$17796 VSS|anode|cathode|vss VSS|anode|cathode|vss \$4845
+ VSS|anode|cathode|vss sg13_lv_nmos L=0.13u W=1u AS=0.265p AD=0.265p PS=2.56u
+ PD=2.56u rfmode=0
M$17797 \$4845 \$4715 OUTP|analog_io_padres[16]|core|padres
+ VSS|anode|cathode|vss sg13_lv_nmos L=0.13u W=2u AS=0.38p AD=0.38p PS=3.52u
+ PD=3.52u rfmode=0
M$17799 \$4845 \$4717 OUTN|analog_io_padres[15]|core|padres
+ VSS|anode|cathode|vss sg13_lv_nmos L=0.13u W=2u AS=0.38p AD=0.38p PS=3.52u
+ PD=3.52u rfmode=0
M$17806 VSS|anode|cathode|vss \$3197 \$5005 VSS|anode|cathode|vss sg13_lv_nmos
+ L=0.13u W=0.55u AS=0.187p AD=0.1045p PS=1.78u PD=0.93u rfmode=0
M$17807 \$5005 \$3685 VSS|anode|cathode|vss VSS|anode|cathode|vss sg13_lv_nmos
+ L=0.13u W=0.55u AS=0.1045p AD=0.146425p PS=0.93u PD=1.155u rfmode=0
M$17808 VSS|anode|cathode|vss \$5005 \$5006 VSS|anode|cathode|vss sg13_lv_nmos
+ L=0.13u W=1.48u AS=0.312925p AD=0.4477p PS=2.345u PD=3.43u rfmode=0
M$17810 \$5129 \$5045 \$5067 VSS|anode|cathode|vss sg13_lv_nmos L=0.13u W=0.42u
+ AS=0.1428p AD=0.0609p PS=1.52u PD=0.71u rfmode=0
M$17811 \$5067 VDD VSS|anode|cathode|vss VSS|anode|cathode|vss sg13_lv_nmos
+ L=0.13u W=0.42u AS=0.0609p AD=0.1626p PS=0.71u PD=1.415u rfmode=0
M$17812 VSS|anode|cathode|vss \$5088 \$4955 VSS|anode|cathode|vss sg13_lv_nmos
+ L=0.13u W=0.74u AS=0.1626p AD=0.2516p PS=1.415u PD=2.16u rfmode=0
M$17813 \$4721 \$4668 \$4811 VSS|anode|cathode|vss sg13_lv_nmos L=0.13u W=0.42u
+ AS=0.1296p AD=0.081p PS=1.52u PD=0.81u rfmode=0
M$17814 \$4811 \$4766 \$4722 VSS|anode|cathode|vss sg13_lv_nmos L=0.13u W=0.42u
+ AS=0.081p AD=0.2163p PS=0.81u PD=1.87u rfmode=0
M$17815 \$5009 \$5089 VSS|anode|cathode|vss VSS|anode|cathode|vss sg13_lv_nmos
+ L=0.13u W=0.42u AS=0.1428p AD=0.0798p PS=1.52u PD=0.8u rfmode=0
M$17816 VSS|anode|cathode|vss VDD \$5066 VSS|anode|cathode|vss sg13_lv_nmos
+ L=0.13u W=0.42u AS=0.0798p AD=0.0378p PS=0.8u PD=0.6u rfmode=0
M$17817 \$5066 \$5046 \$5089 VSS|anode|cathode|vss sg13_lv_nmos L=0.13u W=0.42u
+ AS=0.0378p AD=0.1428p PS=0.6u PD=1.52u rfmode=0
M$17818 VSS|anode|cathode|vss \$5046 \$5011 VSS|anode|cathode|vss sg13_lv_nmos
+ L=0.13u W=0.64u AS=0.1331p AD=0.2176p PS=1.12u PD=1.96u rfmode=0
M$17819 VSS|anode|cathode|vss \$5046 \$5010 VSS|anode|cathode|vss sg13_lv_nmos
+ L=0.13u W=1.48u AS=0.3922p AD=0.2737p PS=3.28u PD=2.24u rfmode=0
M$17821 VSS|anode|cathode|vss \$5011 \$5012 VSS|anode|cathode|vss sg13_lv_nmos
+ L=0.13u W=1.48u AS=0.3922p AD=0.3922p PS=3.28u PD=3.28u rfmode=0
M$17823 VSS|anode|cathode|vss VSS|anode|cathode|vss \$4846
+ VSS|anode|cathode|vss sg13_lv_nmos L=0.13u W=1u AS=0.265p AD=0.265p PS=2.56u
+ PD=2.56u rfmode=0
M$17824 \$4846 \$4724 OUTP|analog_io_padres[16]|core|padres
+ VSS|anode|cathode|vss sg13_lv_nmos L=0.13u W=2u AS=0.38p AD=0.38p PS=3.52u
+ PD=3.52u rfmode=0
M$17826 \$4846 \$4726 OUTN|analog_io_padres[15]|core|padres
+ VSS|anode|cathode|vss sg13_lv_nmos L=0.13u W=2u AS=0.38p AD=0.38p PS=3.52u
+ PD=3.52u rfmode=0
M$17833 VSS|anode|cathode|vss \$3198 \$5013 VSS|anode|cathode|vss sg13_lv_nmos
+ L=0.13u W=0.55u AS=0.187p AD=0.1045p PS=1.78u PD=0.93u rfmode=0
M$17834 \$5013 \$3685 VSS|anode|cathode|vss VSS|anode|cathode|vss sg13_lv_nmos
+ L=0.13u W=0.55u AS=0.1045p AD=0.146425p PS=0.93u PD=1.155u rfmode=0
M$17835 VSS|anode|cathode|vss \$5013 \$5014 VSS|anode|cathode|vss sg13_lv_nmos
+ L=0.13u W=1.48u AS=0.312925p AD=0.4477p PS=2.345u PD=3.43u rfmode=0
M$17837 \$5132 \$5048 \$5063 VSS|anode|cathode|vss sg13_lv_nmos L=0.13u W=0.42u
+ AS=0.1428p AD=0.0609p PS=1.52u PD=0.71u rfmode=0
M$17838 \$5063 VDD VSS|anode|cathode|vss VSS|anode|cathode|vss sg13_lv_nmos
+ L=0.13u W=0.42u AS=0.0609p AD=0.1626p PS=0.71u PD=1.415u rfmode=0
M$17839 VSS|anode|cathode|vss \$5090 \$4957 VSS|anode|cathode|vss sg13_lv_nmos
+ L=0.13u W=0.74u AS=0.1626p AD=0.2516p PS=1.415u PD=2.16u rfmode=0
M$17840 \$4730 \$4670 \$4813 VSS|anode|cathode|vss sg13_lv_nmos L=0.13u W=0.42u
+ AS=0.1296p AD=0.081p PS=1.52u PD=0.81u rfmode=0
M$17841 \$4813 \$4770 \$4731 VSS|anode|cathode|vss sg13_lv_nmos L=0.13u W=0.42u
+ AS=0.081p AD=0.2163p PS=0.81u PD=1.87u rfmode=0
M$17842 \$5017 \$5091 VSS|anode|cathode|vss VSS|anode|cathode|vss sg13_lv_nmos
+ L=0.13u W=0.42u AS=0.1428p AD=0.0798p PS=1.52u PD=0.8u rfmode=0
M$17843 VSS|anode|cathode|vss VDD \$5060 VSS|anode|cathode|vss sg13_lv_nmos
+ L=0.13u W=0.42u AS=0.0798p AD=0.0378p PS=0.8u PD=0.6u rfmode=0
M$17844 \$5060 \$5049 \$5091 VSS|anode|cathode|vss sg13_lv_nmos L=0.13u W=0.42u
+ AS=0.0378p AD=0.1428p PS=0.6u PD=1.52u rfmode=0
M$17845 VSS|anode|cathode|vss \$5049 \$5019 VSS|anode|cathode|vss sg13_lv_nmos
+ L=0.13u W=0.64u AS=0.1331p AD=0.2176p PS=1.12u PD=1.96u rfmode=0
M$17846 VSS|anode|cathode|vss \$5049 \$5018 VSS|anode|cathode|vss sg13_lv_nmos
+ L=0.13u W=1.48u AS=0.3922p AD=0.2737p PS=3.28u PD=2.24u rfmode=0
M$17848 VSS|anode|cathode|vss \$5019 \$5020 VSS|anode|cathode|vss sg13_lv_nmos
+ L=0.13u W=1.48u AS=0.3922p AD=0.3922p PS=3.28u PD=3.28u rfmode=0
M$17850 VSS|anode|cathode|vss VSS|anode|cathode|vss \$4847
+ VSS|anode|cathode|vss sg13_lv_nmos L=0.13u W=1u AS=0.265p AD=0.265p PS=2.56u
+ PD=2.56u rfmode=0
M$17851 \$4847 \$4733 OUTP|analog_io_padres[16]|core|padres
+ VSS|anode|cathode|vss sg13_lv_nmos L=0.13u W=2u AS=0.38p AD=0.38p PS=3.52u
+ PD=3.52u rfmode=0
M$17853 \$4847 \$4735 OUTN|analog_io_padres[15]|core|padres
+ VSS|anode|cathode|vss sg13_lv_nmos L=0.13u W=2u AS=0.38p AD=0.38p PS=3.52u
+ PD=3.52u rfmode=0
M$17860 VSS|anode|cathode|vss VSS|anode|cathode|vss \$5021
+ VSS|anode|cathode|vss sg13_lv_nmos L=0.13u W=0.55u AS=0.187p AD=0.1045p
+ PS=1.78u PD=0.93u rfmode=0
M$17861 \$5021 \$3685 VSS|anode|cathode|vss VSS|anode|cathode|vss sg13_lv_nmos
+ L=0.13u W=0.55u AS=0.1045p AD=0.146425p PS=0.93u PD=1.155u rfmode=0
M$17862 VSS|anode|cathode|vss \$5021 \$5022 VSS|anode|cathode|vss sg13_lv_nmos
+ L=0.13u W=1.48u AS=0.312925p AD=0.4477p PS=2.345u PD=3.43u rfmode=0
M$17864 \$5024 \$5051 \$5059 VSS|anode|cathode|vss sg13_lv_nmos L=0.13u W=0.42u
+ AS=0.1428p AD=0.0609p PS=1.52u PD=0.71u rfmode=0
M$17865 \$5059 VDD VSS|anode|cathode|vss VSS|anode|cathode|vss sg13_lv_nmos
+ L=0.13u W=0.42u AS=0.0609p AD=0.1626p PS=0.71u PD=1.415u rfmode=0
M$17866 VSS|anode|cathode|vss \$5092 \$4959 VSS|anode|cathode|vss sg13_lv_nmos
+ L=0.13u W=0.74u AS=0.1626p AD=0.2516p PS=1.415u PD=2.16u rfmode=0
M$17867 \$4739 \$4672 \$4815 VSS|anode|cathode|vss sg13_lv_nmos L=0.13u W=0.42u
+ AS=0.1296p AD=0.081p PS=1.52u PD=0.81u rfmode=0
M$17868 \$4815 \$4774 \$4740 VSS|anode|cathode|vss sg13_lv_nmos L=0.13u W=0.42u
+ AS=0.081p AD=0.2163p PS=0.81u PD=1.87u rfmode=0
M$17869 \$5026 \$5093 VSS|anode|cathode|vss VSS|anode|cathode|vss sg13_lv_nmos
+ L=0.13u W=0.42u AS=0.1428p AD=0.0798p PS=1.52u PD=0.8u rfmode=0
M$17870 VSS|anode|cathode|vss VDD \$5058 VSS|anode|cathode|vss sg13_lv_nmos
+ L=0.13u W=0.42u AS=0.0798p AD=0.0378p PS=0.8u PD=0.6u rfmode=0
M$17871 \$5058 \$5052 \$5093 VSS|anode|cathode|vss sg13_lv_nmos L=0.13u W=0.42u
+ AS=0.0378p AD=0.1428p PS=0.6u PD=1.52u rfmode=0
M$17872 VSS|anode|cathode|vss \$5052 \$5028 VSS|anode|cathode|vss sg13_lv_nmos
+ L=0.13u W=0.64u AS=0.1331p AD=0.2176p PS=1.12u PD=1.96u rfmode=0
M$17873 VSS|anode|cathode|vss \$5052 \$5027 VSS|anode|cathode|vss sg13_lv_nmos
+ L=0.13u W=1.48u AS=0.3922p AD=0.2737p PS=3.28u PD=2.24u rfmode=0
M$17875 VSS|anode|cathode|vss \$5028 \$5029 VSS|anode|cathode|vss sg13_lv_nmos
+ L=0.13u W=1.48u AS=0.3922p AD=0.3922p PS=3.28u PD=3.28u rfmode=0
M$17877 VSS|anode|cathode|vss VSS|anode|cathode|vss \$4848
+ VSS|anode|cathode|vss sg13_lv_nmos L=0.13u W=1u AS=0.265p AD=0.265p PS=2.56u
+ PD=2.56u rfmode=0
M$17878 \$4848 \$4742 OUTP|analog_io_padres[16]|core|padres
+ VSS|anode|cathode|vss sg13_lv_nmos L=0.13u W=2u AS=0.38p AD=0.38p PS=3.52u
+ PD=3.52u rfmode=0
M$17880 \$4848 \$4744 OUTN|analog_io_padres[15]|core|padres
+ VSS|anode|cathode|vss sg13_lv_nmos L=0.13u W=2u AS=0.38p AD=0.38p PS=3.52u
+ PD=3.52u rfmode=0
M$17887 \$4963 \$4962 VSS|anode|cathode|vss VSS|anode|cathode|vss sg13_lv_nmos
+ L=0.13u W=1.44u AS=0.4068p AD=0.2772p PS=3.29u PD=2.21u rfmode=0
M$17889 \$4963 \$3439 \$5030 VSS|anode|cathode|vss sg13_lv_nmos L=0.13u W=1.44u
+ AS=0.2772p AD=0.3816p PS=2.21u PD=3.22u rfmode=0
M$17891 VSS|anode|cathode|vss VDD \$5054 VSS|anode|cathode|vss sg13_lv_nmos
+ L=0.13u W=0.42u AS=0.1701p AD=0.03885p PS=1.65u PD=0.605u rfmode=0
M$17892 \$5054 \$4945 \$4965 VSS|anode|cathode|vss sg13_lv_nmos L=0.13u W=0.42u
+ AS=0.03885p AD=0.1596p PS=0.605u PD=1.6u rfmode=0
M$17893 VSS|anode|cathode|vss \$4946 \$5118 VSS|anode|cathode|vss sg13_lv_nmos
+ L=0.13u W=0.74u AS=0.43315p AD=0.2516p PS=2.205u PD=2.16u rfmode=0
M$17894 VSS|anode|cathode|vss CLK|clk|core|fclk_in|p2c|ui_p2c[6] \$4946
+ VSS|anode|cathode|vss sg13_lv_nmos L=0.13u W=0.74u AS=0.43315p AD=0.2516p
+ PS=2.205u PD=2.16u rfmode=0
M$17895 \$5031 \$4946 \$4966 VSS|anode|cathode|vss sg13_lv_nmos L=0.13u W=0.42u
+ AS=0.12665p AD=0.1428p PS=1.145u PD=1.52u rfmode=0
M$17896 \$4945 \$5118 \$5031 VSS|anode|cathode|vss sg13_lv_nmos L=0.13u W=0.74u
+ AS=0.3473p AD=0.12665p PS=2.71u PD=1.145u rfmode=0
M$17897 \$4972 \$4971 VSS|anode|cathode|vss VSS|anode|cathode|vss sg13_lv_nmos
+ L=0.13u W=1.44u AS=0.4068p AD=0.2772p PS=3.29u PD=2.21u rfmode=0
M$17899 \$4972 \$3439 \$5033 VSS|anode|cathode|vss sg13_lv_nmos L=0.13u W=1.44u
+ AS=0.2772p AD=0.3816p PS=2.21u PD=3.22u rfmode=0
M$17901 VSS|anode|cathode|vss VDD \$5061 VSS|anode|cathode|vss sg13_lv_nmos
+ L=0.13u W=0.42u AS=0.1701p AD=0.03885p PS=1.65u PD=0.605u rfmode=0
M$17902 \$5061 \$4947 \$4974 VSS|anode|cathode|vss sg13_lv_nmos L=0.13u W=0.42u
+ AS=0.03885p AD=0.1596p PS=0.605u PD=1.6u rfmode=0
M$17903 VSS|anode|cathode|vss \$4948 \$5120 VSS|anode|cathode|vss sg13_lv_nmos
+ L=0.13u W=0.74u AS=0.43315p AD=0.2516p PS=2.205u PD=2.16u rfmode=0
M$17904 VSS|anode|cathode|vss CLK|clk|core|fclk_in|p2c|ui_p2c[6] \$4948
+ VSS|anode|cathode|vss sg13_lv_nmos L=0.13u W=0.74u AS=0.43315p AD=0.2516p
+ PS=2.205u PD=2.16u rfmode=0
M$17905 \$5034 \$4948 \$4975 VSS|anode|cathode|vss sg13_lv_nmos L=0.13u W=0.42u
+ AS=0.12665p AD=0.1428p PS=1.145u PD=1.52u rfmode=0
M$17906 \$4947 \$5120 \$5034 VSS|anode|cathode|vss sg13_lv_nmos L=0.13u W=0.74u
+ AS=0.3473p AD=0.12665p PS=2.71u PD=1.145u rfmode=0
M$17907 \$4981 \$4980 VSS|anode|cathode|vss VSS|anode|cathode|vss sg13_lv_nmos
+ L=0.13u W=1.44u AS=0.4068p AD=0.2772p PS=3.29u PD=2.21u rfmode=0
M$17909 \$4981 \$3439 \$5036 VSS|anode|cathode|vss sg13_lv_nmos L=0.13u W=1.44u
+ AS=0.2772p AD=0.3816p PS=2.21u PD=3.22u rfmode=0
M$17911 VSS|anode|cathode|vss VDD \$5074 VSS|anode|cathode|vss sg13_lv_nmos
+ L=0.13u W=0.42u AS=0.1701p AD=0.03885p PS=1.65u PD=0.605u rfmode=0
M$17912 \$5074 \$4949 \$4982 VSS|anode|cathode|vss sg13_lv_nmos L=0.13u W=0.42u
+ AS=0.03885p AD=0.1596p PS=0.605u PD=1.6u rfmode=0
M$17913 VSS|anode|cathode|vss \$4950 \$5123 VSS|anode|cathode|vss sg13_lv_nmos
+ L=0.13u W=0.74u AS=0.43315p AD=0.2516p PS=2.205u PD=2.16u rfmode=0
M$17914 VSS|anode|cathode|vss CLK|clk|core|fclk_in|p2c|ui_p2c[6] \$4950
+ VSS|anode|cathode|vss sg13_lv_nmos L=0.13u W=0.74u AS=0.43315p AD=0.2516p
+ PS=2.205u PD=2.16u rfmode=0
M$17915 \$5037 \$4950 \$4983 VSS|anode|cathode|vss sg13_lv_nmos L=0.13u W=0.42u
+ AS=0.12665p AD=0.1428p PS=1.145u PD=1.52u rfmode=0
M$17916 \$4949 \$5123 \$5037 VSS|anode|cathode|vss sg13_lv_nmos L=0.13u W=0.74u
+ AS=0.3473p AD=0.12665p PS=2.71u PD=1.145u rfmode=0
M$17917 \$4989 \$4988 VSS|anode|cathode|vss VSS|anode|cathode|vss sg13_lv_nmos
+ L=0.13u W=1.44u AS=0.4068p AD=0.2772p PS=3.29u PD=2.21u rfmode=0
M$17919 \$4989 \$3439 \$5039 VSS|anode|cathode|vss sg13_lv_nmos L=0.13u W=1.44u
+ AS=0.2772p AD=0.3816p PS=2.21u PD=3.22u rfmode=0
M$17921 VSS|anode|cathode|vss VDD \$5076 VSS|anode|cathode|vss sg13_lv_nmos
+ L=0.13u W=0.42u AS=0.1701p AD=0.03885p PS=1.65u PD=0.605u rfmode=0
M$17922 \$5076 \$4951 \$4991 VSS|anode|cathode|vss sg13_lv_nmos L=0.13u W=0.42u
+ AS=0.03885p AD=0.1596p PS=0.605u PD=1.6u rfmode=0
M$17923 VSS|anode|cathode|vss \$4952 \$5125 VSS|anode|cathode|vss sg13_lv_nmos
+ L=0.13u W=0.74u AS=0.43315p AD=0.2516p PS=2.205u PD=2.16u rfmode=0
M$17924 VSS|anode|cathode|vss CLK|clk|core|fclk_in|p2c|ui_p2c[6] \$4952
+ VSS|anode|cathode|vss sg13_lv_nmos L=0.13u W=0.74u AS=0.43315p AD=0.2516p
+ PS=2.205u PD=2.16u rfmode=0
M$17925 \$5040 \$4952 \$4992 VSS|anode|cathode|vss sg13_lv_nmos L=0.13u W=0.42u
+ AS=0.12665p AD=0.1428p PS=1.145u PD=1.52u rfmode=0
M$17926 \$4951 \$5125 \$5040 VSS|anode|cathode|vss sg13_lv_nmos L=0.13u W=0.74u
+ AS=0.3473p AD=0.12665p PS=2.71u PD=1.145u rfmode=0
M$17927 \$4998 \$4997 VSS|anode|cathode|vss VSS|anode|cathode|vss sg13_lv_nmos
+ L=0.13u W=1.44u AS=0.4068p AD=0.2772p PS=3.29u PD=2.21u rfmode=0
M$17929 \$4998 \$3439 \$5042 VSS|anode|cathode|vss sg13_lv_nmos L=0.13u W=1.44u
+ AS=0.2772p AD=0.3816p PS=2.21u PD=3.22u rfmode=0
M$17931 VSS|anode|cathode|vss VDD \$5072 VSS|anode|cathode|vss sg13_lv_nmos
+ L=0.13u W=0.42u AS=0.1701p AD=0.03885p PS=1.65u PD=0.605u rfmode=0
M$17932 \$5072 \$4953 \$5000 VSS|anode|cathode|vss sg13_lv_nmos L=0.13u W=0.42u
+ AS=0.03885p AD=0.1596p PS=0.605u PD=1.6u rfmode=0
M$17933 VSS|anode|cathode|vss \$4954 \$5127 VSS|anode|cathode|vss sg13_lv_nmos
+ L=0.13u W=0.74u AS=0.43315p AD=0.2516p PS=2.205u PD=2.16u rfmode=0
M$17934 VSS|anode|cathode|vss CLK|clk|core|fclk_in|p2c|ui_p2c[6] \$4954
+ VSS|anode|cathode|vss sg13_lv_nmos L=0.13u W=0.74u AS=0.43315p AD=0.2516p
+ PS=2.205u PD=2.16u rfmode=0
M$17935 \$5043 \$4954 \$5001 VSS|anode|cathode|vss sg13_lv_nmos L=0.13u W=0.42u
+ AS=0.12665p AD=0.1428p PS=1.145u PD=1.52u rfmode=0
M$17936 \$4953 \$5127 \$5043 VSS|anode|cathode|vss sg13_lv_nmos L=0.13u W=0.74u
+ AS=0.3473p AD=0.12665p PS=2.71u PD=1.145u rfmode=0
M$17937 \$5007 \$5006 VSS|anode|cathode|vss VSS|anode|cathode|vss sg13_lv_nmos
+ L=0.13u W=1.44u AS=0.4068p AD=0.2772p PS=3.29u PD=2.21u rfmode=0
M$17939 \$5007 \$3439 \$5045 VSS|anode|cathode|vss sg13_lv_nmos L=0.13u W=1.44u
+ AS=0.2772p AD=0.3816p PS=2.21u PD=3.22u rfmode=0
M$17941 VSS|anode|cathode|vss VDD \$5068 VSS|anode|cathode|vss sg13_lv_nmos
+ L=0.13u W=0.42u AS=0.1701p AD=0.03885p PS=1.65u PD=0.605u rfmode=0
M$17942 \$5068 \$4955 \$5008 VSS|anode|cathode|vss sg13_lv_nmos L=0.13u W=0.42u
+ AS=0.03885p AD=0.1596p PS=0.605u PD=1.6u rfmode=0
M$17943 VSS|anode|cathode|vss \$4956 \$5130 VSS|anode|cathode|vss sg13_lv_nmos
+ L=0.13u W=0.74u AS=0.43315p AD=0.2516p PS=2.205u PD=2.16u rfmode=0
M$17944 VSS|anode|cathode|vss CLK|clk|core|fclk_in|p2c|ui_p2c[6] \$4956
+ VSS|anode|cathode|vss sg13_lv_nmos L=0.13u W=0.74u AS=0.43315p AD=0.2516p
+ PS=2.205u PD=2.16u rfmode=0
M$17945 \$5046 \$4956 \$5009 VSS|anode|cathode|vss sg13_lv_nmos L=0.13u W=0.42u
+ AS=0.12665p AD=0.1428p PS=1.145u PD=1.52u rfmode=0
M$17946 \$4955 \$5130 \$5046 VSS|anode|cathode|vss sg13_lv_nmos L=0.13u W=0.74u
+ AS=0.3473p AD=0.12665p PS=2.71u PD=1.145u rfmode=0
M$17947 \$5015 \$5014 VSS|anode|cathode|vss VSS|anode|cathode|vss sg13_lv_nmos
+ L=0.13u W=1.44u AS=0.4068p AD=0.2772p PS=3.29u PD=2.21u rfmode=0
M$17949 \$5015 \$3439 \$5048 VSS|anode|cathode|vss sg13_lv_nmos L=0.13u W=1.44u
+ AS=0.2772p AD=0.3816p PS=2.21u PD=3.22u rfmode=0
M$17951 VSS|anode|cathode|vss VDD \$5064 VSS|anode|cathode|vss sg13_lv_nmos
+ L=0.13u W=0.42u AS=0.1701p AD=0.03885p PS=1.65u PD=0.605u rfmode=0
M$17952 \$5064 \$4957 \$5016 VSS|anode|cathode|vss sg13_lv_nmos L=0.13u W=0.42u
+ AS=0.03885p AD=0.1596p PS=0.605u PD=1.6u rfmode=0
M$17953 VSS|anode|cathode|vss \$4958 \$5133 VSS|anode|cathode|vss sg13_lv_nmos
+ L=0.13u W=0.74u AS=0.43315p AD=0.2516p PS=2.205u PD=2.16u rfmode=0
M$17954 VSS|anode|cathode|vss CLK|clk|core|fclk_in|p2c|ui_p2c[6] \$4958
+ VSS|anode|cathode|vss sg13_lv_nmos L=0.13u W=0.74u AS=0.43315p AD=0.2516p
+ PS=2.205u PD=2.16u rfmode=0
M$17955 \$5049 \$4958 \$5017 VSS|anode|cathode|vss sg13_lv_nmos L=0.13u W=0.42u
+ AS=0.12665p AD=0.1428p PS=1.145u PD=1.52u rfmode=0
M$17956 \$4957 \$5133 \$5049 VSS|anode|cathode|vss sg13_lv_nmos L=0.13u W=0.74u
+ AS=0.3473p AD=0.12665p PS=2.71u PD=1.145u rfmode=0
M$17957 \$5023 \$5022 VSS|anode|cathode|vss VSS|anode|cathode|vss sg13_lv_nmos
+ L=0.13u W=1.44u AS=0.4068p AD=0.2772p PS=3.29u PD=2.21u rfmode=0
M$17959 \$5023 \$3439 \$5051 VSS|anode|cathode|vss sg13_lv_nmos L=0.13u W=1.44u
+ AS=0.2772p AD=0.3816p PS=2.21u PD=3.22u rfmode=0
M$17961 VSS|anode|cathode|vss VDD \$5056 VSS|anode|cathode|vss sg13_lv_nmos
+ L=0.13u W=0.42u AS=0.1701p AD=0.03885p PS=1.65u PD=0.605u rfmode=0
M$17962 \$5056 \$4959 \$5025 VSS|anode|cathode|vss sg13_lv_nmos L=0.13u W=0.42u
+ AS=0.03885p AD=0.1596p PS=0.605u PD=1.6u rfmode=0
M$17963 VSS|anode|cathode|vss \$4960 \$5135 VSS|anode|cathode|vss sg13_lv_nmos
+ L=0.13u W=0.74u AS=0.43315p AD=0.2516p PS=2.205u PD=2.16u rfmode=0
M$17964 VSS|anode|cathode|vss CLK|clk|core|fclk_in|p2c|ui_p2c[6] \$4960
+ VSS|anode|cathode|vss sg13_lv_nmos L=0.13u W=0.74u AS=0.43315p AD=0.2516p
+ PS=2.205u PD=2.16u rfmode=0
M$17965 \$5052 \$4960 \$5026 VSS|anode|cathode|vss sg13_lv_nmos L=0.13u W=0.42u
+ AS=0.12665p AD=0.1428p PS=1.145u PD=1.52u rfmode=0
M$17966 \$4959 \$5135 \$5052 VSS|anode|cathode|vss sg13_lv_nmos L=0.13u W=0.74u
+ AS=0.3473p AD=0.12665p PS=2.71u PD=1.145u rfmode=0
M$17967 VSS|anode|cathode|vss \$3192 \$5263 VSS|anode|cathode|vss sg13_lv_nmos
+ L=0.13u W=0.55u AS=0.187p AD=0.1045p PS=1.78u PD=0.93u rfmode=0
M$17968 \$5263 VSS|anode|cathode|vss VSS|anode|cathode|vss
+ VSS|anode|cathode|vss sg13_lv_nmos L=0.13u W=0.55u AS=0.1045p AD=0.146425p
+ PS=0.93u PD=1.155u rfmode=0
M$17969 VSS|anode|cathode|vss \$5263 \$5264 VSS|anode|cathode|vss sg13_lv_nmos
+ L=0.13u W=1.48u AS=0.312925p AD=0.4477p PS=2.345u PD=3.43u rfmode=0
M$17971 \$5265 \$5264 VSS|anode|cathode|vss VSS|anode|cathode|vss sg13_lv_nmos
+ L=0.13u W=1.44u AS=0.4068p AD=0.2772p PS=3.29u PD=2.21u rfmode=0
M$17973 \$5265 \$3685 \$5326 VSS|anode|cathode|vss sg13_lv_nmos L=0.13u W=1.44u
+ AS=0.2772p AD=0.3816p PS=2.21u PD=3.22u rfmode=0
M$17975 \$5266 \$5326 \$5354 VSS|anode|cathode|vss sg13_lv_nmos L=0.13u W=0.42u
+ AS=0.1428p AD=0.0609p PS=1.52u PD=0.71u rfmode=0
M$17976 \$5354 VDD VSS|anode|cathode|vss VSS|anode|cathode|vss sg13_lv_nmos
+ L=0.13u W=0.42u AS=0.0609p AD=0.1626p PS=0.71u PD=1.415u rfmode=0
M$17977 VSS|anode|cathode|vss \$5396 \$5249 VSS|anode|cathode|vss sg13_lv_nmos
+ L=0.13u W=0.74u AS=0.1626p AD=0.2516p PS=1.415u PD=2.16u rfmode=0
M$17978 \$4964 \$4946 \$5078 VSS|anode|cathode|vss sg13_lv_nmos L=0.13u W=0.42u
+ AS=0.1296p AD=0.081p PS=1.52u PD=0.81u rfmode=0
M$17979 \$5078 \$5118 \$4965 VSS|anode|cathode|vss sg13_lv_nmos L=0.13u W=0.42u
+ AS=0.081p AD=0.2163p PS=0.81u PD=1.87u rfmode=0
M$17980 \$5268 \$5397 VSS|anode|cathode|vss VSS|anode|cathode|vss sg13_lv_nmos
+ L=0.13u W=0.42u AS=0.1428p AD=0.0798p PS=1.52u PD=0.8u rfmode=0
M$17981 VSS|anode|cathode|vss VDD \$5357 VSS|anode|cathode|vss sg13_lv_nmos
+ L=0.13u W=0.42u AS=0.0798p AD=0.0378p PS=0.8u PD=0.6u rfmode=0
M$17982 \$5357 \$5328 \$5397 VSS|anode|cathode|vss sg13_lv_nmos L=0.13u W=0.42u
+ AS=0.0378p AD=0.1428p PS=0.6u PD=1.52u rfmode=0
M$17983 VSS|anode|cathode|vss \$5328 \$5270 VSS|anode|cathode|vss sg13_lv_nmos
+ L=0.13u W=0.64u AS=0.1331p AD=0.2176p PS=1.12u PD=1.96u rfmode=0
M$17984 VSS|anode|cathode|vss \$5328 \$5269 VSS|anode|cathode|vss sg13_lv_nmos
+ L=0.13u W=1.48u AS=0.3922p AD=0.2737p PS=3.28u PD=2.24u rfmode=0
M$17986 VSS|anode|cathode|vss \$5270 \$5271 VSS|anode|cathode|vss sg13_lv_nmos
+ L=0.13u W=1.48u AS=0.3922p AD=0.3922p PS=3.28u PD=3.28u rfmode=0
M$17988 VSS|anode|cathode|vss VSS|anode|cathode|vss \$5119
+ VSS|anode|cathode|vss sg13_lv_nmos L=0.13u W=1u AS=0.265p AD=0.265p PS=2.56u
+ PD=2.56u rfmode=0
M$17989 \$5119 \$4967 OUTP|analog_io_padres[16]|core|padres
+ VSS|anode|cathode|vss sg13_lv_nmos L=0.13u W=2u AS=0.38p AD=0.38p PS=3.52u
+ PD=3.52u rfmode=0
M$17991 \$5119 \$4969 OUTN|analog_io_padres[15]|core|padres
+ VSS|anode|cathode|vss sg13_lv_nmos L=0.13u W=2u AS=0.38p AD=0.38p PS=3.52u
+ PD=3.52u rfmode=0
M$17998 VSS|anode|cathode|vss \$3193 \$5272 VSS|anode|cathode|vss sg13_lv_nmos
+ L=0.13u W=0.55u AS=0.187p AD=0.1045p PS=1.78u PD=0.93u rfmode=0
M$17999 \$5272 VSS|anode|cathode|vss VSS|anode|cathode|vss
+ VSS|anode|cathode|vss sg13_lv_nmos L=0.13u W=0.55u AS=0.1045p AD=0.146425p
+ PS=0.93u PD=1.155u rfmode=0
M$18000 VSS|anode|cathode|vss \$5272 \$5273 VSS|anode|cathode|vss sg13_lv_nmos
+ L=0.13u W=1.48u AS=0.312925p AD=0.4477p PS=2.345u PD=3.43u rfmode=0
M$18002 \$5274 \$5273 VSS|anode|cathode|vss VSS|anode|cathode|vss sg13_lv_nmos
+ L=0.13u W=1.44u AS=0.4068p AD=0.2772p PS=3.29u PD=2.21u rfmode=0
M$18004 \$5274 \$3685 \$5330 VSS|anode|cathode|vss sg13_lv_nmos L=0.13u W=1.44u
+ AS=0.2772p AD=0.3816p PS=2.21u PD=3.22u rfmode=0
M$18006 \$5275 \$5330 \$5360 VSS|anode|cathode|vss sg13_lv_nmos L=0.13u W=0.42u
+ AS=0.1428p AD=0.0609p PS=1.52u PD=0.71u rfmode=0
M$18007 \$5360 VDD VSS|anode|cathode|vss VSS|anode|cathode|vss sg13_lv_nmos
+ L=0.13u W=0.42u AS=0.0609p AD=0.1626p PS=0.71u PD=1.415u rfmode=0
M$18008 VSS|anode|cathode|vss \$5398 \$5251 VSS|anode|cathode|vss sg13_lv_nmos
+ L=0.13u W=0.74u AS=0.1626p AD=0.2516p PS=1.415u PD=2.16u rfmode=0
M$18009 \$4973 \$4948 \$5080 VSS|anode|cathode|vss sg13_lv_nmos L=0.13u W=0.42u
+ AS=0.1296p AD=0.081p PS=1.52u PD=0.81u rfmode=0
M$18010 \$5080 \$5120 \$4974 VSS|anode|cathode|vss sg13_lv_nmos L=0.13u W=0.42u
+ AS=0.081p AD=0.2163p PS=0.81u PD=1.87u rfmode=0
M$18011 \$5277 \$5399 VSS|anode|cathode|vss VSS|anode|cathode|vss sg13_lv_nmos
+ L=0.13u W=0.42u AS=0.1428p AD=0.0798p PS=1.52u PD=0.8u rfmode=0
M$18012 VSS|anode|cathode|vss VDD \$5362 VSS|anode|cathode|vss sg13_lv_nmos
+ L=0.13u W=0.42u AS=0.0798p AD=0.0378p PS=0.8u PD=0.6u rfmode=0
M$18013 \$5362 \$5332 \$5399 VSS|anode|cathode|vss sg13_lv_nmos L=0.13u W=0.42u
+ AS=0.0378p AD=0.1428p PS=0.6u PD=1.52u rfmode=0
M$18014 VSS|anode|cathode|vss \$5332 \$5279 VSS|anode|cathode|vss sg13_lv_nmos
+ L=0.13u W=0.64u AS=0.1331p AD=0.2176p PS=1.12u PD=1.96u rfmode=0
M$18015 VSS|anode|cathode|vss \$5332 \$5278 VSS|anode|cathode|vss sg13_lv_nmos
+ L=0.13u W=1.48u AS=0.3922p AD=0.2737p PS=3.28u PD=2.24u rfmode=0
M$18017 VSS|anode|cathode|vss \$5279 \$5280 VSS|anode|cathode|vss sg13_lv_nmos
+ L=0.13u W=1.48u AS=0.3922p AD=0.3922p PS=3.28u PD=3.28u rfmode=0
M$18019 VSS|anode|cathode|vss VSS|anode|cathode|vss \$5121
+ VSS|anode|cathode|vss sg13_lv_nmos L=0.13u W=1u AS=0.265p AD=0.265p PS=2.56u
+ PD=2.56u rfmode=0
M$18020 \$5121 \$4976 OUTP|analog_io_padres[16]|core|padres
+ VSS|anode|cathode|vss sg13_lv_nmos L=0.13u W=2u AS=0.38p AD=0.38p PS=3.52u
+ PD=3.52u rfmode=0
M$18022 \$5121 \$4978 OUTN|analog_io_padres[15]|core|padres
+ VSS|anode|cathode|vss sg13_lv_nmos L=0.13u W=2u AS=0.38p AD=0.38p PS=3.52u
+ PD=3.52u rfmode=0
M$18029 VSS|anode|cathode|vss \$3194 \$5281 VSS|anode|cathode|vss sg13_lv_nmos
+ L=0.13u W=0.55u AS=0.187p AD=0.1045p PS=1.78u PD=0.93u rfmode=0
M$18030 \$5281 VSS|anode|cathode|vss VSS|anode|cathode|vss
+ VSS|anode|cathode|vss sg13_lv_nmos L=0.13u W=0.55u AS=0.1045p AD=0.146425p
+ PS=0.93u PD=1.155u rfmode=0
M$18031 VSS|anode|cathode|vss \$5281 \$5282 VSS|anode|cathode|vss sg13_lv_nmos
+ L=0.13u W=1.48u AS=0.312925p AD=0.4477p PS=2.345u PD=3.43u rfmode=0
M$18033 \$5283 \$5282 VSS|anode|cathode|vss VSS|anode|cathode|vss sg13_lv_nmos
+ L=0.13u W=1.44u AS=0.4068p AD=0.2772p PS=3.29u PD=2.21u rfmode=0
M$18035 \$5283 \$3685 \$5334 VSS|anode|cathode|vss sg13_lv_nmos L=0.13u W=1.44u
+ AS=0.2772p AD=0.3816p PS=2.21u PD=3.22u rfmode=0
M$18037 \$5284 \$5334 \$5367 VSS|anode|cathode|vss sg13_lv_nmos L=0.13u W=0.42u
+ AS=0.1428p AD=0.0609p PS=1.52u PD=0.71u rfmode=0
M$18038 \$5367 VDD VSS|anode|cathode|vss VSS|anode|cathode|vss sg13_lv_nmos
+ L=0.13u W=0.42u AS=0.0609p AD=0.1626p PS=0.71u PD=1.415u rfmode=0
M$18039 VSS|anode|cathode|vss \$5400 \$5253 VSS|anode|cathode|vss sg13_lv_nmos
+ L=0.13u W=0.74u AS=0.1626p AD=0.2516p PS=1.415u PD=2.16u rfmode=0
M$18040 \$5122 \$4950 \$5082 VSS|anode|cathode|vss sg13_lv_nmos L=0.13u W=0.42u
+ AS=0.1296p AD=0.081p PS=1.52u PD=0.81u rfmode=0
M$18041 \$5082 \$5123 \$4982 VSS|anode|cathode|vss sg13_lv_nmos L=0.13u W=0.42u
+ AS=0.081p AD=0.2163p PS=0.81u PD=1.87u rfmode=0
M$18042 \$5286 \$5401 VSS|anode|cathode|vss VSS|anode|cathode|vss sg13_lv_nmos
+ L=0.13u W=0.42u AS=0.1428p AD=0.0798p PS=1.52u PD=0.8u rfmode=0
M$18043 VSS|anode|cathode|vss VDD \$5368 VSS|anode|cathode|vss sg13_lv_nmos
+ L=0.13u W=0.42u AS=0.0798p AD=0.0378p PS=0.8u PD=0.6u rfmode=0
M$18044 \$5368 \$5336 \$5401 VSS|anode|cathode|vss sg13_lv_nmos L=0.13u W=0.42u
+ AS=0.0378p AD=0.1428p PS=0.6u PD=1.52u rfmode=0
M$18045 VSS|anode|cathode|vss \$5336 \$5288 VSS|anode|cathode|vss sg13_lv_nmos
+ L=0.13u W=0.64u AS=0.1331p AD=0.2176p PS=1.12u PD=1.96u rfmode=0
M$18046 VSS|anode|cathode|vss \$5336 \$5287 VSS|anode|cathode|vss sg13_lv_nmos
+ L=0.13u W=1.48u AS=0.3922p AD=0.2737p PS=3.28u PD=2.24u rfmode=0
M$18048 VSS|anode|cathode|vss \$5288 \$5289 VSS|anode|cathode|vss sg13_lv_nmos
+ L=0.13u W=1.48u AS=0.3922p AD=0.3922p PS=3.28u PD=3.28u rfmode=0
M$18050 VSS|anode|cathode|vss VSS|anode|cathode|vss \$5124
+ VSS|anode|cathode|vss sg13_lv_nmos L=0.13u W=1u AS=0.265p AD=0.265p PS=2.56u
+ PD=2.56u rfmode=0
M$18051 \$5124 \$4984 OUTP|analog_io_padres[16]|core|padres
+ VSS|anode|cathode|vss sg13_lv_nmos L=0.13u W=2u AS=0.38p AD=0.38p PS=3.52u
+ PD=3.52u rfmode=0
M$18053 \$5124 \$4986 OUTN|analog_io_padres[15]|core|padres
+ VSS|anode|cathode|vss sg13_lv_nmos L=0.13u W=2u AS=0.38p AD=0.38p PS=3.52u
+ PD=3.52u rfmode=0
M$18060 VSS|anode|cathode|vss \$3195 \$5290 VSS|anode|cathode|vss sg13_lv_nmos
+ L=0.13u W=0.55u AS=0.187p AD=0.1045p PS=1.78u PD=0.93u rfmode=0
M$18061 \$5290 VSS|anode|cathode|vss VSS|anode|cathode|vss
+ VSS|anode|cathode|vss sg13_lv_nmos L=0.13u W=0.55u AS=0.1045p AD=0.146425p
+ PS=0.93u PD=1.155u rfmode=0
M$18062 VSS|anode|cathode|vss \$5290 \$5291 VSS|anode|cathode|vss sg13_lv_nmos
+ L=0.13u W=1.48u AS=0.312925p AD=0.4477p PS=2.345u PD=3.43u rfmode=0
M$18064 \$5292 \$5291 VSS|anode|cathode|vss VSS|anode|cathode|vss sg13_lv_nmos
+ L=0.13u W=1.44u AS=0.4068p AD=0.2772p PS=3.29u PD=2.21u rfmode=0
M$18066 \$5292 \$3685 \$5338 VSS|anode|cathode|vss sg13_lv_nmos L=0.13u W=1.44u
+ AS=0.2772p AD=0.3816p PS=2.21u PD=3.22u rfmode=0
M$18068 \$5293 \$5338 \$5373 VSS|anode|cathode|vss sg13_lv_nmos L=0.13u W=0.42u
+ AS=0.1428p AD=0.0609p PS=1.52u PD=0.71u rfmode=0
M$18069 \$5373 VDD VSS|anode|cathode|vss VSS|anode|cathode|vss sg13_lv_nmos
+ L=0.13u W=0.42u AS=0.0609p AD=0.1626p PS=0.71u PD=1.415u rfmode=0
M$18070 VSS|anode|cathode|vss \$5402 \$5255 VSS|anode|cathode|vss sg13_lv_nmos
+ L=0.13u W=0.74u AS=0.1626p AD=0.2516p PS=1.415u PD=2.16u rfmode=0
M$18071 \$4990 \$4952 \$5084 VSS|anode|cathode|vss sg13_lv_nmos L=0.13u W=0.42u
+ AS=0.1296p AD=0.081p PS=1.52u PD=0.81u rfmode=0
M$18072 \$5084 \$5125 \$4991 VSS|anode|cathode|vss sg13_lv_nmos L=0.13u W=0.42u
+ AS=0.081p AD=0.2163p PS=0.81u PD=1.87u rfmode=0
M$18073 \$5295 \$5403 VSS|anode|cathode|vss VSS|anode|cathode|vss sg13_lv_nmos
+ L=0.13u W=0.42u AS=0.1428p AD=0.0798p PS=1.52u PD=0.8u rfmode=0
M$18074 VSS|anode|cathode|vss VDD \$5374 VSS|anode|cathode|vss sg13_lv_nmos
+ L=0.13u W=0.42u AS=0.0798p AD=0.0378p PS=0.8u PD=0.6u rfmode=0
M$18075 \$5374 \$5340 \$5403 VSS|anode|cathode|vss sg13_lv_nmos L=0.13u W=0.42u
+ AS=0.0378p AD=0.1428p PS=0.6u PD=1.52u rfmode=0
M$18076 VSS|anode|cathode|vss \$5340 \$5297 VSS|anode|cathode|vss sg13_lv_nmos
+ L=0.13u W=0.64u AS=0.1331p AD=0.2176p PS=1.12u PD=1.96u rfmode=0
M$18077 VSS|anode|cathode|vss \$5340 \$5296 VSS|anode|cathode|vss sg13_lv_nmos
+ L=0.13u W=1.48u AS=0.3922p AD=0.2737p PS=3.28u PD=2.24u rfmode=0
M$18079 VSS|anode|cathode|vss \$5297 \$5298 VSS|anode|cathode|vss sg13_lv_nmos
+ L=0.13u W=1.48u AS=0.3922p AD=0.3922p PS=3.28u PD=3.28u rfmode=0
M$18081 VSS|anode|cathode|vss VSS|anode|cathode|vss \$5126
+ VSS|anode|cathode|vss sg13_lv_nmos L=0.13u W=1u AS=0.265p AD=0.265p PS=2.56u
+ PD=2.56u rfmode=0
M$18082 \$5126 \$4993 OUTP|analog_io_padres[16]|core|padres
+ VSS|anode|cathode|vss sg13_lv_nmos L=0.13u W=2u AS=0.38p AD=0.38p PS=3.52u
+ PD=3.52u rfmode=0
M$18084 \$5126 \$4995 OUTN|analog_io_padres[15]|core|padres
+ VSS|anode|cathode|vss sg13_lv_nmos L=0.13u W=2u AS=0.38p AD=0.38p PS=3.52u
+ PD=3.52u rfmode=0
M$18091 VSS|anode|cathode|vss \$3196 \$5299 VSS|anode|cathode|vss sg13_lv_nmos
+ L=0.13u W=0.55u AS=0.187p AD=0.1045p PS=1.78u PD=0.93u rfmode=0
M$18092 \$5299 VSS|anode|cathode|vss VSS|anode|cathode|vss
+ VSS|anode|cathode|vss sg13_lv_nmos L=0.13u W=0.55u AS=0.1045p AD=0.146425p
+ PS=0.93u PD=1.155u rfmode=0
M$18093 VSS|anode|cathode|vss \$5299 \$5300 VSS|anode|cathode|vss sg13_lv_nmos
+ L=0.13u W=1.48u AS=0.312925p AD=0.4477p PS=2.345u PD=3.43u rfmode=0
M$18095 \$5301 \$5300 VSS|anode|cathode|vss VSS|anode|cathode|vss sg13_lv_nmos
+ L=0.13u W=1.44u AS=0.4068p AD=0.2772p PS=3.29u PD=2.21u rfmode=0
M$18097 \$5301 \$3685 \$5342 VSS|anode|cathode|vss sg13_lv_nmos L=0.13u W=1.44u
+ AS=0.2772p AD=0.3816p PS=2.21u PD=3.22u rfmode=0
M$18099 \$5302 \$5342 \$5383 VSS|anode|cathode|vss sg13_lv_nmos L=0.13u W=0.42u
+ AS=0.1428p AD=0.0609p PS=1.52u PD=0.71u rfmode=0
M$18100 \$5383 VDD VSS|anode|cathode|vss VSS|anode|cathode|vss sg13_lv_nmos
+ L=0.13u W=0.42u AS=0.0609p AD=0.1626p PS=0.71u PD=1.415u rfmode=0
M$18101 VSS|anode|cathode|vss \$5404 \$5257 VSS|anode|cathode|vss sg13_lv_nmos
+ L=0.13u W=0.74u AS=0.1626p AD=0.2516p PS=1.415u PD=2.16u rfmode=0
M$18102 \$4999 \$4954 \$5086 VSS|anode|cathode|vss sg13_lv_nmos L=0.13u W=0.42u
+ AS=0.1296p AD=0.081p PS=1.52u PD=0.81u rfmode=0
M$18103 \$5086 \$5127 \$5000 VSS|anode|cathode|vss sg13_lv_nmos L=0.13u W=0.42u
+ AS=0.081p AD=0.2163p PS=0.81u PD=1.87u rfmode=0
M$18104 \$5304 \$5405 VSS|anode|cathode|vss VSS|anode|cathode|vss sg13_lv_nmos
+ L=0.13u W=0.42u AS=0.1428p AD=0.0798p PS=1.52u PD=0.8u rfmode=0
M$18105 VSS|anode|cathode|vss VDD \$5390 VSS|anode|cathode|vss sg13_lv_nmos
+ L=0.13u W=0.42u AS=0.0798p AD=0.0378p PS=0.8u PD=0.6u rfmode=0
M$18106 \$5390 \$5344 \$5405 VSS|anode|cathode|vss sg13_lv_nmos L=0.13u W=0.42u
+ AS=0.0378p AD=0.1428p PS=0.6u PD=1.52u rfmode=0
M$18107 VSS|anode|cathode|vss \$5344 \$5306 VSS|anode|cathode|vss sg13_lv_nmos
+ L=0.13u W=0.64u AS=0.1331p AD=0.2176p PS=1.12u PD=1.96u rfmode=0
M$18108 VSS|anode|cathode|vss \$5344 \$5305 VSS|anode|cathode|vss sg13_lv_nmos
+ L=0.13u W=1.48u AS=0.3922p AD=0.2737p PS=3.28u PD=2.24u rfmode=0
M$18110 VSS|anode|cathode|vss \$5306 \$5307 VSS|anode|cathode|vss sg13_lv_nmos
+ L=0.13u W=1.48u AS=0.3922p AD=0.3922p PS=3.28u PD=3.28u rfmode=0
M$18112 VSS|anode|cathode|vss VSS|anode|cathode|vss \$5128
+ VSS|anode|cathode|vss sg13_lv_nmos L=0.13u W=1u AS=0.265p AD=0.265p PS=2.56u
+ PD=2.56u rfmode=0
M$18113 \$5128 \$5002 OUTP|analog_io_padres[16]|core|padres
+ VSS|anode|cathode|vss sg13_lv_nmos L=0.13u W=2u AS=0.38p AD=0.38p PS=3.52u
+ PD=3.52u rfmode=0
M$18115 \$5128 \$5004 OUTN|analog_io_padres[15]|core|padres
+ VSS|anode|cathode|vss sg13_lv_nmos L=0.13u W=2u AS=0.38p AD=0.38p PS=3.52u
+ PD=3.52u rfmode=0
M$18122 VSS|anode|cathode|vss \$3197 \$5308 VSS|anode|cathode|vss sg13_lv_nmos
+ L=0.13u W=0.55u AS=0.187p AD=0.1045p PS=1.78u PD=0.93u rfmode=0
M$18123 \$5308 VSS|anode|cathode|vss VSS|anode|cathode|vss
+ VSS|anode|cathode|vss sg13_lv_nmos L=0.13u W=0.55u AS=0.1045p AD=0.146425p
+ PS=0.93u PD=1.155u rfmode=0
M$18124 VSS|anode|cathode|vss \$5308 \$5309 VSS|anode|cathode|vss sg13_lv_nmos
+ L=0.13u W=1.48u AS=0.312925p AD=0.4477p PS=2.345u PD=3.43u rfmode=0
M$18126 \$5310 \$5309 VSS|anode|cathode|vss VSS|anode|cathode|vss sg13_lv_nmos
+ L=0.13u W=1.44u AS=0.4068p AD=0.2772p PS=3.29u PD=2.21u rfmode=0
M$18128 \$5310 \$3685 \$5346 VSS|anode|cathode|vss sg13_lv_nmos L=0.13u W=1.44u
+ AS=0.2772p AD=0.3816p PS=2.21u PD=3.22u rfmode=0
M$18130 \$5311 \$5346 \$5394 VSS|anode|cathode|vss sg13_lv_nmos L=0.13u W=0.42u
+ AS=0.1428p AD=0.0609p PS=1.52u PD=0.71u rfmode=0
M$18131 \$5394 VDD VSS|anode|cathode|vss VSS|anode|cathode|vss sg13_lv_nmos
+ L=0.13u W=0.42u AS=0.0609p AD=0.1626p PS=0.71u PD=1.415u rfmode=0
M$18132 VSS|anode|cathode|vss \$5406 \$5259 VSS|anode|cathode|vss sg13_lv_nmos
+ L=0.13u W=0.74u AS=0.1626p AD=0.2516p PS=1.415u PD=2.16u rfmode=0
M$18133 \$5129 \$4956 \$5088 VSS|anode|cathode|vss sg13_lv_nmos L=0.13u W=0.42u
+ AS=0.1296p AD=0.081p PS=1.52u PD=0.81u rfmode=0
M$18134 \$5088 \$5130 \$5008 VSS|anode|cathode|vss sg13_lv_nmos L=0.13u W=0.42u
+ AS=0.081p AD=0.2163p PS=0.81u PD=1.87u rfmode=0
M$18135 \$5313 \$5407 VSS|anode|cathode|vss VSS|anode|cathode|vss sg13_lv_nmos
+ L=0.13u W=0.42u AS=0.1428p AD=0.0798p PS=1.52u PD=0.8u rfmode=0
M$18136 VSS|anode|cathode|vss VDD \$5392 VSS|anode|cathode|vss sg13_lv_nmos
+ L=0.13u W=0.42u AS=0.0798p AD=0.0378p PS=0.8u PD=0.6u rfmode=0
M$18137 \$5392 \$5348 \$5407 VSS|anode|cathode|vss sg13_lv_nmos L=0.13u W=0.42u
+ AS=0.0378p AD=0.1428p PS=0.6u PD=1.52u rfmode=0
M$18138 VSS|anode|cathode|vss \$5348 \$5315 VSS|anode|cathode|vss sg13_lv_nmos
+ L=0.13u W=0.64u AS=0.1331p AD=0.2176p PS=1.12u PD=1.96u rfmode=0
M$18139 VSS|anode|cathode|vss \$5348 \$5314 VSS|anode|cathode|vss sg13_lv_nmos
+ L=0.13u W=1.48u AS=0.3922p AD=0.2737p PS=3.28u PD=2.24u rfmode=0
M$18141 VSS|anode|cathode|vss \$5315 \$5316 VSS|anode|cathode|vss sg13_lv_nmos
+ L=0.13u W=1.48u AS=0.3922p AD=0.3922p PS=3.28u PD=3.28u rfmode=0
M$18143 VSS|anode|cathode|vss VSS|anode|cathode|vss \$5131
+ VSS|anode|cathode|vss sg13_lv_nmos L=0.13u W=1u AS=0.265p AD=0.265p PS=2.56u
+ PD=2.56u rfmode=0
M$18144 \$5131 \$5010 OUTP|analog_io_padres[16]|core|padres
+ VSS|anode|cathode|vss sg13_lv_nmos L=0.13u W=2u AS=0.38p AD=0.38p PS=3.52u
+ PD=3.52u rfmode=0
M$18146 \$5131 \$5012 OUTN|analog_io_padres[15]|core|padres
+ VSS|anode|cathode|vss sg13_lv_nmos L=0.13u W=2u AS=0.38p AD=0.38p PS=3.52u
+ PD=3.52u rfmode=0
M$18153 VSS|anode|cathode|vss \$3198 \$5317 VSS|anode|cathode|vss sg13_lv_nmos
+ L=0.13u W=0.55u AS=0.187p AD=0.1045p PS=1.78u PD=0.93u rfmode=0
M$18154 \$5317 VSS|anode|cathode|vss VSS|anode|cathode|vss
+ VSS|anode|cathode|vss sg13_lv_nmos L=0.13u W=0.55u AS=0.1045p AD=0.146425p
+ PS=0.93u PD=1.155u rfmode=0
M$18155 VSS|anode|cathode|vss \$5317 \$5318 VSS|anode|cathode|vss sg13_lv_nmos
+ L=0.13u W=1.48u AS=0.312925p AD=0.4477p PS=2.345u PD=3.43u rfmode=0
M$18157 \$5319 \$5318 VSS|anode|cathode|vss VSS|anode|cathode|vss sg13_lv_nmos
+ L=0.13u W=1.44u AS=0.4068p AD=0.2772p PS=3.29u PD=2.21u rfmode=0
M$18159 \$5319 \$3685 \$5350 VSS|anode|cathode|vss sg13_lv_nmos L=0.13u W=1.44u
+ AS=0.2772p AD=0.3816p PS=2.21u PD=3.22u rfmode=0
M$18161 \$5320 \$5350 \$5384 VSS|anode|cathode|vss sg13_lv_nmos L=0.13u W=0.42u
+ AS=0.1428p AD=0.0609p PS=1.52u PD=0.71u rfmode=0
M$18162 \$5384 VDD VSS|anode|cathode|vss VSS|anode|cathode|vss sg13_lv_nmos
+ L=0.13u W=0.42u AS=0.0609p AD=0.1626p PS=0.71u PD=1.415u rfmode=0
M$18163 VSS|anode|cathode|vss \$5408 \$5261 VSS|anode|cathode|vss sg13_lv_nmos
+ L=0.13u W=0.74u AS=0.1626p AD=0.2516p PS=1.415u PD=2.16u rfmode=0
M$18164 \$5132 \$4958 \$5090 VSS|anode|cathode|vss sg13_lv_nmos L=0.13u W=0.42u
+ AS=0.1296p AD=0.081p PS=1.52u PD=0.81u rfmode=0
M$18165 \$5090 \$5133 \$5016 VSS|anode|cathode|vss sg13_lv_nmos L=0.13u W=0.42u
+ AS=0.081p AD=0.2163p PS=0.81u PD=1.87u rfmode=0
M$18166 \$5322 \$5409 VSS|anode|cathode|vss VSS|anode|cathode|vss sg13_lv_nmos
+ L=0.13u W=0.42u AS=0.1428p AD=0.0798p PS=1.52u PD=0.8u rfmode=0
M$18167 VSS|anode|cathode|vss VDD \$5381 VSS|anode|cathode|vss sg13_lv_nmos
+ L=0.13u W=0.42u AS=0.0798p AD=0.0378p PS=0.8u PD=0.6u rfmode=0
M$18168 \$5381 \$5352 \$5409 VSS|anode|cathode|vss sg13_lv_nmos L=0.13u W=0.42u
+ AS=0.0378p AD=0.1428p PS=0.6u PD=1.52u rfmode=0
M$18169 VSS|anode|cathode|vss \$5352 \$5324 VSS|anode|cathode|vss sg13_lv_nmos
+ L=0.13u W=0.64u AS=0.1331p AD=0.2176p PS=1.12u PD=1.96u rfmode=0
M$18170 VSS|anode|cathode|vss \$5352 \$5323 VSS|anode|cathode|vss sg13_lv_nmos
+ L=0.13u W=1.48u AS=0.3922p AD=0.2737p PS=3.28u PD=2.24u rfmode=0
M$18172 VSS|anode|cathode|vss \$5324 \$5325 VSS|anode|cathode|vss sg13_lv_nmos
+ L=0.13u W=1.48u AS=0.3922p AD=0.3922p PS=3.28u PD=3.28u rfmode=0
M$18174 VSS|anode|cathode|vss VSS|anode|cathode|vss \$5134
+ VSS|anode|cathode|vss sg13_lv_nmos L=0.13u W=1u AS=0.265p AD=0.265p PS=2.56u
+ PD=2.56u rfmode=0
M$18175 \$5134 \$5018 OUTP|analog_io_padres[16]|core|padres
+ VSS|anode|cathode|vss sg13_lv_nmos L=0.13u W=2u AS=0.38p AD=0.38p PS=3.52u
+ PD=3.52u rfmode=0
M$18177 \$5134 \$5020 OUTN|analog_io_padres[15]|core|padres
+ VSS|anode|cathode|vss sg13_lv_nmos L=0.13u W=2u AS=0.38p AD=0.38p PS=3.52u
+ PD=3.52u rfmode=0
M$18184 \$5024 \$4960 \$5092 VSS|anode|cathode|vss sg13_lv_nmos L=0.13u W=0.42u
+ AS=0.1296p AD=0.081p PS=1.52u PD=0.81u rfmode=0
M$18185 \$5092 \$5135 \$5025 VSS|anode|cathode|vss sg13_lv_nmos L=0.13u W=0.42u
+ AS=0.081p AD=0.2163p PS=0.81u PD=1.87u rfmode=0
M$18186 VSS|anode|cathode|vss VSS|anode|cathode|vss \$5136
+ VSS|anode|cathode|vss sg13_lv_nmos L=0.13u W=1u AS=0.265p AD=0.265p PS=2.56u
+ PD=2.56u rfmode=0
M$18187 \$5136 \$5027 OUTP|analog_io_padres[16]|core|padres
+ VSS|anode|cathode|vss sg13_lv_nmos L=0.13u W=2u AS=0.38p AD=0.38p PS=3.52u
+ PD=3.52u rfmode=0
M$18189 \$5136 \$5029 OUTN|analog_io_padres[15]|core|padres
+ VSS|anode|cathode|vss sg13_lv_nmos L=0.13u W=2u AS=0.38p AD=0.38p PS=3.52u
+ PD=3.52u rfmode=0
M$18196 VSS|anode|cathode|vss VDD \$5355 VSS|anode|cathode|vss sg13_lv_nmos
+ L=0.13u W=0.42u AS=0.1701p AD=0.03885p PS=1.65u PD=0.605u rfmode=0
M$18197 \$5355 \$5249 \$5267 VSS|anode|cathode|vss sg13_lv_nmos L=0.13u W=0.42u
+ AS=0.03885p AD=0.1596p PS=0.605u PD=1.6u rfmode=0
M$18198 \$5266 \$5250 \$5396 VSS|anode|cathode|vss sg13_lv_nmos L=0.13u W=0.42u
+ AS=0.1296p AD=0.081p PS=1.52u PD=0.81u rfmode=0
M$18199 \$5396 \$5327 \$5267 VSS|anode|cathode|vss sg13_lv_nmos L=0.13u W=0.42u
+ AS=0.081p AD=0.2163p PS=0.81u PD=1.87u rfmode=0
M$18200 VSS|anode|cathode|vss \$5250 \$5327 VSS|anode|cathode|vss sg13_lv_nmos
+ L=0.13u W=0.74u AS=0.43315p AD=0.2516p PS=2.205u PD=2.16u rfmode=0
M$18201 VSS|anode|cathode|vss CLK|clk|core|fclk_in|p2c|ui_p2c[6] \$5250
+ VSS|anode|cathode|vss sg13_lv_nmos L=0.13u W=0.74u AS=0.43315p AD=0.2516p
+ PS=2.205u PD=2.16u rfmode=0
M$18202 \$5328 \$5250 \$5268 VSS|anode|cathode|vss sg13_lv_nmos L=0.13u W=0.42u
+ AS=0.12665p AD=0.1428p PS=1.145u PD=1.52u rfmode=0
M$18203 \$5249 \$5327 \$5328 VSS|anode|cathode|vss sg13_lv_nmos L=0.13u W=0.74u
+ AS=0.3473p AD=0.12665p PS=2.71u PD=1.145u rfmode=0
M$18204 VSS|anode|cathode|vss VSS|anode|cathode|vss \$5410
+ VSS|anode|cathode|vss sg13_lv_nmos L=0.13u W=1u AS=0.265p AD=0.265p PS=2.56u
+ PD=2.56u rfmode=0
M$18205 \$5410 \$5269 OUTP|analog_io_padres[16]|core|padres
+ VSS|anode|cathode|vss sg13_lv_nmos L=0.13u W=2u AS=0.38p AD=0.38p PS=3.52u
+ PD=3.52u rfmode=0
M$18207 \$5410 \$5271 OUTN|analog_io_padres[15]|core|padres
+ VSS|anode|cathode|vss sg13_lv_nmos L=0.13u W=2u AS=0.38p AD=0.38p PS=3.52u
+ PD=3.52u rfmode=0
M$18214 VSS|anode|cathode|vss VDD \$5361 VSS|anode|cathode|vss sg13_lv_nmos
+ L=0.13u W=0.42u AS=0.1701p AD=0.03885p PS=1.65u PD=0.605u rfmode=0
M$18215 \$5361 \$5251 \$5276 VSS|anode|cathode|vss sg13_lv_nmos L=0.13u W=0.42u
+ AS=0.03885p AD=0.1596p PS=0.605u PD=1.6u rfmode=0
M$18216 \$5275 \$5252 \$5398 VSS|anode|cathode|vss sg13_lv_nmos L=0.13u W=0.42u
+ AS=0.1296p AD=0.081p PS=1.52u PD=0.81u rfmode=0
M$18217 \$5398 \$5331 \$5276 VSS|anode|cathode|vss sg13_lv_nmos L=0.13u W=0.42u
+ AS=0.081p AD=0.2163p PS=0.81u PD=1.87u rfmode=0
M$18218 VSS|anode|cathode|vss \$5252 \$5331 VSS|anode|cathode|vss sg13_lv_nmos
+ L=0.13u W=0.74u AS=0.43315p AD=0.2516p PS=2.205u PD=2.16u rfmode=0
M$18219 VSS|anode|cathode|vss CLK|clk|core|fclk_in|p2c|ui_p2c[6] \$5252
+ VSS|anode|cathode|vss sg13_lv_nmos L=0.13u W=0.74u AS=0.43315p AD=0.2516p
+ PS=2.205u PD=2.16u rfmode=0
M$18220 \$5332 \$5252 \$5277 VSS|anode|cathode|vss sg13_lv_nmos L=0.13u W=0.42u
+ AS=0.12665p AD=0.1428p PS=1.145u PD=1.52u rfmode=0
M$18221 \$5251 \$5331 \$5332 VSS|anode|cathode|vss sg13_lv_nmos L=0.13u W=0.74u
+ AS=0.3473p AD=0.12665p PS=2.71u PD=1.145u rfmode=0
M$18222 VSS|anode|cathode|vss VSS|anode|cathode|vss \$5411
+ VSS|anode|cathode|vss sg13_lv_nmos L=0.13u W=1u AS=0.265p AD=0.265p PS=2.56u
+ PD=2.56u rfmode=0
M$18223 \$5411 \$5278 OUTP|analog_io_padres[16]|core|padres
+ VSS|anode|cathode|vss sg13_lv_nmos L=0.13u W=2u AS=0.38p AD=0.38p PS=3.52u
+ PD=3.52u rfmode=0
M$18225 \$5411 \$5280 OUTN|analog_io_padres[15]|core|padres
+ VSS|anode|cathode|vss sg13_lv_nmos L=0.13u W=2u AS=0.38p AD=0.38p PS=3.52u
+ PD=3.52u rfmode=0
M$18232 VSS|anode|cathode|vss VDD \$5366 VSS|anode|cathode|vss sg13_lv_nmos
+ L=0.13u W=0.42u AS=0.1701p AD=0.03885p PS=1.65u PD=0.605u rfmode=0
M$18233 \$5366 \$5253 \$5285 VSS|anode|cathode|vss sg13_lv_nmos L=0.13u W=0.42u
+ AS=0.03885p AD=0.1596p PS=0.605u PD=1.6u rfmode=0
M$18234 \$5284 \$5254 \$5400 VSS|anode|cathode|vss sg13_lv_nmos L=0.13u W=0.42u
+ AS=0.1296p AD=0.081p PS=1.52u PD=0.81u rfmode=0
M$18235 \$5400 \$5335 \$5285 VSS|anode|cathode|vss sg13_lv_nmos L=0.13u W=0.42u
+ AS=0.081p AD=0.2163p PS=0.81u PD=1.87u rfmode=0
M$18236 VSS|anode|cathode|vss \$5254 \$5335 VSS|anode|cathode|vss sg13_lv_nmos
+ L=0.13u W=0.74u AS=0.43315p AD=0.2516p PS=2.205u PD=2.16u rfmode=0
M$18237 VSS|anode|cathode|vss CLK|clk|core|fclk_in|p2c|ui_p2c[6] \$5254
+ VSS|anode|cathode|vss sg13_lv_nmos L=0.13u W=0.74u AS=0.43315p AD=0.2516p
+ PS=2.205u PD=2.16u rfmode=0
M$18238 \$5336 \$5254 \$5286 VSS|anode|cathode|vss sg13_lv_nmos L=0.13u W=0.42u
+ AS=0.12665p AD=0.1428p PS=1.145u PD=1.52u rfmode=0
M$18239 \$5253 \$5335 \$5336 VSS|anode|cathode|vss sg13_lv_nmos L=0.13u W=0.74u
+ AS=0.3473p AD=0.12665p PS=2.71u PD=1.145u rfmode=0
M$18240 VSS|anode|cathode|vss VSS|anode|cathode|vss \$5412
+ VSS|anode|cathode|vss sg13_lv_nmos L=0.13u W=1u AS=0.265p AD=0.265p PS=2.56u
+ PD=2.56u rfmode=0
M$18241 \$5412 \$5287 OUTP|analog_io_padres[16]|core|padres
+ VSS|anode|cathode|vss sg13_lv_nmos L=0.13u W=2u AS=0.38p AD=0.38p PS=3.52u
+ PD=3.52u rfmode=0
M$18243 \$5412 \$5289 OUTN|analog_io_padres[15]|core|padres
+ VSS|anode|cathode|vss sg13_lv_nmos L=0.13u W=2u AS=0.38p AD=0.38p PS=3.52u
+ PD=3.52u rfmode=0
M$18250 VSS|anode|cathode|vss VDD \$5372 VSS|anode|cathode|vss sg13_lv_nmos
+ L=0.13u W=0.42u AS=0.1701p AD=0.03885p PS=1.65u PD=0.605u rfmode=0
M$18251 \$5372 \$5255 \$5294 VSS|anode|cathode|vss sg13_lv_nmos L=0.13u W=0.42u
+ AS=0.03885p AD=0.1596p PS=0.605u PD=1.6u rfmode=0
M$18252 \$5293 \$5256 \$5402 VSS|anode|cathode|vss sg13_lv_nmos L=0.13u W=0.42u
+ AS=0.1296p AD=0.081p PS=1.52u PD=0.81u rfmode=0
M$18253 \$5402 \$5339 \$5294 VSS|anode|cathode|vss sg13_lv_nmos L=0.13u W=0.42u
+ AS=0.081p AD=0.2163p PS=0.81u PD=1.87u rfmode=0
M$18254 VSS|anode|cathode|vss \$5256 \$5339 VSS|anode|cathode|vss sg13_lv_nmos
+ L=0.13u W=0.74u AS=0.43315p AD=0.2516p PS=2.205u PD=2.16u rfmode=0
M$18255 VSS|anode|cathode|vss CLK|clk|core|fclk_in|p2c|ui_p2c[6] \$5256
+ VSS|anode|cathode|vss sg13_lv_nmos L=0.13u W=0.74u AS=0.43315p AD=0.2516p
+ PS=2.205u PD=2.16u rfmode=0
M$18256 \$5340 \$5256 \$5295 VSS|anode|cathode|vss sg13_lv_nmos L=0.13u W=0.42u
+ AS=0.12665p AD=0.1428p PS=1.145u PD=1.52u rfmode=0
M$18257 \$5255 \$5339 \$5340 VSS|anode|cathode|vss sg13_lv_nmos L=0.13u W=0.74u
+ AS=0.3473p AD=0.12665p PS=2.71u PD=1.145u rfmode=0
M$18258 VSS|anode|cathode|vss VSS|anode|cathode|vss \$5413
+ VSS|anode|cathode|vss sg13_lv_nmos L=0.13u W=1u AS=0.265p AD=0.265p PS=2.56u
+ PD=2.56u rfmode=0
M$18259 \$5413 \$5296 OUTP|analog_io_padres[16]|core|padres
+ VSS|anode|cathode|vss sg13_lv_nmos L=0.13u W=2u AS=0.38p AD=0.38p PS=3.52u
+ PD=3.52u rfmode=0
M$18261 \$5413 \$5298 OUTN|analog_io_padres[15]|core|padres
+ VSS|anode|cathode|vss sg13_lv_nmos L=0.13u W=2u AS=0.38p AD=0.38p PS=3.52u
+ PD=3.52u rfmode=0
M$18268 VSS|anode|cathode|vss VDD \$5382 VSS|anode|cathode|vss sg13_lv_nmos
+ L=0.13u W=0.42u AS=0.1701p AD=0.03885p PS=1.65u PD=0.605u rfmode=0
M$18269 \$5382 \$5257 \$5303 VSS|anode|cathode|vss sg13_lv_nmos L=0.13u W=0.42u
+ AS=0.03885p AD=0.1596p PS=0.605u PD=1.6u rfmode=0
M$18270 \$5302 \$5258 \$5404 VSS|anode|cathode|vss sg13_lv_nmos L=0.13u W=0.42u
+ AS=0.1296p AD=0.081p PS=1.52u PD=0.81u rfmode=0
M$18271 \$5404 \$5343 \$5303 VSS|anode|cathode|vss sg13_lv_nmos L=0.13u W=0.42u
+ AS=0.081p AD=0.2163p PS=0.81u PD=1.87u rfmode=0
M$18272 VSS|anode|cathode|vss \$5258 \$5343 VSS|anode|cathode|vss sg13_lv_nmos
+ L=0.13u W=0.74u AS=0.43315p AD=0.2516p PS=2.205u PD=2.16u rfmode=0
M$18273 VSS|anode|cathode|vss CLK|clk|core|fclk_in|p2c|ui_p2c[6] \$5258
+ VSS|anode|cathode|vss sg13_lv_nmos L=0.13u W=0.74u AS=0.43315p AD=0.2516p
+ PS=2.205u PD=2.16u rfmode=0
M$18274 \$5344 \$5258 \$5304 VSS|anode|cathode|vss sg13_lv_nmos L=0.13u W=0.42u
+ AS=0.12665p AD=0.1428p PS=1.145u PD=1.52u rfmode=0
M$18275 \$5257 \$5343 \$5344 VSS|anode|cathode|vss sg13_lv_nmos L=0.13u W=0.74u
+ AS=0.3473p AD=0.12665p PS=2.71u PD=1.145u rfmode=0
M$18276 VSS|anode|cathode|vss VSS|anode|cathode|vss \$5414
+ VSS|anode|cathode|vss sg13_lv_nmos L=0.13u W=1u AS=0.265p AD=0.265p PS=2.56u
+ PD=2.56u rfmode=0
M$18277 \$5414 \$5305 OUTP|analog_io_padres[16]|core|padres
+ VSS|anode|cathode|vss sg13_lv_nmos L=0.13u W=2u AS=0.38p AD=0.38p PS=3.52u
+ PD=3.52u rfmode=0
M$18279 \$5414 \$5307 OUTN|analog_io_padres[15]|core|padres
+ VSS|anode|cathode|vss sg13_lv_nmos L=0.13u W=2u AS=0.38p AD=0.38p PS=3.52u
+ PD=3.52u rfmode=0
M$18286 VSS|anode|cathode|vss VDD \$5395 VSS|anode|cathode|vss sg13_lv_nmos
+ L=0.13u W=0.42u AS=0.1701p AD=0.03885p PS=1.65u PD=0.605u rfmode=0
M$18287 \$5395 \$5259 \$5312 VSS|anode|cathode|vss sg13_lv_nmos L=0.13u W=0.42u
+ AS=0.03885p AD=0.1596p PS=0.605u PD=1.6u rfmode=0
M$18288 \$5311 \$5260 \$5406 VSS|anode|cathode|vss sg13_lv_nmos L=0.13u W=0.42u
+ AS=0.1296p AD=0.081p PS=1.52u PD=0.81u rfmode=0
M$18289 \$5406 \$5347 \$5312 VSS|anode|cathode|vss sg13_lv_nmos L=0.13u W=0.42u
+ AS=0.081p AD=0.2163p PS=0.81u PD=1.87u rfmode=0
M$18290 VSS|anode|cathode|vss \$5260 \$5347 VSS|anode|cathode|vss sg13_lv_nmos
+ L=0.13u W=0.74u AS=0.43315p AD=0.2516p PS=2.205u PD=2.16u rfmode=0
M$18291 VSS|anode|cathode|vss CLK|clk|core|fclk_in|p2c|ui_p2c[6] \$5260
+ VSS|anode|cathode|vss sg13_lv_nmos L=0.13u W=0.74u AS=0.43315p AD=0.2516p
+ PS=2.205u PD=2.16u rfmode=0
M$18292 \$5348 \$5260 \$5313 VSS|anode|cathode|vss sg13_lv_nmos L=0.13u W=0.42u
+ AS=0.12665p AD=0.1428p PS=1.145u PD=1.52u rfmode=0
M$18293 \$5259 \$5347 \$5348 VSS|anode|cathode|vss sg13_lv_nmos L=0.13u W=0.74u
+ AS=0.3473p AD=0.12665p PS=2.71u PD=1.145u rfmode=0
M$18294 VSS|anode|cathode|vss VSS|anode|cathode|vss \$5415
+ VSS|anode|cathode|vss sg13_lv_nmos L=0.13u W=1u AS=0.265p AD=0.265p PS=2.56u
+ PD=2.56u rfmode=0
M$18295 \$5415 \$5314 OUTP|analog_io_padres[16]|core|padres
+ VSS|anode|cathode|vss sg13_lv_nmos L=0.13u W=2u AS=0.38p AD=0.38p PS=3.52u
+ PD=3.52u rfmode=0
M$18297 \$5415 \$5316 OUTN|analog_io_padres[15]|core|padres
+ VSS|anode|cathode|vss sg13_lv_nmos L=0.13u W=2u AS=0.38p AD=0.38p PS=3.52u
+ PD=3.52u rfmode=0
M$18304 VSS|anode|cathode|vss VDD \$5385 VSS|anode|cathode|vss sg13_lv_nmos
+ L=0.13u W=0.42u AS=0.1701p AD=0.03885p PS=1.65u PD=0.605u rfmode=0
M$18305 \$5385 \$5261 \$5321 VSS|anode|cathode|vss sg13_lv_nmos L=0.13u W=0.42u
+ AS=0.03885p AD=0.1596p PS=0.605u PD=1.6u rfmode=0
M$18306 \$5320 \$5262 \$5408 VSS|anode|cathode|vss sg13_lv_nmos L=0.13u W=0.42u
+ AS=0.1296p AD=0.081p PS=1.52u PD=0.81u rfmode=0
M$18307 \$5408 \$5351 \$5321 VSS|anode|cathode|vss sg13_lv_nmos L=0.13u W=0.42u
+ AS=0.081p AD=0.2163p PS=0.81u PD=1.87u rfmode=0
M$18308 VSS|anode|cathode|vss \$5262 \$5351 VSS|anode|cathode|vss sg13_lv_nmos
+ L=0.13u W=0.74u AS=0.43315p AD=0.2516p PS=2.205u PD=2.16u rfmode=0
M$18309 VSS|anode|cathode|vss CLK|clk|core|fclk_in|p2c|ui_p2c[6] \$5262
+ VSS|anode|cathode|vss sg13_lv_nmos L=0.13u W=0.74u AS=0.43315p AD=0.2516p
+ PS=2.205u PD=2.16u rfmode=0
M$18310 \$5352 \$5262 \$5322 VSS|anode|cathode|vss sg13_lv_nmos L=0.13u W=0.42u
+ AS=0.12665p AD=0.1428p PS=1.145u PD=1.52u rfmode=0
M$18311 \$5261 \$5351 \$5352 VSS|anode|cathode|vss sg13_lv_nmos L=0.13u W=0.74u
+ AS=0.3473p AD=0.12665p PS=2.71u PD=1.145u rfmode=0
M$18312 VSS|anode|cathode|vss VSS|anode|cathode|vss \$5416
+ VSS|anode|cathode|vss sg13_lv_nmos L=0.13u W=1u AS=0.265p AD=0.265p PS=2.56u
+ PD=2.56u rfmode=0
M$18313 \$5416 \$5323 OUTP|analog_io_padres[16]|core|padres
+ VSS|anode|cathode|vss sg13_lv_nmos L=0.13u W=2u AS=0.38p AD=0.38p PS=3.52u
+ PD=3.52u rfmode=0
M$18315 \$5416 \$5325 OUTN|analog_io_padres[15]|core|padres
+ VSS|anode|cathode|vss sg13_lv_nmos L=0.13u W=2u AS=0.38p AD=0.38p PS=3.52u
+ PD=3.52u rfmode=0
M$18322 VSS|anode|cathode|vss \$5578 \$3194 VSS|anode|cathode|vss sg13_lv_nmos
+ L=0.13u W=1.48u AS=0.4477p AD=0.312925p PS=3.43u PD=2.345u rfmode=0
M$18324 VSS|anode|cathode|vss \$5574 \$5578 VSS|anode|cathode|vss sg13_lv_nmos
+ L=0.13u W=0.55u AS=0.146425p AD=0.1045p PS=1.155u PD=0.93u rfmode=0
M$18325 \$5578 X7|dout[8] VSS|anode|cathode|vss VSS|anode|cathode|vss
+ sg13_lv_nmos L=0.13u W=0.55u AS=0.1045p AD=0.187p PS=0.93u PD=1.78u rfmode=0
M$18326 VSS|anode|cathode|vss \$5563 \$3196 VSS|anode|cathode|vss sg13_lv_nmos
+ L=0.13u W=1.48u AS=0.4218p AD=0.2737p PS=3.36u PD=2.24u rfmode=0
M$18328 VSS|anode|cathode|vss \$5576 \$5583 VSS|anode|cathode|vss sg13_lv_nmos
+ L=0.13u W=0.64u AS=0.1331p AD=0.1216p PS=1.12u PD=1.02u rfmode=0
M$18329 \$5583 X7|dout[8] \$5563 VSS|anode|cathode|vss sg13_lv_nmos L=0.13u
+ W=0.64u AS=0.1216p AD=0.2176p PS=1.02u PD=1.96u rfmode=0
M$18330 VSS|anode|cathode|vss \$5564 \$3192 VSS|anode|cathode|vss sg13_lv_nmos
+ L=0.13u W=1.48u AS=0.4477p AD=0.312925p PS=3.43u PD=2.345u rfmode=0
M$18332 VSS|anode|cathode|vss \$3193 \$5564 VSS|anode|cathode|vss sg13_lv_nmos
+ L=0.13u W=0.55u AS=0.146425p AD=0.1045p PS=1.155u PD=0.93u rfmode=0
M$18333 \$5564 X5|dout[6] VSS|anode|cathode|vss VSS|anode|cathode|vss
+ sg13_lv_nmos L=0.13u W=0.55u AS=0.1045p AD=0.187p PS=0.93u PD=1.78u rfmode=0
M$18334 VSS|anode|cathode|vss \$5565 \$3198 VSS|anode|cathode|vss sg13_lv_nmos
+ L=0.13u W=1.48u AS=0.4218p AD=0.2737p PS=3.36u PD=2.24u rfmode=0
M$18336 VSS|anode|cathode|vss \$5577 \$5585 VSS|anode|cathode|vss sg13_lv_nmos
+ L=0.13u W=0.64u AS=0.1331p AD=0.1216p PS=1.12u PD=1.02u rfmode=0
M$18337 \$5585 X7|dout[8] \$5565 VSS|anode|cathode|vss sg13_lv_nmos L=0.13u
+ W=0.64u AS=0.1216p AD=0.2176p PS=1.02u PD=1.96u rfmode=0
M$18338 \$5556 X3|dout[4] \$5568 VSS|anode|cathode|vss sg13_lv_nmos L=0.13u
+ W=0.42u AS=0.1428p AD=0.0609p PS=1.52u PD=0.71u rfmode=0
M$18339 \$5568 VDD VSS|anode|cathode|vss VSS|anode|cathode|vss sg13_lv_nmos
+ L=0.13u W=0.42u AS=0.0609p AD=0.1626p PS=0.71u PD=1.415u rfmode=0
M$18340 VSS|anode|cathode|vss \$5579 \$5557 VSS|anode|cathode|vss sg13_lv_nmos
+ L=0.13u W=0.74u AS=0.1626p AD=0.2516p PS=1.415u PD=2.16u rfmode=0
M$18341 VSS|anode|cathode|vss \$5532 \$5531 VSS|anode|cathode|vss sg13_lv_nmos
+ L=0.13u W=0.74u AS=0.1626p AD=0.2516p PS=1.415u PD=2.16u rfmode=0
M$18342 \$5527 X4|dout[5] \$5554 VSS|anode|cathode|vss sg13_lv_nmos L=0.13u
+ W=0.42u AS=0.1428p AD=0.0609p PS=1.52u PD=0.71u rfmode=0
M$18343 VSS|anode|cathode|vss VDD \$5554 VSS|anode|cathode|vss sg13_lv_nmos
+ L=0.13u W=0.42u AS=0.1626p AD=0.0609p PS=1.415u PD=0.71u rfmode=0
M$18344 VSS|anode|cathode|vss VDD \$5570 VSS|anode|cathode|vss sg13_lv_nmos
+ L=0.13u W=0.42u AS=0.1701p AD=0.03885p PS=1.65u PD=0.605u rfmode=0
M$18345 \$5570 \$5557 \$5566 VSS|anode|cathode|vss sg13_lv_nmos L=0.13u W=0.42u
+ AS=0.03885p AD=0.1596p PS=0.605u PD=1.6u rfmode=0
M$18346 VSS|anode|cathode|vss VDD \$5550 VSS|anode|cathode|vss sg13_lv_nmos
+ L=0.13u W=0.42u AS=0.1701p AD=0.03885p PS=1.65u PD=0.605u rfmode=0
M$18347 \$5550 \$5531 \$5544 VSS|anode|cathode|vss sg13_lv_nmos L=0.13u W=0.42u
+ AS=0.03885p AD=0.1596p PS=0.605u PD=1.6u rfmode=0
M$18348 \$5532 \$5542 \$5527 VSS|anode|cathode|vss sg13_lv_nmos L=0.13u W=0.42u
+ AS=0.081p AD=0.1296p PS=0.81u PD=1.52u rfmode=0
M$18349 \$5532 \$5535 \$5544 VSS|anode|cathode|vss sg13_lv_nmos L=0.13u W=0.42u
+ AS=0.081p AD=0.2163p PS=0.81u PD=1.87u rfmode=0
M$18350 \$5535 \$5542 VSS|anode|cathode|vss VSS|anode|cathode|vss sg13_lv_nmos
+ L=0.13u W=0.74u AS=0.2516p AD=0.43315p PS=2.16u PD=2.205u rfmode=0
M$18351 VSS|anode|cathode|vss CLK|clk|core|fclk_in|p2c|ui_p2c[6] \$5542
+ VSS|anode|cathode|vss sg13_lv_nmos L=0.13u W=0.74u AS=0.43315p AD=0.2516p
+ PS=2.205u PD=2.16u rfmode=0
M$18352 VSS|anode|cathode|vss \$5558 \$5580 VSS|anode|cathode|vss sg13_lv_nmos
+ L=0.13u W=0.74u AS=0.43315p AD=0.2516p PS=2.205u PD=2.16u rfmode=0
M$18353 VSS|anode|cathode|vss CLK|clk|core|fclk_in|p2c|ui_p2c[6] \$5558
+ VSS|anode|cathode|vss sg13_lv_nmos L=0.13u W=0.74u AS=0.43315p AD=0.2516p
+ PS=2.205u PD=2.16u rfmode=0
M$18354 \$5545 \$5542 \$5536 VSS|anode|cathode|vss sg13_lv_nmos L=0.13u W=0.42u
+ AS=0.1428p AD=0.12665p PS=1.52u PD=1.145u rfmode=0
M$18355 \$5536 \$5535 \$5531 VSS|anode|cathode|vss sg13_lv_nmos L=0.13u W=0.74u
+ AS=0.12665p AD=0.3473p PS=1.145u PD=2.71u rfmode=0
M$18356 \$5575 \$5558 \$5559 VSS|anode|cathode|vss sg13_lv_nmos L=0.13u W=0.42u
+ AS=0.12665p AD=0.1428p PS=1.145u PD=1.52u rfmode=0
M$18357 \$5557 \$5580 \$5575 VSS|anode|cathode|vss sg13_lv_nmos L=0.13u W=0.74u
+ AS=0.3473p AD=0.12665p PS=2.71u PD=1.145u rfmode=0
M$18358 \$5559 \$5581 VSS|anode|cathode|vss VSS|anode|cathode|vss sg13_lv_nmos
+ L=0.13u W=0.42u AS=0.1428p AD=0.0798p PS=1.52u PD=0.8u rfmode=0
M$18359 VSS|anode|cathode|vss VDD \$5569 VSS|anode|cathode|vss sg13_lv_nmos
+ L=0.13u W=0.42u AS=0.0798p AD=0.0378p PS=0.8u PD=0.6u rfmode=0
M$18360 \$5569 \$5575 \$5581 VSS|anode|cathode|vss sg13_lv_nmos L=0.13u W=0.42u
+ AS=0.0378p AD=0.1428p PS=0.6u PD=1.52u rfmode=0
M$18361 \$5545 \$5537 VSS|anode|cathode|vss VSS|anode|cathode|vss sg13_lv_nmos
+ L=0.13u W=0.42u AS=0.1428p AD=0.0798p PS=1.52u PD=0.8u rfmode=0
M$18362 VSS|anode|cathode|vss VDD \$5553 VSS|anode|cathode|vss sg13_lv_nmos
+ L=0.13u W=0.42u AS=0.0798p AD=0.0378p PS=0.8u PD=0.6u rfmode=0
M$18363 \$5553 \$5536 \$5537 VSS|anode|cathode|vss sg13_lv_nmos L=0.13u W=0.42u
+ AS=0.0378p AD=0.1428p PS=0.6u PD=1.52u rfmode=0
M$18364 VSS|anode|cathode|vss \$5536 \$5501 VSS|anode|cathode|vss sg13_lv_nmos
+ L=0.13u W=1.48u AS=0.3922p AD=0.2737p PS=3.28u PD=2.24u rfmode=0
M$18366 VSS|anode|cathode|vss \$5536 \$5533 VSS|anode|cathode|vss sg13_lv_nmos
+ L=0.13u W=0.64u AS=0.1331p AD=0.2176p PS=1.12u PD=1.96u rfmode=0
M$18367 VSS|anode|cathode|vss \$5575 \$5561 VSS|anode|cathode|vss sg13_lv_nmos
+ L=0.13u W=0.64u AS=0.1331p AD=0.2176p PS=1.12u PD=1.96u rfmode=0
M$18368 VSS|anode|cathode|vss \$5575 \$5560 VSS|anode|cathode|vss sg13_lv_nmos
+ L=0.13u W=1.48u AS=0.3922p AD=0.2737p PS=3.28u PD=2.24u rfmode=0
M$18370 VSS|anode|cathode|vss \$5561 \$5562 VSS|anode|cathode|vss sg13_lv_nmos
+ L=0.13u W=1.48u AS=0.3922p AD=0.3922p PS=3.28u PD=3.28u rfmode=0
M$18372 VSS|anode|cathode|vss \$5533 \$5528 VSS|anode|cathode|vss sg13_lv_nmos
+ L=0.13u W=1.48u AS=0.3922p AD=0.3922p PS=3.28u PD=3.28u rfmode=0
M$18374 VSS|anode|cathode|vss VSS|anode|cathode|vss \$5502
+ VSS|anode|cathode|vss sg13_lv_nmos L=0.13u W=1u AS=0.265p AD=0.265p PS=2.56u
+ PD=2.56u rfmode=0
M$18375 \$5502 \$5501 OUTN|analog_io_padres[15]|core|padres
+ VSS|anode|cathode|vss sg13_lv_nmos L=0.13u W=2u AS=0.38p AD=0.38p PS=3.52u
+ PD=3.52u rfmode=0
M$18377 \$5502 \$5528 OUTP|analog_io_padres[16]|core|padres
+ VSS|anode|cathode|vss sg13_lv_nmos L=0.13u W=2u AS=0.38p AD=0.38p PS=3.52u
+ PD=3.52u rfmode=0
M$18384 VSS|anode|cathode|vss \$5593 \$5574 VSS|anode|cathode|vss sg13_lv_nmos
+ L=0.13u W=1.48u AS=0.4218p AD=0.2737p PS=3.36u PD=2.24u rfmode=0
M$18386 VSS|anode|cathode|vss X6|dout[7] \$5608 VSS|anode|cathode|vss
+ sg13_lv_nmos L=0.13u W=0.64u AS=0.1331p AD=0.1216p PS=1.12u PD=1.02u rfmode=0
M$18387 \$5608 X5|dout[6] \$5593 VSS|anode|cathode|vss sg13_lv_nmos L=0.13u
+ W=0.64u AS=0.1216p AD=0.2176p PS=1.02u PD=1.96u rfmode=0
M$18388 VSS|anode|cathode|vss \$5594 \$5576 VSS|anode|cathode|vss sg13_lv_nmos
+ L=0.13u W=1.48u AS=0.4477p AD=0.312925p PS=3.43u PD=2.345u rfmode=0
M$18390 VSS|anode|cathode|vss X5|dout[6] \$5594 VSS|anode|cathode|vss
+ sg13_lv_nmos L=0.13u W=0.55u AS=0.146425p AD=0.1045p PS=1.155u PD=0.93u
+ rfmode=0
M$18391 \$5594 X6|dout[7] VSS|anode|cathode|vss VSS|anode|cathode|vss
+ sg13_lv_nmos L=0.13u W=0.55u AS=0.1045p AD=0.187p PS=0.93u PD=1.78u rfmode=0
M$18392 VSS|anode|cathode|vss \$5595 \$3193 VSS|anode|cathode|vss sg13_lv_nmos
+ L=0.13u W=1.48u AS=0.4477p AD=0.312925p PS=3.43u PD=2.345u rfmode=0
M$18394 VSS|anode|cathode|vss X7|dout[8] \$5595 VSS|anode|cathode|vss
+ sg13_lv_nmos L=0.13u W=0.55u AS=0.146425p AD=0.1045p PS=1.155u PD=0.93u
+ rfmode=0
M$18395 \$5595 X6|dout[7] VSS|anode|cathode|vss VSS|anode|cathode|vss
+ sg13_lv_nmos L=0.13u W=0.55u AS=0.1045p AD=0.187p PS=0.93u PD=1.78u rfmode=0
M$18396 VSS|anode|cathode|vss \$5601 \$3197 VSS|anode|cathode|vss sg13_lv_nmos
+ L=0.13u W=1.48u AS=0.4218p AD=0.2737p PS=3.36u PD=2.24u rfmode=0
M$18398 VSS|anode|cathode|vss X7|dout[8] \$5612 VSS|anode|cathode|vss
+ sg13_lv_nmos L=0.13u W=0.64u AS=0.1331p AD=0.1216p PS=1.12u PD=1.02u rfmode=0
M$18399 \$5612 X6|dout[7] \$5601 VSS|anode|cathode|vss sg13_lv_nmos L=0.13u
+ W=0.64u AS=0.1216p AD=0.2176p PS=1.02u PD=1.96u rfmode=0
M$18400 VSS|anode|cathode|vss \$5596 \$5577 VSS|anode|cathode|vss sg13_lv_nmos
+ L=0.13u W=1.48u AS=0.4218p AD=0.2737p PS=3.36u PD=2.24u rfmode=0
M$18402 VSS|anode|cathode|vss X6|dout[7] \$5611 VSS|anode|cathode|vss
+ sg13_lv_nmos L=0.13u W=0.64u AS=0.1331p AD=0.1216p PS=1.12u PD=1.02u rfmode=0
M$18403 \$5611 X5|dout[6] \$5596 VSS|anode|cathode|vss sg13_lv_nmos L=0.13u
+ W=0.64u AS=0.1216p AD=0.2176p PS=1.02u PD=1.96u rfmode=0
M$18404 \$5556 \$5558 \$5579 VSS|anode|cathode|vss sg13_lv_nmos L=0.13u W=0.42u
+ AS=0.1296p AD=0.081p PS=1.52u PD=0.81u rfmode=0
M$18405 \$5579 \$5580 \$5566 VSS|anode|cathode|vss sg13_lv_nmos L=0.13u W=0.42u
+ AS=0.081p AD=0.2163p PS=0.81u PD=1.87u rfmode=0
M$18406 VSS|anode|cathode|vss \$5592 \$3195 VSS|anode|cathode|vss sg13_lv_nmos
+ L=0.13u W=1.48u AS=0.3922p AD=0.2777p PS=3.28u PD=2.24u rfmode=0
M$18408 VSS|anode|cathode|vss X7|dout[8] \$5592 VSS|anode|cathode|vss
+ sg13_lv_nmos L=0.13u W=0.64u AS=0.1371p AD=0.2176p PS=1.12u PD=1.96u rfmode=0
M$18409 VSS|anode|cathode|vss VSS|anode|cathode|vss \$5582
+ VSS|anode|cathode|vss sg13_lv_nmos L=0.13u W=1u AS=0.265p AD=0.265p PS=2.56u
+ PD=2.56u rfmode=0
M$18410 \$5582 \$5560 OUTN|analog_io_padres[15]|core|padres
+ VSS|anode|cathode|vss sg13_lv_nmos L=0.13u W=2u AS=0.38p AD=0.38p PS=3.52u
+ PD=3.52u rfmode=0
M$18412 \$5582 \$5562 OUTP|analog_io_padres[16]|core|padres
+ VSS|anode|cathode|vss sg13_lv_nmos L=0.13u W=2u AS=0.38p AD=0.38p PS=3.52u
+ PD=3.52u rfmode=0
M$18419 VSS|anode|cathode|vss VSS|anode|cathode|vss \$5618
+ VSS|anode|cathode|vss sg13_lv_nmos L=0.13u W=1u AS=0.265p AD=0.265p PS=2.56u
+ PD=2.56u rfmode=0
M$18420 \$5618 \$5617 OUTN|analog_io_padres[15]|core|padres
+ VSS|anode|cathode|vss sg13_lv_nmos L=0.13u W=2u AS=0.38p AD=0.38p PS=3.52u
+ PD=3.52u rfmode=0
M$18422 \$5618 \$5626 OUTP|analog_io_padres[16]|core|padres
+ VSS|anode|cathode|vss sg13_lv_nmos L=0.13u W=2u AS=0.38p AD=0.38p PS=3.52u
+ PD=3.52u rfmode=0
M$18429 \$5629 \$5633 \$5625 VSS|anode|cathode|vss sg13_lv_nmos L=0.13u W=0.42u
+ AS=0.081p AD=0.1296p PS=0.81u PD=1.52u rfmode=0
M$18430 \$5629 \$5632 \$5644 VSS|anode|cathode|vss sg13_lv_nmos L=0.13u W=0.42u
+ AS=0.081p AD=0.2163p PS=0.81u PD=1.87u rfmode=0
M$18431 \$5632 \$5633 VSS|anode|cathode|vss VSS|anode|cathode|vss sg13_lv_nmos
+ L=0.13u W=0.74u AS=0.2516p AD=0.43315p PS=2.16u PD=2.205u rfmode=0
M$18432 VSS|anode|cathode|vss CLK|clk|core|fclk_in|p2c|ui_p2c[6] \$5633
+ VSS|anode|cathode|vss sg13_lv_nmos L=0.13u W=0.74u AS=0.43315p AD=0.2516p
+ PS=2.205u PD=2.16u rfmode=0
M$18433 \$5645 \$5633 \$5634 VSS|anode|cathode|vss sg13_lv_nmos L=0.13u W=0.42u
+ AS=0.1428p AD=0.12665p PS=1.52u PD=1.145u rfmode=0
M$18434 \$5634 \$5632 \$5628 VSS|anode|cathode|vss sg13_lv_nmos L=0.13u W=0.74u
+ AS=0.12665p AD=0.3473p PS=1.145u PD=2.71u rfmode=0
M$18435 VSS|anode|cathode|vss VDD \$5649 VSS|anode|cathode|vss sg13_lv_nmos
+ L=0.13u W=0.42u AS=0.1701p AD=0.03885p PS=1.65u PD=0.605u rfmode=0
M$18436 \$5649 \$5628 \$5644 VSS|anode|cathode|vss sg13_lv_nmos L=0.13u W=0.42u
+ AS=0.03885p AD=0.1596p PS=0.605u PD=1.6u rfmode=0
M$18437 VSS|anode|cathode|vss \$5634 \$5617 VSS|anode|cathode|vss sg13_lv_nmos
+ L=0.13u W=1.48u AS=0.3922p AD=0.2737p PS=3.28u PD=2.24u rfmode=0
M$18439 VSS|anode|cathode|vss \$5634 \$5630 VSS|anode|cathode|vss sg13_lv_nmos
+ L=0.13u W=0.64u AS=0.1331p AD=0.2176p PS=1.12u PD=1.96u rfmode=0
M$18440 VSS|anode|cathode|vss \$5630 \$5626 VSS|anode|cathode|vss sg13_lv_nmos
+ L=0.13u W=1.48u AS=0.3922p AD=0.3922p PS=3.28u PD=3.28u rfmode=0
M$18442 VSS|anode|cathode|vss \$5629 \$5628 VSS|anode|cathode|vss sg13_lv_nmos
+ L=0.13u W=0.74u AS=0.1626p AD=0.2516p PS=1.415u PD=2.16u rfmode=0
M$18443 \$5625 X2|dout[3] \$5650 VSS|anode|cathode|vss sg13_lv_nmos L=0.13u
+ W=0.42u AS=0.1428p AD=0.0609p PS=1.52u PD=0.71u rfmode=0
M$18444 VSS|anode|cathode|vss VDD \$5650 VSS|anode|cathode|vss sg13_lv_nmos
+ L=0.13u W=0.42u AS=0.1626p AD=0.0609p PS=1.415u PD=0.71u rfmode=0
M$18445 \$5652 X1|dout[2] \$5667 VSS|anode|cathode|vss sg13_lv_nmos L=0.13u
+ W=0.42u AS=0.1428p AD=0.0609p PS=1.52u PD=0.71u rfmode=0
M$18446 \$5667 VDD VSS|anode|cathode|vss VSS|anode|cathode|vss sg13_lv_nmos
+ L=0.13u W=0.42u AS=0.0609p AD=0.1626p PS=0.71u PD=1.415u rfmode=0
M$18447 VSS|anode|cathode|vss \$5668 \$5653 VSS|anode|cathode|vss sg13_lv_nmos
+ L=0.13u W=0.74u AS=0.1626p AD=0.2516p PS=1.415u PD=2.16u rfmode=0
M$18448 \$5656 \$5669 VSS|anode|cathode|vss VSS|anode|cathode|vss sg13_lv_nmos
+ L=0.13u W=0.42u AS=0.1428p AD=0.0798p PS=1.52u PD=0.8u rfmode=0
M$18449 VSS|anode|cathode|vss VDD \$5666 VSS|anode|cathode|vss sg13_lv_nmos
+ L=0.13u W=0.42u AS=0.0798p AD=0.0378p PS=0.8u PD=0.6u rfmode=0
M$18450 \$5666 \$5660 \$5669 VSS|anode|cathode|vss sg13_lv_nmos L=0.13u W=0.42u
+ AS=0.0378p AD=0.1428p PS=0.6u PD=1.52u rfmode=0
M$18451 \$5645 \$5635 VSS|anode|cathode|vss VSS|anode|cathode|vss sg13_lv_nmos
+ L=0.13u W=0.42u AS=0.1428p AD=0.0798p PS=1.52u PD=0.8u rfmode=0
M$18452 VSS|anode|cathode|vss VDD \$5651 VSS|anode|cathode|vss sg13_lv_nmos
+ L=0.13u W=0.42u AS=0.0798p AD=0.0378p PS=0.8u PD=0.6u rfmode=0
M$18453 \$5651 \$5634 \$5635 VSS|anode|cathode|vss sg13_lv_nmos L=0.13u W=0.42u
+ AS=0.0378p AD=0.1428p PS=0.6u PD=1.52u rfmode=0
M$18454 VSS|anode|cathode|vss \$5660 \$5658 VSS|anode|cathode|vss sg13_lv_nmos
+ L=0.13u W=0.64u AS=0.1331p AD=0.2176p PS=1.12u PD=1.96u rfmode=0
M$18455 VSS|anode|cathode|vss \$5660 \$5657 VSS|anode|cathode|vss sg13_lv_nmos
+ L=0.13u W=1.48u AS=0.3922p AD=0.2737p PS=3.28u PD=2.24u rfmode=0
M$18457 VSS|anode|cathode|vss \$5658 \$5659 VSS|anode|cathode|vss sg13_lv_nmos
+ L=0.13u W=1.48u AS=0.3922p AD=0.3922p PS=3.28u PD=3.28u rfmode=0
M$18459 VSS|anode|cathode|vss VDD \$5665 VSS|anode|cathode|vss sg13_lv_nmos
+ L=0.13u W=0.42u AS=0.1701p AD=0.03885p PS=1.65u PD=0.605u rfmode=0
M$18460 \$5665 \$5653 \$5654 VSS|anode|cathode|vss sg13_lv_nmos L=0.13u W=0.42u
+ AS=0.03885p AD=0.1596p PS=0.605u PD=1.6u rfmode=0
M$18461 \$5652 \$5655 \$5668 VSS|anode|cathode|vss sg13_lv_nmos L=0.13u W=0.42u
+ AS=0.1296p AD=0.081p PS=1.52u PD=0.81u rfmode=0
M$18462 \$5668 \$5674 \$5654 VSS|anode|cathode|vss sg13_lv_nmos L=0.13u W=0.42u
+ AS=0.081p AD=0.2163p PS=0.81u PD=1.87u rfmode=0
M$18463 VSS|anode|cathode|vss \$5655 \$5674 VSS|anode|cathode|vss sg13_lv_nmos
+ L=0.13u W=0.74u AS=0.43315p AD=0.2516p PS=2.205u PD=2.16u rfmode=0
M$18464 VSS|anode|cathode|vss CLK|clk|core|fclk_in|p2c|ui_p2c[6] \$5655
+ VSS|anode|cathode|vss sg13_lv_nmos L=0.13u W=0.74u AS=0.43315p AD=0.2516p
+ PS=2.205u PD=2.16u rfmode=0
M$18465 \$5660 \$5655 \$5656 VSS|anode|cathode|vss sg13_lv_nmos L=0.13u W=0.42u
+ AS=0.12665p AD=0.1428p PS=1.145u PD=1.52u rfmode=0
M$18466 \$5653 \$5674 \$5660 VSS|anode|cathode|vss sg13_lv_nmos L=0.13u W=0.74u
+ AS=0.3473p AD=0.12665p PS=2.71u PD=1.145u rfmode=0
M$18467 VSS|anode|cathode|vss VSS|anode|cathode|vss \$5670
+ VSS|anode|cathode|vss sg13_lv_nmos L=0.13u W=1u AS=0.265p AD=0.265p PS=2.56u
+ PD=2.56u rfmode=0
M$18468 \$5670 \$5657 OUTN|analog_io_padres[15]|core|padres
+ VSS|anode|cathode|vss sg13_lv_nmos L=0.13u W=2u AS=0.38p AD=0.38p PS=3.52u
+ PD=3.52u rfmode=0
M$18470 \$5670 \$5659 OUTP|analog_io_padres[16]|core|padres
+ VSS|anode|cathode|vss sg13_lv_nmos L=0.13u W=2u AS=0.38p AD=0.38p PS=3.52u
+ PD=3.52u rfmode=0
M$18477 \$5690 D2|c2p|core|i|uo_c2p[6] VSS|anode|cathode|vss
+ VSS|anode|cathode|vss sg13_lv_nmos L=0.13u W=2.75u AS=0.935p AD=0.935p
+ PS=6.18u PD=6.18u rfmode=0
M$18478 core|data_in|p2c|ui_p2c[2] \$5695 VSS|anode|cathode|vss
+ VSS|anode|cathode|vss sg13_lv_nmos L=0.13u W=2.75u AS=0.935p AD=0.935p
+ PS=6.18u PD=6.18u rfmode=0
M$18479 \$5701 D2|c2p|core|i|uo_c2p[6] VSS|anode|cathode|vss
+ VSS|anode|cathode|vss sg13_lv_nmos L=0.13u W=2.75u AS=0.935p AD=0.935p
+ PS=6.18u PD=6.18u rfmode=0
M$18480 \$5787 D1|c2p|core|i|uo_c2p[7] VSS|anode|cathode|vss
+ VSS|anode|cathode|vss sg13_lv_nmos L=0.13u W=2.75u AS=0.935p AD=0.935p
+ PS=6.18u PD=6.18u rfmode=0
M$18481 \$5791 D1|c2p|core|i|uo_c2p[7] VSS|anode|cathode|vss
+ VSS|anode|cathode|vss sg13_lv_nmos L=0.13u W=2.75u AS=0.935p AD=0.935p
+ PS=6.18u PD=6.18u rfmode=0
M$18482 \$5879 D0|c2p|core|i|uo_c2p[8] VSS|anode|cathode|vss
+ VSS|anode|cathode|vss sg13_lv_nmos L=0.13u W=2.75u AS=0.935p AD=0.935p
+ PS=6.18u PD=6.18u rfmode=0
M$18483 \$5887 D0|c2p|core|i|uo_c2p[8] VSS|anode|cathode|vss
+ VSS|anode|cathode|vss sg13_lv_nmos L=0.13u W=2.75u AS=0.935p AD=0.935p
+ PS=6.18u PD=6.18u rfmode=0
M$18484 Vs|core|p2c|ui_p2c[1] \$6055 VSS|anode|cathode|vss
+ VSS|anode|cathode|vss sg13_lv_nmos L=0.13u W=2.75u AS=0.935p AD=0.935p
+ PS=6.18u PD=6.18u rfmode=0
M$18485 \$6208 Vs|core|p2c|ui_p2c[1] VSS|anode|cathode|vss
+ VSS|anode|cathode|vss sg13_lv_nmos L=0.13u W=2.24u AS=1.0528p AD=1.0528p
+ PS=5.24u PD=5.24u rfmode=0
M$18487 VFE|X|vfe \$6232 VSS|anode|cathode|vss VSS|anode|cathode|vss
+ sg13_lv_nmos L=0.13u W=0.74u AS=0.2516p AD=0.1331p PS=2.16u PD=1.12u rfmode=0
M$18488 VSS|anode|cathode|vss B|IN|Y \$6237 VSS|anode|cathode|vss sg13_lv_nmos
+ L=0.13u W=0.64u AS=0.1331p AD=0.1216p PS=1.12u PD=1.02u rfmode=0
M$18489 \$6237 IN|Y \$6232 VSS|anode|cathode|vss sg13_lv_nmos L=0.13u W=0.64u
+ AS=0.1216p AD=0.2176p PS=1.02u PD=1.96u rfmode=0
M$18490 VRE|X|vre \$6234 VSS|anode|cathode|vss VSS|anode|cathode|vss
+ sg13_lv_nmos L=0.13u W=0.74u AS=0.2516p AD=0.1331p PS=2.16u PD=1.12u rfmode=0
M$18491 VSS|anode|cathode|vss B|IN|Y$1 \$6238 VSS|anode|cathode|vss
+ sg13_lv_nmos L=0.13u W=0.64u AS=0.1331p AD=0.1216p PS=1.12u PD=1.02u rfmode=0
M$18492 \$6238 IN|Y$1 \$6234 VSS|anode|cathode|vss sg13_lv_nmos L=0.13u W=0.64u
+ AS=0.1216p AD=0.2176p PS=1.02u PD=1.96u rfmode=0
M$18493 B|IN|Y IN|Y$2 VSS|anode|cathode|vss VSS|anode|cathode|vss sg13_lv_nmos
+ L=0.13u W=0.74u AS=0.2516p AD=0.2516p PS=2.16u PD=2.16u rfmode=0
M$18494 IN|Y$1 B|IN|Y VSS|anode|cathode|vss VSS|anode|cathode|vss sg13_lv_nmos
+ L=0.13u W=0.74u AS=0.2516p AD=0.2516p PS=2.16u PD=2.16u rfmode=0
M$18495 IN|Y$2 B|IN|Y$1 VSS|anode|cathode|vss VSS|anode|cathode|vss
+ sg13_lv_nmos L=0.13u W=0.74u AS=0.2516p AD=0.2516p PS=2.16u PD=2.16u rfmode=0
M$18496 B|IN|Y$1 IN|Y$3 VSS|anode|cathode|vss VSS|anode|cathode|vss
+ sg13_lv_nmos L=0.13u W=0.74u AS=0.2516p AD=0.2516p PS=2.16u PD=2.16u rfmode=0
M$18497 IN|Y B|IN|Y$1 VSS|anode|cathode|vss VSS|anode|cathode|vss sg13_lv_nmos
+ L=0.13u W=0.74u AS=0.2516p AD=0.2516p PS=2.16u PD=2.16u rfmode=0
M$18498 IN|Y$3 IN|core|p2c|ui_p2c[0] VSS|anode|cathode|vss
+ VSS|anode|cathode|vss sg13_lv_nmos L=0.13u W=0.74u AS=0.2516p AD=0.2516p
+ PS=2.16u PD=2.16u rfmode=0
M$18499 IN|core|p2c|ui_p2c[0] \$6598 VSS|anode|cathode|vss
+ VSS|anode|cathode|vss sg13_lv_nmos L=0.13u W=2.75u AS=0.935p AD=0.935p
+ PS=6.18u PD=6.18u rfmode=0
M$18500 IOVSS|anode|cathode|guard|iovss|minus gate|out
+ IOVDD|cathode|guard|in|iovdd|pad|pin1|pin2|plus|supply VSS|anode|cathode|vss
+ sg13_hv_nmos L=0.6u W=756.8u AS=344.608p AD=349.36p PS=931.04u PD=933.2u
+ rfmode=0
M$18543 IOVSS|anode|cathode|guard|iovss|minus \$35
+ analog_io[19]|anode|cathode|pad VSS|anode|cathode|vss sg13_hv_nmos L=0.6u
+ W=88u AS=40.7p AD=40.7p PS=110.9u PD=110.9u rfmode=0
M$18563 IOVSS|anode|cathode|guard|iovss|minus \$36
+ analog_io[18]|anode|cathode|pad VSS|anode|cathode|vss sg13_hv_nmos L=0.6u
+ W=88u AS=40.7p AD=40.7p PS=110.9u PD=110.9u rfmode=0
M$18583 IOVSS|anode|cathode|guard|iovss|minus \$37
+ analog_io[17]|anode|cathode|pad VSS|anode|cathode|vss sg13_hv_nmos L=0.6u
+ W=88u AS=40.7p AD=40.7p PS=110.9u PD=110.9u rfmode=0
M$18603 IOVSS|anode|cathode|guard|iovss|minus gate|ngate|o
+ anode|cathode|pad|uo_PAD[3] VSS|anode|cathode|vss sg13_hv_nmos L=0.6u W=66u
+ AS=30.096p AD=31.284p PS=84.08u PD=84.62u rfmode=0
M$18618 IOVSS|anode|cathode|guard|iovss|minus gate|ngate|o$1
+ anode|cathode|pad|uo_PAD[2] VSS|anode|cathode|vss sg13_hv_nmos L=0.6u W=66u
+ AS=30.096p AD=31.284p PS=84.08u PD=84.62u rfmode=0
M$18633 IOVSS|anode|cathode|guard|iovss|minus gate|ngate|o$2
+ anode|cathode|pad|uo_PAD[1] VSS|anode|cathode|vss sg13_hv_nmos L=0.6u W=66u
+ AS=30.096p AD=31.284p PS=84.08u PD=84.62u rfmode=0
M$18648 IOVSS|anode|cathode|guard|iovss|minus gate|ngate|o$3
+ anode|cathode|pad|uo_PAD[0] VSS|anode|cathode|vss sg13_hv_nmos L=0.6u W=66u
+ AS=30.096p AD=31.284p PS=84.08u PD=84.62u rfmode=0
M$18663 IOVSS|anode|cathode|guard|iovss|minus gate|out$1
+ VDD|in|pad|pin1|pin2|supply|vdd VSS|anode|cathode|vss sg13_hv_nmos L=0.6u
+ W=756.8u AS=344.608p AD=349.36p PS=931.04u PD=933.2u rfmode=0
M$18964 IOVSS|anode|cathode|guard|iovss|minus
+ IOVDD|cathode|guard|in|iovdd|pad|pin1|pin2|plus|supply gate|out
+ VSS|anode|cathode|vss sg13_hv_nmos L=0.5u W=108u AS=23.22p AD=20.52p
+ PS=131.16u PD=112.56u rfmode=0
M$18970 IOVSS|anode|cathode|guard|iovss|minus
+ IOVDD|cathode|guard|in|iovdd|pad|pin1|pin2|plus|supply
+ IOVSS|anode|cathode|guard|iovss|minus VSS|anode|cathode|vss sg13_hv_nmos
+ L=9.5u W=630u AS=119.7p AD=133.2p PS=656.6u PD=749.6u rfmode=0
M$18990 \$488 D5|c2p|core|i|uo_c2p[3] VSS|anode|cathode|vss
+ VSS|anode|cathode|vss sg13_hv_nmos L=0.45u W=1.9u AS=0.646p AD=0.361p
+ PS=4.48u PD=2.28u rfmode=0
M$18991 VSS|anode|cathode|vss \$505 \$489 VSS|anode|cathode|vss sg13_hv_nmos
+ L=0.45u W=1.9u AS=0.361p AD=0.646p PS=2.28u PD=4.48u rfmode=0
M$18992 VSS|anode|cathode|vss \$489 gate|ngate|o VSS|anode|cathode|vss
+ sg13_hv_nmos L=0.45u W=1.9u AS=0.646p AD=0.646p PS=4.48u PD=4.48u rfmode=0
M$18993 \$490 D5|c2p|core|i|uo_c2p[3] VSS|anode|cathode|vss
+ VSS|anode|cathode|vss sg13_hv_nmos L=0.45u W=1.9u AS=0.646p AD=0.361p
+ PS=4.48u PD=2.28u rfmode=0
M$18994 VSS|anode|cathode|vss \$506 \$491 VSS|anode|cathode|vss sg13_hv_nmos
+ L=0.45u W=1.9u AS=0.361p AD=0.646p PS=2.28u PD=4.48u rfmode=0
M$18995 VSS|anode|cathode|vss \$491 gate|o|pgate VSS|anode|cathode|vss
+ sg13_hv_nmos L=0.45u W=1.9u AS=0.646p AD=0.646p PS=4.48u PD=4.48u rfmode=0
M$18996 \$492 D6|c2p|core|i|uo_c2p[2] VSS|anode|cathode|vss
+ VSS|anode|cathode|vss sg13_hv_nmos L=0.45u W=1.9u AS=0.646p AD=0.361p
+ PS=4.48u PD=2.28u rfmode=0
M$18997 VSS|anode|cathode|vss \$508 \$493 VSS|anode|cathode|vss sg13_hv_nmos
+ L=0.45u W=1.9u AS=0.361p AD=0.646p PS=2.28u PD=4.48u rfmode=0
M$18998 VSS|anode|cathode|vss \$493 gate|ngate|o$1 VSS|anode|cathode|vss
+ sg13_hv_nmos L=0.45u W=1.9u AS=0.646p AD=0.646p PS=4.48u PD=4.48u rfmode=0
M$18999 \$494 D6|c2p|core|i|uo_c2p[2] VSS|anode|cathode|vss
+ VSS|anode|cathode|vss sg13_hv_nmos L=0.45u W=1.9u AS=0.646p AD=0.361p
+ PS=4.48u PD=2.28u rfmode=0
M$19000 VSS|anode|cathode|vss \$509 \$495 VSS|anode|cathode|vss sg13_hv_nmos
+ L=0.45u W=1.9u AS=0.361p AD=0.646p PS=2.28u PD=4.48u rfmode=0
M$19001 VSS|anode|cathode|vss \$495 gate|o|pgate$1 VSS|anode|cathode|vss
+ sg13_hv_nmos L=0.45u W=1.9u AS=0.646p AD=0.646p PS=4.48u PD=4.48u rfmode=0
M$19002 \$496 D7|c2p|core|i|uo_c2p[1] VSS|anode|cathode|vss
+ VSS|anode|cathode|vss sg13_hv_nmos L=0.45u W=1.9u AS=0.646p AD=0.361p
+ PS=4.48u PD=2.28u rfmode=0
M$19003 VSS|anode|cathode|vss \$511 \$497 VSS|anode|cathode|vss sg13_hv_nmos
+ L=0.45u W=1.9u AS=0.361p AD=0.646p PS=2.28u PD=4.48u rfmode=0
M$19004 VSS|anode|cathode|vss \$497 gate|ngate|o$2 VSS|anode|cathode|vss
+ sg13_hv_nmos L=0.45u W=1.9u AS=0.646p AD=0.646p PS=4.48u PD=4.48u rfmode=0
M$19005 \$498 D7|c2p|core|i|uo_c2p[1] VSS|anode|cathode|vss
+ VSS|anode|cathode|vss sg13_hv_nmos L=0.45u W=1.9u AS=0.646p AD=0.361p
+ PS=4.48u PD=2.28u rfmode=0
M$19006 VSS|anode|cathode|vss \$512 \$499 VSS|anode|cathode|vss sg13_hv_nmos
+ L=0.45u W=1.9u AS=0.361p AD=0.646p PS=2.28u PD=4.48u rfmode=0
M$19007 VSS|anode|cathode|vss \$499 gate|o|pgate$2 VSS|anode|cathode|vss
+ sg13_hv_nmos L=0.45u W=1.9u AS=0.646p AD=0.646p PS=4.48u PD=4.48u rfmode=0
M$19008 \$500 c2p|core|fdac_clk|i|uo_c2p[0] VSS|anode|cathode|vss
+ VSS|anode|cathode|vss sg13_hv_nmos L=0.45u W=1.9u AS=0.646p AD=0.361p
+ PS=4.48u PD=2.28u rfmode=0
M$19009 VSS|anode|cathode|vss \$514 \$501 VSS|anode|cathode|vss sg13_hv_nmos
+ L=0.45u W=1.9u AS=0.361p AD=0.646p PS=2.28u PD=4.48u rfmode=0
M$19010 VSS|anode|cathode|vss \$501 gate|ngate|o$3 VSS|anode|cathode|vss
+ sg13_hv_nmos L=0.45u W=1.9u AS=0.646p AD=0.646p PS=4.48u PD=4.48u rfmode=0
M$19011 \$502 c2p|core|fdac_clk|i|uo_c2p[0] VSS|anode|cathode|vss
+ VSS|anode|cathode|vss sg13_hv_nmos L=0.45u W=1.9u AS=0.646p AD=0.361p
+ PS=4.48u PD=2.28u rfmode=0
M$19012 VSS|anode|cathode|vss \$515 \$503 VSS|anode|cathode|vss sg13_hv_nmos
+ L=0.45u W=1.9u AS=0.361p AD=0.646p PS=2.28u PD=4.48u rfmode=0
M$19013 VSS|anode|cathode|vss \$503 gate|o|pgate$3 VSS|anode|cathode|vss
+ sg13_hv_nmos L=0.45u W=1.9u AS=0.646p AD=0.646p PS=4.48u PD=4.48u rfmode=0
M$19014 \$461 core IOVSS|anode|cathode|guard|iovss|minus VSS|anode|cathode|vss
+ sg13_hv_nmos L=0.45u W=1.3u AS=0.442p AD=0.247p PS=3.28u PD=1.68u rfmode=0
M$19015 IOVSS|anode|cathode|guard|iovss|minus \$461 \$462 VSS|anode|cathode|vss
+ sg13_hv_nmos L=0.45u W=1.3u AS=0.247p AD=0.442p PS=1.68u PD=3.28u rfmode=0
M$19016 \$463 core$1 IOVSS|anode|cathode|guard|iovss|minus
+ VSS|anode|cathode|vss sg13_hv_nmos L=0.45u W=1.3u AS=0.442p AD=0.247p
+ PS=3.28u PD=1.68u rfmode=0
M$19017 IOVSS|anode|cathode|guard|iovss|minus \$463 \$464 VSS|anode|cathode|vss
+ sg13_hv_nmos L=0.45u W=1.3u AS=0.247p AD=0.442p PS=1.68u PD=3.28u rfmode=0
M$19018 IOVSS|anode|cathode|guard|iovss|minus VDD|in|pad|pin1|pin2|supply|vdd
+ gate|out$1 VSS|anode|cathode|vss sg13_hv_nmos L=0.5u W=108u AS=23.22p
+ AD=20.52p PS=131.16u PD=112.56u rfmode=0
M$19024 IOVSS|anode|cathode|guard|iovss|minus VDD|in|pad|pin1|pin2|supply|vdd
+ IOVSS|anode|cathode|guard|iovss|minus VSS|anode|cathode|vss sg13_hv_nmos
+ L=9.5u W=378u AS=71.82p AD=79.92p PS=393.96u PD=449.76u rfmode=0
M$19044 IOVSS|anode|cathode|guard|iovss|minus VDD|in|pad|pin1|pin2|supply|vdd
+ gate|out$2 VSS|anode|cathode|vss sg13_hv_nmos L=0.5u W=108u AS=23.22p
+ AD=20.52p PS=131.16u PD=112.56u rfmode=0
M$19070 VSS|anode|cathode|vss \$462 \$516 VSS|anode|cathode|vss sg13_hv_nmos
+ L=0.45u W=2.65u AS=0.901p AD=0.5035p PS=5.98u PD=3.03u rfmode=0
M$19071 \$516 \$461 VDD|in|pad|pin1|pin2|supply|vdd VSS|anode|cathode|vss
+ sg13_hv_nmos L=0.45u W=2.65u AS=0.5035p AD=0.901p PS=3.03u PD=5.98u rfmode=0
M$19072 VSS|anode|cathode|vss \$464 \$518 VSS|anode|cathode|vss sg13_hv_nmos
+ L=0.45u W=2.65u AS=0.901p AD=0.5035p PS=5.98u PD=3.03u rfmode=0
M$19073 \$518 \$463 VDD|in|pad|pin1|pin2|supply|vdd VSS|anode|cathode|vss
+ sg13_hv_nmos L=0.45u W=2.65u AS=0.5035p AD=0.901p PS=3.03u PD=5.98u rfmode=0
M$19074 IOVSS|anode|cathode|guard|iovss|minus
+ IOVDD|cathode|guard|in|iovdd|pad|pin1|pin2|plus|supply gate|out$3
+ VSS|anode|cathode|vss sg13_hv_nmos L=0.5u W=108u AS=23.22p AD=20.52p
+ PS=131.16u PD=112.56u rfmode=0
M$19100 IOVSS|anode|cathode|guard|iovss|minus gate|out$2
+ VDD|in|pad|pin1|pin2|supply|vdd VSS|anode|cathode|vss sg13_hv_nmos L=0.6u
+ W=756.8u AS=344.608p AD=349.36p PS=931.04u PD=933.2u rfmode=0
M$19229 IOVSS|anode|cathode|guard|iovss|minus gate|out$3
+ IOVDD|cathode|guard|in|iovdd|pad|pin1|pin2|plus|supply VSS|anode|cathode|vss
+ sg13_hv_nmos L=0.6u W=756.8u AS=344.608p AD=349.36p PS=931.04u PD=933.2u
+ rfmode=0
M$19444 IOVSS|anode|cathode|guard|iovss|minus gate|ngate|o$4
+ anode|cathode|pad|uo_PAD[4] VSS|anode|cathode|vss sg13_hv_nmos L=0.6u W=66u
+ AS=30.096p AD=31.284p PS=84.08u PD=84.62u rfmode=0
M$19459 \$2045 D4|c2p|core|i|uo_c2p[4] VSS|anode|cathode|vss
+ VSS|anode|cathode|vss sg13_hv_nmos L=0.45u W=1.9u AS=0.646p AD=0.361p
+ PS=4.48u PD=2.28u rfmode=0
M$19460 VSS|anode|cathode|vss \$2046 \$2047 VSS|anode|cathode|vss sg13_hv_nmos
+ L=0.45u W=1.9u AS=0.361p AD=0.646p PS=2.28u PD=4.48u rfmode=0
M$19461 \$2056 D4|c2p|core|i|uo_c2p[4] VSS|anode|cathode|vss
+ VSS|anode|cathode|vss sg13_hv_nmos L=0.45u W=1.9u AS=0.646p AD=0.361p
+ PS=4.48u PD=2.28u rfmode=0
M$19462 VSS|anode|cathode|vss \$2057 \$2059 VSS|anode|cathode|vss sg13_hv_nmos
+ L=0.45u W=1.9u AS=0.361p AD=0.646p PS=2.28u PD=4.48u rfmode=0
M$19463 VSS|anode|cathode|vss \$2059 gate|o|pgate$4 VSS|anode|cathode|vss
+ sg13_hv_nmos L=0.45u W=1.9u AS=0.646p AD=0.646p PS=4.48u PD=4.48u rfmode=0
M$19464 VSS|anode|cathode|vss \$2047 gate|ngate|o$4 VSS|anode|cathode|vss
+ sg13_hv_nmos L=0.45u W=1.9u AS=0.646p AD=0.646p PS=4.48u PD=4.48u rfmode=0
M$19465 VSS|anode|cathode|vss \$2061 \$2051 VSS|anode|cathode|vss sg13_hv_nmos
+ L=0.45u W=2.65u AS=0.901p AD=0.5035p PS=5.98u PD=3.03u rfmode=0
M$19466 \$2051 \$2062 VDD|in|pad|pin1|pin2|supply|vdd VSS|anode|cathode|vss
+ sg13_hv_nmos L=0.45u W=2.65u AS=0.5035p AD=0.901p PS=3.03u PD=5.98u rfmode=0
M$19467 \$2062 core$2 IOVSS|anode|cathode|guard|iovss|minus
+ VSS|anode|cathode|vss sg13_hv_nmos L=0.45u W=1.3u AS=0.442p AD=0.247p
+ PS=3.28u PD=1.68u rfmode=0
M$19468 IOVSS|anode|cathode|guard|iovss|minus \$2062 \$2061
+ VSS|anode|cathode|vss sg13_hv_nmos L=0.45u W=1.3u AS=0.247p AD=0.442p
+ PS=1.68u PD=3.28u rfmode=0
M$19469 VSS|anode|cathode|vss VSS|anode|cathode|vss VSS|anode|cathode|vss
+ VSS|anode|cathode|vss sg13_hv_nmos L=0.45u W=82.2u AS=21.7605p AD=21.8055p
+ PS=190.31u PD=190.91u rfmode=0
M$19470 VSS|anode|cathode|vss VBIAS|analog_io_padres[14]|core|padres \$3063
+ VSS|anode|cathode|vss sg13_hv_nmos L=0.45u W=5.2u AS=0.988p AD=0.988p
+ PS=8.24u PD=8.24u rfmode=0
M$19480 VSS|anode|cathode|vss VBIAS|analog_io_padres[14]|core|padres \$3067
+ VSS|anode|cathode|vss sg13_hv_nmos L=0.45u W=5.2u AS=0.988p AD=0.988p
+ PS=8.24u PD=8.24u rfmode=0
M$19490 VSS|anode|cathode|vss VBIAS|analog_io_padres[14]|core|padres \$3071
+ VSS|anode|cathode|vss sg13_hv_nmos L=0.45u W=5.2u AS=0.988p AD=0.988p
+ PS=8.24u PD=8.24u rfmode=0
M$19500 VSS|anode|cathode|vss VBIAS|analog_io_padres[14]|core|padres \$3075
+ VSS|anode|cathode|vss sg13_hv_nmos L=0.45u W=5.2u AS=0.988p AD=0.988p
+ PS=8.24u PD=8.24u rfmode=0
M$19510 VSS|anode|cathode|vss VBIAS|analog_io_padres[14]|core|padres \$3079
+ VSS|anode|cathode|vss sg13_hv_nmos L=0.45u W=5.2u AS=0.988p AD=0.988p
+ PS=8.24u PD=8.24u rfmode=0
M$19520 VSS|anode|cathode|vss VBIAS|analog_io_padres[14]|core|padres \$3083
+ VSS|anode|cathode|vss sg13_hv_nmos L=0.45u W=5.2u AS=0.988p AD=0.988p
+ PS=8.24u PD=8.24u rfmode=0
M$19530 VSS|anode|cathode|vss VBIAS|analog_io_padres[14]|core|padres \$3087
+ VSS|anode|cathode|vss sg13_hv_nmos L=0.45u W=5.2u AS=0.988p AD=0.988p
+ PS=8.24u PD=8.24u rfmode=0
M$19540 VSS|anode|cathode|vss VBIAS|analog_io_padres[14]|core|padres \$3091
+ VSS|anode|cathode|vss sg13_hv_nmos L=0.45u W=5.2u AS=0.988p AD=0.988p
+ PS=8.24u PD=8.24u rfmode=0
M$19549 VSS|anode|cathode|vss VSS|anode|cathode|vss \$3222
+ VSS|anode|cathode|vss sg13_hv_nmos L=0.45u W=1.3u AS=0.3445p AD=0.3445p
+ PS=3.01u PD=3.01u rfmode=0
M$19550 \$3222 VBIAS|analog_io_padres[14]|core|padres \$3063
+ VSS|anode|cathode|vss sg13_hv_nmos L=0.45u W=5.2u AS=0.988p AD=0.988p
+ PS=8.24u PD=8.24u rfmode=0
M$19559 VSS|anode|cathode|vss VSS|anode|cathode|vss \$3223
+ VSS|anode|cathode|vss sg13_hv_nmos L=0.45u W=1.3u AS=0.3445p AD=0.3445p
+ PS=3.01u PD=3.01u rfmode=0
M$19560 \$3223 VBIAS|analog_io_padres[14]|core|padres \$3067
+ VSS|anode|cathode|vss sg13_hv_nmos L=0.45u W=5.2u AS=0.988p AD=0.988p
+ PS=8.24u PD=8.24u rfmode=0
M$19569 VSS|anode|cathode|vss VSS|anode|cathode|vss \$3224
+ VSS|anode|cathode|vss sg13_hv_nmos L=0.45u W=1.3u AS=0.3445p AD=0.3445p
+ PS=3.01u PD=3.01u rfmode=0
M$19570 \$3224 VBIAS|analog_io_padres[14]|core|padres \$3071
+ VSS|anode|cathode|vss sg13_hv_nmos L=0.45u W=5.2u AS=0.988p AD=0.988p
+ PS=8.24u PD=8.24u rfmode=0
M$19579 VSS|anode|cathode|vss VSS|anode|cathode|vss \$3225
+ VSS|anode|cathode|vss sg13_hv_nmos L=0.45u W=1.3u AS=0.3445p AD=0.3445p
+ PS=3.01u PD=3.01u rfmode=0
M$19580 \$3225 VBIAS|analog_io_padres[14]|core|padres \$3075
+ VSS|anode|cathode|vss sg13_hv_nmos L=0.45u W=5.2u AS=0.988p AD=0.988p
+ PS=8.24u PD=8.24u rfmode=0
M$19589 VSS|anode|cathode|vss VSS|anode|cathode|vss \$3226
+ VSS|anode|cathode|vss sg13_hv_nmos L=0.45u W=1.3u AS=0.3445p AD=0.3445p
+ PS=3.01u PD=3.01u rfmode=0
M$19590 \$3226 VBIAS|analog_io_padres[14]|core|padres \$3079
+ VSS|anode|cathode|vss sg13_hv_nmos L=0.45u W=5.2u AS=0.988p AD=0.988p
+ PS=8.24u PD=8.24u rfmode=0
M$19599 VSS|anode|cathode|vss VSS|anode|cathode|vss \$3227
+ VSS|anode|cathode|vss sg13_hv_nmos L=0.45u W=1.3u AS=0.3445p AD=0.3445p
+ PS=3.01u PD=3.01u rfmode=0
M$19600 \$3227 VBIAS|analog_io_padres[14]|core|padres \$3083
+ VSS|anode|cathode|vss sg13_hv_nmos L=0.45u W=5.2u AS=0.988p AD=0.988p
+ PS=8.24u PD=8.24u rfmode=0
M$19609 VSS|anode|cathode|vss VSS|anode|cathode|vss \$3228
+ VSS|anode|cathode|vss sg13_hv_nmos L=0.45u W=1.3u AS=0.3445p AD=0.3445p
+ PS=3.01u PD=3.01u rfmode=0
M$19610 \$3228 VBIAS|analog_io_padres[14]|core|padres \$3087
+ VSS|anode|cathode|vss sg13_hv_nmos L=0.45u W=5.2u AS=0.988p AD=0.988p
+ PS=8.24u PD=8.24u rfmode=0
M$19619 VSS|anode|cathode|vss VSS|anode|cathode|vss \$3229
+ VSS|anode|cathode|vss sg13_hv_nmos L=0.45u W=1.3u AS=0.3445p AD=0.3445p
+ PS=3.01u PD=3.01u rfmode=0
M$19620 \$3229 VBIAS|analog_io_padres[14]|core|padres \$3091
+ VSS|anode|cathode|vss sg13_hv_nmos L=0.45u W=5.2u AS=0.988p AD=0.988p
+ PS=8.24u PD=8.24u rfmode=0
M$19630 VSS|anode|cathode|vss VBIAS|analog_io_padres[14]|core|padres \$3509
+ VSS|anode|cathode|vss sg13_hv_nmos L=0.45u W=5.2u AS=0.988p AD=0.988p
+ PS=8.24u PD=8.24u rfmode=0
M$19640 VSS|anode|cathode|vss VBIAS|analog_io_padres[14]|core|padres \$3515
+ VSS|anode|cathode|vss sg13_hv_nmos L=0.45u W=5.2u AS=0.988p AD=0.988p
+ PS=8.24u PD=8.24u rfmode=0
M$19650 VSS|anode|cathode|vss VBIAS|analog_io_padres[14]|core|padres \$3521
+ VSS|anode|cathode|vss sg13_hv_nmos L=0.45u W=5.2u AS=0.988p AD=0.988p
+ PS=8.24u PD=8.24u rfmode=0
M$19660 VSS|anode|cathode|vss VBIAS|analog_io_padres[14]|core|padres \$3527
+ VSS|anode|cathode|vss sg13_hv_nmos L=0.45u W=5.2u AS=0.988p AD=0.988p
+ PS=8.24u PD=8.24u rfmode=0
M$19670 VSS|anode|cathode|vss VBIAS|analog_io_padres[14]|core|padres \$3533
+ VSS|anode|cathode|vss sg13_hv_nmos L=0.45u W=5.2u AS=0.988p AD=0.988p
+ PS=8.24u PD=8.24u rfmode=0
M$19680 VSS|anode|cathode|vss VBIAS|analog_io_padres[14]|core|padres \$3539
+ VSS|anode|cathode|vss sg13_hv_nmos L=0.45u W=5.2u AS=0.988p AD=0.988p
+ PS=8.24u PD=8.24u rfmode=0
M$19690 VSS|anode|cathode|vss VBIAS|analog_io_padres[14]|core|padres \$3545
+ VSS|anode|cathode|vss sg13_hv_nmos L=0.45u W=5.2u AS=0.988p AD=0.988p
+ PS=8.24u PD=8.24u rfmode=0
M$19700 VSS|anode|cathode|vss VBIAS|analog_io_padres[14]|core|padres \$3551
+ VSS|anode|cathode|vss sg13_hv_nmos L=0.45u W=5.2u AS=0.988p AD=0.988p
+ PS=8.24u PD=8.24u rfmode=0
M$19709 VSS|anode|cathode|vss VSS|anode|cathode|vss \$3619
+ VSS|anode|cathode|vss sg13_hv_nmos L=0.45u W=1.3u AS=0.3445p AD=0.3445p
+ PS=3.01u PD=3.01u rfmode=0
M$19710 \$3619 VBIAS|analog_io_padres[14]|core|padres \$3509
+ VSS|anode|cathode|vss sg13_hv_nmos L=0.45u W=5.2u AS=0.988p AD=0.988p
+ PS=8.24u PD=8.24u rfmode=0
M$19719 VSS|anode|cathode|vss VSS|anode|cathode|vss \$3621
+ VSS|anode|cathode|vss sg13_hv_nmos L=0.45u W=1.3u AS=0.3445p AD=0.3445p
+ PS=3.01u PD=3.01u rfmode=0
M$19720 \$3621 VBIAS|analog_io_padres[14]|core|padres \$3515
+ VSS|anode|cathode|vss sg13_hv_nmos L=0.45u W=5.2u AS=0.988p AD=0.988p
+ PS=8.24u PD=8.24u rfmode=0
M$19729 VSS|anode|cathode|vss VSS|anode|cathode|vss \$3623
+ VSS|anode|cathode|vss sg13_hv_nmos L=0.45u W=1.3u AS=0.3445p AD=0.3445p
+ PS=3.01u PD=3.01u rfmode=0
M$19730 \$3623 VBIAS|analog_io_padres[14]|core|padres \$3521
+ VSS|anode|cathode|vss sg13_hv_nmos L=0.45u W=5.2u AS=0.988p AD=0.988p
+ PS=8.24u PD=8.24u rfmode=0
M$19739 VSS|anode|cathode|vss VSS|anode|cathode|vss \$3625
+ VSS|anode|cathode|vss sg13_hv_nmos L=0.45u W=1.3u AS=0.3445p AD=0.3445p
+ PS=3.01u PD=3.01u rfmode=0
M$19740 \$3625 VBIAS|analog_io_padres[14]|core|padres \$3527
+ VSS|anode|cathode|vss sg13_hv_nmos L=0.45u W=5.2u AS=0.988p AD=0.988p
+ PS=8.24u PD=8.24u rfmode=0
M$19749 VSS|anode|cathode|vss VSS|anode|cathode|vss \$3627
+ VSS|anode|cathode|vss sg13_hv_nmos L=0.45u W=1.3u AS=0.3445p AD=0.3445p
+ PS=3.01u PD=3.01u rfmode=0
M$19750 \$3627 VBIAS|analog_io_padres[14]|core|padres \$3533
+ VSS|anode|cathode|vss sg13_hv_nmos L=0.45u W=5.2u AS=0.988p AD=0.988p
+ PS=8.24u PD=8.24u rfmode=0
M$19759 VSS|anode|cathode|vss VSS|anode|cathode|vss \$3629
+ VSS|anode|cathode|vss sg13_hv_nmos L=0.45u W=1.3u AS=0.3445p AD=0.3445p
+ PS=3.01u PD=3.01u rfmode=0
M$19760 \$3629 VBIAS|analog_io_padres[14]|core|padres \$3539
+ VSS|anode|cathode|vss sg13_hv_nmos L=0.45u W=5.2u AS=0.988p AD=0.988p
+ PS=8.24u PD=8.24u rfmode=0
M$19769 VSS|anode|cathode|vss VSS|anode|cathode|vss \$3631
+ VSS|anode|cathode|vss sg13_hv_nmos L=0.45u W=1.3u AS=0.3445p AD=0.3445p
+ PS=3.01u PD=3.01u rfmode=0
M$19770 \$3631 VBIAS|analog_io_padres[14]|core|padres \$3545
+ VSS|anode|cathode|vss sg13_hv_nmos L=0.45u W=5.2u AS=0.988p AD=0.988p
+ PS=8.24u PD=8.24u rfmode=0
M$19779 VSS|anode|cathode|vss VSS|anode|cathode|vss \$3633
+ VSS|anode|cathode|vss sg13_hv_nmos L=0.45u W=1.3u AS=0.3445p AD=0.3445p
+ PS=3.01u PD=3.01u rfmode=0
M$19780 \$3633 VBIAS|analog_io_padres[14]|core|padres \$3551
+ VSS|anode|cathode|vss sg13_hv_nmos L=0.45u W=5.2u AS=0.988p AD=0.988p
+ PS=8.24u PD=8.24u rfmode=0
M$19790 VSS|anode|cathode|vss VBIAS|analog_io_padres[14]|core|padres \$3807
+ VSS|anode|cathode|vss sg13_hv_nmos L=0.45u W=5.2u AS=0.988p AD=0.988p
+ PS=8.24u PD=8.24u rfmode=0
M$19800 VSS|anode|cathode|vss VBIAS|analog_io_padres[14]|core|padres \$3814
+ VSS|anode|cathode|vss sg13_hv_nmos L=0.45u W=5.2u AS=0.988p AD=0.988p
+ PS=8.24u PD=8.24u rfmode=0
M$19810 VSS|anode|cathode|vss VBIAS|analog_io_padres[14]|core|padres \$3821
+ VSS|anode|cathode|vss sg13_hv_nmos L=0.45u W=5.2u AS=0.988p AD=0.988p
+ PS=8.24u PD=8.24u rfmode=0
M$19820 VSS|anode|cathode|vss VBIAS|analog_io_padres[14]|core|padres \$3828
+ VSS|anode|cathode|vss sg13_hv_nmos L=0.45u W=5.2u AS=0.988p AD=0.988p
+ PS=8.24u PD=8.24u rfmode=0
M$19830 VSS|anode|cathode|vss VBIAS|analog_io_padres[14]|core|padres \$3835
+ VSS|anode|cathode|vss sg13_hv_nmos L=0.45u W=5.2u AS=0.988p AD=0.988p
+ PS=8.24u PD=8.24u rfmode=0
M$19840 VSS|anode|cathode|vss VBIAS|analog_io_padres[14]|core|padres \$3842
+ VSS|anode|cathode|vss sg13_hv_nmos L=0.45u W=5.2u AS=0.988p AD=0.988p
+ PS=8.24u PD=8.24u rfmode=0
M$19850 VSS|anode|cathode|vss VBIAS|analog_io_padres[14]|core|padres \$3849
+ VSS|anode|cathode|vss sg13_hv_nmos L=0.45u W=5.2u AS=0.988p AD=0.988p
+ PS=8.24u PD=8.24u rfmode=0
M$19860 VSS|anode|cathode|vss VBIAS|analog_io_padres[14]|core|padres \$3856
+ VSS|anode|cathode|vss sg13_hv_nmos L=0.45u W=5.2u AS=0.988p AD=0.988p
+ PS=8.24u PD=8.24u rfmode=0
M$19869 VSS|anode|cathode|vss VSS|anode|cathode|vss \$3930
+ VSS|anode|cathode|vss sg13_hv_nmos L=0.45u W=1.3u AS=0.3445p AD=0.3445p
+ PS=3.01u PD=3.01u rfmode=0
M$19870 \$3930 VBIAS|analog_io_padres[14]|core|padres \$3807
+ VSS|anode|cathode|vss sg13_hv_nmos L=0.45u W=5.2u AS=0.988p AD=0.988p
+ PS=8.24u PD=8.24u rfmode=0
M$19879 VSS|anode|cathode|vss VSS|anode|cathode|vss \$3932
+ VSS|anode|cathode|vss sg13_hv_nmos L=0.45u W=1.3u AS=0.3445p AD=0.3445p
+ PS=3.01u PD=3.01u rfmode=0
M$19880 \$3932 VBIAS|analog_io_padres[14]|core|padres \$3814
+ VSS|anode|cathode|vss sg13_hv_nmos L=0.45u W=5.2u AS=0.988p AD=0.988p
+ PS=8.24u PD=8.24u rfmode=0
M$19889 VSS|anode|cathode|vss VSS|anode|cathode|vss \$3934
+ VSS|anode|cathode|vss sg13_hv_nmos L=0.45u W=1.3u AS=0.3445p AD=0.3445p
+ PS=3.01u PD=3.01u rfmode=0
M$19890 \$3934 VBIAS|analog_io_padres[14]|core|padres \$3821
+ VSS|anode|cathode|vss sg13_hv_nmos L=0.45u W=5.2u AS=0.988p AD=0.988p
+ PS=8.24u PD=8.24u rfmode=0
M$19899 VSS|anode|cathode|vss VSS|anode|cathode|vss \$3936
+ VSS|anode|cathode|vss sg13_hv_nmos L=0.45u W=1.3u AS=0.3445p AD=0.3445p
+ PS=3.01u PD=3.01u rfmode=0
M$19900 \$3936 VBIAS|analog_io_padres[14]|core|padres \$3828
+ VSS|anode|cathode|vss sg13_hv_nmos L=0.45u W=5.2u AS=0.988p AD=0.988p
+ PS=8.24u PD=8.24u rfmode=0
M$19909 VSS|anode|cathode|vss VSS|anode|cathode|vss \$3938
+ VSS|anode|cathode|vss sg13_hv_nmos L=0.45u W=1.3u AS=0.3445p AD=0.3445p
+ PS=3.01u PD=3.01u rfmode=0
M$19910 \$3938 VBIAS|analog_io_padres[14]|core|padres \$3835
+ VSS|anode|cathode|vss sg13_hv_nmos L=0.45u W=5.2u AS=0.988p AD=0.988p
+ PS=8.24u PD=8.24u rfmode=0
M$19919 VSS|anode|cathode|vss VSS|anode|cathode|vss \$3940
+ VSS|anode|cathode|vss sg13_hv_nmos L=0.45u W=1.3u AS=0.3445p AD=0.3445p
+ PS=3.01u PD=3.01u rfmode=0
M$19920 \$3940 VBIAS|analog_io_padres[14]|core|padres \$3842
+ VSS|anode|cathode|vss sg13_hv_nmos L=0.45u W=5.2u AS=0.988p AD=0.988p
+ PS=8.24u PD=8.24u rfmode=0
M$19929 VSS|anode|cathode|vss VSS|anode|cathode|vss \$3942
+ VSS|anode|cathode|vss sg13_hv_nmos L=0.45u W=1.3u AS=0.3445p AD=0.3445p
+ PS=3.01u PD=3.01u rfmode=0
M$19930 \$3942 VBIAS|analog_io_padres[14]|core|padres \$3849
+ VSS|anode|cathode|vss sg13_hv_nmos L=0.45u W=5.2u AS=0.988p AD=0.988p
+ PS=8.24u PD=8.24u rfmode=0
M$19939 VSS|anode|cathode|vss VSS|anode|cathode|vss \$3944
+ VSS|anode|cathode|vss sg13_hv_nmos L=0.45u W=1.3u AS=0.3445p AD=0.3445p
+ PS=3.01u PD=3.01u rfmode=0
M$19940 \$3944 VBIAS|analog_io_padres[14]|core|padres \$3856
+ VSS|anode|cathode|vss sg13_hv_nmos L=0.45u W=5.2u AS=0.988p AD=0.988p
+ PS=8.24u PD=8.24u rfmode=0
M$19950 VSS|anode|cathode|vss VBIAS|analog_io_padres[14]|core|padres \$4136
+ VSS|anode|cathode|vss sg13_hv_nmos L=0.45u W=5.2u AS=0.988p AD=0.988p
+ PS=8.24u PD=8.24u rfmode=0
M$19960 VSS|anode|cathode|vss VBIAS|analog_io_padres[14]|core|padres \$4140
+ VSS|anode|cathode|vss sg13_hv_nmos L=0.45u W=5.2u AS=0.988p AD=0.988p
+ PS=8.24u PD=8.24u rfmode=0
M$19970 VSS|anode|cathode|vss VBIAS|analog_io_padres[14]|core|padres \$4144
+ VSS|anode|cathode|vss sg13_hv_nmos L=0.45u W=5.2u AS=0.988p AD=0.988p
+ PS=8.24u PD=8.24u rfmode=0
M$19980 VSS|anode|cathode|vss VBIAS|analog_io_padres[14]|core|padres \$4148
+ VSS|anode|cathode|vss sg13_hv_nmos L=0.45u W=5.2u AS=0.988p AD=0.988p
+ PS=8.24u PD=8.24u rfmode=0
M$19990 VSS|anode|cathode|vss VBIAS|analog_io_padres[14]|core|padres \$4152
+ VSS|anode|cathode|vss sg13_hv_nmos L=0.45u W=5.2u AS=0.988p AD=0.988p
+ PS=8.24u PD=8.24u rfmode=0
M$20000 VSS|anode|cathode|vss VBIAS|analog_io_padres[14]|core|padres \$4156
+ VSS|anode|cathode|vss sg13_hv_nmos L=0.45u W=5.2u AS=0.988p AD=0.988p
+ PS=8.24u PD=8.24u rfmode=0
M$20010 VSS|anode|cathode|vss VBIAS|analog_io_padres[14]|core|padres \$4160
+ VSS|anode|cathode|vss sg13_hv_nmos L=0.45u W=5.2u AS=0.988p AD=0.988p
+ PS=8.24u PD=8.24u rfmode=0
M$20020 VSS|anode|cathode|vss VBIAS|analog_io_padres[14]|core|padres \$4164
+ VSS|anode|cathode|vss sg13_hv_nmos L=0.45u W=5.2u AS=0.988p AD=0.988p
+ PS=8.24u PD=8.24u rfmode=0
M$20029 IOVSS|anode|cathode|guard|iovss|minus gate|ngate|o$5
+ anode|cathode|pad|uo_PAD[5] VSS|anode|cathode|vss sg13_hv_nmos L=0.6u W=66u
+ AS=30.096p AD=31.284p PS=84.08u PD=84.62u rfmode=0
M$20044 \$4346 D3|c2p|core|i|uo_c2p[5] VSS|anode|cathode|vss
+ VSS|anode|cathode|vss sg13_hv_nmos L=0.45u W=1.9u AS=0.646p AD=0.361p
+ PS=4.48u PD=2.28u rfmode=0
M$20045 VSS|anode|cathode|vss \$4347 \$4349 VSS|anode|cathode|vss sg13_hv_nmos
+ L=0.45u W=1.9u AS=0.361p AD=0.646p PS=2.28u PD=4.48u rfmode=0
M$20046 VSS|anode|cathode|vss \$4349 gate|o|pgate$5 VSS|anode|cathode|vss
+ sg13_hv_nmos L=0.45u W=1.9u AS=0.646p AD=0.646p PS=4.48u PD=4.48u rfmode=0
M$20047 VSS|anode|cathode|vss \$4337 gate|ngate|o$5 VSS|anode|cathode|vss
+ sg13_hv_nmos L=0.45u W=1.9u AS=0.646p AD=0.646p PS=4.48u PD=4.48u rfmode=0
M$20048 \$4335 D3|c2p|core|i|uo_c2p[5] VSS|anode|cathode|vss
+ VSS|anode|cathode|vss sg13_hv_nmos L=0.45u W=1.9u AS=0.646p AD=0.361p
+ PS=4.48u PD=2.28u rfmode=0
M$20049 VSS|anode|cathode|vss \$4336 \$4337 VSS|anode|cathode|vss sg13_hv_nmos
+ L=0.45u W=1.9u AS=0.361p AD=0.646p PS=2.28u PD=4.48u rfmode=0
M$20050 VSS|anode|cathode|vss VSS|anode|cathode|vss \$4231
+ VSS|anode|cathode|vss sg13_hv_nmos L=0.45u W=1.3u AS=0.3445p AD=0.3445p
+ PS=3.01u PD=3.01u rfmode=0
M$20051 \$4231 VBIAS|analog_io_padres[14]|core|padres \$4136
+ VSS|anode|cathode|vss sg13_hv_nmos L=0.45u W=5.2u AS=0.988p AD=0.988p
+ PS=8.24u PD=8.24u rfmode=0
M$20060 VSS|anode|cathode|vss VSS|anode|cathode|vss \$4232
+ VSS|anode|cathode|vss sg13_hv_nmos L=0.45u W=1.3u AS=0.3445p AD=0.3445p
+ PS=3.01u PD=3.01u rfmode=0
M$20061 \$4232 VBIAS|analog_io_padres[14]|core|padres \$4140
+ VSS|anode|cathode|vss sg13_hv_nmos L=0.45u W=5.2u AS=0.988p AD=0.988p
+ PS=8.24u PD=8.24u rfmode=0
M$20070 VSS|anode|cathode|vss VSS|anode|cathode|vss \$4233
+ VSS|anode|cathode|vss sg13_hv_nmos L=0.45u W=1.3u AS=0.3445p AD=0.3445p
+ PS=3.01u PD=3.01u rfmode=0
M$20071 \$4233 VBIAS|analog_io_padres[14]|core|padres \$4144
+ VSS|anode|cathode|vss sg13_hv_nmos L=0.45u W=5.2u AS=0.988p AD=0.988p
+ PS=8.24u PD=8.24u rfmode=0
M$20080 VSS|anode|cathode|vss VSS|anode|cathode|vss \$4234
+ VSS|anode|cathode|vss sg13_hv_nmos L=0.45u W=1.3u AS=0.3445p AD=0.3445p
+ PS=3.01u PD=3.01u rfmode=0
M$20081 \$4234 VBIAS|analog_io_padres[14]|core|padres \$4148
+ VSS|anode|cathode|vss sg13_hv_nmos L=0.45u W=5.2u AS=0.988p AD=0.988p
+ PS=8.24u PD=8.24u rfmode=0
M$20090 VSS|anode|cathode|vss VSS|anode|cathode|vss \$4235
+ VSS|anode|cathode|vss sg13_hv_nmos L=0.45u W=1.3u AS=0.3445p AD=0.3445p
+ PS=3.01u PD=3.01u rfmode=0
M$20091 \$4235 VBIAS|analog_io_padres[14]|core|padres \$4152
+ VSS|anode|cathode|vss sg13_hv_nmos L=0.45u W=5.2u AS=0.988p AD=0.988p
+ PS=8.24u PD=8.24u rfmode=0
M$20100 VSS|anode|cathode|vss VSS|anode|cathode|vss \$4236
+ VSS|anode|cathode|vss sg13_hv_nmos L=0.45u W=1.3u AS=0.3445p AD=0.3445p
+ PS=3.01u PD=3.01u rfmode=0
M$20101 \$4236 VBIAS|analog_io_padres[14]|core|padres \$4156
+ VSS|anode|cathode|vss sg13_hv_nmos L=0.45u W=5.2u AS=0.988p AD=0.988p
+ PS=8.24u PD=8.24u rfmode=0
M$20110 VSS|anode|cathode|vss VSS|anode|cathode|vss \$4237
+ VSS|anode|cathode|vss sg13_hv_nmos L=0.45u W=1.3u AS=0.3445p AD=0.3445p
+ PS=3.01u PD=3.01u rfmode=0
M$20111 \$4237 VBIAS|analog_io_padres[14]|core|padres \$4160
+ VSS|anode|cathode|vss sg13_hv_nmos L=0.45u W=5.2u AS=0.988p AD=0.988p
+ PS=8.24u PD=8.24u rfmode=0
M$20120 VSS|anode|cathode|vss VSS|anode|cathode|vss \$4238
+ VSS|anode|cathode|vss sg13_hv_nmos L=0.45u W=1.3u AS=0.3445p AD=0.3445p
+ PS=3.01u PD=3.01u rfmode=0
M$20121 \$4238 VBIAS|analog_io_padres[14]|core|padres \$4164
+ VSS|anode|cathode|vss sg13_hv_nmos L=0.45u W=5.2u AS=0.988p AD=0.988p
+ PS=8.24u PD=8.24u rfmode=0
M$20130 VSS|anode|cathode|vss \$4351 \$4341 VSS|anode|cathode|vss sg13_hv_nmos
+ L=0.45u W=2.65u AS=0.901p AD=0.5035p PS=5.98u PD=3.03u rfmode=0
M$20131 \$4341 \$4352 VDD|in|pad|pin1|pin2|supply|vdd VSS|anode|cathode|vss
+ sg13_hv_nmos L=0.45u W=2.65u AS=0.5035p AD=0.901p PS=3.03u PD=5.98u rfmode=0
M$20133 VSS|anode|cathode|vss VBIAS|analog_io_padres[14]|core|padres \$4437
+ VSS|anode|cathode|vss sg13_hv_nmos L=0.45u W=5.2u AS=0.988p AD=0.988p
+ PS=8.24u PD=8.24u rfmode=0
M$20143 VSS|anode|cathode|vss VBIAS|analog_io_padres[14]|core|padres \$4441
+ VSS|anode|cathode|vss sg13_hv_nmos L=0.45u W=5.2u AS=0.988p AD=0.988p
+ PS=8.24u PD=8.24u rfmode=0
M$20153 VSS|anode|cathode|vss VBIAS|analog_io_padres[14]|core|padres \$4445
+ VSS|anode|cathode|vss sg13_hv_nmos L=0.45u W=5.2u AS=0.988p AD=0.988p
+ PS=8.24u PD=8.24u rfmode=0
M$20163 VSS|anode|cathode|vss VBIAS|analog_io_padres[14]|core|padres \$4449
+ VSS|anode|cathode|vss sg13_hv_nmos L=0.45u W=5.2u AS=0.988p AD=0.988p
+ PS=8.24u PD=8.24u rfmode=0
M$20173 VSS|anode|cathode|vss VBIAS|analog_io_padres[14]|core|padres \$4453
+ VSS|anode|cathode|vss sg13_hv_nmos L=0.45u W=5.2u AS=0.988p AD=0.988p
+ PS=8.24u PD=8.24u rfmode=0
M$20183 VSS|anode|cathode|vss VBIAS|analog_io_padres[14]|core|padres \$4457
+ VSS|anode|cathode|vss sg13_hv_nmos L=0.45u W=5.2u AS=0.988p AD=0.988p
+ PS=8.24u PD=8.24u rfmode=0
M$20193 VSS|anode|cathode|vss VBIAS|analog_io_padres[14]|core|padres \$4461
+ VSS|anode|cathode|vss sg13_hv_nmos L=0.45u W=5.2u AS=0.988p AD=0.988p
+ PS=8.24u PD=8.24u rfmode=0
M$20203 VSS|anode|cathode|vss VBIAS|analog_io_padres[14]|core|padres \$4465
+ VSS|anode|cathode|vss sg13_hv_nmos L=0.45u W=5.2u AS=0.988p AD=0.988p
+ PS=8.24u PD=8.24u rfmode=0
M$20212 VSS|anode|cathode|vss VSS|anode|cathode|vss \$4542
+ VSS|anode|cathode|vss sg13_hv_nmos L=0.45u W=1.3u AS=0.3445p AD=0.3445p
+ PS=3.01u PD=3.01u rfmode=0
M$20213 \$4542 VBIAS|analog_io_padres[14]|core|padres \$4437
+ VSS|anode|cathode|vss sg13_hv_nmos L=0.45u W=5.2u AS=0.988p AD=0.988p
+ PS=8.24u PD=8.24u rfmode=0
M$20222 VSS|anode|cathode|vss VSS|anode|cathode|vss \$4543
+ VSS|anode|cathode|vss sg13_hv_nmos L=0.45u W=1.3u AS=0.3445p AD=0.3445p
+ PS=3.01u PD=3.01u rfmode=0
M$20223 \$4543 VBIAS|analog_io_padres[14]|core|padres \$4441
+ VSS|anode|cathode|vss sg13_hv_nmos L=0.45u W=5.2u AS=0.988p AD=0.988p
+ PS=8.24u PD=8.24u rfmode=0
M$20232 VSS|anode|cathode|vss VSS|anode|cathode|vss \$4544
+ VSS|anode|cathode|vss sg13_hv_nmos L=0.45u W=1.3u AS=0.3445p AD=0.3445p
+ PS=3.01u PD=3.01u rfmode=0
M$20233 \$4544 VBIAS|analog_io_padres[14]|core|padres \$4445
+ VSS|anode|cathode|vss sg13_hv_nmos L=0.45u W=5.2u AS=0.988p AD=0.988p
+ PS=8.24u PD=8.24u rfmode=0
M$20242 VSS|anode|cathode|vss VSS|anode|cathode|vss \$4545
+ VSS|anode|cathode|vss sg13_hv_nmos L=0.45u W=1.3u AS=0.3445p AD=0.3445p
+ PS=3.01u PD=3.01u rfmode=0
M$20243 \$4545 VBIAS|analog_io_padres[14]|core|padres \$4449
+ VSS|anode|cathode|vss sg13_hv_nmos L=0.45u W=5.2u AS=0.988p AD=0.988p
+ PS=8.24u PD=8.24u rfmode=0
M$20252 VSS|anode|cathode|vss VSS|anode|cathode|vss \$4546
+ VSS|anode|cathode|vss sg13_hv_nmos L=0.45u W=1.3u AS=0.3445p AD=0.3445p
+ PS=3.01u PD=3.01u rfmode=0
M$20253 \$4546 VBIAS|analog_io_padres[14]|core|padres \$4453
+ VSS|anode|cathode|vss sg13_hv_nmos L=0.45u W=5.2u AS=0.988p AD=0.988p
+ PS=8.24u PD=8.24u rfmode=0
M$20262 VSS|anode|cathode|vss VSS|anode|cathode|vss \$4547
+ VSS|anode|cathode|vss sg13_hv_nmos L=0.45u W=1.3u AS=0.3445p AD=0.3445p
+ PS=3.01u PD=3.01u rfmode=0
M$20263 \$4547 VBIAS|analog_io_padres[14]|core|padres \$4457
+ VSS|anode|cathode|vss sg13_hv_nmos L=0.45u W=5.2u AS=0.988p AD=0.988p
+ PS=8.24u PD=8.24u rfmode=0
M$20272 VSS|anode|cathode|vss VSS|anode|cathode|vss \$4548
+ VSS|anode|cathode|vss sg13_hv_nmos L=0.45u W=1.3u AS=0.3445p AD=0.3445p
+ PS=3.01u PD=3.01u rfmode=0
M$20273 \$4548 VBIAS|analog_io_padres[14]|core|padres \$4461
+ VSS|anode|cathode|vss sg13_hv_nmos L=0.45u W=5.2u AS=0.988p AD=0.988p
+ PS=8.24u PD=8.24u rfmode=0
M$20282 VSS|anode|cathode|vss VSS|anode|cathode|vss \$4549
+ VSS|anode|cathode|vss sg13_hv_nmos L=0.45u W=1.3u AS=0.3445p AD=0.3445p
+ PS=3.01u PD=3.01u rfmode=0
M$20283 \$4549 VBIAS|analog_io_padres[14]|core|padres \$4465
+ VSS|anode|cathode|vss sg13_hv_nmos L=0.45u W=5.2u AS=0.988p AD=0.988p
+ PS=8.24u PD=8.24u rfmode=0
M$20292 \$4352 core$3 IOVSS|anode|cathode|guard|iovss|minus
+ VSS|anode|cathode|vss sg13_hv_nmos L=0.45u W=1.3u AS=0.442p AD=0.247p
+ PS=3.28u PD=1.68u rfmode=0
M$20293 IOVSS|anode|cathode|guard|iovss|minus \$4352 \$4351
+ VSS|anode|cathode|vss sg13_hv_nmos L=0.45u W=1.3u AS=0.247p AD=0.442p
+ PS=1.68u PD=3.28u rfmode=0
M$20295 VSS|anode|cathode|vss VBIAS|analog_io_padres[14]|core|padres \$4748
+ VSS|anode|cathode|vss sg13_hv_nmos L=0.45u W=5.2u AS=0.988p AD=0.988p
+ PS=8.24u PD=8.24u rfmode=0
M$20305 VSS|anode|cathode|vss VBIAS|analog_io_padres[14]|core|padres \$4752
+ VSS|anode|cathode|vss sg13_hv_nmos L=0.45u W=5.2u AS=0.988p AD=0.988p
+ PS=8.24u PD=8.24u rfmode=0
M$20315 VSS|anode|cathode|vss VBIAS|analog_io_padres[14]|core|padres \$4756
+ VSS|anode|cathode|vss sg13_hv_nmos L=0.45u W=5.2u AS=0.988p AD=0.988p
+ PS=8.24u PD=8.24u rfmode=0
M$20325 VSS|anode|cathode|vss VBIAS|analog_io_padres[14]|core|padres \$4760
+ VSS|anode|cathode|vss sg13_hv_nmos L=0.45u W=5.2u AS=0.988p AD=0.988p
+ PS=8.24u PD=8.24u rfmode=0
M$20335 VSS|anode|cathode|vss VBIAS|analog_io_padres[14]|core|padres \$4764
+ VSS|anode|cathode|vss sg13_hv_nmos L=0.45u W=5.2u AS=0.988p AD=0.988p
+ PS=8.24u PD=8.24u rfmode=0
M$20345 VSS|anode|cathode|vss VBIAS|analog_io_padres[14]|core|padres \$4768
+ VSS|anode|cathode|vss sg13_hv_nmos L=0.45u W=5.2u AS=0.988p AD=0.988p
+ PS=8.24u PD=8.24u rfmode=0
M$20355 VSS|anode|cathode|vss VBIAS|analog_io_padres[14]|core|padres \$4772
+ VSS|anode|cathode|vss sg13_hv_nmos L=0.45u W=5.2u AS=0.988p AD=0.988p
+ PS=8.24u PD=8.24u rfmode=0
M$20365 VSS|anode|cathode|vss VBIAS|analog_io_padres[14]|core|padres \$4776
+ VSS|anode|cathode|vss sg13_hv_nmos L=0.45u W=5.2u AS=0.988p AD=0.988p
+ PS=8.24u PD=8.24u rfmode=0
M$20374 VSS|anode|cathode|vss VSS|anode|cathode|vss \$4841
+ VSS|anode|cathode|vss sg13_hv_nmos L=0.45u W=1.3u AS=0.3445p AD=0.3445p
+ PS=3.01u PD=3.01u rfmode=0
M$20375 \$4841 VBIAS|analog_io_padres[14]|core|padres \$4748
+ VSS|anode|cathode|vss sg13_hv_nmos L=0.45u W=5.2u AS=0.988p AD=0.988p
+ PS=8.24u PD=8.24u rfmode=0
M$20384 VSS|anode|cathode|vss VSS|anode|cathode|vss \$4842
+ VSS|anode|cathode|vss sg13_hv_nmos L=0.45u W=1.3u AS=0.3445p AD=0.3445p
+ PS=3.01u PD=3.01u rfmode=0
M$20385 \$4842 VBIAS|analog_io_padres[14]|core|padres \$4752
+ VSS|anode|cathode|vss sg13_hv_nmos L=0.45u W=5.2u AS=0.988p AD=0.988p
+ PS=8.24u PD=8.24u rfmode=0
M$20394 VSS|anode|cathode|vss VSS|anode|cathode|vss \$4843
+ VSS|anode|cathode|vss sg13_hv_nmos L=0.45u W=1.3u AS=0.3445p AD=0.3445p
+ PS=3.01u PD=3.01u rfmode=0
M$20395 \$4843 VBIAS|analog_io_padres[14]|core|padres \$4756
+ VSS|anode|cathode|vss sg13_hv_nmos L=0.45u W=5.2u AS=0.988p AD=0.988p
+ PS=8.24u PD=8.24u rfmode=0
M$20404 VSS|anode|cathode|vss VSS|anode|cathode|vss \$4844
+ VSS|anode|cathode|vss sg13_hv_nmos L=0.45u W=1.3u AS=0.3445p AD=0.3445p
+ PS=3.01u PD=3.01u rfmode=0
M$20405 \$4844 VBIAS|analog_io_padres[14]|core|padres \$4760
+ VSS|anode|cathode|vss sg13_hv_nmos L=0.45u W=5.2u AS=0.988p AD=0.988p
+ PS=8.24u PD=8.24u rfmode=0
M$20414 VSS|anode|cathode|vss VSS|anode|cathode|vss \$4845
+ VSS|anode|cathode|vss sg13_hv_nmos L=0.45u W=1.3u AS=0.3445p AD=0.3445p
+ PS=3.01u PD=3.01u rfmode=0
M$20415 \$4845 VBIAS|analog_io_padres[14]|core|padres \$4764
+ VSS|anode|cathode|vss sg13_hv_nmos L=0.45u W=5.2u AS=0.988p AD=0.988p
+ PS=8.24u PD=8.24u rfmode=0
M$20424 VSS|anode|cathode|vss VSS|anode|cathode|vss \$4846
+ VSS|anode|cathode|vss sg13_hv_nmos L=0.45u W=1.3u AS=0.3445p AD=0.3445p
+ PS=3.01u PD=3.01u rfmode=0
M$20425 \$4846 VBIAS|analog_io_padres[14]|core|padres \$4768
+ VSS|anode|cathode|vss sg13_hv_nmos L=0.45u W=5.2u AS=0.988p AD=0.988p
+ PS=8.24u PD=8.24u rfmode=0
M$20434 VSS|anode|cathode|vss VSS|anode|cathode|vss \$4847
+ VSS|anode|cathode|vss sg13_hv_nmos L=0.45u W=1.3u AS=0.3445p AD=0.3445p
+ PS=3.01u PD=3.01u rfmode=0
M$20435 \$4847 VBIAS|analog_io_padres[14]|core|padres \$4772
+ VSS|anode|cathode|vss sg13_hv_nmos L=0.45u W=5.2u AS=0.988p AD=0.988p
+ PS=8.24u PD=8.24u rfmode=0
M$20444 VSS|anode|cathode|vss VSS|anode|cathode|vss \$4848
+ VSS|anode|cathode|vss sg13_hv_nmos L=0.45u W=1.3u AS=0.3445p AD=0.3445p
+ PS=3.01u PD=3.01u rfmode=0
M$20445 \$4848 VBIAS|analog_io_padres[14]|core|padres \$4776
+ VSS|anode|cathode|vss sg13_hv_nmos L=0.45u W=5.2u AS=0.988p AD=0.988p
+ PS=8.24u PD=8.24u rfmode=0
M$20455 VSS|anode|cathode|vss VBIAS|analog_io_padres[14]|core|padres \$5032
+ VSS|anode|cathode|vss sg13_hv_nmos L=0.45u W=5.2u AS=0.988p AD=0.988p
+ PS=8.24u PD=8.24u rfmode=0
M$20465 VSS|anode|cathode|vss VBIAS|analog_io_padres[14]|core|padres \$5035
+ VSS|anode|cathode|vss sg13_hv_nmos L=0.45u W=5.2u AS=0.988p AD=0.988p
+ PS=8.24u PD=8.24u rfmode=0
M$20475 VSS|anode|cathode|vss VBIAS|analog_io_padres[14]|core|padres \$5038
+ VSS|anode|cathode|vss sg13_hv_nmos L=0.45u W=5.2u AS=0.988p AD=0.988p
+ PS=8.24u PD=8.24u rfmode=0
M$20485 VSS|anode|cathode|vss VBIAS|analog_io_padres[14]|core|padres \$5041
+ VSS|anode|cathode|vss sg13_hv_nmos L=0.45u W=5.2u AS=0.988p AD=0.988p
+ PS=8.24u PD=8.24u rfmode=0
M$20495 VSS|anode|cathode|vss VBIAS|analog_io_padres[14]|core|padres \$5044
+ VSS|anode|cathode|vss sg13_hv_nmos L=0.45u W=5.2u AS=0.988p AD=0.988p
+ PS=8.24u PD=8.24u rfmode=0
M$20505 VSS|anode|cathode|vss VBIAS|analog_io_padres[14]|core|padres \$5047
+ VSS|anode|cathode|vss sg13_hv_nmos L=0.45u W=5.2u AS=0.988p AD=0.988p
+ PS=8.24u PD=8.24u rfmode=0
M$20515 VSS|anode|cathode|vss VBIAS|analog_io_padres[14]|core|padres \$5050
+ VSS|anode|cathode|vss sg13_hv_nmos L=0.45u W=5.2u AS=0.988p AD=0.988p
+ PS=8.24u PD=8.24u rfmode=0
M$20525 VSS|anode|cathode|vss VBIAS|analog_io_padres[14]|core|padres \$5053
+ VSS|anode|cathode|vss sg13_hv_nmos L=0.45u W=5.2u AS=0.988p AD=0.988p
+ PS=8.24u PD=8.24u rfmode=0
M$20534 VSS|anode|cathode|vss VSS|anode|cathode|vss \$5119
+ VSS|anode|cathode|vss sg13_hv_nmos L=0.45u W=1.3u AS=0.3445p AD=0.3445p
+ PS=3.01u PD=3.01u rfmode=0
M$20535 \$5119 VBIAS|analog_io_padres[14]|core|padres \$5032
+ VSS|anode|cathode|vss sg13_hv_nmos L=0.45u W=5.2u AS=0.988p AD=0.988p
+ PS=8.24u PD=8.24u rfmode=0
M$20544 VSS|anode|cathode|vss VSS|anode|cathode|vss \$5121
+ VSS|anode|cathode|vss sg13_hv_nmos L=0.45u W=1.3u AS=0.3445p AD=0.3445p
+ PS=3.01u PD=3.01u rfmode=0
M$20545 \$5121 VBIAS|analog_io_padres[14]|core|padres \$5035
+ VSS|anode|cathode|vss sg13_hv_nmos L=0.45u W=5.2u AS=0.988p AD=0.988p
+ PS=8.24u PD=8.24u rfmode=0
M$20554 VSS|anode|cathode|vss VSS|anode|cathode|vss \$5124
+ VSS|anode|cathode|vss sg13_hv_nmos L=0.45u W=1.3u AS=0.3445p AD=0.3445p
+ PS=3.01u PD=3.01u rfmode=0
M$20555 \$5124 VBIAS|analog_io_padres[14]|core|padres \$5038
+ VSS|anode|cathode|vss sg13_hv_nmos L=0.45u W=5.2u AS=0.988p AD=0.988p
+ PS=8.24u PD=8.24u rfmode=0
M$20564 VSS|anode|cathode|vss VSS|anode|cathode|vss \$5126
+ VSS|anode|cathode|vss sg13_hv_nmos L=0.45u W=1.3u AS=0.3445p AD=0.3445p
+ PS=3.01u PD=3.01u rfmode=0
M$20565 \$5126 VBIAS|analog_io_padres[14]|core|padres \$5041
+ VSS|anode|cathode|vss sg13_hv_nmos L=0.45u W=5.2u AS=0.988p AD=0.988p
+ PS=8.24u PD=8.24u rfmode=0
M$20574 VSS|anode|cathode|vss VSS|anode|cathode|vss \$5128
+ VSS|anode|cathode|vss sg13_hv_nmos L=0.45u W=1.3u AS=0.3445p AD=0.3445p
+ PS=3.01u PD=3.01u rfmode=0
M$20575 \$5128 VBIAS|analog_io_padres[14]|core|padres \$5044
+ VSS|anode|cathode|vss sg13_hv_nmos L=0.45u W=5.2u AS=0.988p AD=0.988p
+ PS=8.24u PD=8.24u rfmode=0
M$20584 VSS|anode|cathode|vss VSS|anode|cathode|vss \$5131
+ VSS|anode|cathode|vss sg13_hv_nmos L=0.45u W=1.3u AS=0.3445p AD=0.3445p
+ PS=3.01u PD=3.01u rfmode=0
M$20585 \$5131 VBIAS|analog_io_padres[14]|core|padres \$5047
+ VSS|anode|cathode|vss sg13_hv_nmos L=0.45u W=5.2u AS=0.988p AD=0.988p
+ PS=8.24u PD=8.24u rfmode=0
M$20594 VSS|anode|cathode|vss VSS|anode|cathode|vss \$5134
+ VSS|anode|cathode|vss sg13_hv_nmos L=0.45u W=1.3u AS=0.3445p AD=0.3445p
+ PS=3.01u PD=3.01u rfmode=0
M$20595 \$5134 VBIAS|analog_io_padres[14]|core|padres \$5050
+ VSS|anode|cathode|vss sg13_hv_nmos L=0.45u W=5.2u AS=0.988p AD=0.988p
+ PS=8.24u PD=8.24u rfmode=0
M$20604 VSS|anode|cathode|vss VSS|anode|cathode|vss \$5136
+ VSS|anode|cathode|vss sg13_hv_nmos L=0.45u W=1.3u AS=0.3445p AD=0.3445p
+ PS=3.01u PD=3.01u rfmode=0
M$20605 \$5136 VBIAS|analog_io_padres[14]|core|padres \$5053
+ VSS|anode|cathode|vss sg13_hv_nmos L=0.45u W=5.2u AS=0.988p AD=0.988p
+ PS=8.24u PD=8.24u rfmode=0
M$20615 VSS|anode|cathode|vss VBIAS|analog_io_padres[14]|core|padres \$5329
+ VSS|anode|cathode|vss sg13_hv_nmos L=0.45u W=5.2u AS=0.988p AD=0.988p
+ PS=8.24u PD=8.24u rfmode=0
M$20625 VSS|anode|cathode|vss VBIAS|analog_io_padres[14]|core|padres \$5333
+ VSS|anode|cathode|vss sg13_hv_nmos L=0.45u W=5.2u AS=0.988p AD=0.988p
+ PS=8.24u PD=8.24u rfmode=0
M$20635 VSS|anode|cathode|vss VBIAS|analog_io_padres[14]|core|padres \$5337
+ VSS|anode|cathode|vss sg13_hv_nmos L=0.45u W=5.2u AS=0.988p AD=0.988p
+ PS=8.24u PD=8.24u rfmode=0
M$20645 VSS|anode|cathode|vss VBIAS|analog_io_padres[14]|core|padres \$5341
+ VSS|anode|cathode|vss sg13_hv_nmos L=0.45u W=5.2u AS=0.988p AD=0.988p
+ PS=8.24u PD=8.24u rfmode=0
M$20655 VSS|anode|cathode|vss VBIAS|analog_io_padres[14]|core|padres \$5345
+ VSS|anode|cathode|vss sg13_hv_nmos L=0.45u W=5.2u AS=0.988p AD=0.988p
+ PS=8.24u PD=8.24u rfmode=0
M$20665 VSS|anode|cathode|vss VBIAS|analog_io_padres[14]|core|padres \$5349
+ VSS|anode|cathode|vss sg13_hv_nmos L=0.45u W=5.2u AS=0.988p AD=0.988p
+ PS=8.24u PD=8.24u rfmode=0
M$20675 VSS|anode|cathode|vss VBIAS|analog_io_padres[14]|core|padres \$5353
+ VSS|anode|cathode|vss sg13_hv_nmos L=0.45u W=5.2u AS=0.988p AD=0.988p
+ PS=8.24u PD=8.24u rfmode=0
M$20684 VSS|anode|cathode|vss VSS|anode|cathode|vss \$5410
+ VSS|anode|cathode|vss sg13_hv_nmos L=0.45u W=1.3u AS=0.3445p AD=0.3445p
+ PS=3.01u PD=3.01u rfmode=0
M$20685 \$5410 VBIAS|analog_io_padres[14]|core|padres \$5329
+ VSS|anode|cathode|vss sg13_hv_nmos L=0.45u W=5.2u AS=0.988p AD=0.988p
+ PS=8.24u PD=8.24u rfmode=0
M$20694 VSS|anode|cathode|vss VSS|anode|cathode|vss \$5411
+ VSS|anode|cathode|vss sg13_hv_nmos L=0.45u W=1.3u AS=0.3445p AD=0.3445p
+ PS=3.01u PD=3.01u rfmode=0
M$20695 \$5411 VBIAS|analog_io_padres[14]|core|padres \$5333
+ VSS|anode|cathode|vss sg13_hv_nmos L=0.45u W=5.2u AS=0.988p AD=0.988p
+ PS=8.24u PD=8.24u rfmode=0
M$20704 VSS|anode|cathode|vss VSS|anode|cathode|vss \$5412
+ VSS|anode|cathode|vss sg13_hv_nmos L=0.45u W=1.3u AS=0.3445p AD=0.3445p
+ PS=3.01u PD=3.01u rfmode=0
M$20705 \$5412 VBIAS|analog_io_padres[14]|core|padres \$5337
+ VSS|anode|cathode|vss sg13_hv_nmos L=0.45u W=5.2u AS=0.988p AD=0.988p
+ PS=8.24u PD=8.24u rfmode=0
M$20714 VSS|anode|cathode|vss VSS|anode|cathode|vss \$5413
+ VSS|anode|cathode|vss sg13_hv_nmos L=0.45u W=1.3u AS=0.3445p AD=0.3445p
+ PS=3.01u PD=3.01u rfmode=0
M$20715 \$5413 VBIAS|analog_io_padres[14]|core|padres \$5341
+ VSS|anode|cathode|vss sg13_hv_nmos L=0.45u W=5.2u AS=0.988p AD=0.988p
+ PS=8.24u PD=8.24u rfmode=0
M$20724 VSS|anode|cathode|vss VSS|anode|cathode|vss \$5414
+ VSS|anode|cathode|vss sg13_hv_nmos L=0.45u W=1.3u AS=0.3445p AD=0.3445p
+ PS=3.01u PD=3.01u rfmode=0
M$20725 \$5414 VBIAS|analog_io_padres[14]|core|padres \$5345
+ VSS|anode|cathode|vss sg13_hv_nmos L=0.45u W=5.2u AS=0.988p AD=0.988p
+ PS=8.24u PD=8.24u rfmode=0
M$20734 VSS|anode|cathode|vss VSS|anode|cathode|vss \$5415
+ VSS|anode|cathode|vss sg13_hv_nmos L=0.45u W=1.3u AS=0.3445p AD=0.3445p
+ PS=3.01u PD=3.01u rfmode=0
M$20735 \$5415 VBIAS|analog_io_padres[14]|core|padres \$5349
+ VSS|anode|cathode|vss sg13_hv_nmos L=0.45u W=5.2u AS=0.988p AD=0.988p
+ PS=8.24u PD=8.24u rfmode=0
M$20744 VSS|anode|cathode|vss VSS|anode|cathode|vss \$5416
+ VSS|anode|cathode|vss sg13_hv_nmos L=0.45u W=1.3u AS=0.3445p AD=0.3445p
+ PS=3.01u PD=3.01u rfmode=0
M$20745 \$5416 VBIAS|analog_io_padres[14]|core|padres \$5353
+ VSS|anode|cathode|vss sg13_hv_nmos L=0.45u W=5.2u AS=0.988p AD=0.988p
+ PS=8.24u PD=8.24u rfmode=0
M$20754 VSS|anode|cathode|vss VSS|anode|cathode|vss \$5567
+ VSS|anode|cathode|vss sg13_hv_nmos L=0.45u W=1.2u AS=0.318p AD=0.318p
+ PS=3.92u PD=3.92u rfmode=0
M$20755 \$5567 VBIAS|analog_io_padres[14]|core|padres VSS|anode|cathode|vss
+ VSS|anode|cathode|vss sg13_hv_nmos L=0.45u W=1.2u AS=0.228p AD=0.228p
+ PS=2.72u PD=2.72u rfmode=0
M$20761 \$5567 VBIAS|analog_io_padres[14]|core|padres \$5582
+ VSS|anode|cathode|vss sg13_hv_nmos L=0.45u W=1.2u AS=0.228p AD=0.228p
+ PS=2.72u PD=2.72u rfmode=0
M$20766 VSS|anode|cathode|vss VSS|anode|cathode|vss \$5534
+ VSS|anode|cathode|vss sg13_hv_nmos L=0.45u W=2.4u AS=0.636p AD=0.636p
+ PS=5.72u PD=5.72u rfmode=0
M$20767 \$5534 VBIAS|analog_io_padres[14]|core|padres \$5502
+ VSS|anode|cathode|vss sg13_hv_nmos L=0.48u W=2.4u AS=0.456p AD=0.456p
+ PS=3.92u PD=3.92u rfmode=0
M$20773 \$5534 VBIAS|analog_io_padres[14]|core|padres VSS|anode|cathode|vss
+ VSS|anode|cathode|vss sg13_hv_nmos L=0.48u W=2.4u AS=0.456p AD=0.456p
+ PS=3.92u PD=3.92u rfmode=0
M$20778 VSS|anode|cathode|vss VSS|anode|cathode|vss \$5639
+ VSS|anode|cathode|vss sg13_hv_nmos L=0.45u W=1.2u AS=0.318p AD=0.318p
+ PS=3.92u PD=3.92u rfmode=0
M$20779 \$5639 VBIAS|analog_io_padres[14]|core|padres \$5618
+ VSS|anode|cathode|vss sg13_hv_nmos L=0.45u W=0.6u AS=0.114p AD=0.114p
+ PS=1.36u PD=1.36u rfmode=0
M$20783 \$5639 VBIAS|analog_io_padres[14]|core|padres VSS|anode|cathode|vss
+ VSS|anode|cathode|vss sg13_hv_nmos L=0.45u W=0.6u AS=0.114p AD=0.114p
+ PS=1.36u PD=1.36u rfmode=0
M$20786 VSS|anode|cathode|vss VSS|anode|cathode|vss \$5661
+ VSS|anode|cathode|vss sg13_hv_nmos L=0.45u W=0.6u AS=0.204p AD=0.114p
+ PS=2.56u PD=1.36u rfmode=0
M$20787 \$5661 VBIAS|analog_io_padres[14]|core|padres VSS|anode|cathode|vss
+ VSS|anode|cathode|vss sg13_hv_nmos L=0.45u W=0.3u AS=0.057p AD=0.057p
+ PS=0.68u PD=0.68u rfmode=0
M$20790 \$5661 VBIAS|analog_io_padres[14]|core|padres \$5670
+ VSS|anode|cathode|vss sg13_hv_nmos L=0.45u W=0.3u AS=0.057p AD=0.057p
+ PS=0.68u PD=0.68u rfmode=0
M$20791 \$5670 VSS|anode|cathode|vss VSS|anode|cathode|vss
+ VSS|anode|cathode|vss sg13_hv_nmos L=0.45u W=0.3u AS=0.057p AD=0.102p
+ PS=0.68u PD=1.28u rfmode=0
M$20792 IOVSS|anode|cathode|guard|iovss|minus gate|ngate|o$6
+ anode|cathode|pad|uo_PAD[6] VSS|anode|cathode|vss sg13_hv_nmos L=0.6u W=66u
+ AS=30.096p AD=31.284p PS=84.08u PD=84.62u rfmode=0
M$20807 \$5689 D2|c2p|core|i|uo_c2p[6] VSS|anode|cathode|vss
+ VSS|anode|cathode|vss sg13_hv_nmos L=0.45u W=1.9u AS=0.646p AD=0.361p
+ PS=4.48u PD=2.28u rfmode=0
M$20808 VSS|anode|cathode|vss \$5690 \$5691 VSS|anode|cathode|vss sg13_hv_nmos
+ L=0.45u W=1.9u AS=0.361p AD=0.646p PS=2.28u PD=4.48u rfmode=0
M$20809 VSS|anode|cathode|vss \$5691 gate|ngate|o$6 VSS|anode|cathode|vss
+ sg13_hv_nmos L=0.45u W=1.9u AS=0.646p AD=0.646p PS=4.48u PD=4.48u rfmode=0
M$20810 \$5700 D2|c2p|core|i|uo_c2p[6] VSS|anode|cathode|vss
+ VSS|anode|cathode|vss sg13_hv_nmos L=0.45u W=1.9u AS=0.646p AD=0.361p
+ PS=4.48u PD=2.28u rfmode=0
M$20811 VSS|anode|cathode|vss \$5701 \$5703 VSS|anode|cathode|vss sg13_hv_nmos
+ L=0.45u W=1.9u AS=0.361p AD=0.646p PS=2.28u PD=4.48u rfmode=0
M$20812 VSS|anode|cathode|vss \$5704 \$5695 VSS|anode|cathode|vss sg13_hv_nmos
+ L=0.45u W=2.65u AS=0.901p AD=0.5035p PS=5.98u PD=3.03u rfmode=0
M$20813 \$5695 \$5706 VDD|in|pad|pin1|pin2|supply|vdd VSS|anode|cathode|vss
+ sg13_hv_nmos L=0.45u W=2.65u AS=0.5035p AD=0.901p PS=3.03u PD=5.98u rfmode=0
M$20814 VSS|anode|cathode|vss \$5703 gate|o|pgate$6 VSS|anode|cathode|vss
+ sg13_hv_nmos L=0.45u W=1.9u AS=0.646p AD=0.646p PS=4.48u PD=4.48u rfmode=0
M$20815 \$5706 core$4 IOVSS|anode|cathode|guard|iovss|minus
+ VSS|anode|cathode|vss sg13_hv_nmos L=0.45u W=1.3u AS=0.442p AD=0.247p
+ PS=3.28u PD=1.68u rfmode=0
M$20816 IOVSS|anode|cathode|guard|iovss|minus \$5706 \$5704
+ VSS|anode|cathode|vss sg13_hv_nmos L=0.45u W=1.3u AS=0.247p AD=0.442p
+ PS=1.68u PD=3.28u rfmode=0
M$20817 IOVSS|anode|cathode|guard|iovss|minus \$5781
+ analog_io[16]|anode|cathode|pad VSS|anode|cathode|vss sg13_hv_nmos L=0.6u
+ W=88u AS=40.7p AD=40.7p PS=110.9u PD=110.9u rfmode=0
M$20837 IOVSS|anode|cathode|guard|iovss|minus gate|ngate|o$7
+ anode|cathode|pad|uo_PAD[7] VSS|anode|cathode|vss sg13_hv_nmos L=0.6u W=66u
+ AS=30.096p AD=31.284p PS=84.08u PD=84.62u rfmode=0
M$20852 \$5786 D1|c2p|core|i|uo_c2p[7] VSS|anode|cathode|vss
+ VSS|anode|cathode|vss sg13_hv_nmos L=0.45u W=1.9u AS=0.646p AD=0.361p
+ PS=4.48u PD=2.28u rfmode=0
M$20853 VSS|anode|cathode|vss \$5787 \$5788 VSS|anode|cathode|vss sg13_hv_nmos
+ L=0.45u W=1.9u AS=0.361p AD=0.646p PS=2.28u PD=4.48u rfmode=0
M$20854 VSS|anode|cathode|vss \$5788 gate|ngate|o$7 VSS|anode|cathode|vss
+ sg13_hv_nmos L=0.45u W=1.9u AS=0.646p AD=0.646p PS=4.48u PD=4.48u rfmode=0
M$20855 \$5790 D1|c2p|core|i|uo_c2p[7] VSS|anode|cathode|vss
+ VSS|anode|cathode|vss sg13_hv_nmos L=0.45u W=1.9u AS=0.646p AD=0.361p
+ PS=4.48u PD=2.28u rfmode=0
M$20856 VSS|anode|cathode|vss \$5791 \$5798 VSS|anode|cathode|vss sg13_hv_nmos
+ L=0.45u W=1.9u AS=0.361p AD=0.646p PS=2.28u PD=4.48u rfmode=0
M$20857 VSS|anode|cathode|vss \$5798 gate|o|pgate$7 VSS|anode|cathode|vss
+ sg13_hv_nmos L=0.45u W=1.9u AS=0.646p AD=0.646p PS=4.48u PD=4.48u rfmode=0
M$20858 IOVSS|anode|cathode|guard|iovss|minus \$5871
+ analog_io[15]|anode|cathode|pad VSS|anode|cathode|vss sg13_hv_nmos L=0.6u
+ W=88u AS=40.7p AD=40.7p PS=110.9u PD=110.9u rfmode=0
M$20878 IOVSS|anode|cathode|guard|iovss|minus gate|ngate|o$8
+ anode|cathode|pad|uo_PAD[8] VSS|anode|cathode|vss sg13_hv_nmos L=0.6u W=66u
+ AS=30.096p AD=31.284p PS=84.08u PD=84.62u rfmode=0
M$20893 \$5876 D0|c2p|core|i|uo_c2p[8] VSS|anode|cathode|vss
+ VSS|anode|cathode|vss sg13_hv_nmos L=0.45u W=1.9u AS=0.646p AD=0.361p
+ PS=4.48u PD=2.28u rfmode=0
M$20894 VSS|anode|cathode|vss \$5879 \$5877 VSS|anode|cathode|vss sg13_hv_nmos
+ L=0.45u W=1.9u AS=0.361p AD=0.646p PS=2.28u PD=4.48u rfmode=0
M$20895 VSS|anode|cathode|vss \$5877 gate|ngate|o$8 VSS|anode|cathode|vss
+ sg13_hv_nmos L=0.45u W=1.9u AS=0.646p AD=0.646p PS=4.48u PD=4.48u rfmode=0
M$20896 \$5886 D0|c2p|core|i|uo_c2p[8] VSS|anode|cathode|vss
+ VSS|anode|cathode|vss sg13_hv_nmos L=0.45u W=1.9u AS=0.646p AD=0.361p
+ PS=4.48u PD=2.28u rfmode=0
M$20897 VSS|anode|cathode|vss \$5887 \$5888 VSS|anode|cathode|vss sg13_hv_nmos
+ L=0.45u W=1.9u AS=0.361p AD=0.646p PS=2.28u PD=4.48u rfmode=0
M$20898 VSS|anode|cathode|vss \$5888 gate|o|pgate$8 VSS|anode|cathode|vss
+ sg13_hv_nmos L=0.45u W=1.9u AS=0.646p AD=0.646p PS=4.48u PD=4.48u rfmode=0
M$20899 IOVSS|anode|cathode|guard|iovss|minus \$5958
+ analog_io[0]|anode|cathode|pad VSS|anode|cathode|vss sg13_hv_nmos L=0.6u
+ W=88u AS=40.7p AD=40.7p PS=110.9u PD=110.9u rfmode=0
M$20919 IOVSS|anode|cathode|guard|iovss|minus \$5961
+ analog_io[14]|anode|cathode|pad VSS|anode|cathode|vss sg13_hv_nmos L=0.6u
+ W=88u AS=40.7p AD=40.7p PS=110.9u PD=110.9u rfmode=0
M$20939 IOVSS|anode|cathode|guard|iovss|minus \$6047
+ analog_io[1]|anode|cathode|pad VSS|anode|cathode|vss sg13_hv_nmos L=0.6u
+ W=88u AS=40.7p AD=40.7p PS=110.9u PD=110.9u rfmode=0
M$20959 VSS|anode|cathode|vss \$6058 \$6055 VSS|anode|cathode|vss sg13_hv_nmos
+ L=0.45u W=2.65u AS=0.901p AD=0.5035p PS=5.98u PD=3.03u rfmode=0
M$20960 \$6055 \$6059 VDD|in|pad|pin1|pin2|supply|vdd VSS|anode|cathode|vss
+ sg13_hv_nmos L=0.45u W=2.65u AS=0.5035p AD=0.901p PS=3.03u PD=5.98u rfmode=0
M$20961 \$6059 core$5 IOVSS|anode|cathode|guard|iovss|minus
+ VSS|anode|cathode|vss sg13_hv_nmos L=0.45u W=1.3u AS=0.442p AD=0.247p
+ PS=3.28u PD=1.68u rfmode=0
M$20962 IOVSS|anode|cathode|guard|iovss|minus \$6059 \$6058
+ VSS|anode|cathode|vss sg13_hv_nmos L=0.45u W=1.3u AS=0.247p AD=0.442p
+ PS=1.68u PD=3.28u rfmode=0
M$20963 VBAT2|analog_io_padres[9]|core|padres
+ VBAT2|analog_io_padres[9]|core|padres VSS|anode|cathode|vss
+ VSS|anode|cathode|vss sg13_hv_nmos L=2u W=200u AS=39.5p AD=39.5p PS=217.9u
+ PD=217.9u rfmode=0
M$20983 \$6107 Q|Reset Vsource Vsource sg13_hv_nmos L=0.5u W=3u AS=1.02p
+ AD=1.02p PS=6.68u PD=6.68u rfmode=0
M$20984 Vsource Q|Qn \$6101 Vsource sg13_hv_nmos L=0.5u W=3u AS=1.02p AD=1.02p
+ PS=6.68u PD=6.68u rfmode=0
M$20985 G1|TRIG|Trig \$6101 Vsource Vsource sg13_hv_nmos L=0.5u W=72u AS=14.13p
+ AD=14.13p PS=84.42u PD=84.42u rfmode=0
M$21009 G2|vg vgmd78 VSS|anode|cathode|vss VSS|anode|cathode|vss sg13_hv_nmos
+ L=0.45u W=2000u AS=510.4p AD=510.4p PS=2142.08u PD=2142.08u rfmode=0
M$21109 \$6150 VBAT2|analog_io_padres[9]|core|padres VSS|anode|cathode|vss
+ VSS|anode|cathode|vss sg13_hv_nmos L=2u W=200u AS=39.5p AD=39.5p PS=217.9u
+ PD=217.9u rfmode=0
M$21229 IOVSS|anode|cathode|guard|iovss|minus \$6169
+ analog_io[2]|anode|cathode|pad VSS|anode|cathode|vss sg13_hv_nmos L=0.6u
+ W=88u AS=40.7p AD=40.7p PS=110.9u PD=110.9u rfmode=0
M$21249 RESET|Reset|reset VFE|X|vfe \$6150 VSS|anode|cathode|vss sg13_hv_nmos
+ L=0.5u W=30u AS=6.6p AD=6.6p PS=38.2u PD=38.2u rfmode=0
M$21254 \$6150 VRE|X|vre Qn|set VSS|anode|cathode|vss sg13_hv_nmos L=0.5u W=30u
+ AS=6.6p AD=6.6p PS=38.2u PD=38.2u rfmode=0
M$21259 Vsource Qn|set \$6171 Vsource sg13_hv_nmos L=3u W=5u AS=1.025p
+ AD=1.025p PS=9.6u PD=9.6u rfmode=0
M$21269 Q|Qn Q|Reset \$6171 Vsource sg13_hv_nmos L=3u W=5u AS=1.025p AD=1.025p
+ PS=9.6u PD=9.6u rfmode=0
M$21279 Q|Reset RESET|Reset|reset \$6206 Vsource sg13_hv_nmos L=3u W=5u
+ AS=1.025p AD=1.025p PS=9.6u PD=9.6u rfmode=0
M$21289 VSS|anode|cathode|vss Vs|core|p2c|ui_p2c[1] vgmd78
+ VSS|anode|cathode|vss sg13_hv_nmos L=0.45u W=250u AS=65.05p AD=64.5p
+ PS=273.01u PD=272.9u rfmode=0
M$21314 vgmd5 \$6208 VSS|anode|cathode|vss VSS|anode|cathode|vss sg13_hv_nmos
+ L=0.45u W=60u AS=17.4p AD=16.95p PS=73.48u PD=73.39u rfmode=0
M$21320 vgmd1 Vs|core|p2c|ui_p2c[1] VSS|anode|cathode|vss VSS|anode|cathode|vss
+ sg13_hv_nmos L=0.45u W=60u AS=17.1p AD=17.6p PS=73.42u PD=73.52u rfmode=0
M$21326 IOVSS|anode|cathode|guard|iovss|minus \$6173
+ analog_io[13]|anode|cathode|pad VSS|anode|cathode|vss sg13_hv_nmos L=0.6u
+ W=88u AS=40.7p AD=40.7p PS=110.9u PD=110.9u rfmode=0
M$21346 Vsource Q|Qn \$6206 Vsource sg13_hv_nmos L=3u W=5u AS=1.025p AD=1.025p
+ PS=9.6u PD=9.6u rfmode=0
M$21356 VOUT|analog_io_padres[11]|core|padres G2|vg VSS|anode|cathode|vss
+ VSS|anode|cathode|vss sg13_hv_nmos L=0.45u W=40800u AS=14616p AD=14616p
+ PS=44523.2u PD=44523.2u rfmode=0
M$21560 VOUT|analog_io_padres[11]|core|padres G1|TRIG|Trig
+ VH|analog_io_padres[10]|core|padres VOUT|analog_io_padres[11]|core|padres
+ sg13_hv_nmos L=0.45u W=40800u AS=14616p AD=14616p PS=44523.2u PD=44523.2u
+ rfmode=0
M$22172 IOVSS|anode|cathode|guard|iovss|minus \$6312
+ analog_io[3]|anode|cathode|pad VSS|anode|cathode|vss sg13_hv_nmos L=0.6u
+ W=88u AS=40.7p AD=40.7p PS=110.9u PD=110.9u rfmode=0
M$23008 IOVSS|anode|cathode|guard|iovss|minus \$6315
+ analog_io[12]|anode|cathode|pad VSS|anode|cathode|vss sg13_hv_nmos L=0.6u
+ W=88u AS=40.7p AD=40.7p PS=110.9u PD=110.9u rfmode=0
M$25068 IOVSS|anode|cathode|guard|iovss|minus gate|out$4
+ IOVDD|cathode|guard|in|iovdd|pad|pin1|pin2|plus|supply VSS|anode|cathode|vss
+ sg13_hv_nmos L=0.6u W=756.8u AS=344.608p AD=349.36p PS=931.04u PD=933.2u
+ rfmode=0
M$25197 IOVSS|anode|cathode|guard|iovss|minus
+ IOVDD|cathode|guard|in|iovdd|pad|pin1|pin2|plus|supply gate|out$4
+ VSS|anode|cathode|vss sg13_hv_nmos L=0.5u W=108u AS=23.22p AD=20.52p
+ PS=131.16u PD=112.56u rfmode=0
M$25631 IOVSS|anode|cathode|guard|iovss|minus VDD|in|pad|pin1|pin2|supply|vdd
+ gate|out$5 VSS|anode|cathode|vss sg13_hv_nmos L=0.5u W=108u AS=23.22p
+ AD=20.52p PS=131.16u PD=112.56u rfmode=0
M$25657 IOVSS|anode|cathode|guard|iovss|minus gate|out$5
+ VDD|in|pad|pin1|pin2|supply|vdd VSS|anode|cathode|vss sg13_hv_nmos L=0.6u
+ W=756.8u AS=344.608p AD=349.36p PS=931.04u PD=933.2u rfmode=0
M$29952 IOVSS|anode|cathode|guard|iovss|minus
+ IOVDD|cathode|guard|in|iovdd|pad|pin1|pin2|plus|supply gate|out$6
+ VSS|anode|cathode|vss sg13_hv_nmos L=0.5u W=108u AS=23.22p AD=20.52p
+ PS=131.16u PD=112.56u rfmode=0
M$29978 IOVSS|anode|cathode|guard|iovss|minus gate|out$6
+ IOVDD|cathode|guard|in|iovdd|pad|pin1|pin2|plus|supply VSS|anode|cathode|vss
+ sg13_hv_nmos L=0.6u W=756.8u AS=344.608p AD=349.36p PS=931.04u PD=933.2u
+ rfmode=0
M$30150 IOVSS|anode|cathode|guard|iovss|minus \$7145
+ analog_io[4]|anode|cathode|pad VSS|anode|cathode|vss sg13_hv_nmos L=0.6u
+ W=88u AS=40.7p AD=40.7p PS=110.9u PD=110.9u rfmode=0
M$30170 IOVSS|anode|cathode|guard|iovss|minus \$7146
+ analog_io[5]|anode|cathode|pad VSS|anode|cathode|vss sg13_hv_nmos L=0.6u
+ W=88u AS=40.7p AD=40.7p PS=110.9u PD=110.9u rfmode=0
M$30190 IOVSS|anode|cathode|guard|iovss|minus \$7147
+ analog_io[6]|anode|cathode|pad VSS|anode|cathode|vss sg13_hv_nmos L=0.6u
+ W=88u AS=40.7p AD=40.7p PS=110.9u PD=110.9u rfmode=0
M$30210 IOVSS|anode|cathode|guard|iovss|minus \$7148
+ analog_io[7]|anode|cathode|pad VSS|anode|cathode|vss sg13_hv_nmos L=0.6u
+ W=88u AS=40.7p AD=40.7p PS=110.9u PD=110.9u rfmode=0
M$30230 IOVSS|anode|cathode|guard|iovss|minus \$7149
+ analog_io[8]|anode|cathode|pad VSS|anode|cathode|vss sg13_hv_nmos L=0.6u
+ W=88u AS=40.7p AD=40.7p PS=110.9u PD=110.9u rfmode=0
M$30250 IOVSS|anode|cathode|guard|iovss|minus \$7150
+ analog_io[9]|anode|cathode|pad VSS|anode|cathode|vss sg13_hv_nmos L=0.6u
+ W=88u AS=40.7p AD=40.7p PS=110.9u PD=110.9u rfmode=0
M$30270 VSS|anode|cathode|vss \$6599 \$6598 VSS|anode|cathode|vss sg13_hv_nmos
+ L=0.45u W=2.65u AS=0.901p AD=0.5035p PS=5.98u PD=3.03u rfmode=0
M$30271 \$6598 \$6600 VDD|in|pad|pin1|pin2|supply|vdd VSS|anode|cathode|vss
+ sg13_hv_nmos L=0.45u W=2.65u AS=0.5035p AD=0.901p PS=3.03u PD=5.98u rfmode=0
M$30272 \$6600 core$6 IOVSS|anode|cathode|guard|iovss|minus
+ VSS|anode|cathode|vss sg13_hv_nmos L=0.45u W=1.3u AS=0.442p AD=0.247p
+ PS=3.28u PD=1.68u rfmode=0
M$30273 IOVSS|anode|cathode|guard|iovss|minus \$6600 \$6599
+ VSS|anode|cathode|vss sg13_hv_nmos L=0.45u W=1.3u AS=0.247p AD=0.442p
+ PS=1.68u PD=3.28u rfmode=0
M$30274 IOVSS|anode|cathode|guard|iovss|minus \$7151
+ analog_io[10]|anode|cathode|pad VSS|anode|cathode|vss sg13_hv_nmos L=0.6u
+ W=88u AS=40.7p AD=40.7p PS=110.9u PD=110.9u rfmode=0
M$30294 IOVSS|anode|cathode|guard|iovss|minus \$7152
+ analog_io[11]|anode|cathode|pad VSS|anode|cathode|vss sg13_hv_nmos L=0.6u
+ W=88u AS=40.7p AD=40.7p PS=110.9u PD=110.9u rfmode=0
M$30314 IOVSS|anode|cathode|guard|iovss|minus
+ IOVDD|cathode|guard|in|iovdd|pad|pin1|pin2|plus|supply gate|out$7
+ VSS|anode|cathode|vss sg13_hv_nmos L=0.5u W=108u AS=23.22p AD=20.52p
+ PS=131.16u PD=112.56u rfmode=0
M$30340 IOVSS|anode|cathode|guard|iovss|minus gate|out$7
+ IOVDD|cathode|guard|in|iovdd|pad|pin1|pin2|plus|supply VSS|anode|cathode|vss
+ sg13_hv_nmos L=0.6u W=756.8u AS=344.608p AD=349.36p PS=931.04u PD=933.2u
+ rfmode=0
M$30512 \$505 D5|c2p|core|i|uo_c2p[3] VDD|in|pad|pin1|pin2|supply|vdd
+ VDD|in|pad|pin1|pin2|supply|vdd sg13_lv_pmos L=0.13u W=4.75u AS=1.615p
+ AD=1.615p PS=10.18u PD=10.18u rfmode=0
M$30513 \$506 D5|c2p|core|i|uo_c2p[3] VDD|in|pad|pin1|pin2|supply|vdd
+ VDD|in|pad|pin1|pin2|supply|vdd sg13_lv_pmos L=0.13u W=4.75u AS=1.615p
+ AD=1.615p PS=10.18u PD=10.18u rfmode=0
M$30514 \$508 D6|c2p|core|i|uo_c2p[2] VDD|in|pad|pin1|pin2|supply|vdd
+ VDD|in|pad|pin1|pin2|supply|vdd sg13_lv_pmos L=0.13u W=4.75u AS=1.615p
+ AD=1.615p PS=10.18u PD=10.18u rfmode=0
M$30515 \$509 D6|c2p|core|i|uo_c2p[2] VDD|in|pad|pin1|pin2|supply|vdd
+ VDD|in|pad|pin1|pin2|supply|vdd sg13_lv_pmos L=0.13u W=4.75u AS=1.615p
+ AD=1.615p PS=10.18u PD=10.18u rfmode=0
M$30516 \$511 D7|c2p|core|i|uo_c2p[1] VDD|in|pad|pin1|pin2|supply|vdd
+ VDD|in|pad|pin1|pin2|supply|vdd sg13_lv_pmos L=0.13u W=4.75u AS=1.615p
+ AD=1.615p PS=10.18u PD=10.18u rfmode=0
M$30517 \$512 D7|c2p|core|i|uo_c2p[1] VDD|in|pad|pin1|pin2|supply|vdd
+ VDD|in|pad|pin1|pin2|supply|vdd sg13_lv_pmos L=0.13u W=4.75u AS=1.615p
+ AD=1.615p PS=10.18u PD=10.18u rfmode=0
M$30518 \$514 c2p|core|fdac_clk|i|uo_c2p[0] VDD|in|pad|pin1|pin2|supply|vdd
+ VDD|in|pad|pin1|pin2|supply|vdd sg13_lv_pmos L=0.13u W=4.75u AS=1.615p
+ AD=1.615p PS=10.18u PD=10.18u rfmode=0
M$30519 \$515 c2p|core|fdac_clk|i|uo_c2p[0] VDD|in|pad|pin1|pin2|supply|vdd
+ VDD|in|pad|pin1|pin2|supply|vdd sg13_lv_pmos L=0.13u W=4.75u AS=1.615p
+ AD=1.615p PS=10.18u PD=10.18u rfmode=0
M$30520 CLK|clk|core|fclk_in|p2c|ui_p2c[6] \$516
+ VDD|in|pad|pin1|pin2|supply|vdd VDD|in|pad|pin1|pin2|supply|vdd sg13_lv_pmos
+ L=0.13u W=4.75u AS=1.615p AD=1.615p PS=10.18u PD=10.18u rfmode=0
M$30521 core|p2c|reset|rst|ui_p2c[5] \$518 VDD|in|pad|pin1|pin2|supply|vdd
+ VDD|in|pad|pin1|pin2|supply|vdd sg13_lv_pmos L=0.13u W=4.75u AS=1.615p
+ AD=1.615p PS=10.18u PD=10.18u rfmode=0
M$30522 VDD|in|pad|pin1|pin2|supply|vdd core|p2c|reset|rst|ui_p2c[5] \$728
+ VDD|in|pad|pin1|pin2|supply|vdd sg13_lv_pmos L=0.13u W=0.84u AS=0.2114p
+ AD=0.2856p PS=1.54u PD=2.36u rfmode=0
M$30523 VDD|in|pad|pin1|pin2|supply|vdd \$728 \$725
+ VDD|in|pad|pin1|pin2|supply|vdd sg13_lv_pmos L=0.13u W=1.12u AS=0.2114p
+ AD=0.42p PS=1.54u PD=2.99u rfmode=0
M$30524 VDD|in|pad|pin1|pin2|supply|vdd VSS|anode|cathode|vss
+ VDD|in|pad|pin1|pin2|supply|vdd VDD|in|pad|pin1|pin2|supply|vdd sg13_lv_pmos
+ L=1u W=13963u AS=3704.77p AD=3704.77p PS=28384.54u PD=28384.54u rfmode=0
M$32720 VDD|in|pad|pin1|pin2|supply|vdd core|done_in|p2c|ui_p2c[4] \$767
+ VDD|in|pad|pin1|pin2|supply|vdd sg13_lv_pmos L=0.13u W=0.84u AS=0.2114p
+ AD=0.2856p PS=1.54u PD=2.36u rfmode=0
M$32721 \$766 \$767 VDD|in|pad|pin1|pin2|supply|vdd
+ VDD|in|pad|pin1|pin2|supply|vdd sg13_lv_pmos L=0.13u W=1.12u AS=0.42p
+ AD=0.2114p PS=2.99u PD=1.54u rfmode=0
M$37745 \$866 \$868 VDD|in|pad|pin1|pin2|supply|vdd
+ VDD|in|pad|pin1|pin2|supply|vdd sg13_lv_pmos L=0.13u W=1.12u AS=0.42p
+ AD=0.2114p PS=2.99u PD=1.54u rfmode=0
M$37746 VDD|in|pad|pin1|pin2|supply|vdd core|p2c|shift_in|ui_p2c[3] \$868
+ VDD|in|pad|pin1|pin2|supply|vdd sg13_lv_pmos L=0.13u W=0.84u AS=0.2114p
+ AD=0.2856p PS=1.54u PD=2.36u rfmode=0
M$41515 VDD|in|pad|pin1|pin2|supply|vdd \$881 \$758
+ VDD|in|pad|pin1|pin2|supply|vdd sg13_lv_pmos L=0.13u W=2u AS=0.68p AD=0.68p
+ PS=4.68u PD=4.68u rfmode=0
M$41516 VDD|in|pad|pin1|pin2|supply|vdd \$881 \$922
+ VDD|in|pad|pin1|pin2|supply|vdd sg13_lv_pmos L=0.13u W=0.8u AS=0.272p
+ AD=0.272p PS=2.28u PD=2.28u rfmode=0
M$41517 VSS|anode|cathode|vss \$922 \$758 VDD|in|pad|pin1|pin2|supply|vdd
+ sg13_lv_pmos L=0.13u W=2u AS=0.68p AD=0.68p PS=4.68u PD=4.68u rfmode=0
M$41518 VDD|in|pad|pin1|pin2|supply|vdd \$882 \$784
+ VDD|in|pad|pin1|pin2|supply|vdd sg13_lv_pmos L=0.13u W=2u AS=0.68p AD=0.68p
+ PS=4.68u PD=4.68u rfmode=0
M$41519 VDD|in|pad|pin1|pin2|supply|vdd \$882 \$923
+ VDD|in|pad|pin1|pin2|supply|vdd sg13_lv_pmos L=0.13u W=0.8u AS=0.272p
+ AD=0.272p PS=2.28u PD=2.28u rfmode=0
M$41520 VSS|anode|cathode|vss \$923 \$784 VDD|in|pad|pin1|pin2|supply|vdd
+ sg13_lv_pmos L=0.13u W=2u AS=0.68p AD=0.68p PS=4.68u PD=4.68u rfmode=0
M$41521 VDD|in|pad|pin1|pin2|supply|vdd \$883 \$788
+ VDD|in|pad|pin1|pin2|supply|vdd sg13_lv_pmos L=0.13u W=2u AS=0.68p AD=0.68p
+ PS=4.68u PD=4.68u rfmode=0
M$41522 VDD|in|pad|pin1|pin2|supply|vdd \$883 \$924
+ VDD|in|pad|pin1|pin2|supply|vdd sg13_lv_pmos L=0.13u W=0.8u AS=0.272p
+ AD=0.272p PS=2.28u PD=2.28u rfmode=0
M$41523 VSS|anode|cathode|vss \$924 \$788 VDD|in|pad|pin1|pin2|supply|vdd
+ sg13_lv_pmos L=0.13u W=2u AS=0.68p AD=0.68p PS=4.68u PD=4.68u rfmode=0
M$41524 VDD|in|pad|pin1|pin2|supply|vdd \$884 \$812
+ VDD|in|pad|pin1|pin2|supply|vdd sg13_lv_pmos L=0.13u W=2u AS=0.68p AD=0.68p
+ PS=4.68u PD=4.68u rfmode=0
M$41525 VDD|in|pad|pin1|pin2|supply|vdd \$884 \$925
+ VDD|in|pad|pin1|pin2|supply|vdd sg13_lv_pmos L=0.13u W=0.8u AS=0.272p
+ AD=0.272p PS=2.28u PD=2.28u rfmode=0
M$41526 VSS|anode|cathode|vss \$925 \$812 VDD|in|pad|pin1|pin2|supply|vdd
+ sg13_lv_pmos L=0.13u W=2u AS=0.68p AD=0.68p PS=4.68u PD=4.68u rfmode=0
M$41527 VDD|in|pad|pin1|pin2|supply|vdd \$885 \$822
+ VDD|in|pad|pin1|pin2|supply|vdd sg13_lv_pmos L=0.13u W=2u AS=0.68p AD=0.68p
+ PS=4.68u PD=4.68u rfmode=0
M$41528 VDD|in|pad|pin1|pin2|supply|vdd \$885 \$926
+ VDD|in|pad|pin1|pin2|supply|vdd sg13_lv_pmos L=0.13u W=0.8u AS=0.272p
+ AD=0.272p PS=2.28u PD=2.28u rfmode=0
M$41529 VSS|anode|cathode|vss \$926 \$822 VDD|in|pad|pin1|pin2|supply|vdd
+ sg13_lv_pmos L=0.13u W=2u AS=0.68p AD=0.68p PS=4.68u PD=4.68u rfmode=0
M$41530 VDD|in|pad|pin1|pin2|supply|vdd \$886 \$825
+ VDD|in|pad|pin1|pin2|supply|vdd sg13_lv_pmos L=0.13u W=2u AS=0.68p AD=0.68p
+ PS=4.68u PD=4.68u rfmode=0
M$41531 VDD|in|pad|pin1|pin2|supply|vdd \$886 \$927
+ VDD|in|pad|pin1|pin2|supply|vdd sg13_lv_pmos L=0.13u W=0.8u AS=0.272p
+ AD=0.272p PS=2.28u PD=2.28u rfmode=0
M$41532 VSS|anode|cathode|vss \$927 \$825 VDD|in|pad|pin1|pin2|supply|vdd
+ sg13_lv_pmos L=0.13u W=2u AS=0.68p AD=0.68p PS=4.68u PD=4.68u rfmode=0
M$41533 VDD|in|pad|pin1|pin2|supply|vdd \$887 \$813
+ VDD|in|pad|pin1|pin2|supply|vdd sg13_lv_pmos L=0.13u W=2u AS=0.68p AD=0.68p
+ PS=4.68u PD=4.68u rfmode=0
M$41534 VDD|in|pad|pin1|pin2|supply|vdd \$887 \$928
+ VDD|in|pad|pin1|pin2|supply|vdd sg13_lv_pmos L=0.13u W=0.8u AS=0.272p
+ AD=0.272p PS=2.28u PD=2.28u rfmode=0
M$41535 VSS|anode|cathode|vss \$928 \$813 VDD|in|pad|pin1|pin2|supply|vdd
+ sg13_lv_pmos L=0.13u W=2u AS=0.68p AD=0.68p PS=4.68u PD=4.68u rfmode=0
M$41536 \$820 \$929 VSS|anode|cathode|vss VDD|in|pad|pin1|pin2|supply|vdd
+ sg13_lv_pmos L=0.13u W=2u AS=0.68p AD=0.68p PS=4.68u PD=4.68u rfmode=0
M$41537 \$929 \$888 VDD|in|pad|pin1|pin2|supply|vdd
+ VDD|in|pad|pin1|pin2|supply|vdd sg13_lv_pmos L=0.13u W=0.8u AS=0.272p
+ AD=0.272p PS=2.28u PD=2.28u rfmode=0
M$41538 \$820 \$888 VDD|in|pad|pin1|pin2|supply|vdd
+ VDD|in|pad|pin1|pin2|supply|vdd sg13_lv_pmos L=0.13u W=2u AS=0.68p AD=0.68p
+ PS=4.68u PD=4.68u rfmode=0
M$41539 \$823 \$930 VSS|anode|cathode|vss VDD|in|pad|pin1|pin2|supply|vdd
+ sg13_lv_pmos L=0.13u W=2u AS=0.68p AD=0.68p PS=4.68u PD=4.68u rfmode=0
M$41540 \$930 \$979 VDD|in|pad|pin1|pin2|supply|vdd
+ VDD|in|pad|pin1|pin2|supply|vdd sg13_lv_pmos L=0.13u W=0.8u AS=0.272p
+ AD=0.272p PS=2.28u PD=2.28u rfmode=0
M$41541 \$823 \$979 VDD|in|pad|pin1|pin2|supply|vdd
+ VDD|in|pad|pin1|pin2|supply|vdd sg13_lv_pmos L=0.13u W=2u AS=0.68p AD=0.68p
+ PS=4.68u PD=4.68u rfmode=0
M$41542 \$824 \$931 VSS|anode|cathode|vss VDD|in|pad|pin1|pin2|supply|vdd
+ sg13_lv_pmos L=0.13u W=2u AS=0.68p AD=0.68p PS=4.68u PD=4.68u rfmode=0
M$41543 \$931 \$889 VDD|in|pad|pin1|pin2|supply|vdd
+ VDD|in|pad|pin1|pin2|supply|vdd sg13_lv_pmos L=0.13u W=0.8u AS=0.272p
+ AD=0.272p PS=2.28u PD=2.28u rfmode=0
M$41544 \$824 \$889 VDD|in|pad|pin1|pin2|supply|vdd
+ VDD|in|pad|pin1|pin2|supply|vdd sg13_lv_pmos L=0.13u W=2u AS=0.68p AD=0.68p
+ PS=4.68u PD=4.68u rfmode=0
M$41545 \$814 \$932 VSS|anode|cathode|vss VDD|in|pad|pin1|pin2|supply|vdd
+ sg13_lv_pmos L=0.13u W=2u AS=0.68p AD=0.68p PS=4.68u PD=4.68u rfmode=0
M$41546 \$932 \$890 VDD|in|pad|pin1|pin2|supply|vdd
+ VDD|in|pad|pin1|pin2|supply|vdd sg13_lv_pmos L=0.13u W=0.8u AS=0.272p
+ AD=0.272p PS=2.28u PD=2.28u rfmode=0
M$41547 \$814 \$890 VDD|in|pad|pin1|pin2|supply|vdd
+ VDD|in|pad|pin1|pin2|supply|vdd sg13_lv_pmos L=0.13u W=2u AS=0.68p AD=0.68p
+ PS=4.68u PD=4.68u rfmode=0
M$41548 \$789 \$933 VSS|anode|cathode|vss VDD|in|pad|pin1|pin2|supply|vdd
+ sg13_lv_pmos L=0.13u W=2u AS=0.68p AD=0.68p PS=4.68u PD=4.68u rfmode=0
M$41549 \$933 \$891 VDD|in|pad|pin1|pin2|supply|vdd
+ VDD|in|pad|pin1|pin2|supply|vdd sg13_lv_pmos L=0.13u W=0.8u AS=0.272p
+ AD=0.272p PS=2.28u PD=2.28u rfmode=0
M$41550 \$789 \$891 VDD|in|pad|pin1|pin2|supply|vdd
+ VDD|in|pad|pin1|pin2|supply|vdd sg13_lv_pmos L=0.13u W=2u AS=0.68p AD=0.68p
+ PS=4.68u PD=4.68u rfmode=0
M$41551 \$785 \$934 VSS|anode|cathode|vss VDD|in|pad|pin1|pin2|supply|vdd
+ sg13_lv_pmos L=0.13u W=2u AS=0.68p AD=0.68p PS=4.68u PD=4.68u rfmode=0
M$41552 \$934 \$892 VDD|in|pad|pin1|pin2|supply|vdd
+ VDD|in|pad|pin1|pin2|supply|vdd sg13_lv_pmos L=0.13u W=0.8u AS=0.272p
+ AD=0.272p PS=2.28u PD=2.28u rfmode=0
M$41553 \$785 \$892 VDD|in|pad|pin1|pin2|supply|vdd
+ VDD|in|pad|pin1|pin2|supply|vdd sg13_lv_pmos L=0.13u W=2u AS=0.68p AD=0.68p
+ PS=4.68u PD=4.68u rfmode=0
M$41554 \$759 \$935 VSS|anode|cathode|vss VDD|in|pad|pin1|pin2|supply|vdd
+ sg13_lv_pmos L=0.13u W=2u AS=0.68p AD=0.68p PS=4.68u PD=4.68u rfmode=0
M$41555 \$935 \$893 VDD|in|pad|pin1|pin2|supply|vdd
+ VDD|in|pad|pin1|pin2|supply|vdd sg13_lv_pmos L=0.13u W=0.8u AS=0.272p
+ AD=0.272p PS=2.28u PD=2.28u rfmode=0
M$41556 \$759 \$893 VDD|in|pad|pin1|pin2|supply|vdd
+ VDD|in|pad|pin1|pin2|supply|vdd sg13_lv_pmos L=0.13u W=2u AS=0.68p AD=0.68p
+ PS=4.68u PD=4.68u rfmode=0
M$42905 VDD|in|pad|pin1|pin2|supply|vdd \$1077 \$1058
+ VDD|in|pad|pin1|pin2|supply|vdd sg13_lv_pmos L=0.13u W=1.12u AS=0.3808p
+ AD=0.3808p PS=2.92u PD=2.92u rfmode=0
M$42935 VDD|in|pad|pin1|pin2|supply|vdd \$1078 \$1059
+ VDD|in|pad|pin1|pin2|supply|vdd sg13_lv_pmos L=0.13u W=0.84u AS=0.2114p
+ AD=0.2856p PS=1.54u PD=2.36u rfmode=0
M$42936 \$1077 \$1059 VDD|in|pad|pin1|pin2|supply|vdd
+ VDD|in|pad|pin1|pin2|supply|vdd sg13_lv_pmos L=0.13u W=1.12u AS=0.42p
+ AD=0.2114p PS=2.99u PD=1.54u rfmode=0
M$42955 VDD|in|pad|pin1|pin2|supply|vdd \$1078 \$1060
+ VDD|in|pad|pin1|pin2|supply|vdd sg13_lv_pmos L=0.13u W=1.12u AS=0.3808p
+ AD=0.3808p PS=2.92u PD=2.92u rfmode=0
M$43064 \$1061 \$1079 \$1084 VDD|in|pad|pin1|pin2|supply|vdd sg13_lv_pmos
+ L=0.13u W=1.12u AS=0.3808p AD=0.1176p PS=2.92u PD=1.33u rfmode=0
M$43065 \$1084 \$1064 VDD|in|pad|pin1|pin2|supply|vdd
+ VDD|in|pad|pin1|pin2|supply|vdd sg13_lv_pmos L=0.13u W=1.12u AS=0.1176p
+ AD=0.2618p PS=1.33u PD=1.63u rfmode=0
M$43066 VDD|in|pad|pin1|pin2|supply|vdd \$866 \$1064
+ VDD|in|pad|pin1|pin2|supply|vdd sg13_lv_pmos L=0.13u W=0.84u AS=0.2618p
+ AD=0.2856p PS=1.63u PD=2.36u rfmode=0
M$43067 VDD|in|pad|pin1|pin2|supply|vdd \$766 \$1062
+ VDD|in|pad|pin1|pin2|supply|vdd sg13_lv_pmos L=0.13u W=0.84u AS=0.2114p
+ AD=0.2856p PS=1.54u PD=2.36u rfmode=0
M$43068 \$1079 \$1062 VDD|in|pad|pin1|pin2|supply|vdd
+ VDD|in|pad|pin1|pin2|supply|vdd sg13_lv_pmos L=0.13u W=1.12u AS=0.42p
+ AD=0.2114p PS=2.99u PD=1.54u rfmode=0
M$43212 \$1092 \$1077 VDD|in|pad|pin1|pin2|supply|vdd
+ VDD|in|pad|pin1|pin2|supply|vdd sg13_lv_pmos L=0.13u W=1.12u AS=0.3808p
+ AD=0.3808p PS=2.92u PD=2.92u rfmode=0
M$43214 VDD|in|pad|pin1|pin2|supply|vdd \$1079 \$1129
+ VDD|in|pad|pin1|pin2|supply|vdd sg13_lv_pmos L=0.13u W=0.84u AS=0.253p
+ AD=0.2856p PS=1.53u PD=2.36u rfmode=0
M$43215 VDD|in|pad|pin1|pin2|supply|vdd \$1129 \$1179
+ VDD|in|pad|pin1|pin2|supply|vdd sg13_lv_pmos L=0.13u W=1u AS=0.2198p
+ AD=0.2975p PS=1.52u PD=1.595u rfmode=0
M$43216 \$1179 \$1127 \$1094 VDD|in|pad|pin1|pin2|supply|vdd sg13_lv_pmos
+ L=0.13u W=1u AS=0.2975p AD=0.2225p PS=1.595u PD=1.445u rfmode=0
M$43217 \$1094 \$1128 \$1178 VDD|in|pad|pin1|pin2|supply|vdd sg13_lv_pmos
+ L=0.13u W=1u AS=0.2225p AD=0.3325p PS=1.445u PD=1.665u rfmode=0
M$43218 \$1178 \$1079 VDD|in|pad|pin1|pin2|supply|vdd
+ VDD|in|pad|pin1|pin2|supply|vdd sg13_lv_pmos L=0.13u W=1u AS=0.3325p
+ AD=0.253p PS=1.665u PD=1.53u rfmode=0
M$43219 \$1093 \$1094 VDD|in|pad|pin1|pin2|supply|vdd
+ VDD|in|pad|pin1|pin2|supply|vdd sg13_lv_pmos L=0.13u W=1.12u AS=0.6048p
+ AD=0.2198p PS=3.32u PD=1.52u rfmode=0
M$43220 \$1130 \$1166 VDD|in|pad|pin1|pin2|supply|vdd
+ VDD|in|pad|pin1|pin2|supply|vdd sg13_lv_pmos L=0.13u W=0.84u AS=0.2856p
+ AD=0.253p PS=2.36u PD=1.53u rfmode=0
M$43221 VDD|in|pad|pin1|pin2|supply|vdd \$1166 \$1182
+ VDD|in|pad|pin1|pin2|supply|vdd sg13_lv_pmos L=0.13u W=1u AS=0.253p
+ AD=0.3325p PS=1.53u PD=1.665u rfmode=0
M$43222 \$1182 \$1131 \$1095 VDD|in|pad|pin1|pin2|supply|vdd sg13_lv_pmos
+ L=0.13u W=1u AS=0.3325p AD=0.2225p PS=1.665u PD=1.445u rfmode=0
M$43223 \$1095 \$1127 \$1181 VDD|in|pad|pin1|pin2|supply|vdd sg13_lv_pmos
+ L=0.13u W=1u AS=0.2225p AD=0.2975p PS=1.445u PD=1.595u rfmode=0
M$43224 \$1181 \$1130 VDD|in|pad|pin1|pin2|supply|vdd
+ VDD|in|pad|pin1|pin2|supply|vdd sg13_lv_pmos L=0.13u W=1u AS=0.2975p
+ AD=0.2198p PS=1.595u PD=1.52u rfmode=0
M$43225 VDD|in|pad|pin1|pin2|supply|vdd \$1095 \$1096
+ VDD|in|pad|pin1|pin2|supply|vdd sg13_lv_pmos L=0.13u W=1.12u AS=0.2198p
+ AD=0.6048p PS=1.52u PD=3.32u rfmode=0
M$43226 VDD|in|pad|pin1|pin2|supply|vdd \$1096 \$1133
+ VDD|in|pad|pin1|pin2|supply|vdd sg13_lv_pmos L=0.13u W=0.42u AS=0.1428p
+ AD=0.0798p PS=1.52u PD=0.8u rfmode=0
M$43227 VDD|in|pad|pin1|pin2|supply|vdd \$1058 \$1133
+ VDD|in|pad|pin1|pin2|supply|vdd sg13_lv_pmos L=0.13u W=0.42u AS=0.3623875p
+ AD=0.0798p PS=2.605u PD=0.8u rfmode=0
M$43228 VDD|in|pad|pin1|pin2|supply|vdd \$1167 \$1097
+ VDD|in|pad|pin1|pin2|supply|vdd sg13_lv_pmos L=0.13u W=1u AS=0.3623875p
+ AD=0.34p PS=2.605u PD=2.68u rfmode=0
M$43229 \$1134 \$1098 VDD|in|pad|pin1|pin2|supply|vdd
+ VDD|in|pad|pin1|pin2|supply|vdd sg13_lv_pmos L=0.13u W=1.12u AS=0.3864p
+ AD=0.41165p PS=2.93u PD=2.12u rfmode=0
M$43230 VDD|in|pad|pin1|pin2|supply|vdd \$1201 \$1098
+ VDD|in|pad|pin1|pin2|supply|vdd sg13_lv_pmos L=0.13u W=1.12u AS=0.41165p
+ AD=0.4088p PS=2.12u PD=2.97u rfmode=0
M$43231 \$1135 \$1134 \$1171 VDD|in|pad|pin1|pin2|supply|vdd sg13_lv_pmos
+ L=0.13u W=0.42u AS=0.2048p AD=0.09345p PS=1.63u PD=0.865u rfmode=0
M$43232 \$1171 \$1100 VDD|in|pad|pin1|pin2|supply|vdd
+ VDD|in|pad|pin1|pin2|supply|vdd sg13_lv_pmos L=0.13u W=0.42u AS=0.09345p
+ AD=0.204p PS=0.865u PD=1.835u rfmode=0
M$43233 VDD|in|pad|pin1|pin2|supply|vdd \$1058 \$1100
+ VDD|in|pad|pin1|pin2|supply|vdd sg13_lv_pmos L=0.13u W=0.42u AS=0.204p
+ AD=0.0798p PS=1.835u PD=0.8u rfmode=0
M$43234 \$1100 \$1135 VDD|in|pad|pin1|pin2|supply|vdd
+ VDD|in|pad|pin1|pin2|supply|vdd sg13_lv_pmos L=0.13u W=0.42u AS=0.0798p
+ AD=0.4659p PS=0.8u PD=3.65u rfmode=0
M$43235 \$1097 \$1098 \$1135 VDD|in|pad|pin1|pin2|supply|vdd sg13_lv_pmos
+ L=0.13u W=1u AS=0.34p AD=0.2048p PS=2.68u PD=1.63u rfmode=0
M$43236 \$1101 \$1135 VDD|in|pad|pin1|pin2|supply|vdd
+ VDD|in|pad|pin1|pin2|supply|vdd sg13_lv_pmos L=0.13u W=1.12u AS=0.3864p
+ AD=0.2128p PS=2.93u PD=1.5u rfmode=0
M$43237 VDD|in|pad|pin1|pin2|supply|vdd \$1101 \$1102
+ VDD|in|pad|pin1|pin2|supply|vdd sg13_lv_pmos L=0.13u W=1.12u AS=0.2128p
+ AD=0.3808p PS=1.5u PD=2.92u rfmode=0
M$43238 VDD|in|pad|pin1|pin2|supply|vdd \$1077 \$1103
+ VDD|in|pad|pin1|pin2|supply|vdd sg13_lv_pmos L=0.13u W=1.12u AS=0.3808p
+ AD=0.3808p PS=2.92u PD=2.92u rfmode=0
M$43243 \$1136 \$1166 VDD|in|pad|pin1|pin2|supply|vdd
+ VDD|in|pad|pin1|pin2|supply|vdd sg13_lv_pmos L=0.13u W=0.84u AS=0.2856p
+ AD=0.253p PS=2.36u PD=1.53u rfmode=0
M$43244 VDD|in|pad|pin1|pin2|supply|vdd \$1166 \$1184
+ VDD|in|pad|pin1|pin2|supply|vdd sg13_lv_pmos L=0.13u W=1u AS=0.253p
+ AD=0.3325p PS=1.53u PD=1.665u rfmode=0
M$43245 \$1184 \$1458 \$1104 VDD|in|pad|pin1|pin2|supply|vdd sg13_lv_pmos
+ L=0.13u W=1u AS=0.3325p AD=0.2225p PS=1.665u PD=1.445u rfmode=0
M$43246 \$1104 \$1453 \$1183 VDD|in|pad|pin1|pin2|supply|vdd sg13_lv_pmos
+ L=0.13u W=1u AS=0.2225p AD=0.2975p PS=1.445u PD=1.595u rfmode=0
M$43247 \$1183 \$1136 VDD|in|pad|pin1|pin2|supply|vdd
+ VDD|in|pad|pin1|pin2|supply|vdd sg13_lv_pmos L=0.13u W=1u AS=0.2975p
+ AD=0.2198p PS=1.595u PD=1.52u rfmode=0
M$43248 VDD|in|pad|pin1|pin2|supply|vdd \$1104 \$1105
+ VDD|in|pad|pin1|pin2|supply|vdd sg13_lv_pmos L=0.13u W=1.12u AS=0.2198p
+ AD=0.6048p PS=1.52u PD=3.32u rfmode=0
M$43261 VDD|in|pad|pin1|pin2|supply|vdd \$1106 \$1137
+ VDD|in|pad|pin1|pin2|supply|vdd sg13_lv_pmos L=0.5u W=1u AS=0.2254p AD=0.34p
+ PS=1.53u PD=2.68u rfmode=0
M$43262 \$1127 \$1137 VDD|in|pad|pin1|pin2|supply|vdd
+ VDD|in|pad|pin1|pin2|supply|vdd sg13_lv_pmos L=0.13u W=1.12u AS=0.4256p
+ AD=0.2254p PS=3u PD=1.53u rfmode=0
M$43263 VDD|in|pad|pin1|pin2|supply|vdd \$1138 \$1107
+ VDD|in|pad|pin1|pin2|supply|vdd sg13_lv_pmos L=0.13u W=0.42u AS=0.1523p
+ AD=0.1428p PS=1.38u PD=1.52u rfmode=0
M$43264 \$1106 \$1107 VDD|in|pad|pin1|pin2|supply|vdd
+ VDD|in|pad|pin1|pin2|supply|vdd sg13_lv_pmos L=0.5u W=1u AS=0.34p AD=0.1523p
+ PS=2.68u PD=1.38u rfmode=0
M$43265 VDD|in|pad|pin1|pin2|supply|vdd \$1139 \$1108
+ VDD|in|pad|pin1|pin2|supply|vdd sg13_lv_pmos L=0.13u W=0.42u AS=0.1523p
+ AD=0.1428p PS=1.38u PD=1.52u rfmode=0
M$43266 VDD|in|pad|pin1|pin2|supply|vdd \$1108 \$1109
+ VDD|in|pad|pin1|pin2|supply|vdd sg13_lv_pmos L=0.5u W=1u AS=0.1523p AD=0.34p
+ PS=1.38u PD=2.68u rfmode=0
M$43267 \$1140 \$1109 VDD|in|pad|pin1|pin2|supply|vdd
+ VDD|in|pad|pin1|pin2|supply|vdd sg13_lv_pmos L=0.5u W=1u AS=0.34p AD=0.2254p
+ PS=2.68u PD=1.53u rfmode=0
M$43268 VDD|in|pad|pin1|pin2|supply|vdd \$1140 \$1110
+ VDD|in|pad|pin1|pin2|supply|vdd sg13_lv_pmos L=0.13u W=1.12u AS=0.2254p
+ AD=0.4256p PS=1.53u PD=3u rfmode=0
M$43273 VDD|in|pad|pin1|pin2|supply|vdd \$1296 \$1111
+ VDD|in|pad|pin1|pin2|supply|vdd sg13_lv_pmos L=0.13u W=0.42u AS=0.1523p
+ AD=0.1428p PS=1.38u PD=1.52u rfmode=0
M$43274 VDD|in|pad|pin1|pin2|supply|vdd \$1111 \$1112
+ VDD|in|pad|pin1|pin2|supply|vdd sg13_lv_pmos L=0.5u W=1u AS=0.1523p AD=0.34p
+ PS=1.38u PD=2.68u rfmode=0
M$43275 \$1141 \$1112 VDD|in|pad|pin1|pin2|supply|vdd
+ VDD|in|pad|pin1|pin2|supply|vdd sg13_lv_pmos L=0.5u W=1u AS=0.34p AD=0.2254p
+ PS=2.68u PD=1.53u rfmode=0
M$43276 VDD|in|pad|pin1|pin2|supply|vdd \$1141 \$1298
+ VDD|in|pad|pin1|pin2|supply|vdd sg13_lv_pmos L=0.13u W=1.12u AS=0.2254p
+ AD=0.4256p PS=1.53u PD=3u rfmode=0
M$43284 \$1142 \$1166 VDD|in|pad|pin1|pin2|supply|vdd
+ VDD|in|pad|pin1|pin2|supply|vdd sg13_lv_pmos L=0.13u W=0.84u AS=0.2856p
+ AD=0.253p PS=2.36u PD=1.53u rfmode=0
M$43285 VDD|in|pad|pin1|pin2|supply|vdd \$1166 \$1185
+ VDD|in|pad|pin1|pin2|supply|vdd sg13_lv_pmos L=0.13u W=1u AS=0.253p
+ AD=0.3325p PS=1.53u PD=1.665u rfmode=0
M$43286 \$1185 \$1127 \$1113 VDD|in|pad|pin1|pin2|supply|vdd sg13_lv_pmos
+ L=0.13u W=1u AS=0.3325p AD=0.2225p PS=1.665u PD=1.445u rfmode=0
M$43287 \$1113 \$1143 \$1186 VDD|in|pad|pin1|pin2|supply|vdd sg13_lv_pmos
+ L=0.13u W=1u AS=0.2225p AD=0.2975p PS=1.445u PD=1.595u rfmode=0
M$43288 \$1186 \$1142 VDD|in|pad|pin1|pin2|supply|vdd
+ VDD|in|pad|pin1|pin2|supply|vdd sg13_lv_pmos L=0.13u W=1u AS=0.2975p
+ AD=0.2198p PS=1.595u PD=1.52u rfmode=0
M$43289 VDD|in|pad|pin1|pin2|supply|vdd \$1113 \$1114
+ VDD|in|pad|pin1|pin2|supply|vdd sg13_lv_pmos L=0.13u W=1.12u AS=0.2198p
+ AD=0.6048p PS=1.52u PD=3.32u rfmode=0
M$43290 VDD|in|pad|pin1|pin2|supply|vdd \$1114 \$1145
+ VDD|in|pad|pin1|pin2|supply|vdd sg13_lv_pmos L=0.13u W=0.42u AS=0.1428p
+ AD=0.0798p PS=1.52u PD=0.8u rfmode=0
M$43291 VDD|in|pad|pin1|pin2|supply|vdd \$1060 \$1145
+ VDD|in|pad|pin1|pin2|supply|vdd sg13_lv_pmos L=0.13u W=0.42u AS=0.3623875p
+ AD=0.0798p PS=2.605u PD=0.8u rfmode=0
M$43292 VDD|in|pad|pin1|pin2|supply|vdd \$1168 \$1115
+ VDD|in|pad|pin1|pin2|supply|vdd sg13_lv_pmos L=0.13u W=1u AS=0.3623875p
+ AD=0.34p PS=2.605u PD=2.68u rfmode=0
M$43293 \$1146 \$1116 VDD|in|pad|pin1|pin2|supply|vdd
+ VDD|in|pad|pin1|pin2|supply|vdd sg13_lv_pmos L=0.13u W=1.12u AS=0.3864p
+ AD=0.41165p PS=2.93u PD=2.12u rfmode=0
M$43294 VDD|in|pad|pin1|pin2|supply|vdd \$1201 \$1116
+ VDD|in|pad|pin1|pin2|supply|vdd sg13_lv_pmos L=0.13u W=1.12u AS=0.41165p
+ AD=0.4088p PS=2.12u PD=2.97u rfmode=0
M$43295 \$1147 \$1146 \$1177 VDD|in|pad|pin1|pin2|supply|vdd sg13_lv_pmos
+ L=0.13u W=0.42u AS=0.2048p AD=0.09345p PS=1.63u PD=0.865u rfmode=0
M$43296 \$1177 \$1118 VDD|in|pad|pin1|pin2|supply|vdd
+ VDD|in|pad|pin1|pin2|supply|vdd sg13_lv_pmos L=0.13u W=0.42u AS=0.09345p
+ AD=0.204p PS=0.865u PD=1.835u rfmode=0
M$43297 VDD|in|pad|pin1|pin2|supply|vdd \$1060 \$1118
+ VDD|in|pad|pin1|pin2|supply|vdd sg13_lv_pmos L=0.13u W=0.42u AS=0.204p
+ AD=0.0798p PS=1.835u PD=0.8u rfmode=0
M$43298 \$1118 \$1147 VDD|in|pad|pin1|pin2|supply|vdd
+ VDD|in|pad|pin1|pin2|supply|vdd sg13_lv_pmos L=0.13u W=0.42u AS=0.0798p
+ AD=0.4659p PS=0.8u PD=3.65u rfmode=0
M$43299 \$1115 \$1116 \$1147 VDD|in|pad|pin1|pin2|supply|vdd sg13_lv_pmos
+ L=0.13u W=1u AS=0.34p AD=0.2048p PS=2.68u PD=1.63u rfmode=0
M$43300 \$1119 \$1147 VDD|in|pad|pin1|pin2|supply|vdd
+ VDD|in|pad|pin1|pin2|supply|vdd sg13_lv_pmos L=0.13u W=1.12u AS=0.3864p
+ AD=0.2128p PS=2.93u PD=1.5u rfmode=0
M$43301 VDD|in|pad|pin1|pin2|supply|vdd \$1119 \$1138
+ VDD|in|pad|pin1|pin2|supply|vdd sg13_lv_pmos L=0.13u W=1.12u AS=0.2128p
+ AD=0.3808p PS=1.5u PD=2.92u rfmode=0
M$43328 \$1121 \$1307 VDD|in|pad|pin1|pin2|supply|vdd
+ VDD|in|pad|pin1|pin2|supply|vdd sg13_lv_pmos L=0.13u W=1.12u AS=0.3808p
+ AD=0.3808p PS=2.92u PD=2.92u rfmode=0
M$43392 VDD|in|pad|pin1|pin2|supply|vdd \$1120 \$1122
+ VDD|in|pad|pin1|pin2|supply|vdd sg13_lv_pmos L=0.13u W=1.12u AS=0.3808p
+ AD=0.3808p PS=2.92u PD=2.92u rfmode=0
M$43393 VDD|in|pad|pin1|pin2|supply|vdd \$725 \$1148
+ VDD|in|pad|pin1|pin2|supply|vdd sg13_lv_pmos L=0.13u W=0.84u AS=0.2114p
+ AD=0.2856p PS=1.54u PD=2.36u rfmode=0
M$43394 VDD|in|pad|pin1|pin2|supply|vdd \$1148 \$1120
+ VDD|in|pad|pin1|pin2|supply|vdd sg13_lv_pmos L=0.13u W=1.12u AS=0.2114p
+ AD=0.42p PS=1.54u PD=2.99u rfmode=0
M$43404 VDD|in|pad|pin1|pin2|supply|vdd \$1120 \$1123
+ VDD|in|pad|pin1|pin2|supply|vdd sg13_lv_pmos L=0.13u W=1.12u AS=0.3808p
+ AD=0.3808p PS=2.92u PD=2.92u rfmode=0
M$43411 VDD|in|pad|pin1|pin2|supply|vdd \$1125 \$1149
+ VDD|in|pad|pin1|pin2|supply|vdd sg13_lv_pmos L=0.5u W=1u AS=0.2254p AD=0.34p
+ PS=1.53u PD=2.68u rfmode=0
M$43412 \$1124 \$1149 VDD|in|pad|pin1|pin2|supply|vdd
+ VDD|in|pad|pin1|pin2|supply|vdd sg13_lv_pmos L=0.13u W=1.12u AS=0.4256p
+ AD=0.2254p PS=3u PD=1.53u rfmode=0
M$43413 VDD|in|pad|pin1|pin2|supply|vdd \$1150 \$1126
+ VDD|in|pad|pin1|pin2|supply|vdd sg13_lv_pmos L=0.13u W=0.42u AS=0.1523p
+ AD=0.1428p PS=1.38u PD=1.52u rfmode=0
M$43414 \$1125 \$1126 VDD|in|pad|pin1|pin2|supply|vdd
+ VDD|in|pad|pin1|pin2|supply|vdd sg13_lv_pmos L=0.5u W=1u AS=0.34p AD=0.1523p
+ PS=2.68u PD=1.38u rfmode=0
M$43467 \$1143 \$1151 VDD|in|pad|pin1|pin2|supply|vdd
+ VDD|in|pad|pin1|pin2|supply|vdd sg13_lv_pmos L=0.13u W=1.12u AS=0.42p
+ AD=0.2114p PS=2.99u PD=1.54u rfmode=0
M$43468 VDD|in|pad|pin1|pin2|supply|vdd core|data_in|p2c|ui_p2c[2] \$1151
+ VDD|in|pad|pin1|pin2|supply|vdd sg13_lv_pmos L=0.13u W=0.84u AS=0.2114p
+ AD=0.2856p PS=1.54u PD=2.36u rfmode=0
M$43551 VDD|in|pad|pin1|pin2|supply|vdd \$1093 \$1235
+ VDD|in|pad|pin1|pin2|supply|vdd sg13_lv_pmos L=0.13u W=0.42u AS=0.1428p
+ AD=0.0798p PS=1.52u PD=0.8u rfmode=0
M$43552 VDD|in|pad|pin1|pin2|supply|vdd \$1092 \$1235
+ VDD|in|pad|pin1|pin2|supply|vdd sg13_lv_pmos L=0.13u W=0.42u AS=0.3623875p
+ AD=0.0798p PS=2.605u PD=0.8u rfmode=0
M$43553 VDD|in|pad|pin1|pin2|supply|vdd \$1237 \$1236
+ VDD|in|pad|pin1|pin2|supply|vdd sg13_lv_pmos L=0.13u W=1u AS=0.3623875p
+ AD=0.34p PS=2.605u PD=2.68u rfmode=0
M$43554 VDD|in|pad|pin1|pin2|supply|vdd \$1239 \$1238
+ VDD|in|pad|pin1|pin2|supply|vdd sg13_lv_pmos L=0.13u W=1.12u AS=0.41165p
+ AD=0.3864p PS=2.12u PD=2.93u rfmode=0
M$43555 VDD|in|pad|pin1|pin2|supply|vdd \$1201 \$1239
+ VDD|in|pad|pin1|pin2|supply|vdd sg13_lv_pmos L=0.13u W=1.12u AS=0.41165p
+ AD=0.4088p PS=2.12u PD=2.97u rfmode=0
M$43556 \$1236 \$1239 \$1291 VDD|in|pad|pin1|pin2|supply|vdd sg13_lv_pmos
+ L=0.13u W=1u AS=0.34p AD=0.2048p PS=2.68u PD=1.63u rfmode=0
M$43557 \$1291 \$1238 \$1316 VDD|in|pad|pin1|pin2|supply|vdd sg13_lv_pmos
+ L=0.13u W=0.42u AS=0.2048p AD=0.09345p PS=1.63u PD=0.865u rfmode=0
M$43558 VDD|in|pad|pin1|pin2|supply|vdd \$1240 \$1316
+ VDD|in|pad|pin1|pin2|supply|vdd sg13_lv_pmos L=0.13u W=0.42u AS=0.204p
+ AD=0.09345p PS=1.835u PD=0.865u rfmode=0
M$43559 VDD|in|pad|pin1|pin2|supply|vdd \$1092 \$1240
+ VDD|in|pad|pin1|pin2|supply|vdd sg13_lv_pmos L=0.13u W=0.42u AS=0.204p
+ AD=0.0798p PS=1.835u PD=0.8u rfmode=0
M$43560 VDD|in|pad|pin1|pin2|supply|vdd \$1291 \$1240
+ VDD|in|pad|pin1|pin2|supply|vdd sg13_lv_pmos L=0.13u W=0.42u AS=0.4659p
+ AD=0.0798p PS=3.65u PD=0.8u rfmode=0
M$43561 \$1189 \$1291 VDD|in|pad|pin1|pin2|supply|vdd
+ VDD|in|pad|pin1|pin2|supply|vdd sg13_lv_pmos L=0.13u W=1.12u AS=0.3864p
+ AD=0.2128p PS=2.93u PD=1.5u rfmode=0
M$43562 VDD|in|pad|pin1|pin2|supply|vdd \$1189 \$1188
+ VDD|in|pad|pin1|pin2|supply|vdd sg13_lv_pmos L=0.13u W=1.12u AS=0.2128p
+ AD=0.3808p PS=1.5u PD=2.92u rfmode=0
M$43563 \$1128 \$1190 VDD|in|pad|pin1|pin2|supply|vdd
+ VDD|in|pad|pin1|pin2|supply|vdd sg13_lv_pmos L=0.13u W=1.12u AS=0.4256p
+ AD=0.2254p PS=3u PD=1.53u rfmode=0
M$43564 VDD|in|pad|pin1|pin2|supply|vdd \$1191 \$1190
+ VDD|in|pad|pin1|pin2|supply|vdd sg13_lv_pmos L=0.5u W=1u AS=0.2254p AD=0.34p
+ PS=1.53u PD=2.68u rfmode=0
M$43565 VDD|in|pad|pin1|pin2|supply|vdd \$1188 \$1241
+ VDD|in|pad|pin1|pin2|supply|vdd sg13_lv_pmos L=0.13u W=0.42u AS=0.1523p
+ AD=0.1428p PS=1.38u PD=1.52u rfmode=0
M$43566 \$1191 \$1241 VDD|in|pad|pin1|pin2|supply|vdd
+ VDD|in|pad|pin1|pin2|supply|vdd sg13_lv_pmos L=0.5u W=1u AS=0.34p AD=0.1523p
+ PS=2.68u PD=1.38u rfmode=0
M$43567 \$1167 \$1058 VDD|in|pad|pin1|pin2|supply|vdd
+ VDD|in|pad|pin1|pin2|supply|vdd sg13_lv_pmos L=0.13u W=0.42u AS=0.147p
+ AD=0.1563p PS=1.54u PD=1.22u rfmode=0
M$43568 VDD|in|pad|pin1|pin2|supply|vdd \$1097 \$1180
+ VDD|in|pad|pin1|pin2|supply|vdd sg13_lv_pmos L=0.13u W=0.42u AS=0.1563p
+ AD=0.063p PS=1.22u PD=0.72u rfmode=0
M$43569 \$1180 \$1098 \$1167 VDD|in|pad|pin1|pin2|supply|vdd sg13_lv_pmos
+ L=0.13u W=0.42u AS=0.063p AD=0.0798p PS=0.72u PD=0.8u rfmode=0
M$43570 \$1167 \$1134 \$1133 VDD|in|pad|pin1|pin2|supply|vdd sg13_lv_pmos
+ L=0.13u W=0.42u AS=0.0798p AD=0.1428p PS=0.8u PD=1.52u rfmode=0
M$43571 \$1131 \$1192 VDD|in|pad|pin1|pin2|supply|vdd
+ VDD|in|pad|pin1|pin2|supply|vdd sg13_lv_pmos L=0.13u W=1.12u AS=0.4256p
+ AD=0.2254p PS=3u PD=1.53u rfmode=0
M$43572 VDD|in|pad|pin1|pin2|supply|vdd \$1193 \$1192
+ VDD|in|pad|pin1|pin2|supply|vdd sg13_lv_pmos L=0.5u W=1u AS=0.2254p AD=0.34p
+ PS=1.53u PD=2.68u rfmode=0
M$43573 VDD|in|pad|pin1|pin2|supply|vdd \$1102 \$1242
+ VDD|in|pad|pin1|pin2|supply|vdd sg13_lv_pmos L=0.13u W=0.42u AS=0.1523p
+ AD=0.1428p PS=1.38u PD=1.52u rfmode=0
M$43574 \$1193 \$1242 VDD|in|pad|pin1|pin2|supply|vdd
+ VDD|in|pad|pin1|pin2|supply|vdd sg13_lv_pmos L=0.5u W=1u AS=0.34p AD=0.1523p
+ PS=2.68u PD=1.38u rfmode=0
M$43575 VDD|in|pad|pin1|pin2|supply|vdd \$1194 \$1245
+ VDD|in|pad|pin1|pin2|supply|vdd sg13_lv_pmos L=0.13u W=0.42u AS=0.1428p
+ AD=0.0798p PS=1.52u PD=0.8u rfmode=0
M$43576 VDD|in|pad|pin1|pin2|supply|vdd \$1103 \$1245
+ VDD|in|pad|pin1|pin2|supply|vdd sg13_lv_pmos L=0.13u W=0.42u AS=0.3623875p
+ AD=0.0798p PS=2.605u PD=0.8u rfmode=0
M$43577 VDD|in|pad|pin1|pin2|supply|vdd \$1247 \$1246
+ VDD|in|pad|pin1|pin2|supply|vdd sg13_lv_pmos L=0.13u W=1u AS=0.3623875p
+ AD=0.34p PS=2.605u PD=2.68u rfmode=0
M$43578 VDD|in|pad|pin1|pin2|supply|vdd \$1249 \$1248
+ VDD|in|pad|pin1|pin2|supply|vdd sg13_lv_pmos L=0.13u W=1.12u AS=0.41165p
+ AD=0.3864p PS=2.12u PD=2.93u rfmode=0
M$43579 VDD|in|pad|pin1|pin2|supply|vdd \$1201 \$1249
+ VDD|in|pad|pin1|pin2|supply|vdd sg13_lv_pmos L=0.13u W=1.12u AS=0.41165p
+ AD=0.4088p PS=2.12u PD=2.97u rfmode=0
M$43580 \$1246 \$1249 \$1293 VDD|in|pad|pin1|pin2|supply|vdd sg13_lv_pmos
+ L=0.13u W=1u AS=0.34p AD=0.2048p PS=2.68u PD=1.63u rfmode=0
M$43581 \$1293 \$1248 \$1319 VDD|in|pad|pin1|pin2|supply|vdd sg13_lv_pmos
+ L=0.13u W=0.42u AS=0.2048p AD=0.09345p PS=1.63u PD=0.865u rfmode=0
M$43582 VDD|in|pad|pin1|pin2|supply|vdd \$1250 \$1319
+ VDD|in|pad|pin1|pin2|supply|vdd sg13_lv_pmos L=0.13u W=0.42u AS=0.204p
+ AD=0.09345p PS=1.835u PD=0.865u rfmode=0
M$43583 VDD|in|pad|pin1|pin2|supply|vdd \$1103 \$1250
+ VDD|in|pad|pin1|pin2|supply|vdd sg13_lv_pmos L=0.13u W=0.42u AS=0.204p
+ AD=0.0798p PS=1.835u PD=0.8u rfmode=0
M$43584 VDD|in|pad|pin1|pin2|supply|vdd \$1293 \$1250
+ VDD|in|pad|pin1|pin2|supply|vdd sg13_lv_pmos L=0.13u W=0.42u AS=0.4659p
+ AD=0.0798p PS=3.65u PD=0.8u rfmode=0
M$43585 \$1195 \$1293 VDD|in|pad|pin1|pin2|supply|vdd
+ VDD|in|pad|pin1|pin2|supply|vdd sg13_lv_pmos L=0.13u W=1.12u AS=0.3864p
+ AD=0.2128p PS=2.93u PD=1.5u rfmode=0
M$43586 VDD|in|pad|pin1|pin2|supply|vdd \$1195 \$1196
+ VDD|in|pad|pin1|pin2|supply|vdd sg13_lv_pmos L=0.13u W=1.12u AS=0.2128p
+ AD=0.3808p PS=1.5u PD=2.92u rfmode=0
M$43587 VDD|in|pad|pin1|pin2|supply|vdd \$1077 \$1197
+ VDD|in|pad|pin1|pin2|supply|vdd sg13_lv_pmos L=0.13u W=1.12u AS=0.3808p
+ AD=0.3808p PS=2.92u PD=2.92u rfmode=0
M$43588 VDD|in|pad|pin1|pin2|supply|vdd \$1077 \$1198
+ VDD|in|pad|pin1|pin2|supply|vdd sg13_lv_pmos L=0.13u W=1.12u AS=0.3808p
+ AD=0.3808p PS=2.92u PD=2.92u rfmode=0
M$43589 VDD|in|pad|pin1|pin2|supply|vdd \$1105 \$1251
+ VDD|in|pad|pin1|pin2|supply|vdd sg13_lv_pmos L=0.13u W=0.42u AS=0.1428p
+ AD=0.0798p PS=1.52u PD=0.8u rfmode=0
M$43590 VDD|in|pad|pin1|pin2|supply|vdd \$1198 \$1251
+ VDD|in|pad|pin1|pin2|supply|vdd sg13_lv_pmos L=0.13u W=0.42u AS=0.3623875p
+ AD=0.0798p PS=2.605u PD=0.8u rfmode=0
M$43591 VDD|in|pad|pin1|pin2|supply|vdd \$1253 \$1252
+ VDD|in|pad|pin1|pin2|supply|vdd sg13_lv_pmos L=0.13u W=1u AS=0.3623875p
+ AD=0.34p PS=2.605u PD=2.68u rfmode=0
M$43592 VDD|in|pad|pin1|pin2|supply|vdd \$1255 \$1254
+ VDD|in|pad|pin1|pin2|supply|vdd sg13_lv_pmos L=0.13u W=1.12u AS=0.41165p
+ AD=0.3864p PS=2.12u PD=2.93u rfmode=0
M$43593 VDD|in|pad|pin1|pin2|supply|vdd \$1201 \$1255
+ VDD|in|pad|pin1|pin2|supply|vdd sg13_lv_pmos L=0.13u W=1.12u AS=0.41165p
+ AD=0.4088p PS=2.12u PD=2.97u rfmode=0
M$43594 \$1252 \$1255 \$1295 VDD|in|pad|pin1|pin2|supply|vdd sg13_lv_pmos
+ L=0.13u W=1u AS=0.34p AD=0.2048p PS=2.68u PD=1.63u rfmode=0
M$43595 \$1295 \$1254 \$1321 VDD|in|pad|pin1|pin2|supply|vdd sg13_lv_pmos
+ L=0.13u W=0.42u AS=0.2048p AD=0.09345p PS=1.63u PD=0.865u rfmode=0
M$43596 VDD|in|pad|pin1|pin2|supply|vdd \$1256 \$1321
+ VDD|in|pad|pin1|pin2|supply|vdd sg13_lv_pmos L=0.13u W=0.42u AS=0.204p
+ AD=0.09345p PS=1.835u PD=0.865u rfmode=0
M$43597 VDD|in|pad|pin1|pin2|supply|vdd \$1198 \$1256
+ VDD|in|pad|pin1|pin2|supply|vdd sg13_lv_pmos L=0.13u W=0.42u AS=0.204p
+ AD=0.0798p PS=1.835u PD=0.8u rfmode=0
M$43598 VDD|in|pad|pin1|pin2|supply|vdd \$1295 \$1256
+ VDD|in|pad|pin1|pin2|supply|vdd sg13_lv_pmos L=0.13u W=0.42u AS=0.4659p
+ AD=0.0798p PS=3.65u PD=0.8u rfmode=0
M$43599 \$1199 \$1295 VDD|in|pad|pin1|pin2|supply|vdd
+ VDD|in|pad|pin1|pin2|supply|vdd sg13_lv_pmos L=0.13u W=1.12u AS=0.3864p
+ AD=0.2128p PS=2.93u PD=1.5u rfmode=0
M$43600 VDD|in|pad|pin1|pin2|supply|vdd \$1199 \$1200
+ VDD|in|pad|pin1|pin2|supply|vdd sg13_lv_pmos L=0.13u W=1.12u AS=0.2128p
+ AD=0.3808p PS=1.5u PD=2.92u rfmode=0
M$43601 VDD|in|pad|pin1|pin2|supply|vdd \$1202 \$1201
+ VDD|in|pad|pin1|pin2|supply|vdd sg13_lv_pmos L=0.13u W=17.92u AS=3.5896p
+ AD=3.4048p PS=25.45u PD=24u rfmode=0
M$43617 VDD|in|pad|pin1|pin2|supply|vdd \$1215 \$1202
+ VDD|in|pad|pin1|pin2|supply|vdd sg13_lv_pmos L=0.13u W=6.72u AS=1.2768p
+ AD=1.4448p PS=9u PD=10.42u rfmode=0
M$43624 \$1204 \$1205 VDD|in|pad|pin1|pin2|supply|vdd
+ VDD|in|pad|pin1|pin2|supply|vdd sg13_lv_pmos L=0.13u W=1.12u AS=0.4256p
+ AD=0.2254p PS=3u PD=1.53u rfmode=0
M$43625 VDD|in|pad|pin1|pin2|supply|vdd \$1206 \$1205
+ VDD|in|pad|pin1|pin2|supply|vdd sg13_lv_pmos L=0.5u W=1u AS=0.2254p AD=0.34p
+ PS=1.53u PD=2.68u rfmode=0
M$43626 VDD|in|pad|pin1|pin2|supply|vdd \$1203 \$1261
+ VDD|in|pad|pin1|pin2|supply|vdd sg13_lv_pmos L=0.13u W=0.42u AS=0.1523p
+ AD=0.1428p PS=1.38u PD=1.52u rfmode=0
M$43627 \$1206 \$1261 VDD|in|pad|pin1|pin2|supply|vdd
+ VDD|in|pad|pin1|pin2|supply|vdd sg13_lv_pmos L=0.5u W=1u AS=0.34p AD=0.1523p
+ PS=2.68u PD=1.38u rfmode=0
M$43637 \$1168 \$1060 VDD|in|pad|pin1|pin2|supply|vdd
+ VDD|in|pad|pin1|pin2|supply|vdd sg13_lv_pmos L=0.13u W=0.42u AS=0.147p
+ AD=0.1563p PS=1.54u PD=1.22u rfmode=0
M$43638 VDD|in|pad|pin1|pin2|supply|vdd \$1115 \$1187
+ VDD|in|pad|pin1|pin2|supply|vdd sg13_lv_pmos L=0.13u W=0.42u AS=0.1563p
+ AD=0.063p PS=1.22u PD=0.72u rfmode=0
M$43639 \$1187 \$1116 \$1168 VDD|in|pad|pin1|pin2|supply|vdd sg13_lv_pmos
+ L=0.13u W=0.42u AS=0.063p AD=0.0798p PS=0.72u PD=0.8u rfmode=0
M$43640 \$1168 \$1146 \$1145 VDD|in|pad|pin1|pin2|supply|vdd sg13_lv_pmos
+ L=0.13u W=0.42u AS=0.0798p AD=0.1428p PS=0.8u PD=1.52u rfmode=0
M$43641 VDD|in|pad|pin1|pin2|supply|vdd \$1300 \$1208
+ VDD|in|pad|pin1|pin2|supply|vdd sg13_lv_pmos L=0.13u W=0.84u AS=0.2114p
+ AD=0.2856p PS=1.54u PD=2.36u rfmode=0
M$43642 X4|dout[5] \$1208 VDD|in|pad|pin1|pin2|supply|vdd
+ VDD|in|pad|pin1|pin2|supply|vdd sg13_lv_pmos L=0.13u W=1.12u AS=0.42p
+ AD=0.2114p PS=2.99u PD=1.54u rfmode=0
M$43647 VDD|in|pad|pin1|pin2|supply|vdd \$1078 \$1209
+ VDD|in|pad|pin1|pin2|supply|vdd sg13_lv_pmos L=0.13u W=1.12u AS=0.3808p
+ AD=0.3808p PS=2.92u PD=2.92u rfmode=0
M$43648 \$1210 \$1211 VDD|in|pad|pin1|pin2|supply|vdd
+ VDD|in|pad|pin1|pin2|supply|vdd sg13_lv_pmos L=0.13u W=1.12u AS=0.4256p
+ AD=0.2254p PS=3u PD=1.53u rfmode=0
M$43649 VDD|in|pad|pin1|pin2|supply|vdd \$1212 \$1211
+ VDD|in|pad|pin1|pin2|supply|vdd sg13_lv_pmos L=0.5u W=1u AS=0.2254p AD=0.34p
+ PS=1.53u PD=2.68u rfmode=0
M$43650 VDD|in|pad|pin1|pin2|supply|vdd \$1301 \$1262
+ VDD|in|pad|pin1|pin2|supply|vdd sg13_lv_pmos L=0.13u W=0.42u AS=0.1523p
+ AD=0.1428p PS=1.38u PD=1.52u rfmode=0
M$43651 \$1212 \$1262 VDD|in|pad|pin1|pin2|supply|vdd
+ VDD|in|pad|pin1|pin2|supply|vdd sg13_lv_pmos L=0.5u W=1u AS=0.34p AD=0.1523p
+ PS=2.68u PD=1.38u rfmode=0
M$43669 VDD|in|pad|pin1|pin2|supply|vdd \$1302 \$1213
+ VDD|in|pad|pin1|pin2|supply|vdd sg13_lv_pmos L=0.13u W=0.84u AS=0.2114p
+ AD=0.2856p PS=1.54u PD=2.36u rfmode=0
M$43670 X5|dout[6] \$1213 VDD|in|pad|pin1|pin2|supply|vdd
+ VDD|in|pad|pin1|pin2|supply|vdd sg13_lv_pmos L=0.13u W=1.12u AS=0.42p
+ AD=0.2114p PS=2.99u PD=1.54u rfmode=0
M$43674 VDD|in|pad|pin1|pin2|supply|vdd CLK|clk|core|fclk_in|p2c|ui_p2c[6]
+ \$1214 VDD|in|pad|pin1|pin2|supply|vdd sg13_lv_pmos L=0.13u W=6.72u
+ AS=1.4448p AD=1.2768p PS=10.42u PD=9u rfmode=0
M$43680 VDD|in|pad|pin1|pin2|supply|vdd \$1214 \$1215
+ VDD|in|pad|pin1|pin2|supply|vdd sg13_lv_pmos L=0.13u W=17.92u AS=3.4048p
+ AD=3.5896p PS=24u PD=25.45u rfmode=0
M$43705 \$1216 \$1303 VDD|in|pad|pin1|pin2|supply|vdd
+ VDD|in|pad|pin1|pin2|supply|vdd sg13_lv_pmos L=0.13u W=1.12u AS=0.6048p
+ AD=0.2198p PS=3.32u PD=1.52u rfmode=0
M$43706 VDD|in|pad|pin1|pin2|supply|vdd \$1217 \$1332
+ VDD|in|pad|pin1|pin2|supply|vdd sg13_lv_pmos L=0.13u W=1u AS=0.2198p
+ AD=0.2975p PS=1.52u PD=1.595u rfmode=0
M$43707 \$1332 \$1304 \$1303 VDD|in|pad|pin1|pin2|supply|vdd sg13_lv_pmos
+ L=0.13u W=1u AS=0.2975p AD=0.2225p PS=1.595u PD=1.445u rfmode=0
M$43708 \$1303 \$1305 \$1331 VDD|in|pad|pin1|pin2|supply|vdd sg13_lv_pmos
+ L=0.13u W=1u AS=0.2225p AD=0.3325p PS=1.445u PD=1.665u rfmode=0
M$43709 \$1331 \$1233 VDD|in|pad|pin1|pin2|supply|vdd
+ VDD|in|pad|pin1|pin2|supply|vdd sg13_lv_pmos L=0.13u W=1u AS=0.3325p
+ AD=0.253p PS=1.665u PD=1.53u rfmode=0
M$43710 VDD|in|pad|pin1|pin2|supply|vdd \$1233 \$1217
+ VDD|in|pad|pin1|pin2|supply|vdd sg13_lv_pmos L=0.13u W=0.84u AS=0.253p
+ AD=0.2856p PS=1.53u PD=2.36u rfmode=0
M$43713 \$1305 \$1218 VDD|in|pad|pin1|pin2|supply|vdd
+ VDD|in|pad|pin1|pin2|supply|vdd sg13_lv_pmos L=0.13u W=1.12u AS=0.4256p
+ AD=0.2254p PS=3u PD=1.53u rfmode=0
M$43714 VDD|in|pad|pin1|pin2|supply|vdd \$1219 \$1218
+ VDD|in|pad|pin1|pin2|supply|vdd sg13_lv_pmos L=0.5u W=1u AS=0.2254p AD=0.34p
+ PS=1.53u PD=2.68u rfmode=0
M$43715 VDD|in|pad|pin1|pin2|supply|vdd \$1306 \$1264
+ VDD|in|pad|pin1|pin2|supply|vdd sg13_lv_pmos L=0.13u W=0.42u AS=0.1523p
+ AD=0.1428p PS=1.38u PD=1.52u rfmode=0
M$43716 \$1219 \$1264 VDD|in|pad|pin1|pin2|supply|vdd
+ VDD|in|pad|pin1|pin2|supply|vdd sg13_lv_pmos L=0.5u W=1u AS=0.34p AD=0.1523p
+ PS=2.68u PD=1.38u rfmode=0
M$43729 VDD|in|pad|pin1|pin2|supply|vdd \$1307 \$1220
+ VDD|in|pad|pin1|pin2|supply|vdd sg13_lv_pmos L=0.13u W=1.12u AS=0.3808p
+ AD=0.3808p PS=2.92u PD=2.92u rfmode=0
M$43747 VDD|in|pad|pin1|pin2|supply|vdd \$1307 \$1221
+ VDD|in|pad|pin1|pin2|supply|vdd sg13_lv_pmos L=0.13u W=1.12u AS=0.3808p
+ AD=0.3808p PS=2.92u PD=2.92u rfmode=0
M$43748 \$1222 \$1223 VDD|in|pad|pin1|pin2|supply|vdd
+ VDD|in|pad|pin1|pin2|supply|vdd sg13_lv_pmos L=0.13u W=1.12u AS=0.4256p
+ AD=0.2254p PS=3u PD=1.53u rfmode=0
M$43749 VDD|in|pad|pin1|pin2|supply|vdd \$1224 \$1223
+ VDD|in|pad|pin1|pin2|supply|vdd sg13_lv_pmos L=0.5u W=1u AS=0.2254p AD=0.34p
+ PS=1.53u PD=2.68u rfmode=0
M$43750 VDD|in|pad|pin1|pin2|supply|vdd \$1512 \$1265
+ VDD|in|pad|pin1|pin2|supply|vdd sg13_lv_pmos L=0.13u W=0.42u AS=0.1523p
+ AD=0.1428p PS=1.38u PD=1.52u rfmode=0
M$43751 \$1224 \$1265 VDD|in|pad|pin1|pin2|supply|vdd
+ VDD|in|pad|pin1|pin2|supply|vdd sg13_lv_pmos L=0.5u W=1u AS=0.34p AD=0.1523p
+ PS=2.68u PD=1.38u rfmode=0
M$43757 VDD|in|pad|pin1|pin2|supply|vdd \$1225 \$1268
+ VDD|in|pad|pin1|pin2|supply|vdd sg13_lv_pmos L=0.13u W=0.42u AS=0.1428p
+ AD=0.0798p PS=1.52u PD=0.8u rfmode=0
M$43758 VDD|in|pad|pin1|pin2|supply|vdd \$1122 \$1268
+ VDD|in|pad|pin1|pin2|supply|vdd sg13_lv_pmos L=0.13u W=0.42u AS=0.3623875p
+ AD=0.0798p PS=2.605u PD=0.8u rfmode=0
M$43759 VDD|in|pad|pin1|pin2|supply|vdd \$1270 \$1269
+ VDD|in|pad|pin1|pin2|supply|vdd sg13_lv_pmos L=0.13u W=1u AS=0.3623875p
+ AD=0.34p PS=2.605u PD=2.68u rfmode=0
M$43760 VDD|in|pad|pin1|pin2|supply|vdd \$1272 \$1271
+ VDD|in|pad|pin1|pin2|supply|vdd sg13_lv_pmos L=0.13u W=1.12u AS=0.41165p
+ AD=0.3864p PS=2.12u PD=2.93u rfmode=0
M$43761 VDD|in|pad|pin1|pin2|supply|vdd \$1311 \$1272
+ VDD|in|pad|pin1|pin2|supply|vdd sg13_lv_pmos L=0.13u W=1.12u AS=0.41165p
+ AD=0.4088p PS=2.12u PD=2.97u rfmode=0
M$43762 \$1269 \$1272 \$1312 VDD|in|pad|pin1|pin2|supply|vdd sg13_lv_pmos
+ L=0.13u W=1u AS=0.34p AD=0.2048p PS=2.68u PD=1.63u rfmode=0
M$43763 \$1312 \$1271 \$1328 VDD|in|pad|pin1|pin2|supply|vdd sg13_lv_pmos
+ L=0.13u W=0.42u AS=0.2048p AD=0.09345p PS=1.63u PD=0.865u rfmode=0
M$43764 VDD|in|pad|pin1|pin2|supply|vdd \$1273 \$1328
+ VDD|in|pad|pin1|pin2|supply|vdd sg13_lv_pmos L=0.13u W=0.42u AS=0.204p
+ AD=0.09345p PS=1.835u PD=0.865u rfmode=0
M$43765 VDD|in|pad|pin1|pin2|supply|vdd \$1122 \$1273
+ VDD|in|pad|pin1|pin2|supply|vdd sg13_lv_pmos L=0.13u W=0.42u AS=0.204p
+ AD=0.0798p PS=1.835u PD=0.8u rfmode=0
M$43766 VDD|in|pad|pin1|pin2|supply|vdd \$1312 \$1273
+ VDD|in|pad|pin1|pin2|supply|vdd sg13_lv_pmos L=0.13u W=0.42u AS=0.4659p
+ AD=0.0798p PS=3.65u PD=0.8u rfmode=0
M$43767 \$1226 \$1312 VDD|in|pad|pin1|pin2|supply|vdd
+ VDD|in|pad|pin1|pin2|supply|vdd sg13_lv_pmos L=0.13u W=1.12u AS=0.3864p
+ AD=0.2128p PS=2.93u PD=1.5u rfmode=0
M$43768 VDD|in|pad|pin1|pin2|supply|vdd \$1226 \$1227
+ VDD|in|pad|pin1|pin2|supply|vdd sg13_lv_pmos L=0.13u W=1.12u AS=0.2128p
+ AD=0.3808p PS=1.5u PD=2.92u rfmode=0
M$43769 VDD|in|pad|pin1|pin2|supply|vdd \$1228 \$1276
+ VDD|in|pad|pin1|pin2|supply|vdd sg13_lv_pmos L=0.13u W=0.42u AS=0.1428p
+ AD=0.0798p PS=1.52u PD=0.8u rfmode=0
M$43770 VDD|in|pad|pin1|pin2|supply|vdd \$1123 \$1276
+ VDD|in|pad|pin1|pin2|supply|vdd sg13_lv_pmos L=0.13u W=0.42u AS=0.3623875p
+ AD=0.0798p PS=2.605u PD=0.8u rfmode=0
M$43771 VDD|in|pad|pin1|pin2|supply|vdd \$1278 \$1277
+ VDD|in|pad|pin1|pin2|supply|vdd sg13_lv_pmos L=0.13u W=1u AS=0.3623875p
+ AD=0.34p PS=2.605u PD=2.68u rfmode=0
M$43772 VDD|in|pad|pin1|pin2|supply|vdd \$1280 \$1279
+ VDD|in|pad|pin1|pin2|supply|vdd sg13_lv_pmos L=0.13u W=1.12u AS=0.41165p
+ AD=0.3864p PS=2.12u PD=2.93u rfmode=0
M$43773 VDD|in|pad|pin1|pin2|supply|vdd \$1311 \$1280
+ VDD|in|pad|pin1|pin2|supply|vdd sg13_lv_pmos L=0.13u W=1.12u AS=0.41165p
+ AD=0.4088p PS=2.12u PD=2.97u rfmode=0
M$43774 \$1277 \$1280 \$1315 VDD|in|pad|pin1|pin2|supply|vdd sg13_lv_pmos
+ L=0.13u W=1u AS=0.34p AD=0.2048p PS=2.68u PD=1.63u rfmode=0
M$43775 \$1315 \$1279 \$1323 VDD|in|pad|pin1|pin2|supply|vdd sg13_lv_pmos
+ L=0.13u W=0.42u AS=0.2048p AD=0.09345p PS=1.63u PD=0.865u rfmode=0
M$43776 VDD|in|pad|pin1|pin2|supply|vdd \$1281 \$1323
+ VDD|in|pad|pin1|pin2|supply|vdd sg13_lv_pmos L=0.13u W=0.42u AS=0.204p
+ AD=0.09345p PS=1.835u PD=0.865u rfmode=0
M$43777 VDD|in|pad|pin1|pin2|supply|vdd \$1123 \$1281
+ VDD|in|pad|pin1|pin2|supply|vdd sg13_lv_pmos L=0.13u W=0.42u AS=0.204p
+ AD=0.0798p PS=1.835u PD=0.8u rfmode=0
M$43778 VDD|in|pad|pin1|pin2|supply|vdd \$1315 \$1281
+ VDD|in|pad|pin1|pin2|supply|vdd sg13_lv_pmos L=0.13u W=0.42u AS=0.4659p
+ AD=0.0798p PS=3.65u PD=0.8u rfmode=0
M$43779 \$1229 \$1315 VDD|in|pad|pin1|pin2|supply|vdd
+ VDD|in|pad|pin1|pin2|supply|vdd sg13_lv_pmos L=0.13u W=1.12u AS=0.3864p
+ AD=0.2128p PS=2.93u PD=1.5u rfmode=0
M$43780 VDD|in|pad|pin1|pin2|supply|vdd \$1229 \$1230
+ VDD|in|pad|pin1|pin2|supply|vdd sg13_lv_pmos L=0.13u W=1.12u AS=0.2128p
+ AD=0.3808p PS=1.5u PD=2.92u rfmode=0
M$43781 \$1313 \$1231 VDD|in|pad|pin1|pin2|supply|vdd
+ VDD|in|pad|pin1|pin2|supply|vdd sg13_lv_pmos L=0.13u W=1.12u AS=0.4256p
+ AD=0.2254p PS=3u PD=1.53u rfmode=0
M$43782 VDD|in|pad|pin1|pin2|supply|vdd \$1232 \$1231
+ VDD|in|pad|pin1|pin2|supply|vdd sg13_lv_pmos L=0.5u W=1u AS=0.2254p AD=0.34p
+ PS=1.53u PD=2.68u rfmode=0
M$43783 VDD|in|pad|pin1|pin2|supply|vdd \$1230 \$1282
+ VDD|in|pad|pin1|pin2|supply|vdd sg13_lv_pmos L=0.13u W=0.42u AS=0.1523p
+ AD=0.1428p PS=1.38u PD=1.52u rfmode=0
M$43784 \$1232 \$1282 VDD|in|pad|pin1|pin2|supply|vdd
+ VDD|in|pad|pin1|pin2|supply|vdd sg13_lv_pmos L=0.5u W=1u AS=0.34p AD=0.1523p
+ PS=2.68u PD=1.38u rfmode=0
M$43785 VDD|in|pad|pin1|pin2|supply|vdd \$766 \$1234
+ VDD|in|pad|pin1|pin2|supply|vdd sg13_lv_pmos L=0.13u W=0.84u AS=0.2114p
+ AD=0.2856p PS=1.54u PD=2.36u rfmode=0
M$43786 \$1233 \$1234 VDD|in|pad|pin1|pin2|supply|vdd
+ VDD|in|pad|pin1|pin2|supply|vdd sg13_lv_pmos L=0.13u W=1.12u AS=0.42p
+ AD=0.2114p PS=2.99u PD=1.54u rfmode=0
M$43839 \$1289 analog_io_padres[18]|core|padres VDD|in|pad|pin1|pin2|supply|vdd
+ \$1288 sg13_lv_pmos L=0.3u W=18u AS=4.095p AD=4.095p PS=24.32u PD=24.32u
+ rfmode=0
M$43927 VDD|in|pad|pin1|pin2|supply|vdd \$1092 \$1237
+ VDD|in|pad|pin1|pin2|supply|vdd sg13_lv_pmos L=0.13u W=0.42u AS=0.1563p
+ AD=0.147p PS=1.22u PD=1.54u rfmode=0
M$43928 VDD|in|pad|pin1|pin2|supply|vdd \$1236 \$1283
+ VDD|in|pad|pin1|pin2|supply|vdd sg13_lv_pmos L=0.13u W=0.42u AS=0.1563p
+ AD=0.063p PS=1.22u PD=0.72u rfmode=0
M$43929 \$1283 \$1239 \$1237 VDD|in|pad|pin1|pin2|supply|vdd sg13_lv_pmos
+ L=0.13u W=0.42u AS=0.063p AD=0.0798p PS=0.72u PD=0.8u rfmode=0
M$43930 \$1237 \$1238 \$1235 VDD|in|pad|pin1|pin2|supply|vdd sg13_lv_pmos
+ L=0.13u W=0.42u AS=0.0798p AD=0.1428p PS=0.8u PD=1.52u rfmode=0
M$43931 \$1446 \$1077 VDD|in|pad|pin1|pin2|supply|vdd
+ VDD|in|pad|pin1|pin2|supply|vdd sg13_lv_pmos L=0.13u W=1.12u AS=0.3808p
+ AD=0.3808p PS=2.92u PD=2.92u rfmode=0
M$43932 VDD|in|pad|pin1|pin2|supply|vdd \$1586 \$1448
+ VDD|in|pad|pin1|pin2|supply|vdd sg13_lv_pmos L=0.5u W=1u AS=0.2254p AD=0.34p
+ PS=1.53u PD=2.68u rfmode=0
M$43933 \$1447 \$1448 VDD|in|pad|pin1|pin2|supply|vdd
+ VDD|in|pad|pin1|pin2|supply|vdd sg13_lv_pmos L=0.13u W=1.12u AS=0.4256p
+ AD=0.2254p PS=3u PD=1.53u rfmode=0
M$43934 VDD|in|pad|pin1|pin2|supply|vdd \$1450 \$1449
+ VDD|in|pad|pin1|pin2|supply|vdd sg13_lv_pmos L=0.13u W=0.42u AS=0.1523p
+ AD=0.1428p PS=1.38u PD=1.52u rfmode=0
M$43935 \$1586 \$1449 VDD|in|pad|pin1|pin2|supply|vdd
+ VDD|in|pad|pin1|pin2|supply|vdd sg13_lv_pmos L=0.5u W=1u AS=0.34p AD=0.1523p
+ PS=2.68u PD=1.38u rfmode=0
M$43936 VDD|in|pad|pin1|pin2|supply|vdd \$1079 \$1451
+ VDD|in|pad|pin1|pin2|supply|vdd sg13_lv_pmos L=0.13u W=0.84u AS=0.253p
+ AD=0.2856p PS=1.53u PD=2.36u rfmode=0
M$43937 VDD|in|pad|pin1|pin2|supply|vdd \$1451 \$1643
+ VDD|in|pad|pin1|pin2|supply|vdd sg13_lv_pmos L=0.13u W=1u AS=0.2198p
+ AD=0.2975p PS=1.52u PD=1.595u rfmode=0
M$43938 \$1643 \$1131 \$1380 VDD|in|pad|pin1|pin2|supply|vdd sg13_lv_pmos
+ L=0.13u W=1u AS=0.2975p AD=0.2225p PS=1.595u PD=1.445u rfmode=0
M$43939 \$1380 \$1764 \$1642 VDD|in|pad|pin1|pin2|supply|vdd sg13_lv_pmos
+ L=0.13u W=1u AS=0.2225p AD=0.3325p PS=1.445u PD=1.665u rfmode=0
M$43940 \$1642 \$1079 VDD|in|pad|pin1|pin2|supply|vdd
+ VDD|in|pad|pin1|pin2|supply|vdd sg13_lv_pmos L=0.13u W=1u AS=0.3325p
+ AD=0.253p PS=1.665u PD=1.53u rfmode=0
M$43941 \$1450 \$1380 VDD|in|pad|pin1|pin2|supply|vdd
+ VDD|in|pad|pin1|pin2|supply|vdd sg13_lv_pmos L=0.13u W=1.12u AS=0.6048p
+ AD=0.2198p PS=3.32u PD=1.52u rfmode=0
M$43944 VDD|in|pad|pin1|pin2|supply|vdd \$1079 \$1587
+ VDD|in|pad|pin1|pin2|supply|vdd sg13_lv_pmos L=0.13u W=0.84u AS=0.253p
+ AD=0.2856p PS=1.53u PD=2.36u rfmode=0
M$43945 VDD|in|pad|pin1|pin2|supply|vdd \$1587 \$1645
+ VDD|in|pad|pin1|pin2|supply|vdd sg13_lv_pmos L=0.13u W=1u AS=0.2198p
+ AD=0.2975p PS=1.52u PD=1.595u rfmode=0
M$43946 \$1645 \$1453 \$1381 VDD|in|pad|pin1|pin2|supply|vdd sg13_lv_pmos
+ L=0.13u W=1u AS=0.2975p AD=0.2225p PS=1.595u PD=1.445u rfmode=0
M$43947 \$1381 \$1765 \$1649 VDD|in|pad|pin1|pin2|supply|vdd sg13_lv_pmos
+ L=0.13u W=1u AS=0.2225p AD=0.3325p PS=1.445u PD=1.665u rfmode=0
M$43948 \$1649 \$1079 VDD|in|pad|pin1|pin2|supply|vdd
+ VDD|in|pad|pin1|pin2|supply|vdd sg13_lv_pmos L=0.13u W=1u AS=0.3325p
+ AD=0.253p PS=1.665u PD=1.53u rfmode=0
M$43949 \$1452 \$1381 VDD|in|pad|pin1|pin2|supply|vdd
+ VDD|in|pad|pin1|pin2|supply|vdd sg13_lv_pmos L=0.13u W=1.12u AS=0.6048p
+ AD=0.2198p PS=3.32u PD=1.52u rfmode=0
M$43950 VDD|in|pad|pin1|pin2|supply|vdd \$1166 \$1243
+ VDD|in|pad|pin1|pin2|supply|vdd sg13_lv_pmos L=0.13u W=0.84u AS=0.253p
+ AD=0.2856p PS=1.53u PD=2.36u rfmode=0
M$43951 VDD|in|pad|pin1|pin2|supply|vdd \$1166 \$1317
+ VDD|in|pad|pin1|pin2|supply|vdd sg13_lv_pmos L=0.13u W=1u AS=0.253p
+ AD=0.3325p PS=1.53u PD=1.665u rfmode=0
M$43952 \$1317 \$1453 \$1244 VDD|in|pad|pin1|pin2|supply|vdd sg13_lv_pmos
+ L=0.13u W=1u AS=0.3325p AD=0.2225p PS=1.665u PD=1.445u rfmode=0
M$43953 \$1244 \$1131 \$1318 VDD|in|pad|pin1|pin2|supply|vdd sg13_lv_pmos
+ L=0.13u W=1u AS=0.2225p AD=0.2975p PS=1.445u PD=1.595u rfmode=0
M$43954 VDD|in|pad|pin1|pin2|supply|vdd \$1243 \$1318
+ VDD|in|pad|pin1|pin2|supply|vdd sg13_lv_pmos L=0.13u W=1u AS=0.2198p
+ AD=0.2975p PS=1.52u PD=1.595u rfmode=0
M$43955 VDD|in|pad|pin1|pin2|supply|vdd \$1244 \$1194
+ VDD|in|pad|pin1|pin2|supply|vdd sg13_lv_pmos L=0.13u W=1.12u AS=0.2198p
+ AD=0.6048p PS=1.52u PD=3.32u rfmode=0
M$43956 \$1454 \$1077 VDD|in|pad|pin1|pin2|supply|vdd
+ VDD|in|pad|pin1|pin2|supply|vdd sg13_lv_pmos L=0.13u W=1.12u AS=0.3808p
+ AD=0.3808p PS=2.92u PD=2.92u rfmode=0
M$43960 VDD|in|pad|pin1|pin2|supply|vdd \$1103 \$1247
+ VDD|in|pad|pin1|pin2|supply|vdd sg13_lv_pmos L=0.13u W=0.42u AS=0.1563p
+ AD=0.147p PS=1.22u PD=1.54u rfmode=0
M$43961 VDD|in|pad|pin1|pin2|supply|vdd \$1246 \$1284
+ VDD|in|pad|pin1|pin2|supply|vdd sg13_lv_pmos L=0.13u W=0.42u AS=0.1563p
+ AD=0.063p PS=1.22u PD=0.72u rfmode=0
M$43962 \$1284 \$1249 \$1247 VDD|in|pad|pin1|pin2|supply|vdd sg13_lv_pmos
+ L=0.13u W=0.42u AS=0.063p AD=0.0798p PS=0.72u PD=0.8u rfmode=0
M$43963 \$1247 \$1248 \$1245 VDD|in|pad|pin1|pin2|supply|vdd sg13_lv_pmos
+ L=0.13u W=0.42u AS=0.0798p AD=0.1428p PS=0.8u PD=1.52u rfmode=0
M$43964 VDD|in|pad|pin1|pin2|supply|vdd \$1588 \$1455
+ VDD|in|pad|pin1|pin2|supply|vdd sg13_lv_pmos L=0.5u W=1u AS=0.2254p AD=0.34p
+ PS=1.53u PD=2.68u rfmode=0
M$43965 \$1453 \$1455 VDD|in|pad|pin1|pin2|supply|vdd
+ VDD|in|pad|pin1|pin2|supply|vdd sg13_lv_pmos L=0.13u W=1.12u AS=0.4256p
+ AD=0.2254p PS=3u PD=1.53u rfmode=0
M$43966 VDD|in|pad|pin1|pin2|supply|vdd \$1196 \$1456
+ VDD|in|pad|pin1|pin2|supply|vdd sg13_lv_pmos L=0.13u W=0.42u AS=0.1523p
+ AD=0.1428p PS=1.38u PD=1.52u rfmode=0
M$43967 \$1588 \$1456 VDD|in|pad|pin1|pin2|supply|vdd
+ VDD|in|pad|pin1|pin2|supply|vdd sg13_lv_pmos L=0.5u W=1u AS=0.34p AD=0.1523p
+ PS=2.68u PD=1.38u rfmode=0
M$43969 \$1457 \$1079 VDD|in|pad|pin1|pin2|supply|vdd
+ VDD|in|pad|pin1|pin2|supply|vdd sg13_lv_pmos L=0.13u W=0.84u AS=0.2856p
+ AD=0.253p PS=2.36u PD=1.53u rfmode=0
M$43970 VDD|in|pad|pin1|pin2|supply|vdd \$1079 \$1653
+ VDD|in|pad|pin1|pin2|supply|vdd sg13_lv_pmos L=0.13u W=1u AS=0.253p
+ AD=0.3325p PS=1.53u PD=1.665u rfmode=0
M$43971 \$1653 \$1772 \$1382 VDD|in|pad|pin1|pin2|supply|vdd sg13_lv_pmos
+ L=0.13u W=1u AS=0.3325p AD=0.2225p PS=1.665u PD=1.445u rfmode=0
M$43972 \$1382 \$1458 \$1651 VDD|in|pad|pin1|pin2|supply|vdd sg13_lv_pmos
+ L=0.13u W=1u AS=0.2225p AD=0.2975p PS=1.445u PD=1.595u rfmode=0
M$43973 \$1651 \$1457 VDD|in|pad|pin1|pin2|supply|vdd
+ VDD|in|pad|pin1|pin2|supply|vdd sg13_lv_pmos L=0.13u W=1u AS=0.2975p
+ AD=0.2198p PS=1.595u PD=1.52u rfmode=0
M$43974 VDD|in|pad|pin1|pin2|supply|vdd \$1382 \$1459
+ VDD|in|pad|pin1|pin2|supply|vdd sg13_lv_pmos L=0.13u W=1.12u AS=0.2198p
+ AD=0.6048p PS=1.52u PD=3.32u rfmode=0
M$43975 VDD|in|pad|pin1|pin2|supply|vdd \$1459 \$1460
+ VDD|in|pad|pin1|pin2|supply|vdd sg13_lv_pmos L=0.13u W=0.42u AS=0.1523p
+ AD=0.1428p PS=1.38u PD=1.52u rfmode=0
M$43976 VDD|in|pad|pin1|pin2|supply|vdd \$1460 \$1461
+ VDD|in|pad|pin1|pin2|supply|vdd sg13_lv_pmos L=0.5u W=1u AS=0.1523p AD=0.34p
+ PS=1.38u PD=2.68u rfmode=0
M$43977 \$1462 \$1461 VDD|in|pad|pin1|pin2|supply|vdd
+ VDD|in|pad|pin1|pin2|supply|vdd sg13_lv_pmos L=0.5u W=1u AS=0.34p AD=0.2254p
+ PS=2.68u PD=1.53u rfmode=0
M$43978 VDD|in|pad|pin1|pin2|supply|vdd \$1462 \$1463
+ VDD|in|pad|pin1|pin2|supply|vdd sg13_lv_pmos L=0.13u W=1.12u AS=0.2254p
+ AD=0.4256p PS=1.53u PD=3u rfmode=0
M$43980 VDD|in|pad|pin1|pin2|supply|vdd \$1198 \$1253
+ VDD|in|pad|pin1|pin2|supply|vdd sg13_lv_pmos L=0.13u W=0.42u AS=0.1563p
+ AD=0.147p PS=1.22u PD=1.54u rfmode=0
M$43981 VDD|in|pad|pin1|pin2|supply|vdd \$1252 \$1285
+ VDD|in|pad|pin1|pin2|supply|vdd sg13_lv_pmos L=0.13u W=0.42u AS=0.1563p
+ AD=0.063p PS=1.22u PD=0.72u rfmode=0
M$43982 \$1285 \$1255 \$1253 VDD|in|pad|pin1|pin2|supply|vdd sg13_lv_pmos
+ L=0.13u W=0.42u AS=0.063p AD=0.0798p PS=0.72u PD=0.8u rfmode=0
M$43983 \$1253 \$1254 \$1251 VDD|in|pad|pin1|pin2|supply|vdd sg13_lv_pmos
+ L=0.13u W=0.42u AS=0.0798p AD=0.1428p PS=0.8u PD=1.52u rfmode=0
M$43984 VDD|in|pad|pin1|pin2|supply|vdd \$1589 \$1464
+ VDD|in|pad|pin1|pin2|supply|vdd sg13_lv_pmos L=0.5u W=1u AS=0.2254p AD=0.34p
+ PS=1.53u PD=2.68u rfmode=0
M$43985 \$1458 \$1464 VDD|in|pad|pin1|pin2|supply|vdd
+ VDD|in|pad|pin1|pin2|supply|vdd sg13_lv_pmos L=0.13u W=1.12u AS=0.4256p
+ AD=0.2254p PS=3u PD=1.53u rfmode=0
M$43986 VDD|in|pad|pin1|pin2|supply|vdd \$1200 \$1465
+ VDD|in|pad|pin1|pin2|supply|vdd sg13_lv_pmos L=0.13u W=0.42u AS=0.1523p
+ AD=0.1428p PS=1.38u PD=1.52u rfmode=0
M$43987 \$1589 \$1465 VDD|in|pad|pin1|pin2|supply|vdd
+ VDD|in|pad|pin1|pin2|supply|vdd sg13_lv_pmos L=0.5u W=1u AS=0.34p AD=0.1523p
+ PS=2.68u PD=1.38u rfmode=0
M$43991 VDD|in|pad|pin1|pin2|supply|vdd \$1079 \$1257
+ VDD|in|pad|pin1|pin2|supply|vdd sg13_lv_pmos L=0.13u W=0.84u AS=0.253p
+ AD=0.2856p PS=1.53u PD=2.36u rfmode=0
M$43992 VDD|in|pad|pin1|pin2|supply|vdd \$1079 \$1320
+ VDD|in|pad|pin1|pin2|supply|vdd sg13_lv_pmos L=0.13u W=1u AS=0.253p
+ AD=0.3325p PS=1.53u PD=1.665u rfmode=0
M$43993 \$1320 \$1297 \$1258 VDD|in|pad|pin1|pin2|supply|vdd sg13_lv_pmos
+ L=0.13u W=1u AS=0.3325p AD=0.2225p PS=1.665u PD=1.445u rfmode=0
M$43994 \$1258 \$1296 \$1322 VDD|in|pad|pin1|pin2|supply|vdd sg13_lv_pmos
+ L=0.13u W=1u AS=0.2225p AD=0.2975p PS=1.445u PD=1.595u rfmode=0
M$43995 VDD|in|pad|pin1|pin2|supply|vdd \$1257 \$1322
+ VDD|in|pad|pin1|pin2|supply|vdd sg13_lv_pmos L=0.13u W=1u AS=0.2198p
+ AD=0.2975p PS=1.52u PD=1.595u rfmode=0
M$43996 VDD|in|pad|pin1|pin2|supply|vdd \$1258 \$1139
+ VDD|in|pad|pin1|pin2|supply|vdd sg13_lv_pmos L=0.13u W=1.12u AS=0.2198p
+ AD=0.6048p PS=1.52u PD=3.32u rfmode=0
M$43997 \$1466 \$1166 VDD|in|pad|pin1|pin2|supply|vdd
+ VDD|in|pad|pin1|pin2|supply|vdd sg13_lv_pmos L=0.13u W=0.84u AS=0.2856p
+ AD=0.253p PS=2.36u PD=1.53u rfmode=0
M$43998 VDD|in|pad|pin1|pin2|supply|vdd \$1166 \$1660
+ VDD|in|pad|pin1|pin2|supply|vdd sg13_lv_pmos L=0.13u W=1u AS=0.253p
+ AD=0.3325p PS=1.53u PD=1.665u rfmode=0
M$43999 \$1660 \$1298 \$1383 VDD|in|pad|pin1|pin2|supply|vdd sg13_lv_pmos
+ L=0.13u W=1u AS=0.3325p AD=0.2225p PS=1.665u PD=1.445u rfmode=0
M$44000 \$1383 \$1458 \$1659 VDD|in|pad|pin1|pin2|supply|vdd sg13_lv_pmos
+ L=0.13u W=1u AS=0.2225p AD=0.2975p PS=1.445u PD=1.595u rfmode=0
M$44001 \$1659 \$1466 VDD|in|pad|pin1|pin2|supply|vdd
+ VDD|in|pad|pin1|pin2|supply|vdd sg13_lv_pmos L=0.13u W=1u AS=0.2975p
+ AD=0.2198p PS=1.595u PD=1.52u rfmode=0
M$44002 VDD|in|pad|pin1|pin2|supply|vdd \$1383 \$1467
+ VDD|in|pad|pin1|pin2|supply|vdd sg13_lv_pmos L=0.13u W=1.12u AS=0.2198p
+ AD=0.6048p PS=1.52u PD=3.32u rfmode=0
M$44003 \$1468 \$1078 VDD|in|pad|pin1|pin2|supply|vdd
+ VDD|in|pad|pin1|pin2|supply|vdd sg13_lv_pmos L=0.13u W=1.12u AS=0.3808p
+ AD=0.3808p PS=2.92u PD=2.92u rfmode=0
M$44004 VDD|in|pad|pin1|pin2|supply|vdd \$1077 \$1469
+ VDD|in|pad|pin1|pin2|supply|vdd sg13_lv_pmos L=0.13u W=1.12u AS=0.3808p
+ AD=0.3808p PS=2.92u PD=2.92u rfmode=0
M$44005 VDD|in|pad|pin1|pin2|supply|vdd \$1467 \$1384
+ VDD|in|pad|pin1|pin2|supply|vdd sg13_lv_pmos L=0.13u W=0.42u AS=0.1428p
+ AD=0.0798p PS=1.52u PD=0.8u rfmode=0
M$44006 VDD|in|pad|pin1|pin2|supply|vdd \$1469 \$1384
+ VDD|in|pad|pin1|pin2|supply|vdd sg13_lv_pmos L=0.13u W=0.42u AS=0.3623875p
+ AD=0.0798p PS=2.605u PD=0.8u rfmode=0
M$44007 VDD|in|pad|pin1|pin2|supply|vdd \$1623 \$1385
+ VDD|in|pad|pin1|pin2|supply|vdd sg13_lv_pmos L=0.13u W=1u AS=0.3623875p
+ AD=0.34p PS=2.605u PD=2.68u rfmode=0
M$44008 \$1624 \$1386 VDD|in|pad|pin1|pin2|supply|vdd
+ VDD|in|pad|pin1|pin2|supply|vdd sg13_lv_pmos L=0.13u W=1.12u AS=0.3864p
+ AD=0.41165p PS=2.93u PD=2.12u rfmode=0
M$44009 VDD|in|pad|pin1|pin2|supply|vdd \$1201 \$1386
+ VDD|in|pad|pin1|pin2|supply|vdd sg13_lv_pmos L=0.13u W=1.12u AS=0.41165p
+ AD=0.4088p PS=2.12u PD=2.97u rfmode=0
M$44010 \$1471 \$1624 \$1665 VDD|in|pad|pin1|pin2|supply|vdd sg13_lv_pmos
+ L=0.13u W=0.42u AS=0.2048p AD=0.09345p PS=1.63u PD=0.865u rfmode=0
M$44011 \$1665 \$1388 VDD|in|pad|pin1|pin2|supply|vdd
+ VDD|in|pad|pin1|pin2|supply|vdd sg13_lv_pmos L=0.13u W=0.42u AS=0.09345p
+ AD=0.204p PS=0.865u PD=1.835u rfmode=0
M$44012 VDD|in|pad|pin1|pin2|supply|vdd \$1469 \$1388
+ VDD|in|pad|pin1|pin2|supply|vdd sg13_lv_pmos L=0.13u W=0.42u AS=0.204p
+ AD=0.0798p PS=1.835u PD=0.8u rfmode=0
M$44013 \$1388 \$1471 VDD|in|pad|pin1|pin2|supply|vdd
+ VDD|in|pad|pin1|pin2|supply|vdd sg13_lv_pmos L=0.13u W=0.42u AS=0.0798p
+ AD=0.4659p PS=0.8u PD=3.65u rfmode=0
M$44014 \$1385 \$1386 \$1471 VDD|in|pad|pin1|pin2|supply|vdd sg13_lv_pmos
+ L=0.13u W=1u AS=0.34p AD=0.2048p PS=2.68u PD=1.63u rfmode=0
M$44015 \$1389 \$1471 VDD|in|pad|pin1|pin2|supply|vdd
+ VDD|in|pad|pin1|pin2|supply|vdd sg13_lv_pmos L=0.13u W=1.12u AS=0.3864p
+ AD=0.2128p PS=2.93u PD=1.5u rfmode=0
M$44016 VDD|in|pad|pin1|pin2|supply|vdd \$1389 \$1296
+ VDD|in|pad|pin1|pin2|supply|vdd sg13_lv_pmos L=0.13u W=1.12u AS=0.2128p
+ AD=0.3808p PS=1.5u PD=2.92u rfmode=0
M$44017 VDD|in|pad|pin1|pin2|supply|vdd \$1166 \$1259
+ VDD|in|pad|pin1|pin2|supply|vdd sg13_lv_pmos L=0.13u W=0.84u AS=0.253p
+ AD=0.2856p PS=1.53u PD=2.36u rfmode=0
M$44018 VDD|in|pad|pin1|pin2|supply|vdd \$1166 \$1325
+ VDD|in|pad|pin1|pin2|supply|vdd sg13_lv_pmos L=0.13u W=1u AS=0.253p
+ AD=0.3325p PS=1.53u PD=1.665u rfmode=0
M$44019 \$1325 \$1299 \$1260 VDD|in|pad|pin1|pin2|supply|vdd sg13_lv_pmos
+ L=0.13u W=1u AS=0.3325p AD=0.2225p PS=1.665u PD=1.445u rfmode=0
M$44020 \$1260 \$1298 \$1324 VDD|in|pad|pin1|pin2|supply|vdd sg13_lv_pmos
+ L=0.13u W=1u AS=0.2225p AD=0.2975p PS=1.445u PD=1.595u rfmode=0
M$44021 VDD|in|pad|pin1|pin2|supply|vdd \$1259 \$1324
+ VDD|in|pad|pin1|pin2|supply|vdd sg13_lv_pmos L=0.13u W=1u AS=0.2198p
+ AD=0.2975p PS=1.52u PD=1.595u rfmode=0
M$44022 VDD|in|pad|pin1|pin2|supply|vdd \$1260 \$1203
+ VDD|in|pad|pin1|pin2|supply|vdd sg13_lv_pmos L=0.13u W=1.12u AS=0.2198p
+ AD=0.6048p PS=1.52u PD=3.32u rfmode=0
M$44023 VDD|in|pad|pin1|pin2|supply|vdd \$1078 \$1472
+ VDD|in|pad|pin1|pin2|supply|vdd sg13_lv_pmos L=0.13u W=1.12u AS=0.3808p
+ AD=0.3808p PS=2.92u PD=2.92u rfmode=0
M$44024 VDD|in|pad|pin1|pin2|supply|vdd \$1204 \$1390
+ VDD|in|pad|pin1|pin2|supply|vdd sg13_lv_pmos L=0.13u W=0.42u AS=0.1428p
+ AD=0.0798p PS=1.52u PD=0.8u rfmode=0
M$44025 VDD|in|pad|pin1|pin2|supply|vdd \$1472 \$1390
+ VDD|in|pad|pin1|pin2|supply|vdd sg13_lv_pmos L=0.13u W=0.42u AS=0.3623875p
+ AD=0.0798p PS=2.605u PD=0.8u rfmode=0
M$44026 VDD|in|pad|pin1|pin2|supply|vdd \$1625 \$1391
+ VDD|in|pad|pin1|pin2|supply|vdd sg13_lv_pmos L=0.13u W=1u AS=0.3623875p
+ AD=0.34p PS=2.605u PD=2.68u rfmode=0
M$44027 \$1626 \$1392 VDD|in|pad|pin1|pin2|supply|vdd
+ VDD|in|pad|pin1|pin2|supply|vdd sg13_lv_pmos L=0.13u W=1.12u AS=0.3864p
+ AD=0.41165p PS=2.93u PD=2.12u rfmode=0
M$44028 VDD|in|pad|pin1|pin2|supply|vdd \$1725 \$1392
+ VDD|in|pad|pin1|pin2|supply|vdd sg13_lv_pmos L=0.13u W=1.12u AS=0.41165p
+ AD=0.4088p PS=2.12u PD=2.97u rfmode=0
M$44029 \$1474 \$1626 \$1669 VDD|in|pad|pin1|pin2|supply|vdd sg13_lv_pmos
+ L=0.13u W=0.42u AS=0.2048p AD=0.09345p PS=1.63u PD=0.865u rfmode=0
M$44030 \$1669 \$1394 VDD|in|pad|pin1|pin2|supply|vdd
+ VDD|in|pad|pin1|pin2|supply|vdd sg13_lv_pmos L=0.13u W=0.42u AS=0.09345p
+ AD=0.204p PS=0.865u PD=1.835u rfmode=0
M$44031 VDD|in|pad|pin1|pin2|supply|vdd \$1472 \$1394
+ VDD|in|pad|pin1|pin2|supply|vdd sg13_lv_pmos L=0.13u W=0.42u AS=0.204p
+ AD=0.0798p PS=1.835u PD=0.8u rfmode=0
M$44032 \$1394 \$1474 VDD|in|pad|pin1|pin2|supply|vdd
+ VDD|in|pad|pin1|pin2|supply|vdd sg13_lv_pmos L=0.13u W=0.42u AS=0.0798p
+ AD=0.4659p PS=0.8u PD=3.65u rfmode=0
M$44033 \$1391 \$1392 \$1474 VDD|in|pad|pin1|pin2|supply|vdd sg13_lv_pmos
+ L=0.13u W=1u AS=0.34p AD=0.2048p PS=2.68u PD=1.63u rfmode=0
M$44034 \$1395 \$1474 VDD|in|pad|pin1|pin2|supply|vdd
+ VDD|in|pad|pin1|pin2|supply|vdd sg13_lv_pmos L=0.13u W=1.12u AS=0.3864p
+ AD=0.2128p PS=2.93u PD=1.5u rfmode=0
M$44035 VDD|in|pad|pin1|pin2|supply|vdd \$1395 \$1299
+ VDD|in|pad|pin1|pin2|supply|vdd sg13_lv_pmos L=0.13u W=1.12u AS=0.2128p
+ AD=0.3808p PS=1.5u PD=2.92u rfmode=0
M$44036 VDD|in|pad|pin1|pin2|supply|vdd \$1078 \$1475
+ VDD|in|pad|pin1|pin2|supply|vdd sg13_lv_pmos L=0.13u W=1.12u AS=0.3808p
+ AD=0.3808p PS=2.92u PD=2.92u rfmode=0
M$44037 VDD|in|pad|pin1|pin2|supply|vdd \$1079 \$1590
+ VDD|in|pad|pin1|pin2|supply|vdd sg13_lv_pmos L=0.13u W=0.84u AS=0.253p
+ AD=0.2856p PS=1.53u PD=2.36u rfmode=0
M$44038 VDD|in|pad|pin1|pin2|supply|vdd \$1590 \$1673
+ VDD|in|pad|pin1|pin2|supply|vdd sg13_lv_pmos L=0.13u W=1u AS=0.2198p
+ AD=0.2975p PS=1.52u PD=1.595u rfmode=0
M$44039 \$1673 \$1299 \$1396 VDD|in|pad|pin1|pin2|supply|vdd sg13_lv_pmos
+ L=0.13u W=1u AS=0.2975p AD=0.2225p PS=1.595u PD=1.445u rfmode=0
M$44040 \$1396 \$1591 \$1677 VDD|in|pad|pin1|pin2|supply|vdd sg13_lv_pmos
+ L=0.13u W=1u AS=0.2225p AD=0.3325p PS=1.445u PD=1.665u rfmode=0
M$44041 \$1677 \$1079 VDD|in|pad|pin1|pin2|supply|vdd
+ VDD|in|pad|pin1|pin2|supply|vdd sg13_lv_pmos L=0.13u W=1u AS=0.3325p
+ AD=0.253p PS=1.665u PD=1.53u rfmode=0
M$44042 \$1476 \$1396 VDD|in|pad|pin1|pin2|supply|vdd
+ VDD|in|pad|pin1|pin2|supply|vdd sg13_lv_pmos L=0.13u W=1.12u AS=0.6048p
+ AD=0.2198p PS=3.32u PD=1.52u rfmode=0
M$44043 VDD|in|pad|pin1|pin2|supply|vdd \$1299 \$1477
+ VDD|in|pad|pin1|pin2|supply|vdd sg13_lv_pmos L=0.13u W=0.42u AS=0.1523p
+ AD=0.1428p PS=1.38u PD=1.52u rfmode=0
M$44044 VDD|in|pad|pin1|pin2|supply|vdd \$1477 \$1478
+ VDD|in|pad|pin1|pin2|supply|vdd sg13_lv_pmos L=0.5u W=1u AS=0.1523p AD=0.34p
+ PS=1.38u PD=2.68u rfmode=0
M$44045 \$1479 \$1478 VDD|in|pad|pin1|pin2|supply|vdd
+ VDD|in|pad|pin1|pin2|supply|vdd sg13_lv_pmos L=0.5u W=1u AS=0.34p AD=0.2254p
+ PS=2.68u PD=1.53u rfmode=0
M$44046 VDD|in|pad|pin1|pin2|supply|vdd \$1479 \$1480
+ VDD|in|pad|pin1|pin2|supply|vdd sg13_lv_pmos L=0.13u W=1.12u AS=0.2254p
+ AD=0.4256p PS=1.53u PD=3u rfmode=0
M$44048 \$1481 \$1166 VDD|in|pad|pin1|pin2|supply|vdd
+ VDD|in|pad|pin1|pin2|supply|vdd sg13_lv_pmos L=0.13u W=0.84u AS=0.2856p
+ AD=0.253p PS=2.36u PD=1.53u rfmode=0
M$44049 VDD|in|pad|pin1|pin2|supply|vdd \$1166 \$1680
+ VDD|in|pad|pin1|pin2|supply|vdd sg13_lv_pmos L=0.13u W=1u AS=0.253p
+ AD=0.3325p PS=1.53u PD=1.665u rfmode=0
M$44050 \$1680 \$1404 \$1397 VDD|in|pad|pin1|pin2|supply|vdd sg13_lv_pmos
+ L=0.13u W=1u AS=0.3325p AD=0.2225p PS=1.665u PD=1.445u rfmode=0
M$44051 \$1397 \$1480 \$1679 VDD|in|pad|pin1|pin2|supply|vdd sg13_lv_pmos
+ L=0.13u W=1u AS=0.2225p AD=0.2975p PS=1.445u PD=1.595u rfmode=0
M$44052 \$1679 \$1481 VDD|in|pad|pin1|pin2|supply|vdd
+ VDD|in|pad|pin1|pin2|supply|vdd sg13_lv_pmos L=0.13u W=1u AS=0.2975p
+ AD=0.2198p PS=1.595u PD=1.52u rfmode=0
M$44053 VDD|in|pad|pin1|pin2|supply|vdd \$1397 \$1301
+ VDD|in|pad|pin1|pin2|supply|vdd sg13_lv_pmos L=0.13u W=1.12u AS=0.2198p
+ AD=0.6048p PS=1.52u PD=3.32u rfmode=0
M$44054 VDD|in|pad|pin1|pin2|supply|vdd \$1210 \$1398
+ VDD|in|pad|pin1|pin2|supply|vdd sg13_lv_pmos L=0.13u W=0.42u AS=0.1428p
+ AD=0.0798p PS=1.52u PD=0.8u rfmode=0
M$44055 VDD|in|pad|pin1|pin2|supply|vdd \$1209 \$1398
+ VDD|in|pad|pin1|pin2|supply|vdd sg13_lv_pmos L=0.13u W=0.42u AS=0.3623875p
+ AD=0.0798p PS=2.605u PD=0.8u rfmode=0
M$44056 VDD|in|pad|pin1|pin2|supply|vdd \$1627 \$1399
+ VDD|in|pad|pin1|pin2|supply|vdd sg13_lv_pmos L=0.13u W=1u AS=0.3623875p
+ AD=0.34p PS=2.605u PD=2.68u rfmode=0
M$44057 \$1628 \$1400 VDD|in|pad|pin1|pin2|supply|vdd
+ VDD|in|pad|pin1|pin2|supply|vdd sg13_lv_pmos L=0.13u W=1.12u AS=0.3864p
+ AD=0.41165p PS=2.93u PD=2.12u rfmode=0
M$44058 VDD|in|pad|pin1|pin2|supply|vdd \$1592 \$1400
+ VDD|in|pad|pin1|pin2|supply|vdd sg13_lv_pmos L=0.13u W=1.12u AS=0.41165p
+ AD=0.4088p PS=2.12u PD=2.97u rfmode=0
M$44059 \$1483 \$1628 \$1684 VDD|in|pad|pin1|pin2|supply|vdd sg13_lv_pmos
+ L=0.13u W=0.42u AS=0.2048p AD=0.09345p PS=1.63u PD=0.865u rfmode=0
M$44060 \$1684 \$1402 VDD|in|pad|pin1|pin2|supply|vdd
+ VDD|in|pad|pin1|pin2|supply|vdd sg13_lv_pmos L=0.13u W=0.42u AS=0.09345p
+ AD=0.204p PS=0.865u PD=1.835u rfmode=0
M$44061 VDD|in|pad|pin1|pin2|supply|vdd \$1209 \$1402
+ VDD|in|pad|pin1|pin2|supply|vdd sg13_lv_pmos L=0.13u W=0.42u AS=0.204p
+ AD=0.0798p PS=1.835u PD=0.8u rfmode=0
M$44062 \$1402 \$1483 VDD|in|pad|pin1|pin2|supply|vdd
+ VDD|in|pad|pin1|pin2|supply|vdd sg13_lv_pmos L=0.13u W=0.42u AS=0.0798p
+ AD=0.4659p PS=0.8u PD=3.65u rfmode=0
M$44063 \$1399 \$1400 \$1483 VDD|in|pad|pin1|pin2|supply|vdd sg13_lv_pmos
+ L=0.13u W=1u AS=0.34p AD=0.2048p PS=2.68u PD=1.63u rfmode=0
M$44064 \$1403 \$1483 VDD|in|pad|pin1|pin2|supply|vdd
+ VDD|in|pad|pin1|pin2|supply|vdd sg13_lv_pmos L=0.13u W=1.12u AS=0.3864p
+ AD=0.2128p PS=2.93u PD=1.5u rfmode=0
M$44065 VDD|in|pad|pin1|pin2|supply|vdd \$1403 \$1404
+ VDD|in|pad|pin1|pin2|supply|vdd sg13_lv_pmos L=0.13u W=1.12u AS=0.2128p
+ AD=0.3808p PS=1.5u PD=2.92u rfmode=0
M$44070 VDD|in|pad|pin1|pin2|supply|vdd \$1078 \$1484
+ VDD|in|pad|pin1|pin2|supply|vdd sg13_lv_pmos L=0.13u W=1.12u AS=0.3808p
+ AD=0.3808p PS=2.92u PD=2.92u rfmode=0
M$44071 \$1078 \$1485 VDD|in|pad|pin1|pin2|supply|vdd
+ VDD|in|pad|pin1|pin2|supply|vdd sg13_lv_pmos L=0.13u W=1.12u AS=0.42p
+ AD=0.2114p PS=2.99u PD=1.54u rfmode=0
M$44072 VDD|in|pad|pin1|pin2|supply|vdd \$1120 \$1485
+ VDD|in|pad|pin1|pin2|supply|vdd sg13_lv_pmos L=0.13u W=0.84u AS=0.2114p
+ AD=0.2856p PS=1.54u PD=2.36u rfmode=0
M$44073 VDD|in|pad|pin1|pin2|supply|vdd \$1079 \$1593
+ VDD|in|pad|pin1|pin2|supply|vdd sg13_lv_pmos L=0.13u W=0.84u AS=0.253p
+ AD=0.2856p PS=1.53u PD=2.36u rfmode=0
M$44074 VDD|in|pad|pin1|pin2|supply|vdd \$1593 \$1691
+ VDD|in|pad|pin1|pin2|supply|vdd sg13_lv_pmos L=0.13u W=1u AS=0.2198p
+ AD=0.2975p PS=1.52u PD=1.595u rfmode=0
M$44075 \$1691 \$1404 \$1405 VDD|in|pad|pin1|pin2|supply|vdd sg13_lv_pmos
+ L=0.13u W=1u AS=0.2975p AD=0.2225p PS=1.595u PD=1.445u rfmode=0
M$44076 \$1405 \$1594 \$1689 VDD|in|pad|pin1|pin2|supply|vdd sg13_lv_pmos
+ L=0.13u W=1u AS=0.2225p AD=0.3325p PS=1.445u PD=1.665u rfmode=0
M$44077 \$1689 \$1079 VDD|in|pad|pin1|pin2|supply|vdd
+ VDD|in|pad|pin1|pin2|supply|vdd sg13_lv_pmos L=0.13u W=1u AS=0.3325p
+ AD=0.253p PS=1.665u PD=1.53u rfmode=0
M$44078 \$1486 \$1405 VDD|in|pad|pin1|pin2|supply|vdd
+ VDD|in|pad|pin1|pin2|supply|vdd sg13_lv_pmos L=0.13u W=1.12u AS=0.6048p
+ AD=0.2198p PS=3.32u PD=1.52u rfmode=0
M$44079 VDD|in|pad|pin1|pin2|supply|vdd \$1404 \$1487
+ VDD|in|pad|pin1|pin2|supply|vdd sg13_lv_pmos L=0.13u W=0.42u AS=0.1523p
+ AD=0.1428p PS=1.38u PD=1.52u rfmode=0
M$44080 VDD|in|pad|pin1|pin2|supply|vdd \$1487 \$1488
+ VDD|in|pad|pin1|pin2|supply|vdd sg13_lv_pmos L=0.5u W=1u AS=0.1523p AD=0.34p
+ PS=1.38u PD=2.68u rfmode=0
M$44081 \$1489 \$1488 VDD|in|pad|pin1|pin2|supply|vdd
+ VDD|in|pad|pin1|pin2|supply|vdd sg13_lv_pmos L=0.5u W=1u AS=0.34p AD=0.2254p
+ PS=2.68u PD=1.53u rfmode=0
M$44082 VDD|in|pad|pin1|pin2|supply|vdd \$1489 \$1490
+ VDD|in|pad|pin1|pin2|supply|vdd sg13_lv_pmos L=0.13u W=1.12u AS=0.2254p
+ AD=0.4256p PS=1.53u PD=3u rfmode=0
M$44083 VDD|in|pad|pin1|pin2|supply|vdd \$1595 \$1491
+ VDD|in|pad|pin1|pin2|supply|vdd sg13_lv_pmos L=0.5u W=1u AS=0.2254p AD=0.34p
+ PS=1.53u PD=2.68u rfmode=0
M$44084 \$1594 \$1491 VDD|in|pad|pin1|pin2|supply|vdd
+ VDD|in|pad|pin1|pin2|supply|vdd sg13_lv_pmos L=0.13u W=1.12u AS=0.4256p
+ AD=0.2254p PS=3u PD=1.53u rfmode=0
M$44085 VDD|in|pad|pin1|pin2|supply|vdd \$1302 \$1492
+ VDD|in|pad|pin1|pin2|supply|vdd sg13_lv_pmos L=0.13u W=0.42u AS=0.1523p
+ AD=0.1428p PS=1.38u PD=1.52u rfmode=0
M$44086 \$1595 \$1492 VDD|in|pad|pin1|pin2|supply|vdd
+ VDD|in|pad|pin1|pin2|supply|vdd sg13_lv_pmos L=0.5u W=1u AS=0.34p AD=0.1523p
+ PS=2.68u PD=1.38u rfmode=0
M$44087 \$1493 \$1352 VDD|in|pad|pin1|pin2|supply|vdd
+ VDD|in|pad|pin1|pin2|supply|vdd sg13_lv_pmos L=0.13u W=0.84u AS=0.2856p
+ AD=0.253p PS=2.36u PD=1.53u rfmode=0
M$44088 VDD|in|pad|pin1|pin2|supply|vdd \$1352 \$1695
+ VDD|in|pad|pin1|pin2|supply|vdd sg13_lv_pmos L=0.13u W=1u AS=0.253p
+ AD=0.3325p PS=1.53u PD=1.665u rfmode=0
M$44089 \$1695 \$1596 \$1406 VDD|in|pad|pin1|pin2|supply|vdd sg13_lv_pmos
+ L=0.13u W=1u AS=0.3325p AD=0.2225p PS=1.665u PD=1.445u rfmode=0
M$44090 \$1406 \$1490 \$1694 VDD|in|pad|pin1|pin2|supply|vdd sg13_lv_pmos
+ L=0.13u W=1u AS=0.2225p AD=0.2975p PS=1.445u PD=1.595u rfmode=0
M$44091 \$1694 \$1493 VDD|in|pad|pin1|pin2|supply|vdd
+ VDD|in|pad|pin1|pin2|supply|vdd sg13_lv_pmos L=0.13u W=1u AS=0.2975p
+ AD=0.2198p PS=1.595u PD=1.52u rfmode=0
M$44092 VDD|in|pad|pin1|pin2|supply|vdd \$1406 \$1494
+ VDD|in|pad|pin1|pin2|supply|vdd sg13_lv_pmos L=0.13u W=1.12u AS=0.2198p
+ AD=0.6048p PS=1.52u PD=3.32u rfmode=0
M$44093 VDD|in|pad|pin1|pin2|supply|vdd \$1494 \$1407
+ VDD|in|pad|pin1|pin2|supply|vdd sg13_lv_pmos L=0.13u W=0.42u AS=0.1428p
+ AD=0.0798p PS=1.52u PD=0.8u rfmode=0
M$44094 VDD|in|pad|pin1|pin2|supply|vdd \$1121 \$1407
+ VDD|in|pad|pin1|pin2|supply|vdd sg13_lv_pmos L=0.13u W=0.42u AS=0.3623875p
+ AD=0.0798p PS=2.605u PD=0.8u rfmode=0
M$44095 VDD|in|pad|pin1|pin2|supply|vdd \$1629 \$1408
+ VDD|in|pad|pin1|pin2|supply|vdd sg13_lv_pmos L=0.13u W=1u AS=0.3623875p
+ AD=0.34p PS=2.605u PD=2.68u rfmode=0
M$44096 \$1630 \$1409 VDD|in|pad|pin1|pin2|supply|vdd
+ VDD|in|pad|pin1|pin2|supply|vdd sg13_lv_pmos L=0.13u W=1.12u AS=0.3864p
+ AD=0.41165p PS=2.93u PD=2.12u rfmode=0
M$44097 VDD|in|pad|pin1|pin2|supply|vdd \$1592 \$1409
+ VDD|in|pad|pin1|pin2|supply|vdd sg13_lv_pmos L=0.13u W=1.12u AS=0.41165p
+ AD=0.4088p PS=2.12u PD=2.97u rfmode=0
M$44098 \$1496 \$1630 \$1696 VDD|in|pad|pin1|pin2|supply|vdd sg13_lv_pmos
+ L=0.13u W=0.42u AS=0.2048p AD=0.09345p PS=1.63u PD=0.865u rfmode=0
M$44099 \$1696 \$1411 VDD|in|pad|pin1|pin2|supply|vdd
+ VDD|in|pad|pin1|pin2|supply|vdd sg13_lv_pmos L=0.13u W=0.42u AS=0.09345p
+ AD=0.204p PS=0.865u PD=1.835u rfmode=0
M$44100 VDD|in|pad|pin1|pin2|supply|vdd \$1121 \$1411
+ VDD|in|pad|pin1|pin2|supply|vdd sg13_lv_pmos L=0.13u W=0.42u AS=0.204p
+ AD=0.0798p PS=1.835u PD=0.8u rfmode=0
M$44101 \$1411 \$1496 VDD|in|pad|pin1|pin2|supply|vdd
+ VDD|in|pad|pin1|pin2|supply|vdd sg13_lv_pmos L=0.13u W=0.42u AS=0.0798p
+ AD=0.4659p PS=0.8u PD=3.65u rfmode=0
M$44102 \$1408 \$1409 \$1496 VDD|in|pad|pin1|pin2|supply|vdd sg13_lv_pmos
+ L=0.13u W=1u AS=0.34p AD=0.2048p PS=2.68u PD=1.63u rfmode=0
M$44103 \$1412 \$1496 VDD|in|pad|pin1|pin2|supply|vdd
+ VDD|in|pad|pin1|pin2|supply|vdd sg13_lv_pmos L=0.13u W=1.12u AS=0.3864p
+ AD=0.2128p PS=2.93u PD=1.5u rfmode=0
M$44104 VDD|in|pad|pin1|pin2|supply|vdd \$1412 \$1304
+ VDD|in|pad|pin1|pin2|supply|vdd sg13_lv_pmos L=0.13u W=1.12u AS=0.2128p
+ AD=0.3808p PS=1.5u PD=2.92u rfmode=0
M$44112 VDD|in|pad|pin1|pin2|supply|vdd \$1307 \$1497
+ VDD|in|pad|pin1|pin2|supply|vdd sg13_lv_pmos L=0.13u W=1.12u AS=0.3808p
+ AD=0.3808p PS=2.92u PD=2.92u rfmode=0
M$44113 VDD|in|pad|pin1|pin2|supply|vdd \$1597 \$1413
+ VDD|in|pad|pin1|pin2|supply|vdd sg13_lv_pmos L=0.13u W=0.42u AS=0.1428p
+ AD=0.0798p PS=1.52u PD=0.8u rfmode=0
M$44114 VDD|in|pad|pin1|pin2|supply|vdd \$1497 \$1413
+ VDD|in|pad|pin1|pin2|supply|vdd sg13_lv_pmos L=0.13u W=0.42u AS=0.3623875p
+ AD=0.0798p PS=2.605u PD=0.8u rfmode=0
M$44115 VDD|in|pad|pin1|pin2|supply|vdd \$1631 \$1414
+ VDD|in|pad|pin1|pin2|supply|vdd sg13_lv_pmos L=0.13u W=1u AS=0.3623875p
+ AD=0.34p PS=2.605u PD=2.68u rfmode=0
M$44116 \$1632 \$1415 VDD|in|pad|pin1|pin2|supply|vdd
+ VDD|in|pad|pin1|pin2|supply|vdd sg13_lv_pmos L=0.13u W=1.12u AS=0.3864p
+ AD=0.41165p PS=2.93u PD=2.12u rfmode=0
M$44117 VDD|in|pad|pin1|pin2|supply|vdd \$1592 \$1415
+ VDD|in|pad|pin1|pin2|supply|vdd sg13_lv_pmos L=0.13u W=1.12u AS=0.41165p
+ AD=0.4088p PS=2.12u PD=2.97u rfmode=0
M$44118 \$1499 \$1632 \$1702 VDD|in|pad|pin1|pin2|supply|vdd sg13_lv_pmos
+ L=0.13u W=0.42u AS=0.2048p AD=0.09345p PS=1.63u PD=0.865u rfmode=0
M$44119 \$1702 \$1417 VDD|in|pad|pin1|pin2|supply|vdd
+ VDD|in|pad|pin1|pin2|supply|vdd sg13_lv_pmos L=0.13u W=0.42u AS=0.09345p
+ AD=0.204p PS=0.865u PD=1.835u rfmode=0
M$44120 VDD|in|pad|pin1|pin2|supply|vdd \$1497 \$1417
+ VDD|in|pad|pin1|pin2|supply|vdd sg13_lv_pmos L=0.13u W=0.42u AS=0.204p
+ AD=0.0798p PS=1.835u PD=0.8u rfmode=0
M$44121 \$1417 \$1499 VDD|in|pad|pin1|pin2|supply|vdd
+ VDD|in|pad|pin1|pin2|supply|vdd sg13_lv_pmos L=0.13u W=0.42u AS=0.0798p
+ AD=0.4659p PS=0.8u PD=3.65u rfmode=0
M$44122 \$1414 \$1415 \$1499 VDD|in|pad|pin1|pin2|supply|vdd sg13_lv_pmos
+ L=0.13u W=1u AS=0.34p AD=0.2048p PS=2.68u PD=1.63u rfmode=0
M$44123 \$1418 \$1499 VDD|in|pad|pin1|pin2|supply|vdd
+ VDD|in|pad|pin1|pin2|supply|vdd sg13_lv_pmos L=0.13u W=1.12u AS=0.3864p
+ AD=0.2128p PS=2.93u PD=1.5u rfmode=0
M$44124 VDD|in|pad|pin1|pin2|supply|vdd \$1418 \$1306
+ VDD|in|pad|pin1|pin2|supply|vdd sg13_lv_pmos L=0.13u W=1.12u AS=0.2128p
+ AD=0.3808p PS=1.5u PD=2.92u rfmode=0
M$44132 \$1500 \$1352 VDD|in|pad|pin1|pin2|supply|vdd
+ VDD|in|pad|pin1|pin2|supply|vdd sg13_lv_pmos L=0.13u W=0.84u AS=0.2856p
+ AD=0.253p PS=2.36u PD=1.53u rfmode=0
M$44133 VDD|in|pad|pin1|pin2|supply|vdd \$1352 \$1699
+ VDD|in|pad|pin1|pin2|supply|vdd sg13_lv_pmos L=0.13u W=1u AS=0.253p
+ AD=0.3325p PS=1.53u PD=1.665u rfmode=0
M$44134 \$1699 \$1598 \$1419 VDD|in|pad|pin1|pin2|supply|vdd sg13_lv_pmos
+ L=0.13u W=1u AS=0.3325p AD=0.2225p PS=1.665u PD=1.445u rfmode=0
M$44135 \$1419 \$1596 \$1700 VDD|in|pad|pin1|pin2|supply|vdd sg13_lv_pmos
+ L=0.13u W=1u AS=0.2225p AD=0.2975p PS=1.445u PD=1.595u rfmode=0
M$44136 \$1700 \$1500 VDD|in|pad|pin1|pin2|supply|vdd
+ VDD|in|pad|pin1|pin2|supply|vdd sg13_lv_pmos L=0.13u W=1u AS=0.2975p
+ AD=0.2198p PS=1.595u PD=1.52u rfmode=0
M$44137 VDD|in|pad|pin1|pin2|supply|vdd \$1419 \$1501
+ VDD|in|pad|pin1|pin2|supply|vdd sg13_lv_pmos L=0.13u W=1.12u AS=0.2198p
+ AD=0.6048p PS=1.52u PD=3.32u rfmode=0
M$44138 VDD|in|pad|pin1|pin2|supply|vdd \$1501 \$1420
+ VDD|in|pad|pin1|pin2|supply|vdd sg13_lv_pmos L=0.13u W=0.42u AS=0.1428p
+ AD=0.0798p PS=1.52u PD=0.8u rfmode=0
M$44139 VDD|in|pad|pin1|pin2|supply|vdd \$1220 \$1420
+ VDD|in|pad|pin1|pin2|supply|vdd sg13_lv_pmos L=0.13u W=0.42u AS=0.3623875p
+ AD=0.0798p PS=2.605u PD=0.8u rfmode=0
M$44140 VDD|in|pad|pin1|pin2|supply|vdd \$1633 \$1421
+ VDD|in|pad|pin1|pin2|supply|vdd sg13_lv_pmos L=0.13u W=1u AS=0.3623875p
+ AD=0.34p PS=2.605u PD=2.68u rfmode=0
M$44141 \$1634 \$1422 VDD|in|pad|pin1|pin2|supply|vdd
+ VDD|in|pad|pin1|pin2|supply|vdd sg13_lv_pmos L=0.13u W=1.12u AS=0.3864p
+ AD=0.41165p PS=2.93u PD=2.12u rfmode=0
M$44142 VDD|in|pad|pin1|pin2|supply|vdd \$1592 \$1422
+ VDD|in|pad|pin1|pin2|supply|vdd sg13_lv_pmos L=0.13u W=1.12u AS=0.41165p
+ AD=0.4088p PS=2.12u PD=2.97u rfmode=0
M$44143 \$1503 \$1634 \$1690 VDD|in|pad|pin1|pin2|supply|vdd sg13_lv_pmos
+ L=0.13u W=0.42u AS=0.2048p AD=0.09345p PS=1.63u PD=0.865u rfmode=0
M$44144 \$1690 \$1424 VDD|in|pad|pin1|pin2|supply|vdd
+ VDD|in|pad|pin1|pin2|supply|vdd sg13_lv_pmos L=0.13u W=0.42u AS=0.09345p
+ AD=0.204p PS=0.865u PD=1.835u rfmode=0
M$44145 VDD|in|pad|pin1|pin2|supply|vdd \$1220 \$1424
+ VDD|in|pad|pin1|pin2|supply|vdd sg13_lv_pmos L=0.13u W=0.42u AS=0.204p
+ AD=0.0798p PS=1.835u PD=0.8u rfmode=0
M$44146 \$1424 \$1503 VDD|in|pad|pin1|pin2|supply|vdd
+ VDD|in|pad|pin1|pin2|supply|vdd sg13_lv_pmos L=0.13u W=0.42u AS=0.0798p
+ AD=0.4659p PS=0.8u PD=3.65u rfmode=0
M$44147 \$1421 \$1422 \$1503 VDD|in|pad|pin1|pin2|supply|vdd sg13_lv_pmos
+ L=0.13u W=1u AS=0.34p AD=0.2048p PS=2.68u PD=1.63u rfmode=0
M$44148 \$1425 \$1503 VDD|in|pad|pin1|pin2|supply|vdd
+ VDD|in|pad|pin1|pin2|supply|vdd sg13_lv_pmos L=0.13u W=1.12u AS=0.3864p
+ AD=0.2128p PS=2.93u PD=1.5u rfmode=0
M$44149 VDD|in|pad|pin1|pin2|supply|vdd \$1425 \$1426
+ VDD|in|pad|pin1|pin2|supply|vdd sg13_lv_pmos L=0.13u W=1.12u AS=0.2128p
+ AD=0.3808p PS=1.5u PD=2.92u rfmode=0
M$44150 VDD|in|pad|pin1|pin2|supply|vdd \$1233 \$1505
+ VDD|in|pad|pin1|pin2|supply|vdd sg13_lv_pmos L=0.13u W=0.84u AS=0.253p
+ AD=0.2856p PS=1.53u PD=2.36u rfmode=0
M$44151 VDD|in|pad|pin1|pin2|supply|vdd \$1505 \$1686
+ VDD|in|pad|pin1|pin2|supply|vdd sg13_lv_pmos L=0.13u W=1u AS=0.2198p
+ AD=0.2975p PS=1.52u PD=1.595u rfmode=0
M$44152 \$1686 \$1426 \$1427 VDD|in|pad|pin1|pin2|supply|vdd sg13_lv_pmos
+ L=0.13u W=1u AS=0.2975p AD=0.2225p PS=1.595u PD=1.445u rfmode=0
M$44153 \$1427 \$1599 \$1687 VDD|in|pad|pin1|pin2|supply|vdd sg13_lv_pmos
+ L=0.13u W=1u AS=0.2225p AD=0.3325p PS=1.445u PD=1.665u rfmode=0
M$44154 \$1687 \$1233 VDD|in|pad|pin1|pin2|supply|vdd
+ VDD|in|pad|pin1|pin2|supply|vdd sg13_lv_pmos L=0.13u W=1u AS=0.3325p
+ AD=0.253p PS=1.665u PD=1.53u rfmode=0
M$44155 \$1504 \$1427 VDD|in|pad|pin1|pin2|supply|vdd
+ VDD|in|pad|pin1|pin2|supply|vdd sg13_lv_pmos L=0.13u W=1.12u AS=0.6048p
+ AD=0.2198p PS=3.32u PD=1.52u rfmode=0
M$44156 \$1506 \$1307 VDD|in|pad|pin1|pin2|supply|vdd
+ VDD|in|pad|pin1|pin2|supply|vdd sg13_lv_pmos L=0.13u W=1.12u AS=0.3808p
+ AD=0.3808p PS=2.92u PD=2.92u rfmode=0
M$44157 VDD|in|pad|pin1|pin2|supply|vdd \$1635 \$1507
+ VDD|in|pad|pin1|pin2|supply|vdd sg13_lv_pmos L=0.13u W=0.84u AS=0.2114p
+ AD=0.2856p PS=1.54u PD=2.36u rfmode=0
M$44158 VDD|in|pad|pin1|pin2|supply|vdd \$1507 X7|dout[8]
+ VDD|in|pad|pin1|pin2|supply|vdd sg13_lv_pmos L=0.13u W=1.12u AS=0.2114p
+ AD=0.42p PS=1.54u PD=2.99u rfmode=0
M$44159 VDD|in|pad|pin1|pin2|supply|vdd \$1426 \$1508
+ VDD|in|pad|pin1|pin2|supply|vdd sg13_lv_pmos L=0.13u W=0.42u AS=0.1523p
+ AD=0.1428p PS=1.38u PD=1.52u rfmode=0
M$44160 VDD|in|pad|pin1|pin2|supply|vdd \$1508 \$1509
+ VDD|in|pad|pin1|pin2|supply|vdd sg13_lv_pmos L=0.5u W=1u AS=0.1523p AD=0.34p
+ PS=1.38u PD=2.68u rfmode=0
M$44161 \$1510 \$1509 VDD|in|pad|pin1|pin2|supply|vdd
+ VDD|in|pad|pin1|pin2|supply|vdd sg13_lv_pmos L=0.5u W=1u AS=0.34p AD=0.2254p
+ PS=2.68u PD=1.53u rfmode=0
M$44162 VDD|in|pad|pin1|pin2|supply|vdd \$1510 \$1598
+ VDD|in|pad|pin1|pin2|supply|vdd sg13_lv_pmos L=0.13u W=1.12u AS=0.2254p
+ AD=0.4256p PS=1.53u PD=3u rfmode=0
M$44164 \$1511 \$1352 VDD|in|pad|pin1|pin2|supply|vdd
+ VDD|in|pad|pin1|pin2|supply|vdd sg13_lv_pmos L=0.13u W=0.84u AS=0.2856p
+ AD=0.253p PS=2.36u PD=1.53u rfmode=0
M$44165 VDD|in|pad|pin1|pin2|supply|vdd \$1352 \$1681
+ VDD|in|pad|pin1|pin2|supply|vdd sg13_lv_pmos L=0.13u W=1u AS=0.253p
+ AD=0.3325p PS=1.53u PD=1.665u rfmode=0
M$44166 \$1681 \$1600 \$1429 VDD|in|pad|pin1|pin2|supply|vdd sg13_lv_pmos
+ L=0.13u W=1u AS=0.3325p AD=0.2225p PS=1.665u PD=1.445u rfmode=0
M$44167 \$1429 \$1598 \$1682 VDD|in|pad|pin1|pin2|supply|vdd sg13_lv_pmos
+ L=0.13u W=1u AS=0.2225p AD=0.2975p PS=1.445u PD=1.595u rfmode=0
M$44168 \$1682 \$1511 VDD|in|pad|pin1|pin2|supply|vdd
+ VDD|in|pad|pin1|pin2|supply|vdd sg13_lv_pmos L=0.13u W=1u AS=0.2975p
+ AD=0.2198p PS=1.595u PD=1.52u rfmode=0
M$44169 VDD|in|pad|pin1|pin2|supply|vdd \$1429 \$1512
+ VDD|in|pad|pin1|pin2|supply|vdd sg13_lv_pmos L=0.13u W=1.12u AS=0.2198p
+ AD=0.6048p PS=1.52u PD=3.32u rfmode=0
M$44170 VDD|in|pad|pin1|pin2|supply|vdd \$1222 \$1430
+ VDD|in|pad|pin1|pin2|supply|vdd sg13_lv_pmos L=0.13u W=0.42u AS=0.1428p
+ AD=0.0798p PS=1.52u PD=0.8u rfmode=0
M$44171 VDD|in|pad|pin1|pin2|supply|vdd \$1221 \$1430
+ VDD|in|pad|pin1|pin2|supply|vdd sg13_lv_pmos L=0.13u W=0.42u AS=0.3623875p
+ AD=0.0798p PS=2.605u PD=0.8u rfmode=0
M$44172 VDD|in|pad|pin1|pin2|supply|vdd \$1636 \$1431
+ VDD|in|pad|pin1|pin2|supply|vdd sg13_lv_pmos L=0.13u W=1u AS=0.3623875p
+ AD=0.34p PS=2.605u PD=2.68u rfmode=0
M$44173 \$1637 \$1432 VDD|in|pad|pin1|pin2|supply|vdd
+ VDD|in|pad|pin1|pin2|supply|vdd sg13_lv_pmos L=0.13u W=1.12u AS=0.3864p
+ AD=0.41165p PS=2.93u PD=2.12u rfmode=0
M$44174 VDD|in|pad|pin1|pin2|supply|vdd \$1311 \$1432
+ VDD|in|pad|pin1|pin2|supply|vdd sg13_lv_pmos L=0.13u W=1.12u AS=0.41165p
+ AD=0.4088p PS=2.12u PD=2.97u rfmode=0
M$44175 \$1514 \$1637 \$1678 VDD|in|pad|pin1|pin2|supply|vdd sg13_lv_pmos
+ L=0.13u W=0.42u AS=0.2048p AD=0.09345p PS=1.63u PD=0.865u rfmode=0
M$44176 \$1678 \$1434 VDD|in|pad|pin1|pin2|supply|vdd
+ VDD|in|pad|pin1|pin2|supply|vdd sg13_lv_pmos L=0.13u W=0.42u AS=0.09345p
+ AD=0.204p PS=0.865u PD=1.835u rfmode=0
M$44177 VDD|in|pad|pin1|pin2|supply|vdd \$1221 \$1434
+ VDD|in|pad|pin1|pin2|supply|vdd sg13_lv_pmos L=0.13u W=0.42u AS=0.204p
+ AD=0.0798p PS=1.835u PD=0.8u rfmode=0
M$44178 \$1434 \$1514 VDD|in|pad|pin1|pin2|supply|vdd
+ VDD|in|pad|pin1|pin2|supply|vdd sg13_lv_pmos L=0.13u W=0.42u AS=0.0798p
+ AD=0.4659p PS=0.8u PD=3.65u rfmode=0
M$44179 \$1431 \$1432 \$1514 VDD|in|pad|pin1|pin2|supply|vdd sg13_lv_pmos
+ L=0.13u W=1u AS=0.34p AD=0.2048p PS=2.68u PD=1.63u rfmode=0
M$44180 \$1435 \$1514 VDD|in|pad|pin1|pin2|supply|vdd
+ VDD|in|pad|pin1|pin2|supply|vdd sg13_lv_pmos L=0.13u W=1.12u AS=0.3864p
+ AD=0.2128p PS=2.93u PD=1.5u rfmode=0
M$44181 VDD|in|pad|pin1|pin2|supply|vdd \$1435 \$1600
+ VDD|in|pad|pin1|pin2|supply|vdd sg13_lv_pmos L=0.13u W=1.12u AS=0.2128p
+ AD=0.3808p PS=1.5u PD=2.92u rfmode=0
M$44182 VDD|in|pad|pin1|pin2|supply|vdd \$1352 \$1266
+ VDD|in|pad|pin1|pin2|supply|vdd sg13_lv_pmos L=0.13u W=0.84u AS=0.253p
+ AD=0.2856p PS=1.53u PD=2.36u rfmode=0
M$44183 VDD|in|pad|pin1|pin2|supply|vdd \$1352 \$1329
+ VDD|in|pad|pin1|pin2|supply|vdd sg13_lv_pmos L=0.13u W=1u AS=0.253p
+ AD=0.3325p PS=1.53u PD=1.665u rfmode=0
M$44184 \$1329 \$1309 \$1267 VDD|in|pad|pin1|pin2|supply|vdd sg13_lv_pmos
+ L=0.13u W=1u AS=0.3325p AD=0.2225p PS=1.665u PD=1.445u rfmode=0
M$44185 \$1267 \$1308 \$1330 VDD|in|pad|pin1|pin2|supply|vdd sg13_lv_pmos
+ L=0.13u W=1u AS=0.2225p AD=0.2975p PS=1.445u PD=1.595u rfmode=0
M$44186 VDD|in|pad|pin1|pin2|supply|vdd \$1266 \$1330
+ VDD|in|pad|pin1|pin2|supply|vdd sg13_lv_pmos L=0.13u W=1u AS=0.2198p
+ AD=0.2975p PS=1.52u PD=1.595u rfmode=0
M$44187 VDD|in|pad|pin1|pin2|supply|vdd \$1267 \$1225
+ VDD|in|pad|pin1|pin2|supply|vdd sg13_lv_pmos L=0.13u W=1.12u AS=0.2198p
+ AD=0.6048p PS=1.52u PD=3.32u rfmode=0
M$44188 \$1515 \$1233 VDD|in|pad|pin1|pin2|supply|vdd
+ VDD|in|pad|pin1|pin2|supply|vdd sg13_lv_pmos L=0.13u W=0.84u AS=0.2856p
+ AD=0.253p PS=2.36u PD=1.53u rfmode=0
M$44189 VDD|in|pad|pin1|pin2|supply|vdd \$1233 \$1664
+ VDD|in|pad|pin1|pin2|supply|vdd sg13_lv_pmos L=0.13u W=1u AS=0.253p
+ AD=0.3325p PS=1.53u PD=1.665u rfmode=0
M$44190 \$1664 \$1601 \$1436 VDD|in|pad|pin1|pin2|supply|vdd sg13_lv_pmos
+ L=0.13u W=1u AS=0.3325p AD=0.2225p PS=1.665u PD=1.445u rfmode=0
M$44191 \$1436 \$1600 \$1666 VDD|in|pad|pin1|pin2|supply|vdd sg13_lv_pmos
+ L=0.13u W=1u AS=0.2225p AD=0.2975p PS=1.445u PD=1.595u rfmode=0
M$44192 \$1666 \$1515 VDD|in|pad|pin1|pin2|supply|vdd
+ VDD|in|pad|pin1|pin2|supply|vdd sg13_lv_pmos L=0.13u W=1u AS=0.2975p
+ AD=0.2198p PS=1.595u PD=1.52u rfmode=0
M$44193 VDD|in|pad|pin1|pin2|supply|vdd \$1436 \$1602
+ VDD|in|pad|pin1|pin2|supply|vdd sg13_lv_pmos L=0.13u W=1.12u AS=0.2198p
+ AD=0.6048p PS=1.52u PD=3.32u rfmode=0
M$44194 VDD|in|pad|pin1|pin2|supply|vdd \$1603 \$1517
+ VDD|in|pad|pin1|pin2|supply|vdd sg13_lv_pmos L=0.5u W=1u AS=0.2254p AD=0.34p
+ PS=1.53u PD=2.68u rfmode=0
M$44195 \$1516 \$1517 VDD|in|pad|pin1|pin2|supply|vdd
+ VDD|in|pad|pin1|pin2|supply|vdd sg13_lv_pmos L=0.13u W=1.12u AS=0.4256p
+ AD=0.2254p PS=3u PD=1.53u rfmode=0
M$44196 VDD|in|pad|pin1|pin2|supply|vdd \$1122 \$1270
+ VDD|in|pad|pin1|pin2|supply|vdd sg13_lv_pmos L=0.13u W=0.42u AS=0.1563p
+ AD=0.147p PS=1.22u PD=1.54u rfmode=0
M$44197 VDD|in|pad|pin1|pin2|supply|vdd \$1269 \$1287
+ VDD|in|pad|pin1|pin2|supply|vdd sg13_lv_pmos L=0.13u W=0.42u AS=0.1563p
+ AD=0.063p PS=1.22u PD=0.72u rfmode=0
M$44198 \$1287 \$1272 \$1270 VDD|in|pad|pin1|pin2|supply|vdd sg13_lv_pmos
+ L=0.13u W=0.42u AS=0.063p AD=0.0798p PS=0.72u PD=0.8u rfmode=0
M$44199 \$1270 \$1271 \$1268 VDD|in|pad|pin1|pin2|supply|vdd sg13_lv_pmos
+ L=0.13u W=0.42u AS=0.0798p AD=0.1428p PS=0.8u PD=1.52u rfmode=0
M$44200 VDD|in|pad|pin1|pin2|supply|vdd \$1602 \$1518
+ VDD|in|pad|pin1|pin2|supply|vdd sg13_lv_pmos L=0.13u W=0.42u AS=0.1523p
+ AD=0.1428p PS=1.38u PD=1.52u rfmode=0
M$44201 \$1603 \$1518 VDD|in|pad|pin1|pin2|supply|vdd
+ VDD|in|pad|pin1|pin2|supply|vdd sg13_lv_pmos L=0.5u W=1u AS=0.34p AD=0.1523p
+ PS=2.68u PD=1.38u rfmode=0
M$44202 VDD|in|pad|pin1|pin2|supply|vdd \$1604 \$1519
+ VDD|in|pad|pin1|pin2|supply|vdd sg13_lv_pmos L=0.5u W=1u AS=0.2254p AD=0.34p
+ PS=1.53u PD=2.68u rfmode=0
M$44203 \$1601 \$1519 VDD|in|pad|pin1|pin2|supply|vdd
+ VDD|in|pad|pin1|pin2|supply|vdd sg13_lv_pmos L=0.13u W=1.12u AS=0.4256p
+ AD=0.2254p PS=3u PD=1.53u rfmode=0
M$44204 VDD|in|pad|pin1|pin2|supply|vdd \$1605 \$1520
+ VDD|in|pad|pin1|pin2|supply|vdd sg13_lv_pmos L=0.13u W=0.42u AS=0.1523p
+ AD=0.1428p PS=1.38u PD=1.52u rfmode=0
M$44205 \$1604 \$1520 VDD|in|pad|pin1|pin2|supply|vdd
+ VDD|in|pad|pin1|pin2|supply|vdd sg13_lv_pmos L=0.5u W=1u AS=0.34p AD=0.1523p
+ PS=2.68u PD=1.38u rfmode=0
M$44206 \$1307 \$1521 VDD|in|pad|pin1|pin2|supply|vdd
+ VDD|in|pad|pin1|pin2|supply|vdd sg13_lv_pmos L=0.13u W=1.12u AS=0.42p
+ AD=0.2114p PS=2.99u PD=1.54u rfmode=0
M$44207 VDD|in|pad|pin1|pin2|supply|vdd \$1120 \$1521
+ VDD|in|pad|pin1|pin2|supply|vdd sg13_lv_pmos L=0.13u W=0.84u AS=0.2114p
+ AD=0.2856p PS=1.54u PD=2.36u rfmode=0
M$44208 \$1522 \$1307 VDD|in|pad|pin1|pin2|supply|vdd
+ VDD|in|pad|pin1|pin2|supply|vdd sg13_lv_pmos L=0.13u W=1.12u AS=0.3808p
+ AD=0.3808p PS=2.92u PD=2.92u rfmode=0
M$44209 VDD|in|pad|pin1|pin2|supply|vdd \$1166 \$1274
+ VDD|in|pad|pin1|pin2|supply|vdd sg13_lv_pmos L=0.13u W=0.84u AS=0.253p
+ AD=0.2856p PS=1.53u PD=2.36u rfmode=0
M$44210 VDD|in|pad|pin1|pin2|supply|vdd \$1166 \$1326
+ VDD|in|pad|pin1|pin2|supply|vdd sg13_lv_pmos L=0.13u W=1u AS=0.253p
+ AD=0.3325p PS=1.53u PD=1.665u rfmode=0
M$44211 \$1326 \$1313 \$1275 VDD|in|pad|pin1|pin2|supply|vdd sg13_lv_pmos
+ L=0.13u W=1u AS=0.3325p AD=0.2225p PS=1.665u PD=1.445u rfmode=0
M$44212 \$1275 \$1309 \$1327 VDD|in|pad|pin1|pin2|supply|vdd sg13_lv_pmos
+ L=0.13u W=1u AS=0.2225p AD=0.2975p PS=1.445u PD=1.595u rfmode=0
M$44213 VDD|in|pad|pin1|pin2|supply|vdd \$1274 \$1327
+ VDD|in|pad|pin1|pin2|supply|vdd sg13_lv_pmos L=0.13u W=1u AS=0.2198p
+ AD=0.2975p PS=1.52u PD=1.595u rfmode=0
M$44214 VDD|in|pad|pin1|pin2|supply|vdd \$1275 \$1228
+ VDD|in|pad|pin1|pin2|supply|vdd sg13_lv_pmos L=0.13u W=1.12u AS=0.2198p
+ AD=0.6048p PS=1.52u PD=3.32u rfmode=0
M$44215 VDD|in|pad|pin1|pin2|supply|vdd \$1227 \$1523
+ VDD|in|pad|pin1|pin2|supply|vdd sg13_lv_pmos L=0.13u W=0.42u AS=0.1523p
+ AD=0.1428p PS=1.38u PD=1.52u rfmode=0
M$44216 VDD|in|pad|pin1|pin2|supply|vdd \$1523 \$1524
+ VDD|in|pad|pin1|pin2|supply|vdd sg13_lv_pmos L=0.5u W=1u AS=0.1523p AD=0.34p
+ PS=1.38u PD=2.68u rfmode=0
M$44217 \$1525 \$1524 VDD|in|pad|pin1|pin2|supply|vdd
+ VDD|in|pad|pin1|pin2|supply|vdd sg13_lv_pmos L=0.5u W=1u AS=0.34p AD=0.2254p
+ PS=2.68u PD=1.53u rfmode=0
M$44218 VDD|in|pad|pin1|pin2|supply|vdd \$1525 \$1309
+ VDD|in|pad|pin1|pin2|supply|vdd sg13_lv_pmos L=0.13u W=1.12u AS=0.2254p
+ AD=0.4256p PS=1.53u PD=3u rfmode=0
M$44219 \$1526 \$1233 VDD|in|pad|pin1|pin2|supply|vdd
+ VDD|in|pad|pin1|pin2|supply|vdd sg13_lv_pmos L=0.13u W=0.84u AS=0.2856p
+ AD=0.253p PS=2.36u PD=1.53u rfmode=0
M$44220 VDD|in|pad|pin1|pin2|supply|vdd \$1233 \$1656
+ VDD|in|pad|pin1|pin2|supply|vdd sg13_lv_pmos L=0.13u W=1u AS=0.253p
+ AD=0.3325p PS=1.53u PD=1.665u rfmode=0
M$44221 \$1656 \$1606 \$1437 VDD|in|pad|pin1|pin2|supply|vdd sg13_lv_pmos
+ L=0.13u W=1u AS=0.3325p AD=0.2225p PS=1.665u PD=1.445u rfmode=0
M$44222 \$1437 \$1309 \$1657 VDD|in|pad|pin1|pin2|supply|vdd sg13_lv_pmos
+ L=0.13u W=1u AS=0.2225p AD=0.2975p PS=1.445u PD=1.595u rfmode=0
M$44223 \$1657 \$1526 VDD|in|pad|pin1|pin2|supply|vdd
+ VDD|in|pad|pin1|pin2|supply|vdd sg13_lv_pmos L=0.13u W=1u AS=0.2975p
+ AD=0.2198p PS=1.595u PD=1.52u rfmode=0
M$44224 VDD|in|pad|pin1|pin2|supply|vdd \$1437 \$1527
+ VDD|in|pad|pin1|pin2|supply|vdd sg13_lv_pmos L=0.13u W=1.12u AS=0.2198p
+ AD=0.6048p PS=1.52u PD=3.32u rfmode=0
M$44225 VDD|in|pad|pin1|pin2|supply|vdd \$1123 \$1278
+ VDD|in|pad|pin1|pin2|supply|vdd sg13_lv_pmos L=0.13u W=0.42u AS=0.1563p
+ AD=0.147p PS=1.22u PD=1.54u rfmode=0
M$44226 VDD|in|pad|pin1|pin2|supply|vdd \$1277 \$1286
+ VDD|in|pad|pin1|pin2|supply|vdd sg13_lv_pmos L=0.13u W=0.42u AS=0.1563p
+ AD=0.063p PS=1.22u PD=0.72u rfmode=0
M$44227 \$1286 \$1280 \$1278 VDD|in|pad|pin1|pin2|supply|vdd sg13_lv_pmos
+ L=0.13u W=0.42u AS=0.063p AD=0.0798p PS=0.72u PD=0.8u rfmode=0
M$44228 \$1278 \$1279 \$1276 VDD|in|pad|pin1|pin2|supply|vdd sg13_lv_pmos
+ L=0.13u W=0.42u AS=0.0798p AD=0.1428p PS=0.8u PD=1.52u rfmode=0
M$44229 VDD|in|pad|pin1|pin2|supply|vdd \$1307 \$1528
+ VDD|in|pad|pin1|pin2|supply|vdd sg13_lv_pmos L=0.13u W=1.12u AS=0.3808p
+ AD=0.3808p PS=2.92u PD=2.92u rfmode=0
M$44230 VDD|in|pad|pin1|pin2|supply|vdd \$1307 \$1529
+ VDD|in|pad|pin1|pin2|supply|vdd sg13_lv_pmos L=0.13u W=1.12u AS=0.3808p
+ AD=0.3808p PS=2.92u PD=2.92u rfmode=0
M$44231 \$1530 \$1233 VDD|in|pad|pin1|pin2|supply|vdd
+ VDD|in|pad|pin1|pin2|supply|vdd sg13_lv_pmos L=0.13u W=0.84u AS=0.2856p
+ AD=0.253p PS=2.36u PD=1.53u rfmode=0
M$44232 VDD|in|pad|pin1|pin2|supply|vdd \$1233 \$1652
+ VDD|in|pad|pin1|pin2|supply|vdd sg13_lv_pmos L=0.13u W=1u AS=0.253p
+ AD=0.3325p PS=1.53u PD=1.665u rfmode=0
M$44233 \$1652 \$1445 \$1438 VDD|in|pad|pin1|pin2|supply|vdd sg13_lv_pmos
+ L=0.13u W=1u AS=0.3325p AD=0.2225p PS=1.665u PD=1.445u rfmode=0
M$44234 \$1438 \$1313 \$1654 VDD|in|pad|pin1|pin2|supply|vdd sg13_lv_pmos
+ L=0.13u W=1u AS=0.2225p AD=0.2975p PS=1.445u PD=1.595u rfmode=0
M$44235 \$1654 \$1530 VDD|in|pad|pin1|pin2|supply|vdd
+ VDD|in|pad|pin1|pin2|supply|vdd sg13_lv_pmos L=0.13u W=1u AS=0.2975p
+ AD=0.2198p PS=1.595u PD=1.52u rfmode=0
M$44236 VDD|in|pad|pin1|pin2|supply|vdd \$1438 \$1150
+ VDD|in|pad|pin1|pin2|supply|vdd sg13_lv_pmos L=0.13u W=1.12u AS=0.2198p
+ AD=0.6048p PS=1.52u PD=3.32u rfmode=0
M$44237 VDD|in|pad|pin1|pin2|supply|vdd \$1124 \$1439
+ VDD|in|pad|pin1|pin2|supply|vdd sg13_lv_pmos L=0.13u W=0.42u AS=0.1428p
+ AD=0.0798p PS=1.52u PD=0.8u rfmode=0
M$44238 VDD|in|pad|pin1|pin2|supply|vdd \$1528 \$1439
+ VDD|in|pad|pin1|pin2|supply|vdd sg13_lv_pmos L=0.13u W=0.42u AS=0.3623875p
+ AD=0.0798p PS=2.605u PD=0.8u rfmode=0
M$44239 VDD|in|pad|pin1|pin2|supply|vdd \$1638 \$1440
+ VDD|in|pad|pin1|pin2|supply|vdd sg13_lv_pmos L=0.13u W=1u AS=0.3623875p
+ AD=0.34p PS=2.605u PD=2.68u rfmode=0
M$44240 \$1639 \$1441 VDD|in|pad|pin1|pin2|supply|vdd
+ VDD|in|pad|pin1|pin2|supply|vdd sg13_lv_pmos L=0.13u W=1.12u AS=0.3864p
+ AD=0.41165p PS=2.93u PD=2.12u rfmode=0
M$44241 VDD|in|pad|pin1|pin2|supply|vdd \$1311 \$1441
+ VDD|in|pad|pin1|pin2|supply|vdd sg13_lv_pmos L=0.13u W=1.12u AS=0.41165p
+ AD=0.4088p PS=2.12u PD=2.97u rfmode=0
M$44242 \$1532 \$1639 \$1644 VDD|in|pad|pin1|pin2|supply|vdd sg13_lv_pmos
+ L=0.13u W=0.42u AS=0.2048p AD=0.09345p PS=1.63u PD=0.865u rfmode=0
M$44243 \$1644 \$1443 VDD|in|pad|pin1|pin2|supply|vdd
+ VDD|in|pad|pin1|pin2|supply|vdd sg13_lv_pmos L=0.13u W=0.42u AS=0.09345p
+ AD=0.204p PS=0.865u PD=1.835u rfmode=0
M$44244 VDD|in|pad|pin1|pin2|supply|vdd \$1528 \$1443
+ VDD|in|pad|pin1|pin2|supply|vdd sg13_lv_pmos L=0.13u W=0.42u AS=0.204p
+ AD=0.0798p PS=1.835u PD=0.8u rfmode=0
M$44245 \$1443 \$1532 VDD|in|pad|pin1|pin2|supply|vdd
+ VDD|in|pad|pin1|pin2|supply|vdd sg13_lv_pmos L=0.13u W=0.42u AS=0.0798p
+ AD=0.4659p PS=0.8u PD=3.65u rfmode=0
M$44246 \$1440 \$1441 \$1532 VDD|in|pad|pin1|pin2|supply|vdd sg13_lv_pmos
+ L=0.13u W=1u AS=0.34p AD=0.2048p PS=2.68u PD=1.63u rfmode=0
M$44247 \$1444 \$1532 VDD|in|pad|pin1|pin2|supply|vdd
+ VDD|in|pad|pin1|pin2|supply|vdd sg13_lv_pmos L=0.13u W=1.12u AS=0.3864p
+ AD=0.2128p PS=2.93u PD=1.5u rfmode=0
M$44248 VDD|in|pad|pin1|pin2|supply|vdd \$1444 \$1445
+ VDD|in|pad|pin1|pin2|supply|vdd sg13_lv_pmos L=0.13u W=1.12u AS=0.2128p
+ AD=0.3808p PS=1.5u PD=2.92u rfmode=0
M$44297 \$1622 clk_comp \$1289 \$1288 sg13_lv_pmos L=0.3u W=18u AS=4.095p
+ AD=4.095p PS=24.32u PD=24.32u rfmode=0
M$44313 VDD|in|pad|pin1|pin2|supply|vdd \$1188 \$1705
+ VDD|in|pad|pin1|pin2|supply|vdd sg13_lv_pmos L=0.13u W=0.84u AS=0.2114p
+ AD=0.2856p PS=1.54u PD=2.36u rfmode=0
M$44314 dout[0] \$1705 VDD|in|pad|pin1|pin2|supply|vdd
+ VDD|in|pad|pin1|pin2|supply|vdd sg13_lv_pmos L=0.13u W=1.12u AS=0.42p
+ AD=0.2114p PS=2.99u PD=1.54u rfmode=0
M$44340 VDD|in|pad|pin1|pin2|supply|vdd \$1764 \$1707
+ VDD|in|pad|pin1|pin2|supply|vdd sg13_lv_pmos L=0.13u W=0.84u AS=0.2114p
+ AD=0.2856p PS=1.54u PD=2.36u rfmode=0
M$44341 En|dout[1] \$1707 VDD|in|pad|pin1|pin2|supply|vdd
+ VDD|in|pad|pin1|pin2|supply|vdd sg13_lv_pmos L=0.13u W=1.12u AS=0.42p
+ AD=0.2114p PS=2.99u PD=1.54u rfmode=0
M$44367 VDD|in|pad|pin1|pin2|supply|vdd \$1765 \$1709
+ VDD|in|pad|pin1|pin2|supply|vdd sg13_lv_pmos L=0.13u W=0.84u AS=0.2114p
+ AD=0.2856p PS=1.54u PD=2.36u rfmode=0
M$44368 X1|dout[2] \$1709 VDD|in|pad|pin1|pin2|supply|vdd
+ VDD|in|pad|pin1|pin2|supply|vdd sg13_lv_pmos L=0.13u W=1.12u AS=0.42p
+ AD=0.2114p PS=2.99u PD=1.54u rfmode=0
M$44386 VDD|in|pad|pin1|pin2|supply|vdd \$1447 \$1766
+ VDD|in|pad|pin1|pin2|supply|vdd sg13_lv_pmos L=0.13u W=0.42u AS=0.1428p
+ AD=0.0798p PS=1.52u PD=0.8u rfmode=0
M$44387 VDD|in|pad|pin1|pin2|supply|vdd \$1446 \$1766
+ VDD|in|pad|pin1|pin2|supply|vdd sg13_lv_pmos L=0.13u W=0.42u AS=0.3623875p
+ AD=0.0798p PS=2.605u PD=0.8u rfmode=0
M$44388 VDD|in|pad|pin1|pin2|supply|vdd \$1768 \$1767
+ VDD|in|pad|pin1|pin2|supply|vdd sg13_lv_pmos L=0.13u W=1u AS=0.3623875p
+ AD=0.34p PS=2.605u PD=2.68u rfmode=0
M$44389 VDD|in|pad|pin1|pin2|supply|vdd \$1770 \$1769
+ VDD|in|pad|pin1|pin2|supply|vdd sg13_lv_pmos L=0.13u W=1.12u AS=0.41165p
+ AD=0.3864p PS=2.12u PD=2.93u rfmode=0
M$44390 VDD|in|pad|pin1|pin2|supply|vdd \$1725 \$1770
+ VDD|in|pad|pin1|pin2|supply|vdd sg13_lv_pmos L=0.13u W=1.12u AS=0.41165p
+ AD=0.4088p PS=2.12u PD=2.97u rfmode=0
M$44391 \$1767 \$1770 \$1842 VDD|in|pad|pin1|pin2|supply|vdd sg13_lv_pmos
+ L=0.13u W=1u AS=0.34p AD=0.2048p PS=2.68u PD=1.63u rfmode=0
M$44392 \$1842 \$1769 \$1861 VDD|in|pad|pin1|pin2|supply|vdd sg13_lv_pmos
+ L=0.13u W=0.42u AS=0.2048p AD=0.09345p PS=1.63u PD=0.865u rfmode=0
M$44393 VDD|in|pad|pin1|pin2|supply|vdd \$1771 \$1861
+ VDD|in|pad|pin1|pin2|supply|vdd sg13_lv_pmos L=0.13u W=0.42u AS=0.204p
+ AD=0.09345p PS=1.835u PD=0.865u rfmode=0
M$44394 VDD|in|pad|pin1|pin2|supply|vdd \$1446 \$1771
+ VDD|in|pad|pin1|pin2|supply|vdd sg13_lv_pmos L=0.13u W=0.42u AS=0.204p
+ AD=0.0798p PS=1.835u PD=0.8u rfmode=0
M$44395 VDD|in|pad|pin1|pin2|supply|vdd \$1842 \$1771
+ VDD|in|pad|pin1|pin2|supply|vdd sg13_lv_pmos L=0.13u W=0.42u AS=0.4659p
+ AD=0.0798p PS=3.65u PD=0.8u rfmode=0
M$44396 \$1710 \$1842 VDD|in|pad|pin1|pin2|supply|vdd
+ VDD|in|pad|pin1|pin2|supply|vdd sg13_lv_pmos L=0.13u W=1.12u AS=0.3864p
+ AD=0.2128p PS=2.93u PD=1.5u rfmode=0
M$44397 VDD|in|pad|pin1|pin2|supply|vdd \$1710 \$1764
+ VDD|in|pad|pin1|pin2|supply|vdd sg13_lv_pmos L=0.13u W=1.12u AS=0.2128p
+ AD=0.3808p PS=1.5u PD=2.92u rfmode=0
M$44398 VDD|in|pad|pin1|pin2|supply|vdd \$1772 \$1712
+ VDD|in|pad|pin1|pin2|supply|vdd sg13_lv_pmos L=0.13u W=0.84u AS=0.2114p
+ AD=0.2856p PS=1.54u PD=2.36u rfmode=0
M$44399 X2|dout[3] \$1712 VDD|in|pad|pin1|pin2|supply|vdd
+ VDD|in|pad|pin1|pin2|supply|vdd sg13_lv_pmos L=0.13u W=1.12u AS=0.42p
+ AD=0.2114p PS=2.99u PD=1.54u rfmode=0
M$44400 VDD|in|pad|pin1|pin2|supply|vdd \$1452 \$1773
+ VDD|in|pad|pin1|pin2|supply|vdd sg13_lv_pmos L=0.13u W=0.42u AS=0.1523p
+ AD=0.1428p PS=1.38u PD=1.52u rfmode=0
M$44401 VDD|in|pad|pin1|pin2|supply|vdd \$1773 \$1713
+ VDD|in|pad|pin1|pin2|supply|vdd sg13_lv_pmos L=0.5u W=1u AS=0.1523p AD=0.34p
+ PS=1.38u PD=2.68u rfmode=0
M$44402 VDD|in|pad|pin1|pin2|supply|vdd \$1713 \$1714
+ VDD|in|pad|pin1|pin2|supply|vdd sg13_lv_pmos L=0.5u W=1u AS=0.2254p AD=0.34p
+ PS=1.53u PD=2.68u rfmode=0
M$44403 VDD|in|pad|pin1|pin2|supply|vdd \$1714 \$1715
+ VDD|in|pad|pin1|pin2|supply|vdd sg13_lv_pmos L=0.13u W=1.12u AS=0.2254p
+ AD=0.4256p PS=1.53u PD=3u rfmode=0
M$44404 VDD|in|pad|pin1|pin2|supply|vdd \$1715 \$1774
+ VDD|in|pad|pin1|pin2|supply|vdd sg13_lv_pmos L=0.13u W=0.42u AS=0.1428p
+ AD=0.0798p PS=1.52u PD=0.8u rfmode=0
M$44405 VDD|in|pad|pin1|pin2|supply|vdd \$1454 \$1774
+ VDD|in|pad|pin1|pin2|supply|vdd sg13_lv_pmos L=0.13u W=0.42u AS=0.3623875p
+ AD=0.0798p PS=2.605u PD=0.8u rfmode=0
M$44406 VDD|in|pad|pin1|pin2|supply|vdd \$1776 \$1775
+ VDD|in|pad|pin1|pin2|supply|vdd sg13_lv_pmos L=0.13u W=1u AS=0.3623875p
+ AD=0.34p PS=2.605u PD=2.68u rfmode=0
M$44407 VDD|in|pad|pin1|pin2|supply|vdd \$1778 \$1777
+ VDD|in|pad|pin1|pin2|supply|vdd sg13_lv_pmos L=0.13u W=1.12u AS=0.41165p
+ AD=0.3864p PS=2.12u PD=2.93u rfmode=0
M$44408 VDD|in|pad|pin1|pin2|supply|vdd \$1725 \$1778
+ VDD|in|pad|pin1|pin2|supply|vdd sg13_lv_pmos L=0.13u W=1.12u AS=0.41165p
+ AD=0.4088p PS=2.12u PD=2.97u rfmode=0
M$44409 \$1775 \$1778 \$1844 VDD|in|pad|pin1|pin2|supply|vdd sg13_lv_pmos
+ L=0.13u W=1u AS=0.34p AD=0.2048p PS=2.68u PD=1.63u rfmode=0
M$44410 \$1844 \$1777 \$1862 VDD|in|pad|pin1|pin2|supply|vdd sg13_lv_pmos
+ L=0.13u W=0.42u AS=0.2048p AD=0.09345p PS=1.63u PD=0.865u rfmode=0
M$44411 VDD|in|pad|pin1|pin2|supply|vdd \$1779 \$1862
+ VDD|in|pad|pin1|pin2|supply|vdd sg13_lv_pmos L=0.13u W=0.42u AS=0.204p
+ AD=0.09345p PS=1.835u PD=0.865u rfmode=0
M$44412 VDD|in|pad|pin1|pin2|supply|vdd \$1454 \$1779
+ VDD|in|pad|pin1|pin2|supply|vdd sg13_lv_pmos L=0.13u W=0.42u AS=0.204p
+ AD=0.0798p PS=1.835u PD=0.8u rfmode=0
M$44413 VDD|in|pad|pin1|pin2|supply|vdd \$1844 \$1779
+ VDD|in|pad|pin1|pin2|supply|vdd sg13_lv_pmos L=0.13u W=0.42u AS=0.4659p
+ AD=0.0798p PS=3.65u PD=0.8u rfmode=0
M$44414 \$1716 \$1844 VDD|in|pad|pin1|pin2|supply|vdd
+ VDD|in|pad|pin1|pin2|supply|vdd sg13_lv_pmos L=0.13u W=1.12u AS=0.3864p
+ AD=0.2128p PS=2.93u PD=1.5u rfmode=0
M$44415 VDD|in|pad|pin1|pin2|supply|vdd \$1716 \$1765
+ VDD|in|pad|pin1|pin2|supply|vdd sg13_lv_pmos L=0.13u W=1.12u AS=0.2128p
+ AD=0.3808p PS=1.5u PD=2.92u rfmode=0
M$44420 \$1772 \$1717 VDD|in|pad|pin1|pin2|supply|vdd
+ VDD|in|pad|pin1|pin2|supply|vdd sg13_lv_pmos L=0.13u W=1.12u AS=0.3808p
+ AD=0.2128p PS=2.92u PD=1.5u rfmode=0
M$44421 VDD|in|pad|pin1|pin2|supply|vdd \$1845 \$1717
+ VDD|in|pad|pin1|pin2|supply|vdd sg13_lv_pmos L=0.13u W=1.12u AS=0.2128p
+ AD=0.3864p PS=1.5u PD=2.93u rfmode=0
M$44422 VDD|in|pad|pin1|pin2|supply|vdd \$1725 \$1782
+ VDD|in|pad|pin1|pin2|supply|vdd sg13_lv_pmos L=0.13u W=1.12u AS=0.41165p
+ AD=0.4088p PS=2.12u PD=2.97u rfmode=0
M$44423 VDD|in|pad|pin1|pin2|supply|vdd \$1782 \$1781
+ VDD|in|pad|pin1|pin2|supply|vdd sg13_lv_pmos L=0.13u W=1.12u AS=0.41165p
+ AD=0.3864p PS=2.12u PD=2.93u rfmode=0
M$44424 VDD|in|pad|pin1|pin2|supply|vdd \$1783 \$1847
+ VDD|in|pad|pin1|pin2|supply|vdd sg13_lv_pmos L=0.13u W=1u AS=0.3623875p
+ AD=0.34p PS=2.605u PD=2.68u rfmode=0
M$44425 VDD|in|pad|pin1|pin2|supply|vdd \$1197 \$1718
+ VDD|in|pad|pin1|pin2|supply|vdd sg13_lv_pmos L=0.13u W=0.42u AS=0.3623875p
+ AD=0.0798p PS=2.605u PD=0.8u rfmode=0
M$44426 \$1718 \$1463 VDD|in|pad|pin1|pin2|supply|vdd
+ VDD|in|pad|pin1|pin2|supply|vdd sg13_lv_pmos L=0.13u W=0.42u AS=0.0798p
+ AD=0.1428p PS=0.8u PD=1.52u rfmode=0
M$44427 \$1719 \$1784 VDD|in|pad|pin1|pin2|supply|vdd
+ VDD|in|pad|pin1|pin2|supply|vdd sg13_lv_pmos L=0.13u W=0.84u AS=0.2856p
+ AD=0.2114p PS=2.36u PD=1.54u rfmode=0
M$44428 VDD|in|pad|pin1|pin2|supply|vdd \$1719 X3|dout[4]
+ VDD|in|pad|pin1|pin2|supply|vdd sg13_lv_pmos L=0.13u W=1.12u AS=0.2114p
+ AD=0.42p PS=1.54u PD=2.99u rfmode=0
M$44429 VDD|in|pad|pin1|pin2|supply|vdd \$1784 \$1785
+ VDD|in|pad|pin1|pin2|supply|vdd sg13_lv_pmos L=0.13u W=0.42u AS=0.1523p
+ AD=0.1428p PS=1.38u PD=1.52u rfmode=0
M$44430 VDD|in|pad|pin1|pin2|supply|vdd \$1785 \$1721
+ VDD|in|pad|pin1|pin2|supply|vdd sg13_lv_pmos L=0.5u W=1u AS=0.1523p AD=0.34p
+ PS=1.38u PD=2.68u rfmode=0
M$44431 VDD|in|pad|pin1|pin2|supply|vdd \$1721 \$1722
+ VDD|in|pad|pin1|pin2|supply|vdd sg13_lv_pmos L=0.5u W=1u AS=0.2254p AD=0.34p
+ PS=1.53u PD=2.68u rfmode=0
M$44432 VDD|in|pad|pin1|pin2|supply|vdd \$1722 \$1297
+ VDD|in|pad|pin1|pin2|supply|vdd sg13_lv_pmos L=0.13u W=1.12u AS=0.2254p
+ AD=0.4256p PS=1.53u PD=3u rfmode=0
M$44433 \$1784 \$1723 VDD|in|pad|pin1|pin2|supply|vdd
+ VDD|in|pad|pin1|pin2|supply|vdd sg13_lv_pmos L=0.13u W=1.12u AS=0.3808p
+ AD=0.2128p PS=2.92u PD=1.5u rfmode=0
M$44434 VDD|in|pad|pin1|pin2|supply|vdd \$1848 \$1723
+ VDD|in|pad|pin1|pin2|supply|vdd sg13_lv_pmos L=0.13u W=1.12u AS=0.2128p
+ AD=0.3864p PS=1.5u PD=2.93u rfmode=0
M$44435 VDD|in|pad|pin1|pin2|supply|vdd \$1725 \$1788
+ VDD|in|pad|pin1|pin2|supply|vdd sg13_lv_pmos L=0.13u W=1.12u AS=0.41165p
+ AD=0.4088p PS=2.12u PD=2.97u rfmode=0
M$44436 VDD|in|pad|pin1|pin2|supply|vdd \$1788 \$1787
+ VDD|in|pad|pin1|pin2|supply|vdd sg13_lv_pmos L=0.13u W=1.12u AS=0.41165p
+ AD=0.3864p PS=2.12u PD=2.93u rfmode=0
M$44437 \$1623 \$1469 VDD|in|pad|pin1|pin2|supply|vdd
+ VDD|in|pad|pin1|pin2|supply|vdd sg13_lv_pmos L=0.13u W=0.42u AS=0.147p
+ AD=0.1563p PS=1.54u PD=1.22u rfmode=0
M$44438 VDD|in|pad|pin1|pin2|supply|vdd \$1385 \$1662
+ VDD|in|pad|pin1|pin2|supply|vdd sg13_lv_pmos L=0.13u W=0.42u AS=0.1563p
+ AD=0.063p PS=1.22u PD=0.72u rfmode=0
M$44439 \$1662 \$1386 \$1623 VDD|in|pad|pin1|pin2|supply|vdd sg13_lv_pmos
+ L=0.13u W=0.42u AS=0.063p AD=0.0798p PS=0.72u PD=0.8u rfmode=0
M$44440 \$1623 \$1624 \$1384 VDD|in|pad|pin1|pin2|supply|vdd sg13_lv_pmos
+ L=0.13u W=0.42u AS=0.0798p AD=0.1428p PS=0.8u PD=1.52u rfmode=0
M$44441 VDD|in|pad|pin1|pin2|supply|vdd \$1789 \$1850
+ VDD|in|pad|pin1|pin2|supply|vdd sg13_lv_pmos L=0.13u W=1u AS=0.3623875p
+ AD=0.34p PS=2.605u PD=2.68u rfmode=0
M$44442 VDD|in|pad|pin1|pin2|supply|vdd \$1468 \$1724
+ VDD|in|pad|pin1|pin2|supply|vdd sg13_lv_pmos L=0.13u W=0.42u AS=0.3623875p
+ AD=0.0798p PS=2.605u PD=0.8u rfmode=0
M$44443 \$1724 \$1110 VDD|in|pad|pin1|pin2|supply|vdd
+ VDD|in|pad|pin1|pin2|supply|vdd sg13_lv_pmos L=0.13u W=0.42u AS=0.0798p
+ AD=0.1428p PS=0.8u PD=1.52u rfmode=0
M$44444 VDD|in|pad|pin1|pin2|supply|vdd \$1726 \$1725
+ VDD|in|pad|pin1|pin2|supply|vdd sg13_lv_pmos L=0.13u W=17.92u AS=3.5896p
+ AD=3.4048p PS=25.45u PD=24u rfmode=0
M$44460 VDD|in|pad|pin1|pin2|supply|vdd \$1215 \$1726
+ VDD|in|pad|pin1|pin2|supply|vdd sg13_lv_pmos L=0.13u W=6.72u AS=1.2768p
+ AD=1.4448p PS=9u PD=10.42u rfmode=0
M$44466 \$1625 \$1472 VDD|in|pad|pin1|pin2|supply|vdd
+ VDD|in|pad|pin1|pin2|supply|vdd sg13_lv_pmos L=0.13u W=0.42u AS=0.147p
+ AD=0.1563p PS=1.54u PD=1.22u rfmode=0
M$44467 VDD|in|pad|pin1|pin2|supply|vdd \$1391 \$1672
+ VDD|in|pad|pin1|pin2|supply|vdd sg13_lv_pmos L=0.13u W=0.42u AS=0.1563p
+ AD=0.063p PS=1.22u PD=0.72u rfmode=0
M$44468 \$1672 \$1392 \$1625 VDD|in|pad|pin1|pin2|supply|vdd sg13_lv_pmos
+ L=0.13u W=0.42u AS=0.063p AD=0.0798p PS=0.72u PD=0.8u rfmode=0
M$44469 \$1625 \$1626 \$1390 VDD|in|pad|pin1|pin2|supply|vdd sg13_lv_pmos
+ L=0.13u W=0.42u AS=0.0798p AD=0.1428p PS=0.8u PD=1.52u rfmode=0
M$44474 VDD|in|pad|pin1|pin2|supply|vdd \$1476 \$1790
+ VDD|in|pad|pin1|pin2|supply|vdd sg13_lv_pmos L=0.13u W=0.42u AS=0.1523p
+ AD=0.1428p PS=1.38u PD=1.52u rfmode=0
M$44475 VDD|in|pad|pin1|pin2|supply|vdd \$1790 \$1727
+ VDD|in|pad|pin1|pin2|supply|vdd sg13_lv_pmos L=0.5u W=1u AS=0.1523p AD=0.34p
+ PS=1.38u PD=2.68u rfmode=0
M$44476 VDD|in|pad|pin1|pin2|supply|vdd \$1727 \$1728
+ VDD|in|pad|pin1|pin2|supply|vdd sg13_lv_pmos L=0.5u W=1u AS=0.2254p AD=0.34p
+ PS=1.53u PD=2.68u rfmode=0
M$44477 VDD|in|pad|pin1|pin2|supply|vdd \$1728 \$1729
+ VDD|in|pad|pin1|pin2|supply|vdd sg13_lv_pmos L=0.13u W=1.12u AS=0.2254p
+ AD=0.4256p PS=1.53u PD=3u rfmode=0
M$44478 VDD|in|pad|pin1|pin2|supply|vdd \$1729 \$1791
+ VDD|in|pad|pin1|pin2|supply|vdd sg13_lv_pmos L=0.13u W=0.42u AS=0.1428p
+ AD=0.0798p PS=1.52u PD=0.8u rfmode=0
M$44479 VDD|in|pad|pin1|pin2|supply|vdd \$1475 \$1791
+ VDD|in|pad|pin1|pin2|supply|vdd sg13_lv_pmos L=0.13u W=0.42u AS=0.3623875p
+ AD=0.0798p PS=2.605u PD=0.8u rfmode=0
M$44480 VDD|in|pad|pin1|pin2|supply|vdd \$1793 \$1792
+ VDD|in|pad|pin1|pin2|supply|vdd sg13_lv_pmos L=0.13u W=1u AS=0.3623875p
+ AD=0.34p PS=2.605u PD=2.68u rfmode=0
M$44481 VDD|in|pad|pin1|pin2|supply|vdd \$1795 \$1794
+ VDD|in|pad|pin1|pin2|supply|vdd sg13_lv_pmos L=0.13u W=1.12u AS=0.41165p
+ AD=0.3864p PS=2.12u PD=2.93u rfmode=0
M$44482 VDD|in|pad|pin1|pin2|supply|vdd \$1725 \$1795
+ VDD|in|pad|pin1|pin2|supply|vdd sg13_lv_pmos L=0.13u W=1.12u AS=0.41165p
+ AD=0.4088p PS=2.12u PD=2.97u rfmode=0
M$44483 \$1792 \$1795 \$1852 VDD|in|pad|pin1|pin2|supply|vdd sg13_lv_pmos
+ L=0.13u W=1u AS=0.34p AD=0.2048p PS=2.68u PD=1.63u rfmode=0
M$44484 \$1852 \$1794 \$1866 VDD|in|pad|pin1|pin2|supply|vdd sg13_lv_pmos
+ L=0.13u W=0.42u AS=0.2048p AD=0.09345p PS=1.63u PD=0.865u rfmode=0
M$44485 VDD|in|pad|pin1|pin2|supply|vdd \$1796 \$1866
+ VDD|in|pad|pin1|pin2|supply|vdd sg13_lv_pmos L=0.13u W=0.42u AS=0.204p
+ AD=0.09345p PS=1.835u PD=0.865u rfmode=0
M$44486 VDD|in|pad|pin1|pin2|supply|vdd \$1475 \$1796
+ VDD|in|pad|pin1|pin2|supply|vdd sg13_lv_pmos L=0.13u W=0.42u AS=0.204p
+ AD=0.0798p PS=1.835u PD=0.8u rfmode=0
M$44487 VDD|in|pad|pin1|pin2|supply|vdd \$1852 \$1796
+ VDD|in|pad|pin1|pin2|supply|vdd sg13_lv_pmos L=0.13u W=0.42u AS=0.4659p
+ AD=0.0798p PS=3.65u PD=0.8u rfmode=0
M$44488 \$1730 \$1852 VDD|in|pad|pin1|pin2|supply|vdd
+ VDD|in|pad|pin1|pin2|supply|vdd sg13_lv_pmos L=0.13u W=1.12u AS=0.3864p
+ AD=0.2128p PS=2.93u PD=1.5u rfmode=0
M$44489 VDD|in|pad|pin1|pin2|supply|vdd \$1730 \$1300
+ VDD|in|pad|pin1|pin2|supply|vdd sg13_lv_pmos L=0.13u W=1.12u AS=0.2128p
+ AD=0.3808p PS=1.5u PD=2.92u rfmode=0
M$44490 \$1591 \$1731 VDD|in|pad|pin1|pin2|supply|vdd
+ VDD|in|pad|pin1|pin2|supply|vdd sg13_lv_pmos L=0.13u W=1.12u AS=0.4256p
+ AD=0.2254p PS=3u PD=1.53u rfmode=0
M$44491 VDD|in|pad|pin1|pin2|supply|vdd \$1732 \$1731
+ VDD|in|pad|pin1|pin2|supply|vdd sg13_lv_pmos L=0.5u W=1u AS=0.2254p AD=0.34p
+ PS=1.53u PD=2.68u rfmode=0
M$44492 VDD|in|pad|pin1|pin2|supply|vdd \$1300 \$1797
+ VDD|in|pad|pin1|pin2|supply|vdd sg13_lv_pmos L=0.13u W=0.42u AS=0.1523p
+ AD=0.1428p PS=1.38u PD=1.52u rfmode=0
M$44493 \$1732 \$1797 VDD|in|pad|pin1|pin2|supply|vdd
+ VDD|in|pad|pin1|pin2|supply|vdd sg13_lv_pmos L=0.5u W=1u AS=0.34p AD=0.1523p
+ PS=2.68u PD=1.38u rfmode=0
M$44496 \$1627 \$1209 VDD|in|pad|pin1|pin2|supply|vdd
+ VDD|in|pad|pin1|pin2|supply|vdd sg13_lv_pmos L=0.13u W=0.42u AS=0.147p
+ AD=0.1563p PS=1.54u PD=1.22u rfmode=0
M$44497 VDD|in|pad|pin1|pin2|supply|vdd \$1399 \$1683
+ VDD|in|pad|pin1|pin2|supply|vdd sg13_lv_pmos L=0.13u W=0.42u AS=0.1563p
+ AD=0.063p PS=1.22u PD=0.72u rfmode=0
M$44498 \$1683 \$1400 \$1627 VDD|in|pad|pin1|pin2|supply|vdd sg13_lv_pmos
+ L=0.13u W=0.42u AS=0.063p AD=0.0798p PS=0.72u PD=0.8u rfmode=0
M$44499 \$1627 \$1628 \$1398 VDD|in|pad|pin1|pin2|supply|vdd sg13_lv_pmos
+ L=0.13u W=0.42u AS=0.0798p AD=0.1428p PS=0.8u PD=1.52u rfmode=0
M$44509 VDD|in|pad|pin1|pin2|supply|vdd \$1486 \$1798
+ VDD|in|pad|pin1|pin2|supply|vdd sg13_lv_pmos L=0.13u W=0.42u AS=0.1523p
+ AD=0.1428p PS=1.38u PD=1.52u rfmode=0
M$44510 VDD|in|pad|pin1|pin2|supply|vdd \$1798 \$1733
+ VDD|in|pad|pin1|pin2|supply|vdd sg13_lv_pmos L=0.5u W=1u AS=0.1523p AD=0.34p
+ PS=1.38u PD=2.68u rfmode=0
M$44511 VDD|in|pad|pin1|pin2|supply|vdd \$1733 \$1734
+ VDD|in|pad|pin1|pin2|supply|vdd sg13_lv_pmos L=0.5u W=1u AS=0.2254p AD=0.34p
+ PS=1.53u PD=2.68u rfmode=0
M$44512 VDD|in|pad|pin1|pin2|supply|vdd \$1734 \$1735
+ VDD|in|pad|pin1|pin2|supply|vdd sg13_lv_pmos L=0.13u W=1.12u AS=0.2254p
+ AD=0.4256p PS=1.53u PD=3u rfmode=0
M$44513 VDD|in|pad|pin1|pin2|supply|vdd \$1735 \$1799
+ VDD|in|pad|pin1|pin2|supply|vdd sg13_lv_pmos L=0.13u W=0.42u AS=0.1428p
+ AD=0.0798p PS=1.52u PD=0.8u rfmode=0
M$44514 VDD|in|pad|pin1|pin2|supply|vdd \$1484 \$1799
+ VDD|in|pad|pin1|pin2|supply|vdd sg13_lv_pmos L=0.13u W=0.42u AS=0.3623875p
+ AD=0.0798p PS=2.605u PD=0.8u rfmode=0
M$44515 VDD|in|pad|pin1|pin2|supply|vdd \$1801 \$1800
+ VDD|in|pad|pin1|pin2|supply|vdd sg13_lv_pmos L=0.13u W=1u AS=0.3623875p
+ AD=0.34p PS=2.605u PD=2.68u rfmode=0
M$44516 VDD|in|pad|pin1|pin2|supply|vdd \$1803 \$1802
+ VDD|in|pad|pin1|pin2|supply|vdd sg13_lv_pmos L=0.13u W=1.12u AS=0.41165p
+ AD=0.3864p PS=2.12u PD=2.93u rfmode=0
M$44517 VDD|in|pad|pin1|pin2|supply|vdd \$1592 \$1803
+ VDD|in|pad|pin1|pin2|supply|vdd sg13_lv_pmos L=0.13u W=1.12u AS=0.41165p
+ AD=0.4088p PS=2.12u PD=2.97u rfmode=0
M$44518 \$1800 \$1803 \$1854 VDD|in|pad|pin1|pin2|supply|vdd sg13_lv_pmos
+ L=0.13u W=1u AS=0.34p AD=0.2048p PS=2.68u PD=1.63u rfmode=0
M$44519 \$1854 \$1802 \$1868 VDD|in|pad|pin1|pin2|supply|vdd sg13_lv_pmos
+ L=0.13u W=0.42u AS=0.2048p AD=0.09345p PS=1.63u PD=0.865u rfmode=0
M$44520 VDD|in|pad|pin1|pin2|supply|vdd \$1804 \$1868
+ VDD|in|pad|pin1|pin2|supply|vdd sg13_lv_pmos L=0.13u W=0.42u AS=0.204p
+ AD=0.09345p PS=1.835u PD=0.865u rfmode=0
M$44521 VDD|in|pad|pin1|pin2|supply|vdd \$1484 \$1804
+ VDD|in|pad|pin1|pin2|supply|vdd sg13_lv_pmos L=0.13u W=0.42u AS=0.204p
+ AD=0.0798p PS=1.835u PD=0.8u rfmode=0
M$44522 VDD|in|pad|pin1|pin2|supply|vdd \$1854 \$1804
+ VDD|in|pad|pin1|pin2|supply|vdd sg13_lv_pmos L=0.13u W=0.42u AS=0.4659p
+ AD=0.0798p PS=3.65u PD=0.8u rfmode=0
M$44523 \$1736 \$1854 VDD|in|pad|pin1|pin2|supply|vdd
+ VDD|in|pad|pin1|pin2|supply|vdd sg13_lv_pmos L=0.13u W=1.12u AS=0.3864p
+ AD=0.2128p PS=2.93u PD=1.5u rfmode=0
M$44524 VDD|in|pad|pin1|pin2|supply|vdd \$1736 \$1302
+ VDD|in|pad|pin1|pin2|supply|vdd sg13_lv_pmos L=0.13u W=1.12u AS=0.2128p
+ AD=0.3808p PS=1.5u PD=2.92u rfmode=0
M$44531 \$1629 \$1121 VDD|in|pad|pin1|pin2|supply|vdd
+ VDD|in|pad|pin1|pin2|supply|vdd sg13_lv_pmos L=0.13u W=0.42u AS=0.147p
+ AD=0.1563p PS=1.54u PD=1.22u rfmode=0
M$44532 VDD|in|pad|pin1|pin2|supply|vdd \$1408 \$1698
+ VDD|in|pad|pin1|pin2|supply|vdd sg13_lv_pmos L=0.13u W=0.42u AS=0.1563p
+ AD=0.063p PS=1.22u PD=0.72u rfmode=0
M$44533 \$1698 \$1409 \$1629 VDD|in|pad|pin1|pin2|supply|vdd sg13_lv_pmos
+ L=0.13u W=0.42u AS=0.063p AD=0.0798p PS=0.72u PD=0.8u rfmode=0
M$44534 \$1629 \$1630 \$1407 VDD|in|pad|pin1|pin2|supply|vdd sg13_lv_pmos
+ L=0.13u W=0.42u AS=0.0798p AD=0.1428p PS=0.8u PD=1.52u rfmode=0
M$44547 \$1597 \$1737 VDD|in|pad|pin1|pin2|supply|vdd
+ VDD|in|pad|pin1|pin2|supply|vdd sg13_lv_pmos L=0.13u W=1.12u AS=0.4256p
+ AD=0.2254p PS=3u PD=1.53u rfmode=0
M$44548 VDD|in|pad|pin1|pin2|supply|vdd \$1738 \$1737
+ VDD|in|pad|pin1|pin2|supply|vdd sg13_lv_pmos L=0.5u W=1u AS=0.2254p AD=0.34p
+ PS=1.53u PD=2.68u rfmode=0
M$44549 \$1631 \$1497 VDD|in|pad|pin1|pin2|supply|vdd
+ VDD|in|pad|pin1|pin2|supply|vdd sg13_lv_pmos L=0.13u W=0.42u AS=0.147p
+ AD=0.1563p PS=1.54u PD=1.22u rfmode=0
M$44550 VDD|in|pad|pin1|pin2|supply|vdd \$1414 \$1703
+ VDD|in|pad|pin1|pin2|supply|vdd sg13_lv_pmos L=0.13u W=0.42u AS=0.1563p
+ AD=0.063p PS=1.22u PD=0.72u rfmode=0
M$44551 \$1703 \$1415 \$1631 VDD|in|pad|pin1|pin2|supply|vdd sg13_lv_pmos
+ L=0.13u W=0.42u AS=0.063p AD=0.0798p PS=0.72u PD=0.8u rfmode=0
M$44552 \$1631 \$1632 \$1413 VDD|in|pad|pin1|pin2|supply|vdd sg13_lv_pmos
+ L=0.13u W=0.42u AS=0.0798p AD=0.1428p PS=0.8u PD=1.52u rfmode=0
M$44553 VDD|in|pad|pin1|pin2|supply|vdd \$1216 \$1805
+ VDD|in|pad|pin1|pin2|supply|vdd sg13_lv_pmos L=0.13u W=0.42u AS=0.1523p
+ AD=0.1428p PS=1.38u PD=1.52u rfmode=0
M$44554 \$1738 \$1805 VDD|in|pad|pin1|pin2|supply|vdd
+ VDD|in|pad|pin1|pin2|supply|vdd sg13_lv_pmos L=0.5u W=1u AS=0.34p AD=0.1523p
+ PS=2.68u PD=1.38u rfmode=0
M$44556 VDD|in|pad|pin1|pin2|supply|vdd \$1304 \$1806
+ VDD|in|pad|pin1|pin2|supply|vdd sg13_lv_pmos L=0.13u W=0.42u AS=0.1523p
+ AD=0.1428p PS=1.38u PD=1.52u rfmode=0
M$44557 VDD|in|pad|pin1|pin2|supply|vdd \$1806 \$1739
+ VDD|in|pad|pin1|pin2|supply|vdd sg13_lv_pmos L=0.5u W=1u AS=0.1523p AD=0.34p
+ PS=1.38u PD=2.68u rfmode=0
M$44558 VDD|in|pad|pin1|pin2|supply|vdd \$1739 \$1740
+ VDD|in|pad|pin1|pin2|supply|vdd sg13_lv_pmos L=0.5u W=1u AS=0.2254p AD=0.34p
+ PS=1.53u PD=2.68u rfmode=0
M$44559 VDD|in|pad|pin1|pin2|supply|vdd \$1740 \$1596
+ VDD|in|pad|pin1|pin2|supply|vdd sg13_lv_pmos L=0.13u W=1.12u AS=0.2254p
+ AD=0.4256p PS=1.53u PD=3u rfmode=0
M$44560 VDD|in|pad|pin1|pin2|supply|vdd \$1306 \$1742
+ VDD|in|pad|pin1|pin2|supply|vdd sg13_lv_pmos L=0.13u W=0.84u AS=0.2114p
+ AD=0.2856p PS=1.54u PD=2.36u rfmode=0
M$44561 X6|dout[7] \$1742 VDD|in|pad|pin1|pin2|supply|vdd
+ VDD|in|pad|pin1|pin2|supply|vdd sg13_lv_pmos L=0.13u W=1.12u AS=0.42p
+ AD=0.2114p PS=2.99u PD=1.54u rfmode=0
M$44570 VDD|in|pad|pin1|pin2|supply|vdd \$1215 \$1743
+ VDD|in|pad|pin1|pin2|supply|vdd sg13_lv_pmos L=0.13u W=6.72u AS=1.4448p
+ AD=1.2768p PS=10.42u PD=9u rfmode=0
M$44576 VDD|in|pad|pin1|pin2|supply|vdd \$1743 \$1592
+ VDD|in|pad|pin1|pin2|supply|vdd sg13_lv_pmos L=0.13u W=17.92u AS=3.4048p
+ AD=3.5896p PS=24u PD=25.45u rfmode=0
M$44592 \$1633 \$1220 VDD|in|pad|pin1|pin2|supply|vdd
+ VDD|in|pad|pin1|pin2|supply|vdd sg13_lv_pmos L=0.13u W=0.42u AS=0.147p
+ AD=0.1563p PS=1.54u PD=1.22u rfmode=0
M$44593 VDD|in|pad|pin1|pin2|supply|vdd \$1421 \$1693
+ VDD|in|pad|pin1|pin2|supply|vdd sg13_lv_pmos L=0.13u W=0.42u AS=0.1563p
+ AD=0.063p PS=1.22u PD=0.72u rfmode=0
M$44594 \$1693 \$1422 \$1633 VDD|in|pad|pin1|pin2|supply|vdd sg13_lv_pmos
+ L=0.13u W=0.42u AS=0.063p AD=0.0798p PS=0.72u PD=0.8u rfmode=0
M$44595 \$1633 \$1634 \$1420 VDD|in|pad|pin1|pin2|supply|vdd sg13_lv_pmos
+ L=0.13u W=0.42u AS=0.0798p AD=0.1428p PS=0.8u PD=1.52u rfmode=0
M$44597 VDD|in|pad|pin1|pin2|supply|vdd \$1504 \$1807
+ VDD|in|pad|pin1|pin2|supply|vdd sg13_lv_pmos L=0.13u W=0.42u AS=0.1523p
+ AD=0.1428p PS=1.38u PD=1.52u rfmode=0
M$44598 VDD|in|pad|pin1|pin2|supply|vdd \$1807 \$1744
+ VDD|in|pad|pin1|pin2|supply|vdd sg13_lv_pmos L=0.5u W=1u AS=0.1523p AD=0.34p
+ PS=1.38u PD=2.68u rfmode=0
M$44599 VDD|in|pad|pin1|pin2|supply|vdd \$1744 \$1745
+ VDD|in|pad|pin1|pin2|supply|vdd sg13_lv_pmos L=0.5u W=1u AS=0.2254p AD=0.34p
+ PS=1.53u PD=2.68u rfmode=0
M$44600 VDD|in|pad|pin1|pin2|supply|vdd \$1745 \$1746
+ VDD|in|pad|pin1|pin2|supply|vdd sg13_lv_pmos L=0.13u W=1.12u AS=0.2254p
+ AD=0.4256p PS=1.53u PD=3u rfmode=0
M$44601 VDD|in|pad|pin1|pin2|supply|vdd \$1746 \$1808
+ VDD|in|pad|pin1|pin2|supply|vdd sg13_lv_pmos L=0.13u W=0.42u AS=0.1428p
+ AD=0.0798p PS=1.52u PD=0.8u rfmode=0
M$44602 VDD|in|pad|pin1|pin2|supply|vdd \$1506 \$1808
+ VDD|in|pad|pin1|pin2|supply|vdd sg13_lv_pmos L=0.13u W=0.42u AS=0.3623875p
+ AD=0.0798p PS=2.605u PD=0.8u rfmode=0
M$44603 VDD|in|pad|pin1|pin2|supply|vdd \$1810 \$1809
+ VDD|in|pad|pin1|pin2|supply|vdd sg13_lv_pmos L=0.13u W=1u AS=0.3623875p
+ AD=0.34p PS=2.605u PD=2.68u rfmode=0
M$44604 VDD|in|pad|pin1|pin2|supply|vdd \$1812 \$1811
+ VDD|in|pad|pin1|pin2|supply|vdd sg13_lv_pmos L=0.13u W=1.12u AS=0.41165p
+ AD=0.3864p PS=2.12u PD=2.93u rfmode=0
M$44605 VDD|in|pad|pin1|pin2|supply|vdd \$1592 \$1812
+ VDD|in|pad|pin1|pin2|supply|vdd sg13_lv_pmos L=0.13u W=1.12u AS=0.41165p
+ AD=0.4088p PS=2.12u PD=2.97u rfmode=0
M$44606 \$1809 \$1812 \$1856 VDD|in|pad|pin1|pin2|supply|vdd sg13_lv_pmos
+ L=0.13u W=1u AS=0.34p AD=0.2048p PS=2.68u PD=1.63u rfmode=0
M$44607 \$1856 \$1811 \$1869 VDD|in|pad|pin1|pin2|supply|vdd sg13_lv_pmos
+ L=0.13u W=0.42u AS=0.2048p AD=0.09345p PS=1.63u PD=0.865u rfmode=0
M$44608 VDD|in|pad|pin1|pin2|supply|vdd \$1813 \$1869
+ VDD|in|pad|pin1|pin2|supply|vdd sg13_lv_pmos L=0.13u W=0.42u AS=0.204p
+ AD=0.09345p PS=1.835u PD=0.865u rfmode=0
M$44609 VDD|in|pad|pin1|pin2|supply|vdd \$1506 \$1813
+ VDD|in|pad|pin1|pin2|supply|vdd sg13_lv_pmos L=0.13u W=0.42u AS=0.204p
+ AD=0.0798p PS=1.835u PD=0.8u rfmode=0
M$44610 VDD|in|pad|pin1|pin2|supply|vdd \$1856 \$1813
+ VDD|in|pad|pin1|pin2|supply|vdd sg13_lv_pmos L=0.13u W=0.42u AS=0.4659p
+ AD=0.0798p PS=3.65u PD=0.8u rfmode=0
M$44611 \$1747 \$1856 VDD|in|pad|pin1|pin2|supply|vdd
+ VDD|in|pad|pin1|pin2|supply|vdd sg13_lv_pmos L=0.13u W=1.12u AS=0.3864p
+ AD=0.2128p PS=2.93u PD=1.5u rfmode=0
M$44612 VDD|in|pad|pin1|pin2|supply|vdd \$1747 \$1635
+ VDD|in|pad|pin1|pin2|supply|vdd sg13_lv_pmos L=0.13u W=1.12u AS=0.2128p
+ AD=0.3808p PS=1.5u PD=2.92u rfmode=0
M$44613 \$1599 \$1748 VDD|in|pad|pin1|pin2|supply|vdd
+ VDD|in|pad|pin1|pin2|supply|vdd sg13_lv_pmos L=0.13u W=1.12u AS=0.4256p
+ AD=0.2254p PS=3u PD=1.53u rfmode=0
M$44614 VDD|in|pad|pin1|pin2|supply|vdd \$1749 \$1748
+ VDD|in|pad|pin1|pin2|supply|vdd sg13_lv_pmos L=0.5u W=1u AS=0.2254p AD=0.34p
+ PS=1.53u PD=2.68u rfmode=0
M$44615 VDD|in|pad|pin1|pin2|supply|vdd \$1635 \$1814
+ VDD|in|pad|pin1|pin2|supply|vdd sg13_lv_pmos L=0.13u W=0.42u AS=0.1523p
+ AD=0.1428p PS=1.38u PD=1.52u rfmode=0
M$44616 \$1749 \$1814 VDD|in|pad|pin1|pin2|supply|vdd
+ VDD|in|pad|pin1|pin2|supply|vdd sg13_lv_pmos L=0.5u W=1u AS=0.34p AD=0.1523p
+ PS=2.68u PD=1.38u rfmode=0
M$44617 VDD|in|pad|pin1|pin2|supply|vdd \$1215 \$1750
+ VDD|in|pad|pin1|pin2|supply|vdd sg13_lv_pmos L=0.13u W=6.72u AS=1.4448p
+ AD=1.2768p PS=10.42u PD=9u rfmode=0
M$44623 VDD|in|pad|pin1|pin2|supply|vdd \$1750 \$1311
+ VDD|in|pad|pin1|pin2|supply|vdd sg13_lv_pmos L=0.13u W=17.92u AS=3.4048p
+ AD=3.5896p PS=24u PD=25.45u rfmode=0
M$44639 \$1636 \$1221 VDD|in|pad|pin1|pin2|supply|vdd
+ VDD|in|pad|pin1|pin2|supply|vdd sg13_lv_pmos L=0.13u W=0.42u AS=0.147p
+ AD=0.1563p PS=1.54u PD=1.22u rfmode=0
M$44640 VDD|in|pad|pin1|pin2|supply|vdd \$1431 \$1674
+ VDD|in|pad|pin1|pin2|supply|vdd sg13_lv_pmos L=0.13u W=0.42u AS=0.1563p
+ AD=0.063p PS=1.22u PD=0.72u rfmode=0
M$44641 \$1674 \$1432 \$1636 VDD|in|pad|pin1|pin2|supply|vdd sg13_lv_pmos
+ L=0.13u W=0.42u AS=0.063p AD=0.0798p PS=0.72u PD=0.8u rfmode=0
M$44642 \$1636 \$1637 \$1430 VDD|in|pad|pin1|pin2|supply|vdd sg13_lv_pmos
+ L=0.13u W=0.42u AS=0.0798p AD=0.1428p PS=0.8u PD=1.52u rfmode=0
M$44643 VDD|in|pad|pin1|pin2|supply|vdd \$1061 \$1751
+ VDD|in|pad|pin1|pin2|supply|vdd sg13_lv_pmos L=0.13u W=0.84u AS=0.2114p
+ AD=0.2856p PS=1.54u PD=2.36u rfmode=0
M$44644 \$1352 \$1751 VDD|in|pad|pin1|pin2|supply|vdd
+ VDD|in|pad|pin1|pin2|supply|vdd sg13_lv_pmos L=0.13u W=1.12u AS=0.42p
+ AD=0.2114p PS=2.99u PD=1.54u rfmode=0
M$44645 VDD|in|pad|pin1|pin2|supply|vdd \$1600 \$1815
+ VDD|in|pad|pin1|pin2|supply|vdd sg13_lv_pmos L=0.13u W=0.42u AS=0.1523p
+ AD=0.1428p PS=1.38u PD=1.52u rfmode=0
M$44646 VDD|in|pad|pin1|pin2|supply|vdd \$1815 \$1752
+ VDD|in|pad|pin1|pin2|supply|vdd sg13_lv_pmos L=0.5u W=1u AS=0.1523p AD=0.34p
+ PS=1.38u PD=2.68u rfmode=0
M$44647 VDD|in|pad|pin1|pin2|supply|vdd \$1752 \$1753
+ VDD|in|pad|pin1|pin2|supply|vdd sg13_lv_pmos L=0.5u W=1u AS=0.2254p AD=0.34p
+ PS=1.53u PD=2.68u rfmode=0
M$44648 VDD|in|pad|pin1|pin2|supply|vdd \$1753 \$1308
+ VDD|in|pad|pin1|pin2|supply|vdd sg13_lv_pmos L=0.13u W=1.12u AS=0.2254p
+ AD=0.4256p PS=1.53u PD=3u rfmode=0
M$44649 VDD|in|pad|pin1|pin2|supply|vdd \$1516 \$1816
+ VDD|in|pad|pin1|pin2|supply|vdd sg13_lv_pmos L=0.13u W=0.42u AS=0.1428p
+ AD=0.0798p PS=1.52u PD=0.8u rfmode=0
M$44650 VDD|in|pad|pin1|pin2|supply|vdd \$1522 \$1816
+ VDD|in|pad|pin1|pin2|supply|vdd sg13_lv_pmos L=0.13u W=0.42u AS=0.3623875p
+ AD=0.0798p PS=2.605u PD=0.8u rfmode=0
M$44651 VDD|in|pad|pin1|pin2|supply|vdd \$1818 \$1817
+ VDD|in|pad|pin1|pin2|supply|vdd sg13_lv_pmos L=0.13u W=1u AS=0.3623875p
+ AD=0.34p PS=2.605u PD=2.68u rfmode=0
M$44652 VDD|in|pad|pin1|pin2|supply|vdd \$1820 \$1819
+ VDD|in|pad|pin1|pin2|supply|vdd sg13_lv_pmos L=0.13u W=1.12u AS=0.41165p
+ AD=0.3864p PS=2.12u PD=2.93u rfmode=0
M$44653 VDD|in|pad|pin1|pin2|supply|vdd \$1311 \$1820
+ VDD|in|pad|pin1|pin2|supply|vdd sg13_lv_pmos L=0.13u W=1.12u AS=0.41165p
+ AD=0.4088p PS=2.12u PD=2.97u rfmode=0
M$44654 \$1817 \$1820 \$1858 VDD|in|pad|pin1|pin2|supply|vdd sg13_lv_pmos
+ L=0.13u W=1u AS=0.34p AD=0.2048p PS=2.68u PD=1.63u rfmode=0
M$44655 \$1858 \$1819 \$1867 VDD|in|pad|pin1|pin2|supply|vdd sg13_lv_pmos
+ L=0.13u W=0.42u AS=0.2048p AD=0.09345p PS=1.63u PD=0.865u rfmode=0
M$44656 VDD|in|pad|pin1|pin2|supply|vdd \$1821 \$1867
+ VDD|in|pad|pin1|pin2|supply|vdd sg13_lv_pmos L=0.13u W=0.42u AS=0.204p
+ AD=0.09345p PS=1.835u PD=0.865u rfmode=0
M$44657 VDD|in|pad|pin1|pin2|supply|vdd \$1522 \$1821
+ VDD|in|pad|pin1|pin2|supply|vdd sg13_lv_pmos L=0.13u W=0.42u AS=0.204p
+ AD=0.0798p PS=1.835u PD=0.8u rfmode=0
M$44658 VDD|in|pad|pin1|pin2|supply|vdd \$1858 \$1821
+ VDD|in|pad|pin1|pin2|supply|vdd sg13_lv_pmos L=0.13u W=0.42u AS=0.4659p
+ AD=0.0798p PS=3.65u PD=0.8u rfmode=0
M$44659 \$1754 \$1858 VDD|in|pad|pin1|pin2|supply|vdd
+ VDD|in|pad|pin1|pin2|supply|vdd sg13_lv_pmos L=0.13u W=1.12u AS=0.3864p
+ AD=0.2128p PS=2.93u PD=1.5u rfmode=0
M$44660 VDD|in|pad|pin1|pin2|supply|vdd \$1754 \$1605
+ VDD|in|pad|pin1|pin2|supply|vdd sg13_lv_pmos L=0.13u W=1.12u AS=0.2128p
+ AD=0.3808p PS=1.5u PD=2.92u rfmode=0
M$44661 VDD|in|pad|pin1|pin2|supply|vdd \$1605 \$1755
+ VDD|in|pad|pin1|pin2|supply|vdd sg13_lv_pmos L=0.13u W=0.84u AS=0.2114p
+ AD=0.2856p PS=1.54u PD=2.36u rfmode=0
M$44662 X8|dout[9] \$1755 VDD|in|pad|pin1|pin2|supply|vdd
+ VDD|in|pad|pin1|pin2|supply|vdd sg13_lv_pmos L=0.13u W=1.12u AS=0.42p
+ AD=0.2114p PS=2.99u PD=1.54u rfmode=0
M$44663 VDD|in|pad|pin1|pin2|supply|vdd \$1061 \$1756
+ VDD|in|pad|pin1|pin2|supply|vdd sg13_lv_pmos L=0.13u W=0.84u AS=0.2114p
+ AD=0.2856p PS=1.54u PD=2.36u rfmode=0
M$44664 \$1166 \$1756 VDD|in|pad|pin1|pin2|supply|vdd
+ VDD|in|pad|pin1|pin2|supply|vdd sg13_lv_pmos L=0.13u W=1.12u AS=0.42p
+ AD=0.2114p PS=2.99u PD=1.54u rfmode=0
M$44666 \$1606 \$1757 VDD|in|pad|pin1|pin2|supply|vdd
+ VDD|in|pad|pin1|pin2|supply|vdd sg13_lv_pmos L=0.13u W=1.12u AS=0.4256p
+ AD=0.2254p PS=3u PD=1.53u rfmode=0
M$44667 VDD|in|pad|pin1|pin2|supply|vdd \$1758 \$1757
+ VDD|in|pad|pin1|pin2|supply|vdd sg13_lv_pmos L=0.5u W=1u AS=0.2254p AD=0.34p
+ PS=1.53u PD=2.68u rfmode=0
M$44668 VDD|in|pad|pin1|pin2|supply|vdd \$1760 \$1822
+ VDD|in|pad|pin1|pin2|supply|vdd sg13_lv_pmos L=0.13u W=0.42u AS=0.1523p
+ AD=0.1428p PS=1.38u PD=1.52u rfmode=0
M$44669 \$1758 \$1822 VDD|in|pad|pin1|pin2|supply|vdd
+ VDD|in|pad|pin1|pin2|supply|vdd sg13_lv_pmos L=0.5u W=1u AS=0.34p AD=0.1523p
+ PS=2.68u PD=1.38u rfmode=0
M$44670 VDD|in|pad|pin1|pin2|supply|vdd \$1527 \$1823
+ VDD|in|pad|pin1|pin2|supply|vdd sg13_lv_pmos L=0.13u W=0.42u AS=0.1428p
+ AD=0.0798p PS=1.52u PD=0.8u rfmode=0
M$44671 VDD|in|pad|pin1|pin2|supply|vdd \$1529 \$1823
+ VDD|in|pad|pin1|pin2|supply|vdd sg13_lv_pmos L=0.13u W=0.42u AS=0.3623875p
+ AD=0.0798p PS=2.605u PD=0.8u rfmode=0
M$44672 VDD|in|pad|pin1|pin2|supply|vdd \$1825 \$1824
+ VDD|in|pad|pin1|pin2|supply|vdd sg13_lv_pmos L=0.13u W=1u AS=0.3623875p
+ AD=0.34p PS=2.605u PD=2.68u rfmode=0
M$44673 VDD|in|pad|pin1|pin2|supply|vdd \$1827 \$1826
+ VDD|in|pad|pin1|pin2|supply|vdd sg13_lv_pmos L=0.13u W=1.12u AS=0.41165p
+ AD=0.3864p PS=2.12u PD=2.93u rfmode=0
M$44674 VDD|in|pad|pin1|pin2|supply|vdd \$1311 \$1827
+ VDD|in|pad|pin1|pin2|supply|vdd sg13_lv_pmos L=0.13u W=1.12u AS=0.41165p
+ AD=0.4088p PS=2.12u PD=2.97u rfmode=0
M$44675 \$1824 \$1827 \$1860 VDD|in|pad|pin1|pin2|supply|vdd sg13_lv_pmos
+ L=0.13u W=1u AS=0.34p AD=0.2048p PS=2.68u PD=1.63u rfmode=0
M$44676 \$1860 \$1826 \$1865 VDD|in|pad|pin1|pin2|supply|vdd sg13_lv_pmos
+ L=0.13u W=0.42u AS=0.2048p AD=0.09345p PS=1.63u PD=0.865u rfmode=0
M$44677 VDD|in|pad|pin1|pin2|supply|vdd \$1828 \$1865
+ VDD|in|pad|pin1|pin2|supply|vdd sg13_lv_pmos L=0.13u W=0.42u AS=0.204p
+ AD=0.09345p PS=1.835u PD=0.865u rfmode=0
M$44678 VDD|in|pad|pin1|pin2|supply|vdd \$1529 \$1828
+ VDD|in|pad|pin1|pin2|supply|vdd sg13_lv_pmos L=0.13u W=0.42u AS=0.204p
+ AD=0.0798p PS=1.835u PD=0.8u rfmode=0
M$44679 VDD|in|pad|pin1|pin2|supply|vdd \$1860 \$1828
+ VDD|in|pad|pin1|pin2|supply|vdd sg13_lv_pmos L=0.13u W=0.42u AS=0.4659p
+ AD=0.0798p PS=3.65u PD=0.8u rfmode=0
M$44680 \$1638 \$1528 VDD|in|pad|pin1|pin2|supply|vdd
+ VDD|in|pad|pin1|pin2|supply|vdd sg13_lv_pmos L=0.13u W=0.42u AS=0.147p
+ AD=0.1563p PS=1.54u PD=1.22u rfmode=0
M$44681 VDD|in|pad|pin1|pin2|supply|vdd \$1440 \$1648
+ VDD|in|pad|pin1|pin2|supply|vdd sg13_lv_pmos L=0.13u W=0.42u AS=0.1563p
+ AD=0.063p PS=1.22u PD=0.72u rfmode=0
M$44682 \$1648 \$1441 \$1638 VDD|in|pad|pin1|pin2|supply|vdd sg13_lv_pmos
+ L=0.13u W=0.42u AS=0.063p AD=0.0798p PS=0.72u PD=0.8u rfmode=0
M$44683 \$1638 \$1639 \$1439 VDD|in|pad|pin1|pin2|supply|vdd sg13_lv_pmos
+ L=0.13u W=0.42u AS=0.0798p AD=0.1428p PS=0.8u PD=1.52u rfmode=0
M$44684 \$1759 \$1860 VDD|in|pad|pin1|pin2|supply|vdd
+ VDD|in|pad|pin1|pin2|supply|vdd sg13_lv_pmos L=0.13u W=1.12u AS=0.3864p
+ AD=0.2128p PS=2.93u PD=1.5u rfmode=0
M$44685 VDD|in|pad|pin1|pin2|supply|vdd \$1759 \$1760
+ VDD|in|pad|pin1|pin2|supply|vdd sg13_lv_pmos L=0.13u W=1.12u AS=0.2128p
+ AD=0.3808p PS=1.5u PD=2.92u rfmode=0
M$44698 VDD|in|pad|pin1|pin2|supply|vdd \$1760 \$1761
+ VDD|in|pad|pin1|pin2|supply|vdd sg13_lv_pmos L=0.13u W=0.84u AS=0.2114p
+ AD=0.2856p PS=1.54u PD=2.36u rfmode=0
M$44699 X9|dout[10] \$1761 VDD|in|pad|pin1|pin2|supply|vdd
+ VDD|in|pad|pin1|pin2|supply|vdd sg13_lv_pmos L=0.13u W=1.12u AS=0.42p
+ AD=0.2114p PS=2.99u PD=1.54u rfmode=0
M$44725 VDD|in|pad|pin1|pin2|supply|vdd \$1445 \$1762
+ VDD|in|pad|pin1|pin2|supply|vdd sg13_lv_pmos L=0.13u W=0.84u AS=0.2114p
+ AD=0.2856p PS=1.54u PD=2.36u rfmode=0
M$44726 X10|dout[11] \$1762 VDD|in|pad|pin1|pin2|supply|vdd
+ VDD|in|pad|pin1|pin2|supply|vdd sg13_lv_pmos L=0.13u W=1.12u AS=0.42p
+ AD=0.2114p PS=2.99u PD=1.54u rfmode=0
M$44739 \$2046 D4|c2p|core|i|uo_c2p[4] VDD|in|pad|pin1|pin2|supply|vdd
+ VDD|in|pad|pin1|pin2|supply|vdd sg13_lv_pmos L=0.13u W=4.75u AS=1.615p
+ AD=1.615p PS=10.18u PD=10.18u rfmode=0
M$44740 \$2057 D4|c2p|core|i|uo_c2p[4] VDD|in|pad|pin1|pin2|supply|vdd
+ VDD|in|pad|pin1|pin2|supply|vdd sg13_lv_pmos L=0.13u W=4.75u AS=1.615p
+ AD=1.615p PS=10.18u PD=10.18u rfmode=0
M$44741 \$887 \$2103 VDD|in|pad|pin1|pin2|supply|vdd
+ VDD|in|pad|pin1|pin2|supply|vdd sg13_lv_pmos L=0.13u W=1.12u AS=0.42p
+ AD=0.2114p PS=2.99u PD=1.54u rfmode=0
M$44742 VDD|in|pad|pin1|pin2|supply|vdd \$2132 \$2103
+ VDD|in|pad|pin1|pin2|supply|vdd sg13_lv_pmos L=0.13u W=0.84u AS=0.2114p
+ AD=0.2856p PS=1.54u PD=2.36u rfmode=0
M$44743 VDD|in|pad|pin1|pin2|supply|vdd \$2245 \$2183
+ VDD|in|pad|pin1|pin2|supply|vdd sg13_lv_pmos L=0.13u W=0.84u AS=0.2114p
+ AD=0.2856p PS=1.54u PD=2.36u rfmode=0
M$44744 \$886 \$2183 VDD|in|pad|pin1|pin2|supply|vdd
+ VDD|in|pad|pin1|pin2|supply|vdd sg13_lv_pmos L=0.13u W=1.12u AS=0.42p
+ AD=0.2114p PS=2.99u PD=1.54u rfmode=0
M$44751 VDD|in|pad|pin1|pin2|supply|vdd Op \$2104
+ VDD|in|pad|pin1|pin2|supply|vdd sg13_lv_pmos L=0.13u W=0.84u AS=0.2114p
+ AD=0.2856p PS=1.54u PD=2.36u rfmode=0
M$44752 VDD|in|pad|pin1|pin2|supply|vdd \$2104 \$2073
+ VDD|in|pad|pin1|pin2|supply|vdd sg13_lv_pmos L=0.13u W=1.12u AS=0.2114p
+ AD=0.42p PS=1.54u PD=2.99u rfmode=0
M$44755 \$1977 \$1992 \$1968 \$1968 sg13_lv_pmos L=0.13u W=0.5u AS=0.17p
+ AD=0.17p PS=1.68u PD=1.68u rfmode=0
M$44758 \$1992 \$1996 VDD|in|pad|pin1|pin2|supply|vdd
+ VDD|in|pad|pin1|pin2|supply|vdd sg13_lv_pmos L=0.13u W=0.8u AS=0.272p
+ AD=0.272p PS=2.28u PD=2.28u rfmode=0
M$44761 VDD|in|pad|pin1|pin2|supply|vdd \$1996 \$1928
+ VDD|in|pad|pin1|pin2|supply|vdd sg13_lv_pmos L=0.13u W=0.5u AS=0.17p AD=0.17p
+ PS=1.68u PD=1.68u rfmode=0
M$44766 \$1838 \$1839 VDD|in|pad|pin1|pin2|supply|vdd
+ VDD|in|pad|pin1|pin2|supply|vdd sg13_lv_pmos L=0.13u W=0.8u AS=0.272p
+ AD=0.272p PS=2.28u PD=2.28u rfmode=0
M$44769 \$1839 fclk_samp VDD|in|pad|pin1|pin2|supply|vdd
+ VDD|in|pad|pin1|pin2|supply|vdd sg13_lv_pmos L=0.13u W=0.8u AS=0.272p
+ AD=0.272p PS=2.28u PD=2.28u rfmode=0
M$44770 VDD|in|pad|pin1|pin2|supply|vdd \$2149 \$2105
+ VDD|in|pad|pin1|pin2|supply|vdd sg13_lv_pmos L=0.13u W=0.84u AS=0.2114p
+ AD=0.2856p PS=1.54u PD=2.36u rfmode=0
M$44771 VDD|in|pad|pin1|pin2|supply|vdd \$2105 clk_comp
+ VDD|in|pad|pin1|pin2|supply|vdd sg13_lv_pmos L=0.13u W=1.12u AS=0.2114p
+ AD=0.42p PS=1.54u PD=2.99u rfmode=0
M$44774 \$2074 \$2131 VDD|in|pad|pin1|pin2|supply|vdd
+ VDD|in|pad|pin1|pin2|supply|vdd sg13_lv_pmos L=0.13u W=0.84u AS=0.2856p
+ AD=0.253p PS=2.36u PD=1.53u rfmode=0
M$44775 VDD|in|pad|pin1|pin2|supply|vdd \$2131 \$2169
+ VDD|in|pad|pin1|pin2|supply|vdd sg13_lv_pmos L=0.13u W=1u AS=0.253p
+ AD=0.3325p PS=1.53u PD=1.665u rfmode=0
M$44776 \$2169 \$2132 \$2075 VDD|in|pad|pin1|pin2|supply|vdd sg13_lv_pmos
+ L=0.13u W=1u AS=0.3325p AD=0.2225p PS=1.665u PD=1.445u rfmode=0
M$44777 \$2075 \$2106 \$2168 VDD|in|pad|pin1|pin2|supply|vdd sg13_lv_pmos
+ L=0.13u W=1u AS=0.2225p AD=0.2975p PS=1.445u PD=1.595u rfmode=0
M$44778 \$2168 \$2074 VDD|in|pad|pin1|pin2|supply|vdd
+ VDD|in|pad|pin1|pin2|supply|vdd sg13_lv_pmos L=0.13u W=1u AS=0.2975p
+ AD=0.2198p PS=1.595u PD=1.52u rfmode=0
M$44779 VDD|in|pad|pin1|pin2|supply|vdd \$2075 \$2076
+ VDD|in|pad|pin1|pin2|supply|vdd sg13_lv_pmos L=0.13u W=1.12u AS=0.2198p
+ AD=0.6048p PS=1.52u PD=3.32u rfmode=0
M$44780 \$2184 \$2205 VDD|in|pad|pin1|pin2|supply|vdd
+ VDD|in|pad|pin1|pin2|supply|vdd sg13_lv_pmos L=0.13u W=1.12u AS=0.3808p
+ AD=0.3808p PS=2.92u PD=2.92u rfmode=0
M$44781 VDD|in|pad|pin1|pin2|supply|vdd \$2373 \$2185
+ VDD|in|pad|pin1|pin2|supply|vdd sg13_lv_pmos L=0.13u W=0.84u AS=0.2114p
+ AD=0.2856p PS=1.54u PD=2.36u rfmode=0
M$44782 \$2149 \$2185 VDD|in|pad|pin1|pin2|supply|vdd
+ VDD|in|pad|pin1|pin2|supply|vdd sg13_lv_pmos L=0.13u W=1.12u AS=0.42p
+ AD=0.2114p PS=2.99u PD=1.54u rfmode=0
M$44783 VDD|in|pad|pin1|pin2|supply|vdd \$2078 \$2077
+ VDD|in|pad|pin1|pin2|supply|vdd sg13_lv_pmos L=0.13u W=17.92u AS=3.5896p
+ AD=3.4048p PS=25.45u PD=24u rfmode=0
M$44799 VDD|in|pad|pin1|pin2|supply|vdd CLK|clk|core|fclk_in|p2c|ui_p2c[6]
+ \$2078 VDD|in|pad|pin1|pin2|supply|vdd sg13_lv_pmos L=0.13u W=6.72u
+ AS=1.2768p AD=1.4448p PS=9u PD=10.42u rfmode=0
M$44805 VDD|in|pad|pin1|pin2|supply|vdd \$2246 \$2208
+ VDD|in|pad|pin1|pin2|supply|vdd sg13_lv_pmos L=0.13u W=1.12u AS=0.41165p
+ AD=0.3864p PS=2.12u PD=2.93u rfmode=0
M$44806 VDD|in|pad|pin1|pin2|supply|vdd \$2247 \$2246
+ VDD|in|pad|pin1|pin2|supply|vdd sg13_lv_pmos L=0.13u W=1.12u AS=0.41165p
+ AD=0.4088p PS=2.12u PD=2.97u rfmode=0
M$44807 \$2186 \$2209 VDD|in|pad|pin1|pin2|supply|vdd
+ VDD|in|pad|pin1|pin2|supply|vdd sg13_lv_pmos L=0.13u W=1.12u AS=0.3864p
+ AD=0.2128p PS=2.93u PD=1.5u rfmode=0
M$44808 VDD|in|pad|pin1|pin2|supply|vdd \$2186 \$2132
+ VDD|in|pad|pin1|pin2|supply|vdd sg13_lv_pmos L=0.13u W=1.12u AS=0.2128p
+ AD=0.3808p PS=1.5u PD=2.92u rfmode=0
M$44809 VDD|in|pad|pin1|pin2|supply|vdd \$2136 \$2079
+ VDD|in|pad|pin1|pin2|supply|vdd sg13_lv_pmos L=0.13u W=1.12u AS=0.3808p
+ AD=0.2128p PS=2.92u PD=1.5u rfmode=0
M$44810 \$2079 \$2133 VDD|in|pad|pin1|pin2|supply|vdd
+ VDD|in|pad|pin1|pin2|supply|vdd sg13_lv_pmos L=0.13u W=1.12u AS=0.2128p
+ AD=0.2128p PS=1.5u PD=1.5u rfmode=0
M$44811 VDD|in|pad|pin1|pin2|supply|vdd \$2134 \$2079
+ VDD|in|pad|pin1|pin2|supply|vdd sg13_lv_pmos L=0.13u W=1.12u AS=0.2128p
+ AD=0.3808p PS=1.5u PD=2.92u rfmode=0
M$44812 VDD|in|pad|pin1|pin2|supply|vdd \$2248 \$2187
+ VDD|in|pad|pin1|pin2|supply|vdd sg13_lv_pmos L=0.13u W=0.84u AS=0.2114p
+ AD=0.2856p PS=1.54u PD=2.36u rfmode=0
M$44813 \$2205 \$2187 VDD|in|pad|pin1|pin2|supply|vdd
+ VDD|in|pad|pin1|pin2|supply|vdd sg13_lv_pmos L=0.13u W=1.12u AS=0.42p
+ AD=0.2114p PS=2.99u PD=1.54u rfmode=0
M$44814 \$2080 \$2135 \$2154 VDD|in|pad|pin1|pin2|supply|vdd sg13_lv_pmos
+ L=0.13u W=1.12u AS=0.3808p AD=0.2128p PS=2.92u PD=1.5u rfmode=0
M$44815 \$2154 \$2136 VDD|in|pad|pin1|pin2|supply|vdd
+ VDD|in|pad|pin1|pin2|supply|vdd sg13_lv_pmos L=0.13u W=1.12u AS=0.2128p
+ AD=0.2128p PS=1.5u PD=1.5u rfmode=0
M$44816 VDD|in|pad|pin1|pin2|supply|vdd \$2134 \$2154
+ VDD|in|pad|pin1|pin2|supply|vdd sg13_lv_pmos L=0.13u W=1.12u AS=0.2128p
+ AD=0.3808p PS=1.5u PD=2.92u rfmode=0
M$44817 \$2135 \$2136 \$2170 VDD|in|pad|pin1|pin2|supply|vdd sg13_lv_pmos
+ L=0.13u W=1u AS=0.34p AD=0.1225p PS=2.68u PD=1.245u rfmode=0
M$44818 \$2170 \$2134 VDD|in|pad|pin1|pin2|supply|vdd
+ VDD|in|pad|pin1|pin2|supply|vdd sg13_lv_pmos L=0.13u W=1u AS=0.1225p AD=0.36p
+ PS=1.245u PD=2.72u rfmode=0
M$44819 VDD|in|pad|pin1|pin2|supply|vdd \$2137 \$2107
+ VDD|in|pad|pin1|pin2|supply|vdd sg13_lv_pmos L=0.13u W=0.84u AS=0.4536p
+ AD=0.1596p PS=2.76u PD=1.22u rfmode=0
M$44820 VDD|in|pad|pin1|pin2|supply|vdd \$2079 \$2107
+ VDD|in|pad|pin1|pin2|supply|vdd sg13_lv_pmos L=0.13u W=0.84u AS=0.2891p
+ AD=0.1596p PS=1.695u PD=1.22u rfmode=0
M$44821 VDD|in|pad|pin1|pin2|supply|vdd \$2137 \$2171
+ VDD|in|pad|pin1|pin2|supply|vdd sg13_lv_pmos L=0.13u W=1.12u AS=0.2891p
+ AD=0.1428p PS=1.695u PD=1.375u rfmode=0
M$44822 \$2171 \$2079 \$2150 VDD|in|pad|pin1|pin2|supply|vdd sg13_lv_pmos
+ L=0.13u W=1.12u AS=0.1428p AD=0.2408p PS=1.375u PD=1.55u rfmode=0
M$44823 \$2150 \$2107 VDD|in|pad|pin1|pin2|supply|vdd
+ VDD|in|pad|pin1|pin2|supply|vdd sg13_lv_pmos L=0.13u W=1.12u AS=0.2408p
+ AD=0.3808p PS=1.55u PD=2.92u rfmode=0
M$44824 VDD|in|pad|pin1|pin2|supply|vdd \$2249 \$2213
+ VDD|in|pad|pin1|pin2|supply|vdd sg13_lv_pmos L=0.13u W=1.12u AS=0.41165p
+ AD=0.3864p PS=2.12u PD=2.93u rfmode=0
M$44825 VDD|in|pad|pin1|pin2|supply|vdd \$2368 \$2249
+ VDD|in|pad|pin1|pin2|supply|vdd sg13_lv_pmos L=0.13u W=1.12u AS=0.41165p
+ AD=0.4088p PS=2.12u PD=2.97u rfmode=0
M$44826 VDD|in|pad|pin1|pin2|supply|vdd \$2138 \$2108
+ VDD|in|pad|pin1|pin2|supply|vdd sg13_lv_pmos L=0.5u W=1u AS=0.2254p AD=0.34p
+ PS=1.53u PD=2.68u rfmode=0
M$44827 \$2136 \$2108 VDD|in|pad|pin1|pin2|supply|vdd
+ VDD|in|pad|pin1|pin2|supply|vdd sg13_lv_pmos L=0.13u W=1.12u AS=0.4256p
+ AD=0.2254p PS=3u PD=1.53u rfmode=0
M$44828 VDD|in|pad|pin1|pin2|supply|vdd \$2139 \$2082
+ VDD|in|pad|pin1|pin2|supply|vdd sg13_lv_pmos L=0.13u W=0.42u AS=0.1523p
+ AD=0.1428p PS=1.38u PD=1.52u rfmode=0
M$44829 \$2138 \$2082 VDD|in|pad|pin1|pin2|supply|vdd
+ VDD|in|pad|pin1|pin2|supply|vdd sg13_lv_pmos L=0.5u W=1u AS=0.34p AD=0.1523p
+ PS=2.68u PD=1.38u rfmode=0
M$44830 \$2188 \$2214 VDD|in|pad|pin1|pin2|supply|vdd
+ VDD|in|pad|pin1|pin2|supply|vdd sg13_lv_pmos L=0.13u W=1.12u AS=0.3864p
+ AD=0.2128p PS=2.93u PD=1.5u rfmode=0
M$44831 VDD|in|pad|pin1|pin2|supply|vdd \$2188 \$2139
+ VDD|in|pad|pin1|pin2|supply|vdd sg13_lv_pmos L=0.13u W=1.12u AS=0.2128p
+ AD=0.3808p PS=1.5u PD=2.92u rfmode=0
M$44833 VDD|in|pad|pin1|pin2|supply|vdd \$2140 \$2109
+ VDD|in|pad|pin1|pin2|supply|vdd sg13_lv_pmos L=0.5u W=1u AS=0.2254p AD=0.34p
+ PS=1.53u PD=2.68u rfmode=0
M$44834 \$2083 \$2109 VDD|in|pad|pin1|pin2|supply|vdd
+ VDD|in|pad|pin1|pin2|supply|vdd sg13_lv_pmos L=0.13u W=1.12u AS=0.4256p
+ AD=0.2254p PS=3u PD=1.53u rfmode=0
M$44835 VDD|in|pad|pin1|pin2|supply|vdd \$2150 \$2084
+ VDD|in|pad|pin1|pin2|supply|vdd sg13_lv_pmos L=0.13u W=0.42u AS=0.1523p
+ AD=0.1428p PS=1.38u PD=1.52u rfmode=0
M$44836 \$2140 \$2084 VDD|in|pad|pin1|pin2|supply|vdd
+ VDD|in|pad|pin1|pin2|supply|vdd sg13_lv_pmos L=0.5u W=1u AS=0.34p AD=0.1523p
+ PS=2.68u PD=1.38u rfmode=0
M$44837 VDD|in|pad|pin1|pin2|supply|vdd \$2250 \$2218
+ VDD|in|pad|pin1|pin2|supply|vdd sg13_lv_pmos L=0.13u W=1.12u AS=0.41165p
+ AD=0.3864p PS=2.12u PD=2.93u rfmode=0
M$44838 VDD|in|pad|pin1|pin2|supply|vdd \$2368 \$2250
+ VDD|in|pad|pin1|pin2|supply|vdd sg13_lv_pmos L=0.13u W=1.12u AS=0.41165p
+ AD=0.4088p PS=2.12u PD=2.97u rfmode=0
M$44839 VDD|in|pad|pin1|pin2|supply|vdd \$2141 \$2110
+ VDD|in|pad|pin1|pin2|supply|vdd sg13_lv_pmos L=0.5u W=1u AS=0.2254p AD=0.34p
+ PS=1.53u PD=2.68u rfmode=0
M$44840 \$2137 \$2110 VDD|in|pad|pin1|pin2|supply|vdd
+ VDD|in|pad|pin1|pin2|supply|vdd sg13_lv_pmos L=0.13u W=1.12u AS=0.4256p
+ AD=0.2254p PS=3u PD=1.53u rfmode=0
M$44841 VDD|in|pad|pin1|pin2|supply|vdd \$2142 \$2085
+ VDD|in|pad|pin1|pin2|supply|vdd sg13_lv_pmos L=0.13u W=0.42u AS=0.1523p
+ AD=0.1428p PS=1.38u PD=1.52u rfmode=0
M$44842 \$2141 \$2085 VDD|in|pad|pin1|pin2|supply|vdd
+ VDD|in|pad|pin1|pin2|supply|vdd sg13_lv_pmos L=0.5u W=1u AS=0.34p AD=0.1523p
+ PS=2.68u PD=1.38u rfmode=0
M$44843 \$2086 \$2111 VDD|in|pad|pin1|pin2|supply|vdd
+ VDD|in|pad|pin1|pin2|supply|vdd sg13_lv_pmos L=0.13u W=1.12u AS=0.42p
+ AD=0.2114p PS=2.99u PD=1.54u rfmode=0
M$44844 VDD|in|pad|pin1|pin2|supply|vdd core|p2c|reset|rst|ui_p2c[5] \$2111
+ VDD|in|pad|pin1|pin2|supply|vdd sg13_lv_pmos L=0.13u W=0.84u AS=0.2114p
+ AD=0.2856p PS=1.54u PD=2.36u rfmode=0
M$44845 \$2189 \$2219 VDD|in|pad|pin1|pin2|supply|vdd
+ VDD|in|pad|pin1|pin2|supply|vdd sg13_lv_pmos L=0.13u W=1.12u AS=0.3864p
+ AD=0.2128p PS=2.93u PD=1.5u rfmode=0
M$44846 VDD|in|pad|pin1|pin2|supply|vdd \$2189 \$2142
+ VDD|in|pad|pin1|pin2|supply|vdd sg13_lv_pmos L=0.13u W=1.12u AS=0.2128p
+ AD=0.3808p PS=1.5u PD=2.92u rfmode=0
M$44847 VDD|in|pad|pin1|pin2|supply|vdd \$2143 \$2087
+ VDD|in|pad|pin1|pin2|supply|vdd sg13_lv_pmos L=0.13u W=0.42u AS=0.1523p
+ AD=0.1428p PS=1.38u PD=1.52u rfmode=0
M$44848 VDD|in|pad|pin1|pin2|supply|vdd \$2087 \$2088
+ VDD|in|pad|pin1|pin2|supply|vdd sg13_lv_pmos L=0.5u W=1u AS=0.1523p AD=0.34p
+ PS=1.38u PD=2.68u rfmode=0
M$44849 VDD|in|pad|pin1|pin2|supply|vdd \$2251 \$2221
+ VDD|in|pad|pin1|pin2|supply|vdd sg13_lv_pmos L=0.13u W=0.42u AS=0.1523p
+ AD=0.1428p PS=1.38u PD=1.52u rfmode=0
M$44850 VDD|in|pad|pin1|pin2|supply|vdd \$2221 \$2190
+ VDD|in|pad|pin1|pin2|supply|vdd sg13_lv_pmos L=0.5u W=1u AS=0.1523p AD=0.34p
+ PS=1.38u PD=2.68u rfmode=0
M$44851 \$2112 \$2088 VDD|in|pad|pin1|pin2|supply|vdd
+ VDD|in|pad|pin1|pin2|supply|vdd sg13_lv_pmos L=0.5u W=1u AS=0.34p AD=0.2254p
+ PS=2.68u PD=1.53u rfmode=0
M$44852 VDD|in|pad|pin1|pin2|supply|vdd \$2112 \$2089
+ VDD|in|pad|pin1|pin2|supply|vdd sg13_lv_pmos L=0.13u W=1.12u AS=0.2254p
+ AD=0.4256p PS=1.53u PD=3u rfmode=0
M$44853 \$1622 \$764 \$1351 \$1288 sg13_lv_pmos L=0.2u W=32u AS=8.48p AD=8.48p
+ PS=52.24u PD=52.24u rfmode=0
M$44857 \$1622 \$765 \$1350 \$1288 sg13_lv_pmos L=0.2u W=32u AS=8.48p AD=8.48p
+ PS=52.24u PD=52.24u rfmode=0
M$44861 Op \$1350 VDD|in|pad|pin1|pin2|supply|vdd \$1288 sg13_lv_pmos L=0.2u
+ W=8u AS=2.12p AD=2.12p PS=13.06u PD=13.06u rfmode=0
M$44863 VDD|in|pad|pin1|pin2|supply|vdd \$2190 \$2191
+ VDD|in|pad|pin1|pin2|supply|vdd sg13_lv_pmos L=0.5u W=1u AS=0.2254p AD=0.34p
+ PS=1.53u PD=2.68u rfmode=0
M$44864 VDD|in|pad|pin1|pin2|supply|vdd \$2191 \$2192
+ VDD|in|pad|pin1|pin2|supply|vdd sg13_lv_pmos L=0.13u W=1.12u AS=0.2254p
+ AD=0.4256p PS=1.53u PD=3u rfmode=0
M$44865 VDD|in|pad|pin1|pin2|supply|vdd \$2089 \$2113
+ VDD|in|pad|pin1|pin2|supply|vdd sg13_lv_pmos L=0.13u W=0.42u AS=0.1428p
+ AD=0.0798p PS=1.52u PD=0.8u rfmode=0
M$44866 VDD|in|pad|pin1|pin2|supply|vdd \$2145 \$2113
+ VDD|in|pad|pin1|pin2|supply|vdd sg13_lv_pmos L=0.13u W=0.42u AS=0.3623875p
+ AD=0.0798p PS=2.605u PD=0.8u rfmode=0
M$44867 VDD|in|pad|pin1|pin2|supply|vdd \$2144 \$2071
+ VDD|in|pad|pin1|pin2|supply|vdd sg13_lv_pmos L=0.13u W=1u AS=0.3623875p
+ AD=0.34p PS=2.605u PD=2.68u rfmode=0
M$44868 \$2193 \$2089 \$2261 VDD|in|pad|pin1|pin2|supply|vdd sg13_lv_pmos
+ L=0.13u W=1.12u AS=0.3808p AD=0.1176p PS=2.92u PD=1.33u rfmode=0
M$44869 \$2261 \$2222 VDD|in|pad|pin1|pin2|supply|vdd
+ VDD|in|pad|pin1|pin2|supply|vdd sg13_lv_pmos L=0.13u W=1.12u AS=0.1176p
+ AD=0.2618p PS=1.33u PD=1.63u rfmode=0
M$44870 VDD|in|pad|pin1|pin2|supply|vdd \$2096 \$2222
+ VDD|in|pad|pin1|pin2|supply|vdd sg13_lv_pmos L=0.13u W=0.84u AS=0.2618p
+ AD=0.2856p PS=1.63u PD=2.36u rfmode=0
M$44871 \$2144 \$2145 VDD|in|pad|pin1|pin2|supply|vdd
+ VDD|in|pad|pin1|pin2|supply|vdd sg13_lv_pmos L=0.13u W=0.42u AS=0.147p
+ AD=0.1563p PS=1.54u PD=1.22u rfmode=0
M$44872 VDD|in|pad|pin1|pin2|supply|vdd \$2071 \$2172
+ VDD|in|pad|pin1|pin2|supply|vdd sg13_lv_pmos L=0.13u W=0.42u AS=0.1563p
+ AD=0.063p PS=1.22u PD=0.72u rfmode=0
M$44873 \$2172 \$2072 \$2144 VDD|in|pad|pin1|pin2|supply|vdd sg13_lv_pmos
+ L=0.13u W=0.42u AS=0.063p AD=0.0798p PS=0.72u PD=0.8u rfmode=0
M$44874 \$2144 \$2151 \$2113 VDD|in|pad|pin1|pin2|supply|vdd sg13_lv_pmos
+ L=0.13u W=0.42u AS=0.0798p AD=0.1428p PS=0.8u PD=1.52u rfmode=0
M$44875 VDD|in|pad|pin1|pin2|supply|vdd Op \$2035
+ VDD|in|pad|pin1|pin2|supply|vdd sg13_lv_pmos L=0.13u W=0.5u AS=0.17p
+ AD=0.095p PS=1.68u PD=0.88u rfmode=0
M$44876 \$2035 Om VDD|in|pad|pin1|pin2|supply|vdd
+ VDD|in|pad|pin1|pin2|supply|vdd sg13_lv_pmos L=0.13u W=0.5u AS=0.095p
+ AD=0.17p PS=0.88u PD=1.68u rfmode=0
M$44877 Om \$1351 VDD|in|pad|pin1|pin2|supply|vdd \$1288 sg13_lv_pmos L=0.2u
+ W=8u AS=2.12p AD=2.12p PS=13.06u PD=13.06u rfmode=0
M$44887 \$2151 \$2072 VDD|in|pad|pin1|pin2|supply|vdd
+ VDD|in|pad|pin1|pin2|supply|vdd sg13_lv_pmos L=0.13u W=1.12u AS=0.3864p
+ AD=0.41165p PS=2.93u PD=2.12u rfmode=0
M$44888 VDD|in|pad|pin1|pin2|supply|vdd \$2325 \$2072
+ VDD|in|pad|pin1|pin2|supply|vdd sg13_lv_pmos L=0.13u W=1.12u AS=0.41165p
+ AD=0.4088p PS=2.12u PD=2.97u rfmode=0
M$44889 \$2114 \$2151 \$2159 VDD|in|pad|pin1|pin2|supply|vdd sg13_lv_pmos
+ L=0.13u W=0.42u AS=0.2048p AD=0.09345p PS=1.63u PD=0.865u rfmode=0
M$44890 \$2159 \$2092 VDD|in|pad|pin1|pin2|supply|vdd
+ VDD|in|pad|pin1|pin2|supply|vdd sg13_lv_pmos L=0.13u W=0.42u AS=0.09345p
+ AD=0.204p PS=0.865u PD=1.835u rfmode=0
M$44891 VDD|in|pad|pin1|pin2|supply|vdd \$2145 \$2092
+ VDD|in|pad|pin1|pin2|supply|vdd sg13_lv_pmos L=0.13u W=0.42u AS=0.204p
+ AD=0.0798p PS=1.835u PD=0.8u rfmode=0
M$44892 \$2092 \$2114 VDD|in|pad|pin1|pin2|supply|vdd
+ VDD|in|pad|pin1|pin2|supply|vdd sg13_lv_pmos L=0.13u W=0.42u AS=0.0798p
+ AD=0.4659p PS=0.8u PD=3.65u rfmode=0
M$44893 \$2071 \$2072 \$2114 VDD|in|pad|pin1|pin2|supply|vdd sg13_lv_pmos
+ L=0.13u W=1u AS=0.34p AD=0.2048p PS=2.68u PD=1.63u rfmode=0
M$44894 VDD|in|pad|pin1|pin2|supply|vdd \$2253 \$2225
+ VDD|in|pad|pin1|pin2|supply|vdd sg13_lv_pmos L=0.13u W=1.12u AS=0.41165p
+ AD=0.3864p PS=2.12u PD=2.93u rfmode=0
M$44895 VDD|in|pad|pin1|pin2|supply|vdd \$2325 \$2253
+ VDD|in|pad|pin1|pin2|supply|vdd sg13_lv_pmos L=0.13u W=1.12u AS=0.41165p
+ AD=0.4088p PS=2.12u PD=2.97u rfmode=0
M$44896 \$2093 \$2114 VDD|in|pad|pin1|pin2|supply|vdd
+ VDD|in|pad|pin1|pin2|supply|vdd sg13_lv_pmos L=0.13u W=1.12u AS=0.3864p
+ AD=0.2128p PS=2.93u PD=1.5u rfmode=0
M$44897 VDD|in|pad|pin1|pin2|supply|vdd \$2093 \$2094
+ VDD|in|pad|pin1|pin2|supply|vdd sg13_lv_pmos L=0.13u W=1.12u AS=0.2128p
+ AD=0.3808p PS=1.5u PD=2.92u rfmode=0
M$44898 VDD|in|pad|pin1|pin2|supply|vdd \$2321 \$2173
+ VDD|in|pad|pin1|pin2|supply|vdd sg13_lv_pmos L=0.15u W=1.12u AS=0.3808p
+ AD=0.2128p PS=2.92u PD=1.5u rfmode=0
M$44899 \$2173 \$2192 \$2096 VDD|in|pad|pin1|pin2|supply|vdd sg13_lv_pmos
+ L=0.15u W=1.12u AS=0.2128p AD=0.2128p PS=1.5u PD=1.5u rfmode=0
M$44900 \$2096 \$2146 VDD|in|pad|pin1|pin2|supply|vdd
+ VDD|in|pad|pin1|pin2|supply|vdd sg13_lv_pmos L=0.15u W=1.12u AS=0.2128p
+ AD=0.3808p PS=1.5u PD=2.92u rfmode=0
M$44901 \$2194 \$2226 VDD|in|pad|pin1|pin2|supply|vdd
+ VDD|in|pad|pin1|pin2|supply|vdd sg13_lv_pmos L=0.13u W=1.12u AS=0.3864p
+ AD=0.2128p PS=2.93u PD=1.5u rfmode=0
M$44902 VDD|in|pad|pin1|pin2|supply|vdd \$2194 \$2195
+ VDD|in|pad|pin1|pin2|supply|vdd sg13_lv_pmos L=0.13u W=1.12u AS=0.2128p
+ AD=0.3808p PS=1.5u PD=2.92u rfmode=0
M$44903 VDD|in|pad|pin1|pin2|supply|vdd \$2400 \$2145
+ VDD|in|pad|pin1|pin2|supply|vdd sg13_lv_pmos L=0.13u W=1.12u AS=0.3808p
+ AD=0.3808p PS=2.92u PD=2.92u rfmode=0
M$44906 \$2196 \$2131 \$2263 VDD|in|pad|pin1|pin2|supply|vdd sg13_lv_pmos
+ L=0.13u W=1.12u AS=0.3808p AD=0.1176p PS=2.92u PD=1.33u rfmode=0
M$44907 \$2263 \$2152 VDD|in|pad|pin1|pin2|supply|vdd
+ VDD|in|pad|pin1|pin2|supply|vdd sg13_lv_pmos L=0.13u W=1.12u AS=0.1176p
+ AD=0.4032p PS=1.33u PD=2.96u rfmode=0
M$44908 \$2197 \$2196 \$2198 VDD|in|pad|pin1|pin2|supply|vdd sg13_lv_pmos
+ L=0.13u W=1.12u AS=0.3808p AD=0.2128p PS=2.92u PD=1.5u rfmode=0
M$44909 \$2198 \$2131 VDD|in|pad|pin1|pin2|supply|vdd
+ VDD|in|pad|pin1|pin2|supply|vdd sg13_lv_pmos L=0.13u W=1.12u AS=0.2128p
+ AD=0.2128p PS=1.5u PD=1.5u rfmode=0
M$44910 VDD|in|pad|pin1|pin2|supply|vdd \$2106 \$2198
+ VDD|in|pad|pin1|pin2|supply|vdd sg13_lv_pmos L=0.13u W=1.12u AS=0.2128p
+ AD=0.3808p PS=1.5u PD=2.92u rfmode=0
M$44911 \$2115 \$2073 VDD|in|pad|pin1|pin2|supply|vdd
+ VDD|in|pad|pin1|pin2|supply|vdd sg13_lv_pmos L=0.13u W=0.84u AS=0.2856p
+ AD=0.2618p PS=2.36u PD=1.63u rfmode=0
M$44912 VDD|in|pad|pin1|pin2|supply|vdd \$2115 \$2174
+ VDD|in|pad|pin1|pin2|supply|vdd sg13_lv_pmos L=0.13u W=1.12u AS=0.2618p
+ AD=0.1176p PS=1.63u PD=1.33u rfmode=0
M$44913 \$2174 \$2147 \$2097 VDD|in|pad|pin1|pin2|supply|vdd sg13_lv_pmos
+ L=0.13u W=1.12u AS=0.1176p AD=0.3808p PS=1.33u PD=2.92u rfmode=0
M$44914 \$2098 \$2116 VDD|in|pad|pin1|pin2|supply|vdd
+ VDD|in|pad|pin1|pin2|supply|vdd sg13_lv_pmos L=0.13u W=1.12u AS=0.42p
+ AD=0.2114p PS=2.99u PD=1.54u rfmode=0
M$44915 VDD|in|pad|pin1|pin2|supply|vdd \$2429 \$2116
+ VDD|in|pad|pin1|pin2|supply|vdd sg13_lv_pmos L=0.13u W=0.84u AS=0.2114p
+ AD=0.2856p PS=1.54u PD=2.36u rfmode=0
M$44918 VDD|in|pad|pin1|pin2|supply|vdd \$2255 \$2230
+ VDD|in|pad|pin1|pin2|supply|vdd sg13_lv_pmos L=0.13u W=1.12u AS=0.41165p
+ AD=0.3864p PS=2.12u PD=2.93u rfmode=0
M$44919 VDD|in|pad|pin1|pin2|supply|vdd \$2256 \$2255
+ VDD|in|pad|pin1|pin2|supply|vdd sg13_lv_pmos L=0.13u W=1.12u AS=0.41165p
+ AD=0.4088p PS=2.12u PD=2.97u rfmode=0
M$44924 \$2199 \$2231 VDD|in|pad|pin1|pin2|supply|vdd
+ VDD|in|pad|pin1|pin2|supply|vdd sg13_lv_pmos L=0.13u W=1.12u AS=0.3864p
+ AD=0.2128p PS=2.93u PD=1.5u rfmode=0
M$44925 VDD|in|pad|pin1|pin2|supply|vdd \$2199 \$2152
+ VDD|in|pad|pin1|pin2|supply|vdd sg13_lv_pmos L=0.13u W=1.12u AS=0.2128p
+ AD=0.3808p PS=1.5u PD=2.92u rfmode=0
M$44929 VDD|in|pad|pin1|pin2|supply|vdd \$2035 \$2117
+ VDD|in|pad|pin1|pin2|supply|vdd sg13_lv_pmos L=0.13u W=0.84u AS=0.2114p
+ AD=0.2856p PS=1.54u PD=2.36u rfmode=0
M$44930 VDD|in|pad|pin1|pin2|supply|vdd \$2117 \$2099
+ VDD|in|pad|pin1|pin2|supply|vdd sg13_lv_pmos L=0.13u W=1.12u AS=0.2114p
+ AD=0.42p PS=1.54u PD=2.99u rfmode=0
M$44933 VDD|in|pad|pin1|pin2|supply|vdd \$2098 \$2100
+ VDD|in|pad|pin1|pin2|supply|vdd sg13_lv_pmos L=0.13u W=1.12u AS=0.3808p
+ AD=0.3808p PS=2.92u PD=2.92u rfmode=0
M$44936 VDD|in|pad|pin1|pin2|supply|vdd \$2257 \$2236
+ VDD|in|pad|pin1|pin2|supply|vdd sg13_lv_pmos L=0.13u W=1.12u AS=0.41165p
+ AD=0.3864p PS=2.12u PD=2.93u rfmode=0
M$44937 VDD|in|pad|pin1|pin2|supply|vdd \$2256 \$2257
+ VDD|in|pad|pin1|pin2|supply|vdd sg13_lv_pmos L=0.13u W=1.12u AS=0.41165p
+ AD=0.4088p PS=2.12u PD=2.97u rfmode=0
M$44942 \$2202 \$2237 VDD|in|pad|pin1|pin2|supply|vdd
+ VDD|in|pad|pin1|pin2|supply|vdd sg13_lv_pmos L=0.13u W=1.12u AS=0.3864p
+ AD=0.2128p PS=2.93u PD=1.5u rfmode=0
M$44943 VDD|in|pad|pin1|pin2|supply|vdd \$2202 \$2203
+ VDD|in|pad|pin1|pin2|supply|vdd sg13_lv_pmos L=0.13u W=1.12u AS=0.2128p
+ AD=0.3808p PS=1.5u PD=2.92u rfmode=0
M$44944 fclk_samp \$2118 VDD|in|pad|pin1|pin2|supply|vdd
+ VDD|in|pad|pin1|pin2|supply|vdd sg13_lv_pmos L=0.13u W=1.12u AS=0.42p
+ AD=0.2114p PS=2.99u PD=1.54u rfmode=0
M$44945 VDD|in|pad|pin1|pin2|supply|vdd \$2146 \$2118
+ VDD|in|pad|pin1|pin2|supply|vdd sg13_lv_pmos L=0.13u W=0.84u AS=0.2114p
+ AD=0.2856p PS=1.54u PD=2.36u rfmode=0
M$44950 VDD|in|pad|pin1|pin2|supply|vdd fclk_samp \$1840
+ VDD|in|pad|pin1|pin2|supply|vdd sg13_lv_pmos L=0.13u W=0.8u AS=0.272p
+ AD=0.272p PS=2.28u PD=2.28u rfmode=0
M$44955 VDD|in|pad|pin1|pin2|supply|vdd \$1840 \$1873
+ VDD|in|pad|pin1|pin2|supply|vdd sg13_lv_pmos L=0.13u W=0.8u AS=0.272p
+ AD=0.272p PS=2.28u PD=2.28u rfmode=0
M$44960 \$1933 \$1997 VDD|in|pad|pin1|pin2|supply|vdd
+ VDD|in|pad|pin1|pin2|supply|vdd sg13_lv_pmos L=0.13u W=0.5u AS=0.17p AD=0.17p
+ PS=1.68u PD=1.68u rfmode=0
M$44963 VDD|in|pad|pin1|pin2|supply|vdd \$1997 \$1993
+ VDD|in|pad|pin1|pin2|supply|vdd sg13_lv_pmos L=0.13u W=0.8u AS=0.272p
+ AD=0.272p PS=2.28u PD=2.28u rfmode=0
M$44966 \$1969 \$1993 \$1971 \$1969 sg13_lv_pmos L=0.13u W=0.5u AS=0.17p
+ AD=0.17p PS=1.68u PD=1.68u rfmode=0
M$44971 \$2147 \$2119 VDD|in|pad|pin1|pin2|supply|vdd
+ VDD|in|pad|pin1|pin2|supply|vdd sg13_lv_pmos L=0.13u W=1.12u AS=0.42p
+ AD=0.2114p PS=2.99u PD=1.54u rfmode=0
M$44972 VDD|in|pad|pin1|pin2|supply|vdd Om \$2119
+ VDD|in|pad|pin1|pin2|supply|vdd sg13_lv_pmos L=0.13u W=0.84u AS=0.2114p
+ AD=0.2856p PS=1.54u PD=2.36u rfmode=0
M$44973 \$2204 \$2203 VDD|in|pad|pin1|pin2|supply|vdd
+ VDD|in|pad|pin1|pin2|supply|vdd sg13_lv_pmos L=0.13u W=0.84u AS=0.2856p
+ AD=0.2114p PS=2.36u PD=1.54u rfmode=0
M$44974 VDD|in|pad|pin1|pin2|supply|vdd \$2204 \$979
+ VDD|in|pad|pin1|pin2|supply|vdd sg13_lv_pmos L=0.13u W=1.12u AS=0.2114p
+ AD=0.42p PS=1.54u PD=2.99u rfmode=0
M$44975 VDD|in|pad|pin1|pin2|supply|vdd \$2152 \$2120
+ VDD|in|pad|pin1|pin2|supply|vdd sg13_lv_pmos L=0.13u W=0.84u AS=0.2114p
+ AD=0.2856p PS=1.54u PD=2.36u rfmode=0
M$44976 VDD|in|pad|pin1|pin2|supply|vdd \$2120 \$888
+ VDD|in|pad|pin1|pin2|supply|vdd sg13_lv_pmos L=0.13u W=1.12u AS=0.2114p
+ AD=0.42p PS=1.54u PD=2.99u rfmode=0
M$44977 VDD|in|pad|pin1|pin2|supply|vdd \$1446 \$1768
+ VDD|in|pad|pin1|pin2|supply|vdd sg13_lv_pmos L=0.13u W=0.42u AS=0.1563p
+ AD=0.147p PS=1.22u PD=1.54u rfmode=0
M$44978 VDD|in|pad|pin1|pin2|supply|vdd \$1767 \$1829
+ VDD|in|pad|pin1|pin2|supply|vdd sg13_lv_pmos L=0.13u W=0.42u AS=0.1563p
+ AD=0.063p PS=1.22u PD=0.72u rfmode=0
M$44979 \$1829 \$1770 \$1768 VDD|in|pad|pin1|pin2|supply|vdd sg13_lv_pmos
+ L=0.13u W=0.42u AS=0.063p AD=0.0798p PS=0.72u PD=0.8u rfmode=0
M$44980 \$1768 \$1769 \$1766 VDD|in|pad|pin1|pin2|supply|vdd sg13_lv_pmos
+ L=0.13u W=0.42u AS=0.0798p AD=0.1428p PS=0.8u PD=1.52u rfmode=0
M$44981 VDD|in|pad|pin1|pin2|supply|vdd \$1454 \$1776
+ VDD|in|pad|pin1|pin2|supply|vdd sg13_lv_pmos L=0.13u W=0.42u AS=0.1563p
+ AD=0.147p PS=1.22u PD=1.54u rfmode=0
M$44982 VDD|in|pad|pin1|pin2|supply|vdd \$1775 \$1830
+ VDD|in|pad|pin1|pin2|supply|vdd sg13_lv_pmos L=0.13u W=0.42u AS=0.1563p
+ AD=0.063p PS=1.22u PD=0.72u rfmode=0
M$44983 \$1830 \$1778 \$1776 VDD|in|pad|pin1|pin2|supply|vdd sg13_lv_pmos
+ L=0.13u W=0.42u AS=0.063p AD=0.0798p PS=0.72u PD=0.8u rfmode=0
M$44984 \$1776 \$1777 \$1774 VDD|in|pad|pin1|pin2|supply|vdd sg13_lv_pmos
+ L=0.13u W=0.42u AS=0.0798p AD=0.1428p PS=0.8u PD=1.52u rfmode=0
M$44985 VDD|in|pad|pin1|pin2|supply|vdd \$1845 \$1780
+ VDD|in|pad|pin1|pin2|supply|vdd sg13_lv_pmos L=0.13u W=0.42u AS=0.4659p
+ AD=0.0798p PS=3.65u PD=0.8u rfmode=0
M$44986 VDD|in|pad|pin1|pin2|supply|vdd \$1197 \$1780
+ VDD|in|pad|pin1|pin2|supply|vdd sg13_lv_pmos L=0.13u W=0.42u AS=0.204p
+ AD=0.0798p PS=1.835u PD=0.8u rfmode=0
M$44987 VDD|in|pad|pin1|pin2|supply|vdd \$1780 \$1863
+ VDD|in|pad|pin1|pin2|supply|vdd sg13_lv_pmos L=0.13u W=0.42u AS=0.204p
+ AD=0.09345p PS=1.835u PD=0.865u rfmode=0
M$44988 \$1845 \$1781 \$1863 VDD|in|pad|pin1|pin2|supply|vdd sg13_lv_pmos
+ L=0.13u W=0.42u AS=0.2048p AD=0.09345p PS=1.63u PD=0.865u rfmode=0
M$44989 \$1845 \$1782 \$1847 VDD|in|pad|pin1|pin2|supply|vdd sg13_lv_pmos
+ L=0.13u W=1u AS=0.2048p AD=0.34p PS=1.63u PD=2.68u rfmode=0
M$44990 \$1718 \$1781 \$1783 VDD|in|pad|pin1|pin2|supply|vdd sg13_lv_pmos
+ L=0.13u W=0.42u AS=0.1428p AD=0.0798p PS=1.52u PD=0.8u rfmode=0
M$44991 \$1783 \$1782 \$1831 VDD|in|pad|pin1|pin2|supply|vdd sg13_lv_pmos
+ L=0.13u W=0.42u AS=0.0798p AD=0.063p PS=0.8u PD=0.72u rfmode=0
M$44992 VDD|in|pad|pin1|pin2|supply|vdd \$1847 \$1831
+ VDD|in|pad|pin1|pin2|supply|vdd sg13_lv_pmos L=0.13u W=0.42u AS=0.1563p
+ AD=0.063p PS=1.22u PD=0.72u rfmode=0
M$44993 VDD|in|pad|pin1|pin2|supply|vdd \$1197 \$1783
+ VDD|in|pad|pin1|pin2|supply|vdd sg13_lv_pmos L=0.13u W=0.42u AS=0.1563p
+ AD=0.147p PS=1.22u PD=1.54u rfmode=0
M$44994 VDD|in|pad|pin1|pin2|supply|vdd \$1848 \$1786
+ VDD|in|pad|pin1|pin2|supply|vdd sg13_lv_pmos L=0.13u W=0.42u AS=0.4659p
+ AD=0.0798p PS=3.65u PD=0.8u rfmode=0
M$44995 VDD|in|pad|pin1|pin2|supply|vdd \$1468 \$1786
+ VDD|in|pad|pin1|pin2|supply|vdd sg13_lv_pmos L=0.13u W=0.42u AS=0.204p
+ AD=0.0798p PS=1.835u PD=0.8u rfmode=0
M$44996 VDD|in|pad|pin1|pin2|supply|vdd \$1786 \$1864
+ VDD|in|pad|pin1|pin2|supply|vdd sg13_lv_pmos L=0.13u W=0.42u AS=0.204p
+ AD=0.09345p PS=1.835u PD=0.865u rfmode=0
M$44997 \$1848 \$1787 \$1864 VDD|in|pad|pin1|pin2|supply|vdd sg13_lv_pmos
+ L=0.13u W=0.42u AS=0.2048p AD=0.09345p PS=1.63u PD=0.865u rfmode=0
M$44998 \$1848 \$1788 \$1850 VDD|in|pad|pin1|pin2|supply|vdd sg13_lv_pmos
+ L=0.13u W=1u AS=0.2048p AD=0.34p PS=1.63u PD=2.68u rfmode=0
M$44999 \$1724 \$1787 \$1789 VDD|in|pad|pin1|pin2|supply|vdd sg13_lv_pmos
+ L=0.13u W=0.42u AS=0.1428p AD=0.0798p PS=1.52u PD=0.8u rfmode=0
M$45000 \$1789 \$1788 \$1833 VDD|in|pad|pin1|pin2|supply|vdd sg13_lv_pmos
+ L=0.13u W=0.42u AS=0.0798p AD=0.063p PS=0.8u PD=0.72u rfmode=0
M$45001 VDD|in|pad|pin1|pin2|supply|vdd \$1850 \$1833
+ VDD|in|pad|pin1|pin2|supply|vdd sg13_lv_pmos L=0.13u W=0.42u AS=0.1563p
+ AD=0.063p PS=1.22u PD=0.72u rfmode=0
M$45002 VDD|in|pad|pin1|pin2|supply|vdd \$1468 \$1789
+ VDD|in|pad|pin1|pin2|supply|vdd sg13_lv_pmos L=0.13u W=0.42u AS=0.1563p
+ AD=0.147p PS=1.22u PD=1.54u rfmode=0
M$45003 VDD|in|pad|pin1|pin2|supply|vdd \$1475 \$1793
+ VDD|in|pad|pin1|pin2|supply|vdd sg13_lv_pmos L=0.13u W=0.42u AS=0.1563p
+ AD=0.147p PS=1.22u PD=1.54u rfmode=0
M$45004 VDD|in|pad|pin1|pin2|supply|vdd \$1792 \$1835
+ VDD|in|pad|pin1|pin2|supply|vdd sg13_lv_pmos L=0.13u W=0.42u AS=0.1563p
+ AD=0.063p PS=1.22u PD=0.72u rfmode=0
M$45005 \$1835 \$1795 \$1793 VDD|in|pad|pin1|pin2|supply|vdd sg13_lv_pmos
+ L=0.13u W=0.42u AS=0.063p AD=0.0798p PS=0.72u PD=0.8u rfmode=0
M$45006 \$1793 \$1794 \$1791 VDD|in|pad|pin1|pin2|supply|vdd sg13_lv_pmos
+ L=0.13u W=0.42u AS=0.0798p AD=0.1428p PS=0.8u PD=1.52u rfmode=0
M$45007 VDD|in|pad|pin1|pin2|supply|vdd \$1484 \$1801
+ VDD|in|pad|pin1|pin2|supply|vdd sg13_lv_pmos L=0.13u W=0.42u AS=0.1563p
+ AD=0.147p PS=1.22u PD=1.54u rfmode=0
M$45008 VDD|in|pad|pin1|pin2|supply|vdd \$1800 \$1837
+ VDD|in|pad|pin1|pin2|supply|vdd sg13_lv_pmos L=0.13u W=0.42u AS=0.1563p
+ AD=0.063p PS=1.22u PD=0.72u rfmode=0
M$45009 \$1837 \$1803 \$1801 VDD|in|pad|pin1|pin2|supply|vdd sg13_lv_pmos
+ L=0.13u W=0.42u AS=0.063p AD=0.0798p PS=0.72u PD=0.8u rfmode=0
M$45010 \$1801 \$1802 \$1799 VDD|in|pad|pin1|pin2|supply|vdd sg13_lv_pmos
+ L=0.13u W=0.42u AS=0.0798p AD=0.1428p PS=0.8u PD=1.52u rfmode=0
M$45011 VDD|in|pad|pin1|pin2|supply|vdd \$1506 \$1810
+ VDD|in|pad|pin1|pin2|supply|vdd sg13_lv_pmos L=0.13u W=0.42u AS=0.1563p
+ AD=0.147p PS=1.22u PD=1.54u rfmode=0
M$45012 VDD|in|pad|pin1|pin2|supply|vdd \$1809 \$1836
+ VDD|in|pad|pin1|pin2|supply|vdd sg13_lv_pmos L=0.13u W=0.42u AS=0.1563p
+ AD=0.063p PS=1.22u PD=0.72u rfmode=0
M$45013 \$1836 \$1812 \$1810 VDD|in|pad|pin1|pin2|supply|vdd sg13_lv_pmos
+ L=0.13u W=0.42u AS=0.063p AD=0.0798p PS=0.72u PD=0.8u rfmode=0
M$45014 \$1810 \$1811 \$1808 VDD|in|pad|pin1|pin2|supply|vdd sg13_lv_pmos
+ L=0.13u W=0.42u AS=0.0798p AD=0.1428p PS=0.8u PD=1.52u rfmode=0
M$45015 VDD|in|pad|pin1|pin2|supply|vdd \$1522 \$1818
+ VDD|in|pad|pin1|pin2|supply|vdd sg13_lv_pmos L=0.13u W=0.42u AS=0.1563p
+ AD=0.147p PS=1.22u PD=1.54u rfmode=0
M$45016 VDD|in|pad|pin1|pin2|supply|vdd \$1817 \$1834
+ VDD|in|pad|pin1|pin2|supply|vdd sg13_lv_pmos L=0.13u W=0.42u AS=0.1563p
+ AD=0.063p PS=1.22u PD=0.72u rfmode=0
M$45017 \$1834 \$1820 \$1818 VDD|in|pad|pin1|pin2|supply|vdd sg13_lv_pmos
+ L=0.13u W=0.42u AS=0.063p AD=0.0798p PS=0.72u PD=0.8u rfmode=0
M$45018 \$1818 \$1819 \$1816 VDD|in|pad|pin1|pin2|supply|vdd sg13_lv_pmos
+ L=0.13u W=0.42u AS=0.0798p AD=0.1428p PS=0.8u PD=1.52u rfmode=0
M$45019 VDD|in|pad|pin1|pin2|supply|vdd \$1529 \$1825
+ VDD|in|pad|pin1|pin2|supply|vdd sg13_lv_pmos L=0.13u W=0.42u AS=0.1563p
+ AD=0.147p PS=1.22u PD=1.54u rfmode=0
M$45020 VDD|in|pad|pin1|pin2|supply|vdd \$1824 \$1832
+ VDD|in|pad|pin1|pin2|supply|vdd sg13_lv_pmos L=0.13u W=0.42u AS=0.1563p
+ AD=0.063p PS=1.22u PD=0.72u rfmode=0
M$45021 \$1832 \$1827 \$1825 VDD|in|pad|pin1|pin2|supply|vdd sg13_lv_pmos
+ L=0.13u W=0.42u AS=0.063p AD=0.0798p PS=0.72u PD=0.8u rfmode=0
M$45022 \$1825 \$1826 \$1823 VDD|in|pad|pin1|pin2|supply|vdd sg13_lv_pmos
+ L=0.13u W=0.42u AS=0.0798p AD=0.1428p PS=0.8u PD=1.52u rfmode=0
M$45023 core|done_in|p2c|ui_p2c[4] \$2051 VDD|in|pad|pin1|pin2|supply|vdd
+ VDD|in|pad|pin1|pin2|supply|vdd sg13_lv_pmos L=0.13u W=4.75u AS=1.615p
+ AD=1.615p PS=10.18u PD=10.18u rfmode=0
M$45024 VDD|in|pad|pin1|pin2|supply|vdd \$2076 \$2175
+ VDD|in|pad|pin1|pin2|supply|vdd sg13_lv_pmos L=0.13u W=0.42u AS=0.1428p
+ AD=0.0798p PS=1.52u PD=0.8u rfmode=0
M$45025 VDD|in|pad|pin1|pin2|supply|vdd \$2184 \$2175
+ VDD|in|pad|pin1|pin2|supply|vdd sg13_lv_pmos L=0.13u W=0.42u AS=0.3623875p
+ AD=0.0798p PS=2.605u PD=0.8u rfmode=0
M$45026 VDD|in|pad|pin1|pin2|supply|vdd \$2207 \$2206
+ VDD|in|pad|pin1|pin2|supply|vdd sg13_lv_pmos L=0.13u W=1u AS=0.3623875p
+ AD=0.34p PS=2.605u PD=2.68u rfmode=0
M$45027 VDD|in|pad|pin1|pin2|supply|vdd \$2184 \$2207
+ VDD|in|pad|pin1|pin2|supply|vdd sg13_lv_pmos L=0.13u W=0.42u AS=0.1563p
+ AD=0.147p PS=1.22u PD=1.54u rfmode=0
M$45028 VDD|in|pad|pin1|pin2|supply|vdd \$2206 \$2240
+ VDD|in|pad|pin1|pin2|supply|vdd sg13_lv_pmos L=0.13u W=0.42u AS=0.1563p
+ AD=0.063p PS=1.22u PD=0.72u rfmode=0
M$45029 \$2240 \$2246 \$2207 VDD|in|pad|pin1|pin2|supply|vdd sg13_lv_pmos
+ L=0.13u W=0.42u AS=0.063p AD=0.0798p PS=0.72u PD=0.8u rfmode=0
M$45030 \$2207 \$2208 \$2175 VDD|in|pad|pin1|pin2|supply|vdd sg13_lv_pmos
+ L=0.13u W=0.42u AS=0.0798p AD=0.1428p PS=0.8u PD=1.52u rfmode=0
M$45031 \$2352 \$2308 VDD|in|pad|pin1|pin2|supply|vdd
+ VDD|in|pad|pin1|pin2|supply|vdd sg13_lv_pmos L=0.13u W=1.12u AS=0.3864p
+ AD=0.41165p PS=2.93u PD=2.12u rfmode=0
M$45032 VDD|in|pad|pin1|pin2|supply|vdd \$2247 \$2308
+ VDD|in|pad|pin1|pin2|supply|vdd sg13_lv_pmos L=0.13u W=1.12u AS=0.41165p
+ AD=0.4088p PS=2.12u PD=2.97u rfmode=0
M$45033 \$2206 \$2246 \$2209 VDD|in|pad|pin1|pin2|supply|vdd sg13_lv_pmos
+ L=0.13u W=1u AS=0.34p AD=0.2048p PS=2.68u PD=1.63u rfmode=0
M$45034 \$2209 \$2208 \$2258 VDD|in|pad|pin1|pin2|supply|vdd sg13_lv_pmos
+ L=0.13u W=0.42u AS=0.2048p AD=0.09345p PS=1.63u PD=0.865u rfmode=0
M$45035 VDD|in|pad|pin1|pin2|supply|vdd \$2210 \$2258
+ VDD|in|pad|pin1|pin2|supply|vdd sg13_lv_pmos L=0.13u W=0.42u AS=0.204p
+ AD=0.09345p PS=1.835u PD=0.865u rfmode=0
M$45036 VDD|in|pad|pin1|pin2|supply|vdd \$2184 \$2210
+ VDD|in|pad|pin1|pin2|supply|vdd sg13_lv_pmos L=0.13u W=0.42u AS=0.204p
+ AD=0.0798p PS=1.835u PD=0.8u rfmode=0
M$45037 VDD|in|pad|pin1|pin2|supply|vdd \$2209 \$2210
+ VDD|in|pad|pin1|pin2|supply|vdd sg13_lv_pmos L=0.13u W=0.42u AS=0.4659p
+ AD=0.0798p PS=3.65u PD=0.8u rfmode=0
M$45038 \$2315 \$2327 VDD|in|pad|pin1|pin2|supply|vdd
+ VDD|in|pad|pin1|pin2|supply|vdd sg13_lv_pmos L=0.13u W=1.12u AS=0.3864p
+ AD=0.2128p PS=2.93u PD=1.5u rfmode=0
M$45039 VDD|in|pad|pin1|pin2|supply|vdd \$2315 \$2245
+ VDD|in|pad|pin1|pin2|supply|vdd sg13_lv_pmos L=0.13u W=1.12u AS=0.2128p
+ AD=0.3808p PS=1.5u PD=2.92u rfmode=0
M$45040 VDD|in|pad|pin1|pin2|supply|vdd En|dout[1] \$2328
+ VDD|in|pad|pin1|pin2|supply|vdd sg13_lv_pmos L=0.13u W=0.84u AS=0.2114p
+ AD=0.2856p PS=1.54u PD=2.36u rfmode=0
M$45041 VDD|in|pad|pin1|pin2|supply|vdd \$2328 \$2134
+ VDD|in|pad|pin1|pin2|supply|vdd sg13_lv_pmos L=0.13u W=1.12u AS=0.2114p
+ AD=0.42p PS=1.54u PD=2.99u rfmode=0
M$45042 VDD|in|pad|pin1|pin2|supply|vdd \$2080 \$2176
+ VDD|in|pad|pin1|pin2|supply|vdd sg13_lv_pmos L=0.13u W=0.42u AS=0.1428p
+ AD=0.0798p PS=1.52u PD=0.8u rfmode=0
M$45043 VDD|in|pad|pin1|pin2|supply|vdd \$2177 \$2176
+ VDD|in|pad|pin1|pin2|supply|vdd sg13_lv_pmos L=0.13u W=0.42u AS=0.3623875p
+ AD=0.0798p PS=2.605u PD=0.8u rfmode=0
M$45044 VDD|in|pad|pin1|pin2|supply|vdd \$2212 \$2211
+ VDD|in|pad|pin1|pin2|supply|vdd sg13_lv_pmos L=0.13u W=1u AS=0.3623875p
+ AD=0.34p PS=2.605u PD=2.68u rfmode=0
M$45045 \$2247 \$2329 VDD|in|pad|pin1|pin2|supply|vdd
+ VDD|in|pad|pin1|pin2|supply|vdd sg13_lv_pmos L=0.13u W=1.12u AS=0.42p
+ AD=0.2114p PS=2.99u PD=1.54u rfmode=0
M$45046 VDD|in|pad|pin1|pin2|supply|vdd \$2530 \$2329
+ VDD|in|pad|pin1|pin2|supply|vdd sg13_lv_pmos L=0.13u W=0.84u AS=0.2114p
+ AD=0.2856p PS=1.54u PD=2.36u rfmode=0
M$45047 VDD|in|pad|pin1|pin2|supply|vdd \$2177 \$2212
+ VDD|in|pad|pin1|pin2|supply|vdd sg13_lv_pmos L=0.13u W=0.42u AS=0.1563p
+ AD=0.147p PS=1.22u PD=1.54u rfmode=0
M$45048 VDD|in|pad|pin1|pin2|supply|vdd \$2211 \$2243
+ VDD|in|pad|pin1|pin2|supply|vdd sg13_lv_pmos L=0.13u W=0.42u AS=0.1563p
+ AD=0.063p PS=1.22u PD=0.72u rfmode=0
M$45049 \$2243 \$2249 \$2212 VDD|in|pad|pin1|pin2|supply|vdd sg13_lv_pmos
+ L=0.13u W=0.42u AS=0.063p AD=0.0798p PS=0.72u PD=0.8u rfmode=0
M$45050 \$2212 \$2213 \$2176 VDD|in|pad|pin1|pin2|supply|vdd sg13_lv_pmos
+ L=0.13u W=0.42u AS=0.0798p AD=0.1428p PS=0.8u PD=1.52u rfmode=0
M$45051 \$2211 \$2249 \$2214 VDD|in|pad|pin1|pin2|supply|vdd sg13_lv_pmos
+ L=0.13u W=1u AS=0.34p AD=0.2048p PS=2.68u PD=1.63u rfmode=0
M$45052 \$2214 \$2213 \$2259 VDD|in|pad|pin1|pin2|supply|vdd sg13_lv_pmos
+ L=0.13u W=0.42u AS=0.2048p AD=0.09345p PS=1.63u PD=0.865u rfmode=0
M$45053 VDD|in|pad|pin1|pin2|supply|vdd \$2215 \$2259
+ VDD|in|pad|pin1|pin2|supply|vdd sg13_lv_pmos L=0.13u W=0.42u AS=0.204p
+ AD=0.09345p PS=1.835u PD=0.865u rfmode=0
M$45054 VDD|in|pad|pin1|pin2|supply|vdd \$2177 \$2215
+ VDD|in|pad|pin1|pin2|supply|vdd sg13_lv_pmos L=0.13u W=0.42u AS=0.204p
+ AD=0.0798p PS=1.835u PD=0.8u rfmode=0
M$45055 VDD|in|pad|pin1|pin2|supply|vdd \$2214 \$2215
+ VDD|in|pad|pin1|pin2|supply|vdd sg13_lv_pmos L=0.13u W=0.42u AS=0.4659p
+ AD=0.0798p PS=3.65u PD=0.8u rfmode=0
M$45056 \$2353 \$2310 VDD|in|pad|pin1|pin2|supply|vdd
+ VDD|in|pad|pin1|pin2|supply|vdd sg13_lv_pmos L=0.13u W=1.12u AS=0.3864p
+ AD=0.41165p PS=2.93u PD=2.12u rfmode=0
M$45057 VDD|in|pad|pin1|pin2|supply|vdd \$2368 \$2310
+ VDD|in|pad|pin1|pin2|supply|vdd sg13_lv_pmos L=0.13u W=1.12u AS=0.41165p
+ AD=0.4088p PS=2.12u PD=2.97u rfmode=0
M$45058 VDD|in|pad|pin1|pin2|supply|vdd \$2083 \$2178
+ VDD|in|pad|pin1|pin2|supply|vdd sg13_lv_pmos L=0.13u W=0.42u AS=0.1428p
+ AD=0.0798p PS=1.52u PD=0.8u rfmode=0
M$45059 VDD|in|pad|pin1|pin2|supply|vdd \$2179 \$2178
+ VDD|in|pad|pin1|pin2|supply|vdd sg13_lv_pmos L=0.13u W=0.42u AS=0.3623875p
+ AD=0.0798p PS=2.605u PD=0.8u rfmode=0
M$45060 VDD|in|pad|pin1|pin2|supply|vdd \$2217 \$2216
+ VDD|in|pad|pin1|pin2|supply|vdd sg13_lv_pmos L=0.13u W=1u AS=0.3623875p
+ AD=0.34p PS=2.605u PD=2.68u rfmode=0
M$45061 VDD|in|pad|pin1|pin2|supply|vdd \$2179 \$2217
+ VDD|in|pad|pin1|pin2|supply|vdd sg13_lv_pmos L=0.13u W=0.42u AS=0.1563p
+ AD=0.147p PS=1.22u PD=1.54u rfmode=0
M$45062 VDD|in|pad|pin1|pin2|supply|vdd \$2216 \$2244
+ VDD|in|pad|pin1|pin2|supply|vdd sg13_lv_pmos L=0.13u W=0.42u AS=0.1563p
+ AD=0.063p PS=1.22u PD=0.72u rfmode=0
M$45063 \$2244 \$2250 \$2217 VDD|in|pad|pin1|pin2|supply|vdd sg13_lv_pmos
+ L=0.13u W=0.42u AS=0.063p AD=0.0798p PS=0.72u PD=0.8u rfmode=0
M$45064 \$2217 \$2218 \$2178 VDD|in|pad|pin1|pin2|supply|vdd sg13_lv_pmos
+ L=0.13u W=0.42u AS=0.0798p AD=0.1428p PS=0.8u PD=1.52u rfmode=0
M$45065 \$2319 \$2331 VDD|in|pad|pin1|pin2|supply|vdd
+ VDD|in|pad|pin1|pin2|supply|vdd sg13_lv_pmos L=0.13u W=1.12u AS=0.3864p
+ AD=0.2128p PS=2.93u PD=1.5u rfmode=0
M$45066 VDD|in|pad|pin1|pin2|supply|vdd \$2319 \$2349
+ VDD|in|pad|pin1|pin2|supply|vdd sg13_lv_pmos L=0.13u W=1.12u AS=0.2128p
+ AD=0.3808p PS=1.5u PD=2.92u rfmode=0
M$45067 VDD|in|pad|pin1|pin2|supply|vdd \$2348 \$2332
+ VDD|in|pad|pin1|pin2|supply|vdd sg13_lv_pmos L=0.5u W=1u AS=0.2254p AD=0.34p
+ PS=1.53u PD=2.68u rfmode=0
M$45068 \$2133 \$2332 VDD|in|pad|pin1|pin2|supply|vdd
+ VDD|in|pad|pin1|pin2|supply|vdd sg13_lv_pmos L=0.13u W=1.12u AS=0.4256p
+ AD=0.2254p PS=3u PD=1.53u rfmode=0
M$45069 \$2216 \$2250 \$2219 VDD|in|pad|pin1|pin2|supply|vdd sg13_lv_pmos
+ L=0.13u W=1u AS=0.34p AD=0.2048p PS=2.68u PD=1.63u rfmode=0
M$45070 \$2219 \$2218 \$2260 VDD|in|pad|pin1|pin2|supply|vdd sg13_lv_pmos
+ L=0.13u W=0.42u AS=0.2048p AD=0.09345p PS=1.63u PD=0.865u rfmode=0
M$45071 VDD|in|pad|pin1|pin2|supply|vdd \$2220 \$2260
+ VDD|in|pad|pin1|pin2|supply|vdd sg13_lv_pmos L=0.13u W=0.42u AS=0.204p
+ AD=0.09345p PS=1.835u PD=0.865u rfmode=0
M$45072 VDD|in|pad|pin1|pin2|supply|vdd \$2179 \$2220
+ VDD|in|pad|pin1|pin2|supply|vdd sg13_lv_pmos L=0.13u W=0.42u AS=0.204p
+ AD=0.0798p PS=1.835u PD=0.8u rfmode=0
M$45073 VDD|in|pad|pin1|pin2|supply|vdd \$2219 \$2220
+ VDD|in|pad|pin1|pin2|supply|vdd sg13_lv_pmos L=0.13u W=0.42u AS=0.4659p
+ AD=0.0798p PS=3.65u PD=0.8u rfmode=0
M$45074 VDD|in|pad|pin1|pin2|supply|vdd \$2322 \$2350
+ VDD|in|pad|pin1|pin2|supply|vdd sg13_lv_pmos L=0.13u W=17.92u AS=3.5896p
+ AD=3.4048p PS=25.45u PD=24u rfmode=0
M$45090 VDD|in|pad|pin1|pin2|supply|vdd \$2433 \$2322
+ VDD|in|pad|pin1|pin2|supply|vdd sg13_lv_pmos L=0.13u W=6.72u AS=1.2768p
+ AD=1.4448p PS=9u PD=10.42u rfmode=0
M$45096 VDD|in|pad|pin1|pin2|supply|vdd \$2274 \$2180
+ VDD|in|pad|pin1|pin2|supply|vdd sg13_lv_pmos L=0.13u W=0.42u AS=0.1428p
+ AD=0.0798p PS=1.52u PD=0.8u rfmode=0
M$45097 VDD|in|pad|pin1|pin2|supply|vdd \$2252 \$2180
+ VDD|in|pad|pin1|pin2|supply|vdd sg13_lv_pmos L=0.13u W=0.42u AS=0.3623875p
+ AD=0.0798p PS=2.605u PD=0.8u rfmode=0
M$45098 VDD|in|pad|pin1|pin2|supply|vdd \$2224 \$2223
+ VDD|in|pad|pin1|pin2|supply|vdd sg13_lv_pmos L=0.13u W=1u AS=0.3623875p
+ AD=0.34p PS=2.605u PD=2.68u rfmode=0
M$45099 VDD|in|pad|pin1|pin2|supply|vdd \$2252 \$2224
+ VDD|in|pad|pin1|pin2|supply|vdd sg13_lv_pmos L=0.13u W=0.42u AS=0.1563p
+ AD=0.147p PS=1.22u PD=1.54u rfmode=0
M$45100 VDD|in|pad|pin1|pin2|supply|vdd \$2223 \$2242
+ VDD|in|pad|pin1|pin2|supply|vdd sg13_lv_pmos L=0.13u W=0.42u AS=0.1563p
+ AD=0.063p PS=1.22u PD=0.72u rfmode=0
M$45101 \$2242 \$2253 \$2224 VDD|in|pad|pin1|pin2|supply|vdd sg13_lv_pmos
+ L=0.13u W=0.42u AS=0.063p AD=0.0798p PS=0.72u PD=0.8u rfmode=0
M$45102 \$2224 \$2225 \$2180 VDD|in|pad|pin1|pin2|supply|vdd sg13_lv_pmos
+ L=0.13u W=0.42u AS=0.0798p AD=0.1428p PS=0.8u PD=1.52u rfmode=0
M$45103 VDD|in|pad|pin1|pin2|supply|vdd \$2351 \$2333
+ VDD|in|pad|pin1|pin2|supply|vdd sg13_lv_pmos L=0.5u W=1u AS=0.2254p AD=0.34p
+ PS=1.53u PD=2.68u rfmode=0
M$45104 \$2321 \$2333 VDD|in|pad|pin1|pin2|supply|vdd
+ VDD|in|pad|pin1|pin2|supply|vdd sg13_lv_pmos L=0.13u W=1.12u AS=0.4256p
+ AD=0.2254p PS=3u PD=1.53u rfmode=0
M$45105 \$2223 \$2253 \$2226 VDD|in|pad|pin1|pin2|supply|vdd sg13_lv_pmos
+ L=0.13u W=1u AS=0.34p AD=0.2048p PS=2.68u PD=1.63u rfmode=0
M$45106 \$2226 \$2225 \$2262 VDD|in|pad|pin1|pin2|supply|vdd sg13_lv_pmos
+ L=0.13u W=0.42u AS=0.2048p AD=0.09345p PS=1.63u PD=0.865u rfmode=0
M$45107 VDD|in|pad|pin1|pin2|supply|vdd \$2227 \$2262
+ VDD|in|pad|pin1|pin2|supply|vdd sg13_lv_pmos L=0.13u W=0.42u AS=0.204p
+ AD=0.09345p PS=1.835u PD=0.865u rfmode=0
M$45108 VDD|in|pad|pin1|pin2|supply|vdd \$2252 \$2227
+ VDD|in|pad|pin1|pin2|supply|vdd sg13_lv_pmos L=0.13u W=0.42u AS=0.204p
+ AD=0.0798p PS=1.835u PD=0.8u rfmode=0
M$45109 VDD|in|pad|pin1|pin2|supply|vdd \$2226 \$2227
+ VDD|in|pad|pin1|pin2|supply|vdd sg13_lv_pmos L=0.13u W=0.42u AS=0.4659p
+ AD=0.0798p PS=3.65u PD=0.8u rfmode=0
M$45110 VDD|in|pad|pin1|pin2|supply|vdd \$2350 \$2324
+ VDD|in|pad|pin1|pin2|supply|vdd sg13_lv_pmos L=0.13u W=6.72u AS=1.4448p
+ AD=1.2768p PS=10.42u PD=9u rfmode=0
M$45116 VDD|in|pad|pin1|pin2|supply|vdd \$2324 \$2325
+ VDD|in|pad|pin1|pin2|supply|vdd sg13_lv_pmos L=0.13u W=17.92u AS=3.4048p
+ AD=3.5896p PS=24u PD=25.45u rfmode=0
M$45132 VDD|in|pad|pin1|pin2|supply|vdd \$2197 \$2181
+ VDD|in|pad|pin1|pin2|supply|vdd sg13_lv_pmos L=0.13u W=0.42u AS=0.1428p
+ AD=0.0798p PS=1.52u PD=0.8u rfmode=0
M$45133 VDD|in|pad|pin1|pin2|supply|vdd \$2254 \$2181
+ VDD|in|pad|pin1|pin2|supply|vdd sg13_lv_pmos L=0.13u W=0.42u AS=0.3623875p
+ AD=0.0798p PS=2.605u PD=0.8u rfmode=0
M$45134 VDD|in|pad|pin1|pin2|supply|vdd \$2229 \$2228
+ VDD|in|pad|pin1|pin2|supply|vdd sg13_lv_pmos L=0.13u W=1u AS=0.3623875p
+ AD=0.34p PS=2.605u PD=2.68u rfmode=0
M$45135 VDD|in|pad|pin1|pin2|supply|vdd \$2254 \$2229
+ VDD|in|pad|pin1|pin2|supply|vdd sg13_lv_pmos L=0.13u W=0.42u AS=0.1563p
+ AD=0.147p PS=1.22u PD=1.54u rfmode=0
M$45136 VDD|in|pad|pin1|pin2|supply|vdd \$2228 \$2241
+ VDD|in|pad|pin1|pin2|supply|vdd sg13_lv_pmos L=0.13u W=0.42u AS=0.1563p
+ AD=0.063p PS=1.22u PD=0.72u rfmode=0
M$45137 \$2241 \$2255 \$2229 VDD|in|pad|pin1|pin2|supply|vdd sg13_lv_pmos
+ L=0.13u W=0.42u AS=0.063p AD=0.0798p PS=0.72u PD=0.8u rfmode=0
M$45138 \$2229 \$2230 \$2181 VDD|in|pad|pin1|pin2|supply|vdd sg13_lv_pmos
+ L=0.13u W=0.42u AS=0.0798p AD=0.1428p PS=0.8u PD=1.52u rfmode=0
M$45139 VDD|in|pad|pin1|pin2|supply|vdd \$2147 \$2334
+ VDD|in|pad|pin1|pin2|supply|vdd sg13_lv_pmos L=0.13u W=0.84u AS=0.2198p
+ AD=0.2856p PS=1.53u PD=2.36u rfmode=0
M$45140 VDD|in|pad|pin1|pin2|supply|vdd \$2334 \$2106
+ VDD|in|pad|pin1|pin2|supply|vdd sg13_lv_pmos L=0.13u W=1.12u AS=0.3808p
+ AD=0.2128p PS=2.92u PD=1.5u rfmode=0
M$45141 \$2106 \$2073 VDD|in|pad|pin1|pin2|supply|vdd
+ VDD|in|pad|pin1|pin2|supply|vdd sg13_lv_pmos L=0.13u W=1.12u AS=0.2128p
+ AD=0.2198p PS=1.5u PD=1.53u rfmode=0
M$45142 \$2228 \$2255 \$2231 VDD|in|pad|pin1|pin2|supply|vdd sg13_lv_pmos
+ L=0.13u W=1u AS=0.34p AD=0.2048p PS=2.68u PD=1.63u rfmode=0
M$45143 \$2231 \$2230 \$2264 VDD|in|pad|pin1|pin2|supply|vdd sg13_lv_pmos
+ L=0.13u W=0.42u AS=0.2048p AD=0.09345p PS=1.63u PD=0.865u rfmode=0
M$45144 VDD|in|pad|pin1|pin2|supply|vdd \$2232 \$2264
+ VDD|in|pad|pin1|pin2|supply|vdd sg13_lv_pmos L=0.13u W=0.42u AS=0.204p
+ AD=0.09345p PS=1.835u PD=0.865u rfmode=0
M$45145 VDD|in|pad|pin1|pin2|supply|vdd \$2254 \$2232
+ VDD|in|pad|pin1|pin2|supply|vdd sg13_lv_pmos L=0.13u W=0.42u AS=0.204p
+ AD=0.0798p PS=1.835u PD=0.8u rfmode=0
M$45146 VDD|in|pad|pin1|pin2|supply|vdd \$2231 \$2232
+ VDD|in|pad|pin1|pin2|supply|vdd sg13_lv_pmos L=0.13u W=0.42u AS=0.4659p
+ AD=0.0798p PS=3.65u PD=0.8u rfmode=0
M$45147 VDD|in|pad|pin1|pin2|supply|vdd \$2690 \$2233
+ VDD|in|pad|pin1|pin2|supply|vdd sg13_lv_pmos L=0.13u W=0.84u AS=0.253p
+ AD=0.2856p PS=1.53u PD=2.36u rfmode=0
M$45148 VDD|in|pad|pin1|pin2|supply|vdd \$2690 \$2266
+ VDD|in|pad|pin1|pin2|supply|vdd sg13_lv_pmos L=0.13u W=1u AS=0.253p
+ AD=0.3325p PS=1.53u PD=1.665u rfmode=0
M$45149 \$2266 \$2203 \$2200 VDD|in|pad|pin1|pin2|supply|vdd sg13_lv_pmos
+ L=0.13u W=1u AS=0.3325p AD=0.2225p PS=1.665u PD=1.445u rfmode=0
M$45150 \$2200 \$2390 \$2265 VDD|in|pad|pin1|pin2|supply|vdd sg13_lv_pmos
+ L=0.13u W=1u AS=0.2225p AD=0.2975p PS=1.445u PD=1.595u rfmode=0
M$45151 VDD|in|pad|pin1|pin2|supply|vdd \$2233 \$2265
+ VDD|in|pad|pin1|pin2|supply|vdd sg13_lv_pmos L=0.13u W=1u AS=0.2198p
+ AD=0.2975p PS=1.52u PD=1.595u rfmode=0
M$45152 VDD|in|pad|pin1|pin2|supply|vdd \$2200 \$2201
+ VDD|in|pad|pin1|pin2|supply|vdd sg13_lv_pmos L=0.13u W=1.12u AS=0.2198p
+ AD=0.6048p PS=1.52u PD=3.32u rfmode=0
M$45153 VDD|in|pad|pin1|pin2|supply|vdd \$2201 \$2182
+ VDD|in|pad|pin1|pin2|supply|vdd sg13_lv_pmos L=0.13u W=0.42u AS=0.1428p
+ AD=0.0798p PS=1.52u PD=0.8u rfmode=0
M$45154 VDD|in|pad|pin1|pin2|supply|vdd \$2100 \$2182
+ VDD|in|pad|pin1|pin2|supply|vdd sg13_lv_pmos L=0.13u W=0.42u AS=0.3623875p
+ AD=0.0798p PS=2.605u PD=0.8u rfmode=0
M$45155 VDD|in|pad|pin1|pin2|supply|vdd \$2235 \$2234
+ VDD|in|pad|pin1|pin2|supply|vdd sg13_lv_pmos L=0.13u W=1u AS=0.3623875p
+ AD=0.34p PS=2.605u PD=2.68u rfmode=0
M$45156 VDD|in|pad|pin1|pin2|supply|vdd \$2100 \$2235
+ VDD|in|pad|pin1|pin2|supply|vdd sg13_lv_pmos L=0.13u W=0.42u AS=0.1563p
+ AD=0.147p PS=1.22u PD=1.54u rfmode=0
M$45157 VDD|in|pad|pin1|pin2|supply|vdd \$2234 \$2239
+ VDD|in|pad|pin1|pin2|supply|vdd sg13_lv_pmos L=0.13u W=0.42u AS=0.1563p
+ AD=0.063p PS=1.22u PD=0.72u rfmode=0
M$45158 \$2239 \$2257 \$2235 VDD|in|pad|pin1|pin2|supply|vdd sg13_lv_pmos
+ L=0.13u W=0.42u AS=0.063p AD=0.0798p PS=0.72u PD=0.8u rfmode=0
M$45159 \$2235 \$2236 \$2182 VDD|in|pad|pin1|pin2|supply|vdd sg13_lv_pmos
+ L=0.13u W=0.42u AS=0.0798p AD=0.1428p PS=0.8u PD=1.52u rfmode=0
M$45160 \$2256 \$2335 VDD|in|pad|pin1|pin2|supply|vdd
+ VDD|in|pad|pin1|pin2|supply|vdd sg13_lv_pmos L=0.13u W=1.12u AS=0.42p
+ AD=0.2114p PS=2.99u PD=1.54u rfmode=0
M$45161 VDD|in|pad|pin1|pin2|supply|vdd \$2099 \$2335
+ VDD|in|pad|pin1|pin2|supply|vdd sg13_lv_pmos L=0.13u W=0.84u AS=0.2114p
+ AD=0.2856p PS=1.54u PD=2.36u rfmode=0
M$45162 \$2234 \$2257 \$2237 VDD|in|pad|pin1|pin2|supply|vdd sg13_lv_pmos
+ L=0.13u W=1u AS=0.34p AD=0.2048p PS=2.68u PD=1.63u rfmode=0
M$45163 \$2237 \$2236 \$2267 VDD|in|pad|pin1|pin2|supply|vdd sg13_lv_pmos
+ L=0.13u W=0.42u AS=0.2048p AD=0.09345p PS=1.63u PD=0.865u rfmode=0
M$45164 VDD|in|pad|pin1|pin2|supply|vdd \$2238 \$2267
+ VDD|in|pad|pin1|pin2|supply|vdd sg13_lv_pmos L=0.13u W=0.42u AS=0.204p
+ AD=0.09345p PS=1.835u PD=0.865u rfmode=0
M$45165 VDD|in|pad|pin1|pin2|supply|vdd \$2100 \$2238
+ VDD|in|pad|pin1|pin2|supply|vdd sg13_lv_pmos L=0.13u W=0.42u AS=0.204p
+ AD=0.0798p PS=1.835u PD=0.8u rfmode=0
M$45166 VDD|in|pad|pin1|pin2|supply|vdd \$2237 \$2238
+ VDD|in|pad|pin1|pin2|supply|vdd sg13_lv_pmos L=0.13u W=0.42u AS=0.4659p
+ AD=0.0798p PS=3.65u PD=0.8u rfmode=0
M$45181 VDD|in|pad|pin1|pin2|supply|vdd \$2205 \$2311
+ VDD|in|pad|pin1|pin2|supply|vdd sg13_lv_pmos L=0.13u W=1.12u AS=0.3808p
+ AD=0.3808p PS=2.92u PD=2.92u rfmode=0
M$45182 VDD|in|pad|pin1|pin2|supply|vdd \$2343 \$2326
+ VDD|in|pad|pin1|pin2|supply|vdd sg13_lv_pmos L=0.13u W=0.42u AS=0.1428p
+ AD=0.0798p PS=1.52u PD=0.8u rfmode=0
M$45183 VDD|in|pad|pin1|pin2|supply|vdd \$2311 \$2326
+ VDD|in|pad|pin1|pin2|supply|vdd sg13_lv_pmos L=0.13u W=0.42u AS=0.3623875p
+ AD=0.0798p PS=2.605u PD=0.8u rfmode=0
M$45184 VDD|in|pad|pin1|pin2|supply|vdd \$2344 \$2307
+ VDD|in|pad|pin1|pin2|supply|vdd sg13_lv_pmos L=0.13u W=1u AS=0.3623875p
+ AD=0.34p PS=2.605u PD=2.68u rfmode=0
M$45185 \$2327 \$2352 \$2357 VDD|in|pad|pin1|pin2|supply|vdd sg13_lv_pmos
+ L=0.13u W=0.42u AS=0.2048p AD=0.09345p PS=1.63u PD=0.865u rfmode=0
M$45186 \$2357 \$2314 VDD|in|pad|pin1|pin2|supply|vdd
+ VDD|in|pad|pin1|pin2|supply|vdd sg13_lv_pmos L=0.13u W=0.42u AS=0.09345p
+ AD=0.204p PS=0.865u PD=1.835u rfmode=0
M$45187 VDD|in|pad|pin1|pin2|supply|vdd \$2311 \$2314
+ VDD|in|pad|pin1|pin2|supply|vdd sg13_lv_pmos L=0.13u W=0.42u AS=0.204p
+ AD=0.0798p PS=1.835u PD=0.8u rfmode=0
M$45188 \$2314 \$2327 VDD|in|pad|pin1|pin2|supply|vdd
+ VDD|in|pad|pin1|pin2|supply|vdd sg13_lv_pmos L=0.13u W=0.42u AS=0.0798p
+ AD=0.4659p PS=0.8u PD=3.65u rfmode=0
M$45189 \$2307 \$2308 \$2327 VDD|in|pad|pin1|pin2|supply|vdd sg13_lv_pmos
+ L=0.13u W=1u AS=0.34p AD=0.2048p PS=2.68u PD=1.63u rfmode=0
M$45190 \$2177 \$2205 VDD|in|pad|pin1|pin2|supply|vdd
+ VDD|in|pad|pin1|pin2|supply|vdd sg13_lv_pmos L=0.13u W=1.12u AS=0.3808p
+ AD=0.3808p PS=2.92u PD=2.92u rfmode=0
M$45191 VDD|in|pad|pin1|pin2|supply|vdd \$2345 \$2330
+ VDD|in|pad|pin1|pin2|supply|vdd sg13_lv_pmos L=0.13u W=0.42u AS=0.1428p
+ AD=0.0798p PS=1.52u PD=0.8u rfmode=0
M$45192 VDD|in|pad|pin1|pin2|supply|vdd \$2347 \$2330
+ VDD|in|pad|pin1|pin2|supply|vdd sg13_lv_pmos L=0.13u W=0.42u AS=0.3623875p
+ AD=0.0798p PS=2.605u PD=0.8u rfmode=0
M$45193 VDD|in|pad|pin1|pin2|supply|vdd \$2346 \$2309
+ VDD|in|pad|pin1|pin2|supply|vdd sg13_lv_pmos L=0.13u W=1u AS=0.3623875p
+ AD=0.34p PS=2.605u PD=2.68u rfmode=0
M$45194 \$2331 \$2353 \$2359 VDD|in|pad|pin1|pin2|supply|vdd sg13_lv_pmos
+ L=0.13u W=0.42u AS=0.2048p AD=0.09345p PS=1.63u PD=0.865u rfmode=0
M$45195 \$2359 \$2318 VDD|in|pad|pin1|pin2|supply|vdd
+ VDD|in|pad|pin1|pin2|supply|vdd sg13_lv_pmos L=0.13u W=0.42u AS=0.09345p
+ AD=0.204p PS=0.865u PD=1.835u rfmode=0
M$45196 VDD|in|pad|pin1|pin2|supply|vdd \$2347 \$2318
+ VDD|in|pad|pin1|pin2|supply|vdd sg13_lv_pmos L=0.13u W=0.42u AS=0.204p
+ AD=0.0798p PS=1.835u PD=0.8u rfmode=0
M$45197 \$2318 \$2331 VDD|in|pad|pin1|pin2|supply|vdd
+ VDD|in|pad|pin1|pin2|supply|vdd sg13_lv_pmos L=0.13u W=0.42u AS=0.0798p
+ AD=0.4659p PS=0.8u PD=3.65u rfmode=0
M$45198 \$2309 \$2310 \$2331 VDD|in|pad|pin1|pin2|supply|vdd sg13_lv_pmos
+ L=0.13u W=1u AS=0.34p AD=0.2048p PS=2.68u PD=1.63u rfmode=0
M$45199 VDD|in|pad|pin1|pin2|supply|vdd \$2349 \$2320
+ VDD|in|pad|pin1|pin2|supply|vdd sg13_lv_pmos L=0.13u W=0.42u AS=0.1523p
+ AD=0.1428p PS=1.38u PD=1.52u rfmode=0
M$45200 \$2348 \$2320 VDD|in|pad|pin1|pin2|supply|vdd
+ VDD|in|pad|pin1|pin2|supply|vdd sg13_lv_pmos L=0.5u W=1u AS=0.34p AD=0.1523p
+ PS=2.68u PD=1.38u rfmode=0
M$45201 VDD|in|pad|pin1|pin2|supply|vdd \$2195 \$2323
+ VDD|in|pad|pin1|pin2|supply|vdd sg13_lv_pmos L=0.13u W=0.42u AS=0.1523p
+ AD=0.1428p PS=1.38u PD=1.52u rfmode=0
M$45202 \$2351 \$2323 VDD|in|pad|pin1|pin2|supply|vdd
+ VDD|in|pad|pin1|pin2|supply|vdd sg13_lv_pmos L=0.5u W=1u AS=0.34p AD=0.1523p
+ PS=2.68u PD=1.38u rfmode=0
M$45203 \$2254 \$2098 VDD|in|pad|pin1|pin2|supply|vdd
+ VDD|in|pad|pin1|pin2|supply|vdd sg13_lv_pmos L=0.13u W=1.12u AS=0.3808p
+ AD=0.3808p PS=2.92u PD=2.92u rfmode=0
M$45246 VDD|in|pad|pin1|pin2|supply|vdd \$2077 \$2372
+ VDD|in|pad|pin1|pin2|supply|vdd sg13_lv_pmos L=0.13u W=6.72u AS=1.4448p
+ AD=1.2768p PS=10.42u PD=9u rfmode=0
M$45252 VDD|in|pad|pin1|pin2|supply|vdd \$2372 \$2373
+ VDD|in|pad|pin1|pin2|supply|vdd sg13_lv_pmos L=0.13u W=17.92u AS=3.4048p
+ AD=3.5896p PS=24u PD=25.45u rfmode=0
M$45268 \$2344 \$2311 VDD|in|pad|pin1|pin2|supply|vdd
+ VDD|in|pad|pin1|pin2|supply|vdd sg13_lv_pmos L=0.13u W=0.42u AS=0.147p
+ AD=0.1563p PS=1.54u PD=1.22u rfmode=0
M$45269 VDD|in|pad|pin1|pin2|supply|vdd \$2307 \$2365
+ VDD|in|pad|pin1|pin2|supply|vdd sg13_lv_pmos L=0.13u W=0.42u AS=0.1563p
+ AD=0.063p PS=1.22u PD=0.72u rfmode=0
M$45270 \$2365 \$2308 \$2344 VDD|in|pad|pin1|pin2|supply|vdd sg13_lv_pmos
+ L=0.13u W=0.42u AS=0.063p AD=0.0798p PS=0.72u PD=0.8u rfmode=0
M$45271 \$2344 \$2352 \$2326 VDD|in|pad|pin1|pin2|supply|vdd sg13_lv_pmos
+ L=0.13u W=0.42u AS=0.0798p AD=0.1428p PS=0.8u PD=1.52u rfmode=0
M$45272 \$2374 \$2399 VDD|in|pad|pin1|pin2|supply|vdd
+ VDD|in|pad|pin1|pin2|supply|vdd sg13_lv_pmos L=0.13u W=1.12u AS=0.6048p
+ AD=0.2198p PS=3.32u PD=1.52u rfmode=0
M$45273 VDD|in|pad|pin1|pin2|supply|vdd \$2367 \$2398
+ VDD|in|pad|pin1|pin2|supply|vdd sg13_lv_pmos L=0.13u W=1u AS=0.2198p
+ AD=0.2975p PS=1.52u PD=1.595u rfmode=0
M$45274 \$2398 \$2106 \$2399 VDD|in|pad|pin1|pin2|supply|vdd sg13_lv_pmos
+ L=0.13u W=1u AS=0.2975p AD=0.2225p PS=1.595u PD=1.445u rfmode=0
M$45275 \$2399 \$2480 \$2397 VDD|in|pad|pin1|pin2|supply|vdd sg13_lv_pmos
+ L=0.13u W=1u AS=0.2225p AD=0.3325p PS=1.445u PD=1.665u rfmode=0
M$45276 \$2397 \$2375 VDD|in|pad|pin1|pin2|supply|vdd
+ VDD|in|pad|pin1|pin2|supply|vdd sg13_lv_pmos L=0.13u W=1u AS=0.3325p
+ AD=0.253p PS=1.665u PD=1.53u rfmode=0
M$45277 VDD|in|pad|pin1|pin2|supply|vdd \$2375 \$2367
+ VDD|in|pad|pin1|pin2|supply|vdd sg13_lv_pmos L=0.13u W=0.84u AS=0.253p
+ AD=0.2856p PS=1.53u PD=2.36u rfmode=0
M$45279 VDD|in|pad|pin1|pin2|supply|vdd \$2205 \$2347
+ VDD|in|pad|pin1|pin2|supply|vdd sg13_lv_pmos L=0.13u W=1.12u AS=0.3808p
+ AD=0.3808p PS=2.92u PD=2.92u rfmode=0
M$45280 VDD|in|pad|pin1|pin2|supply|vdd \$2376 \$2368
+ VDD|in|pad|pin1|pin2|supply|vdd sg13_lv_pmos L=0.13u W=17.92u AS=3.5896p
+ AD=3.4048p PS=25.45u PD=24u rfmode=0
M$45296 VDD|in|pad|pin1|pin2|supply|vdd \$2350 \$2376
+ VDD|in|pad|pin1|pin2|supply|vdd sg13_lv_pmos L=0.13u W=6.72u AS=1.2768p
+ AD=1.4448p PS=9u PD=10.42u rfmode=0
M$45302 \$2346 \$2347 VDD|in|pad|pin1|pin2|supply|vdd
+ VDD|in|pad|pin1|pin2|supply|vdd sg13_lv_pmos L=0.13u W=0.42u AS=0.147p
+ AD=0.1563p PS=1.54u PD=1.22u rfmode=0
M$45303 VDD|in|pad|pin1|pin2|supply|vdd \$2309 \$2366
+ VDD|in|pad|pin1|pin2|supply|vdd sg13_lv_pmos L=0.13u W=0.42u AS=0.1563p
+ AD=0.063p PS=1.22u PD=0.72u rfmode=0
M$45304 \$2366 \$2310 \$2346 VDD|in|pad|pin1|pin2|supply|vdd sg13_lv_pmos
+ L=0.13u W=0.42u AS=0.063p AD=0.0798p PS=0.72u PD=0.8u rfmode=0
M$45305 \$2346 \$2353 \$2330 VDD|in|pad|pin1|pin2|supply|vdd sg13_lv_pmos
+ L=0.13u W=0.42u AS=0.0798p AD=0.1428p PS=0.8u PD=1.52u rfmode=0
M$45306 VDD|in|pad|pin1|pin2|supply|vdd \$2139 \$2251
+ VDD|in|pad|pin1|pin2|supply|vdd sg13_lv_pmos L=0.13u W=1.12u AS=0.3808p
+ AD=0.2128p PS=2.92u PD=1.5u rfmode=0
M$45307 \$2251 \$2133 VDD|in|pad|pin1|pin2|supply|vdd
+ VDD|in|pad|pin1|pin2|supply|vdd sg13_lv_pmos L=0.13u W=1.12u AS=0.2128p
+ AD=0.2128p PS=1.5u PD=1.5u rfmode=0
M$45308 VDD|in|pad|pin1|pin2|supply|vdd \$2137 \$2251
+ VDD|in|pad|pin1|pin2|supply|vdd sg13_lv_pmos L=0.13u W=1.12u AS=0.2128p
+ AD=0.2128p PS=1.5u PD=1.5u rfmode=0
M$45309 \$2251 \$2134 VDD|in|pad|pin1|pin2|supply|vdd
+ VDD|in|pad|pin1|pin2|supply|vdd sg13_lv_pmos L=0.13u W=1.12u AS=0.2128p
+ AD=0.3808p PS=1.5u PD=2.92u rfmode=0
M$45310 VDD|in|pad|pin1|pin2|supply|vdd \$2134 \$2377
+ VDD|in|pad|pin1|pin2|supply|vdd sg13_lv_pmos L=0.13u W=1.12u AS=0.3808p
+ AD=0.2128p PS=2.92u PD=1.5u rfmode=0
M$45311 \$2377 \$2146 VDD|in|pad|pin1|pin2|supply|vdd
+ VDD|in|pad|pin1|pin2|supply|vdd sg13_lv_pmos L=0.13u W=1.12u AS=0.2128p
+ AD=0.3808p PS=1.5u PD=2.92u rfmode=0
M$45312 \$2143 \$2251 \$2395 VDD|in|pad|pin1|pin2|supply|vdd sg13_lv_pmos
+ L=0.13u W=1.12u AS=0.3808p AD=0.2128p PS=2.92u PD=1.5u rfmode=0
M$45313 \$2395 \$2146 \$2396 VDD|in|pad|pin1|pin2|supply|vdd sg13_lv_pmos
+ L=0.13u W=1.12u AS=0.2128p AD=0.2464p PS=1.5u PD=1.56u rfmode=0
M$45314 \$2396 \$2321 VDD|in|pad|pin1|pin2|supply|vdd
+ VDD|in|pad|pin1|pin2|supply|vdd sg13_lv_pmos L=0.13u W=1.12u AS=0.2464p
+ AD=0.3808p PS=1.56u PD=2.92u rfmode=0
M$45315 VDD|in|pad|pin1|pin2|supply|vdd \$2393 \$2378
+ VDD|in|pad|pin1|pin2|supply|vdd sg13_lv_pmos L=0.13u W=0.84u AS=0.2198p
+ AD=0.2856p PS=1.53u PD=2.36u rfmode=0
M$45316 VDD|in|pad|pin1|pin2|supply|vdd \$2134 \$2379
+ VDD|in|pad|pin1|pin2|supply|vdd sg13_lv_pmos L=0.13u W=1.12u AS=0.2198p
+ AD=0.2128p PS=1.53u PD=1.5u rfmode=0
M$45317 \$2379 \$2383 VDD|in|pad|pin1|pin2|supply|vdd
+ VDD|in|pad|pin1|pin2|supply|vdd sg13_lv_pmos L=0.13u W=1.12u AS=0.2128p
+ AD=0.2128p PS=1.5u PD=1.5u rfmode=0
M$45318 VDD|in|pad|pin1|pin2|supply|vdd \$2378 \$2379
+ VDD|in|pad|pin1|pin2|supply|vdd sg13_lv_pmos L=0.13u W=1.12u AS=0.2128p
+ AD=0.3808p PS=1.5u PD=2.92u rfmode=0
M$45319 VDD|in|pad|pin1|pin2|supply|vdd \$2321 \$2380
+ VDD|in|pad|pin1|pin2|supply|vdd sg13_lv_pmos L=0.13u W=0.84u AS=0.2856p
+ AD=0.1596p PS=2.36u PD=1.22u rfmode=0
M$45320 \$2380 \$2192 VDD|in|pad|pin1|pin2|supply|vdd
+ VDD|in|pad|pin1|pin2|supply|vdd sg13_lv_pmos L=0.13u W=0.84u AS=0.1596p
+ AD=0.1918p PS=1.22u PD=1.5u rfmode=0
M$45321 VDD|in|pad|pin1|pin2|supply|vdd \$2380 \$2274
+ VDD|in|pad|pin1|pin2|supply|vdd sg13_lv_pmos L=0.13u W=1.12u AS=0.1918p
+ AD=0.3808p PS=1.5u PD=2.92u rfmode=0
M$45322 VDD|in|pad|pin1|pin2|supply|vdd \$2400 \$2252
+ VDD|in|pad|pin1|pin2|supply|vdd sg13_lv_pmos L=0.13u W=1.12u AS=0.3808p
+ AD=0.3808p PS=2.92u PD=2.92u rfmode=0
M$45323 \$2382 \$2388 VDD|in|pad|pin1|pin2|supply|vdd
+ VDD|in|pad|pin1|pin2|supply|vdd sg13_lv_pmos L=0.13u W=1.12u AS=0.3864p
+ AD=0.2128p PS=2.93u PD=1.5u rfmode=0
M$45324 VDD|in|pad|pin1|pin2|supply|vdd \$2382 \$2383
+ VDD|in|pad|pin1|pin2|supply|vdd sg13_lv_pmos L=0.13u W=1.12u AS=0.2128p
+ AD=0.3808p PS=1.5u PD=2.92u rfmode=0
M$45327 VDD|in|pad|pin1|pin2|supply|vdd \$2390 \$2385
+ VDD|in|pad|pin1|pin2|supply|vdd sg13_lv_pmos L=0.13u W=0.84u AS=0.2114p
+ AD=0.2856p PS=1.54u PD=2.36u rfmode=0
M$45328 \$2384 \$2385 VDD|in|pad|pin1|pin2|supply|vdd
+ VDD|in|pad|pin1|pin2|supply|vdd sg13_lv_pmos L=0.13u W=1.12u AS=0.42p
+ AD=0.2114p PS=2.99u PD=1.54u rfmode=0
M$45329 VDD|in|pad|pin1|pin2|supply|vdd \$2098 \$2371
+ VDD|in|pad|pin1|pin2|supply|vdd sg13_lv_pmos L=0.13u W=1.12u AS=0.3808p
+ AD=0.3808p PS=2.92u PD=2.92u rfmode=0
M$45362 \$885 \$2444 VDD|in|pad|pin1|pin2|supply|vdd
+ VDD|in|pad|pin1|pin2|supply|vdd sg13_lv_pmos L=0.13u W=1.12u AS=0.42p
+ AD=0.2114p PS=2.99u PD=1.54u rfmode=0
M$45363 VDD|in|pad|pin1|pin2|supply|vdd \$2480 \$2444
+ VDD|in|pad|pin1|pin2|supply|vdd sg13_lv_pmos L=0.13u W=0.84u AS=0.2114p
+ AD=0.2856p PS=1.54u PD=2.36u rfmode=0
M$45378 VDD|in|pad|pin1|pin2|supply|vdd \$2690 \$2465
+ VDD|in|pad|pin1|pin2|supply|vdd sg13_lv_pmos L=0.13u W=0.84u AS=0.253p
+ AD=0.2856p PS=1.53u PD=2.36u rfmode=0
M$45379 VDD|in|pad|pin1|pin2|supply|vdd \$2465 \$2486
+ VDD|in|pad|pin1|pin2|supply|vdd sg13_lv_pmos L=0.13u W=1u AS=0.2198p
+ AD=0.2975p PS=1.52u PD=1.595u rfmode=0
M$45380 \$2486 \$2106 \$2421 VDD|in|pad|pin1|pin2|supply|vdd sg13_lv_pmos
+ L=0.13u W=1u AS=0.2975p AD=0.2225p PS=1.595u PD=1.445u rfmode=0
M$45381 \$2421 \$2245 \$2485 VDD|in|pad|pin1|pin2|supply|vdd sg13_lv_pmos
+ L=0.13u W=1u AS=0.2225p AD=0.3325p PS=1.445u PD=1.665u rfmode=0
M$45382 \$2485 \$2690 VDD|in|pad|pin1|pin2|supply|vdd
+ VDD|in|pad|pin1|pin2|supply|vdd sg13_lv_pmos L=0.13u W=1u AS=0.3325p
+ AD=0.253p PS=1.665u PD=1.53u rfmode=0
M$45383 \$2343 \$2421 VDD|in|pad|pin1|pin2|supply|vdd
+ VDD|in|pad|pin1|pin2|supply|vdd sg13_lv_pmos L=0.13u W=1.12u AS=0.6048p
+ AD=0.2198p PS=3.32u PD=1.52u rfmode=0
M$45385 VDD|in|pad|pin1|pin2|supply|vdd \$2205 \$2422
+ VDD|in|pad|pin1|pin2|supply|vdd sg13_lv_pmos L=0.13u W=1.12u AS=0.3808p
+ AD=0.3808p PS=2.92u PD=2.92u rfmode=0
M$45386 VDD|in|pad|pin1|pin2|supply|vdd \$2374 \$2423
+ VDD|in|pad|pin1|pin2|supply|vdd sg13_lv_pmos L=0.13u W=0.42u AS=0.1428p
+ AD=0.0798p PS=1.52u PD=0.8u rfmode=0
M$45387 VDD|in|pad|pin1|pin2|supply|vdd \$2422 \$2423
+ VDD|in|pad|pin1|pin2|supply|vdd sg13_lv_pmos L=0.13u W=0.42u AS=0.3623875p
+ AD=0.0798p PS=2.605u PD=0.8u rfmode=0
M$45388 VDD|in|pad|pin1|pin2|supply|vdd \$2481 \$2424
+ VDD|in|pad|pin1|pin2|supply|vdd sg13_lv_pmos L=0.13u W=1u AS=0.3623875p
+ AD=0.34p PS=2.605u PD=2.68u rfmode=0
M$45389 \$2446 \$2425 VDD|in|pad|pin1|pin2|supply|vdd
+ VDD|in|pad|pin1|pin2|supply|vdd sg13_lv_pmos L=0.13u W=1.12u AS=0.3864p
+ AD=0.41165p PS=2.93u PD=2.12u rfmode=0
M$45390 VDD|in|pad|pin1|pin2|supply|vdd \$2247 \$2425
+ VDD|in|pad|pin1|pin2|supply|vdd sg13_lv_pmos L=0.13u W=1.12u AS=0.41165p
+ AD=0.4088p PS=2.12u PD=2.97u rfmode=0
M$45391 \$2447 \$2446 \$2489 VDD|in|pad|pin1|pin2|supply|vdd sg13_lv_pmos
+ L=0.13u W=0.42u AS=0.2048p AD=0.09345p PS=1.63u PD=0.865u rfmode=0
M$45392 \$2489 \$2427 VDD|in|pad|pin1|pin2|supply|vdd
+ VDD|in|pad|pin1|pin2|supply|vdd sg13_lv_pmos L=0.13u W=0.42u AS=0.09345p
+ AD=0.204p PS=0.865u PD=1.835u rfmode=0
M$45393 VDD|in|pad|pin1|pin2|supply|vdd \$2422 \$2427
+ VDD|in|pad|pin1|pin2|supply|vdd sg13_lv_pmos L=0.13u W=0.42u AS=0.204p
+ AD=0.0798p PS=1.835u PD=0.8u rfmode=0
M$45394 \$2427 \$2447 VDD|in|pad|pin1|pin2|supply|vdd
+ VDD|in|pad|pin1|pin2|supply|vdd sg13_lv_pmos L=0.13u W=0.42u AS=0.0798p
+ AD=0.4659p PS=0.8u PD=3.65u rfmode=0
M$45395 \$2424 \$2425 \$2447 VDD|in|pad|pin1|pin2|supply|vdd sg13_lv_pmos
+ L=0.13u W=1u AS=0.34p AD=0.2048p PS=2.68u PD=1.63u rfmode=0
M$45396 \$2428 \$2447 VDD|in|pad|pin1|pin2|supply|vdd
+ VDD|in|pad|pin1|pin2|supply|vdd sg13_lv_pmos L=0.13u W=1.12u AS=0.3864p
+ AD=0.2128p PS=2.93u PD=1.5u rfmode=0
M$45397 VDD|in|pad|pin1|pin2|supply|vdd \$2428 \$2480
+ VDD|in|pad|pin1|pin2|supply|vdd sg13_lv_pmos L=0.13u W=1.12u AS=0.2128p
+ AD=0.3808p PS=1.5u PD=2.92u rfmode=0
M$45398 \$2345 \$2448 VDD|in|pad|pin1|pin2|supply|vdd
+ VDD|in|pad|pin1|pin2|supply|vdd sg13_lv_pmos L=0.13u W=1.12u AS=0.3808p
+ AD=0.1918p PS=2.92u PD=1.5u rfmode=0
M$45399 VDD|in|pad|pin1|pin2|supply|vdd \$2466 \$2448
+ VDD|in|pad|pin1|pin2|supply|vdd sg13_lv_pmos L=0.13u W=0.84u AS=0.1918p
+ AD=0.1596p PS=1.5u PD=1.22u rfmode=0
M$45400 \$2448 \$2079 VDD|in|pad|pin1|pin2|supply|vdd
+ VDD|in|pad|pin1|pin2|supply|vdd sg13_lv_pmos L=0.13u W=0.84u AS=0.1596p
+ AD=0.2856p PS=1.22u PD=2.36u rfmode=0
M$45401 \$2466 \$2467 VDD|in|pad|pin1|pin2|supply|vdd
+ VDD|in|pad|pin1|pin2|supply|vdd sg13_lv_pmos L=0.13u W=1.12u AS=0.3808p
+ AD=0.3808p PS=2.92u PD=2.92u rfmode=0
M$45402 \$2467 \$2133 \$2483 VDD|in|pad|pin1|pin2|supply|vdd sg13_lv_pmos
+ L=0.13u W=1u AS=0.35p AD=0.2125p PS=2.7u PD=1.425u rfmode=0
M$45403 \$2483 \$2134 VDD|in|pad|pin1|pin2|supply|vdd
+ VDD|in|pad|pin1|pin2|supply|vdd sg13_lv_pmos L=0.13u W=1u AS=0.2125p AD=0.19p
+ PS=1.425u PD=1.38u rfmode=0
M$45404 VDD|in|pad|pin1|pin2|supply|vdd \$2136 \$2483
+ VDD|in|pad|pin1|pin2|supply|vdd sg13_lv_pmos L=0.13u W=1u AS=0.19p AD=0.34p
+ PS=1.38u PD=2.68u rfmode=0
M$45405 \$2469 \$2393 VDD|in|pad|pin1|pin2|supply|vdd
+ VDD|in|pad|pin1|pin2|supply|vdd sg13_lv_pmos L=0.13u W=1.12u AS=0.3808p
+ AD=0.3808p PS=2.92u PD=2.92u rfmode=0
M$45406 \$2429 \$2449 VDD|in|pad|pin1|pin2|supply|vdd
+ VDD|in|pad|pin1|pin2|supply|vdd sg13_lv_pmos L=0.13u W=1.12u AS=0.42p
+ AD=0.2114p PS=2.99u PD=1.54u rfmode=0
M$45407 VDD|in|pad|pin1|pin2|supply|vdd \$2086 \$2449
+ VDD|in|pad|pin1|pin2|supply|vdd sg13_lv_pmos L=0.13u W=0.84u AS=0.2114p
+ AD=0.2856p PS=1.54u PD=2.36u rfmode=0
M$45408 VDD|in|pad|pin1|pin2|supply|vdd \$2429 \$2450
+ VDD|in|pad|pin1|pin2|supply|vdd sg13_lv_pmos L=0.13u W=0.84u AS=0.2114p
+ AD=0.2856p PS=1.54u PD=2.36u rfmode=0
M$45409 VDD|in|pad|pin1|pin2|supply|vdd \$2450 \$2400
+ VDD|in|pad|pin1|pin2|supply|vdd sg13_lv_pmos L=0.13u W=1.12u AS=0.2114p
+ AD=0.42p PS=1.54u PD=2.99u rfmode=0
M$45410 \$2451 \$2468 VDD|in|pad|pin1|pin2|supply|vdd
+ VDD|in|pad|pin1|pin2|supply|vdd sg13_lv_pmos L=0.13u W=1.12u AS=0.3808p
+ AD=0.3808p PS=2.92u PD=2.92u rfmode=0
M$45411 \$2468 \$2556 \$2484 VDD|in|pad|pin1|pin2|supply|vdd sg13_lv_pmos
+ L=0.13u W=1u AS=0.35p AD=0.2125p PS=2.7u PD=1.425u rfmode=0
M$45412 \$2484 \$2393 VDD|in|pad|pin1|pin2|supply|vdd
+ VDD|in|pad|pin1|pin2|supply|vdd sg13_lv_pmos L=0.13u W=1u AS=0.2125p AD=0.19p
+ PS=1.425u PD=1.38u rfmode=0
M$45413 VDD|in|pad|pin1|pin2|supply|vdd \$2377 \$2484
+ VDD|in|pad|pin1|pin2|supply|vdd sg13_lv_pmos L=0.13u W=1u AS=0.19p AD=0.34p
+ PS=1.38u PD=2.68u rfmode=0
M$45414 VDD|in|pad|pin1|pin2|supply|vdd \$2146 \$2495
+ VDD|in|pad|pin1|pin2|supply|vdd sg13_lv_pmos L=0.15u W=1.12u AS=0.3808p
+ AD=0.2128p PS=2.92u PD=1.5u rfmode=0
M$45415 \$2495 \$2469 \$2431 VDD|in|pad|pin1|pin2|supply|vdd sg13_lv_pmos
+ L=0.15u W=1.12u AS=0.2128p AD=0.2128p PS=1.5u PD=1.5u rfmode=0
M$45416 \$2431 \$2134 VDD|in|pad|pin1|pin2|supply|vdd
+ VDD|in|pad|pin1|pin2|supply|vdd sg13_lv_pmos L=0.15u W=1.12u AS=0.2128p
+ AD=0.3808p PS=1.5u PD=2.92u rfmode=0
M$45417 VDD|in|pad|pin1|pin2|supply|vdd CLK|clk|core|fclk_in|p2c|ui_p2c[6]
+ \$2432 VDD|in|pad|pin1|pin2|supply|vdd sg13_lv_pmos L=0.13u W=6.72u
+ AS=1.4448p AD=1.2768p PS=10.42u PD=9u rfmode=0
M$45423 VDD|in|pad|pin1|pin2|supply|vdd \$2432 \$2433
+ VDD|in|pad|pin1|pin2|supply|vdd sg13_lv_pmos L=0.13u W=17.92u AS=3.4048p
+ AD=3.5896p PS=24u PD=25.45u rfmode=0
M$45439 VDD|in|pad|pin1|pin2|supply|vdd \$2193 \$2369
+ VDD|in|pad|pin1|pin2|supply|vdd sg13_lv_pmos L=0.13u W=0.42u AS=0.1428p
+ AD=0.0798p PS=1.52u PD=0.8u rfmode=0
M$45440 VDD|in|pad|pin1|pin2|supply|vdd \$2370 \$2369
+ VDD|in|pad|pin1|pin2|supply|vdd sg13_lv_pmos L=0.13u W=0.42u AS=0.3623875p
+ AD=0.0798p PS=2.605u PD=0.8u rfmode=0
M$45441 VDD|in|pad|pin1|pin2|supply|vdd \$2381 \$2394
+ VDD|in|pad|pin1|pin2|supply|vdd sg13_lv_pmos L=0.13u W=1u AS=0.3623875p
+ AD=0.34p PS=2.605u PD=2.68u rfmode=0
M$45442 VDD|in|pad|pin1|pin2|supply|vdd \$2370 \$2381
+ VDD|in|pad|pin1|pin2|supply|vdd sg13_lv_pmos L=0.13u W=0.42u AS=0.1563p
+ AD=0.147p PS=1.22u PD=1.54u rfmode=0
M$45443 VDD|in|pad|pin1|pin2|supply|vdd \$2394 \$2391
+ VDD|in|pad|pin1|pin2|supply|vdd sg13_lv_pmos L=0.13u W=0.42u AS=0.1563p
+ AD=0.063p PS=1.22u PD=0.72u rfmode=0
M$45444 \$2391 \$2387 \$2381 VDD|in|pad|pin1|pin2|supply|vdd sg13_lv_pmos
+ L=0.13u W=0.42u AS=0.063p AD=0.0798p PS=0.72u PD=0.8u rfmode=0
M$45445 \$2381 \$2386 \$2369 VDD|in|pad|pin1|pin2|supply|vdd sg13_lv_pmos
+ L=0.13u W=0.42u AS=0.0798p AD=0.1428p PS=0.8u PD=1.52u rfmode=0
M$45446 c2p|core|fdac_clk|i|uo_c2p[0] \$2452 VDD|in|pad|pin1|pin2|supply|vdd
+ VDD|in|pad|pin1|pin2|supply|vdd sg13_lv_pmos L=0.13u W=1.12u AS=0.42p
+ AD=0.2114p PS=2.99u PD=1.54u rfmode=0
M$45447 VDD|in|pad|pin1|pin2|supply|vdd \$2094 \$2452
+ VDD|in|pad|pin1|pin2|supply|vdd sg13_lv_pmos L=0.13u W=0.84u AS=0.2114p
+ AD=0.2856p PS=1.54u PD=2.36u rfmode=0
M$45448 VDD|in|pad|pin1|pin2|supply|vdd \$2387 \$2386
+ VDD|in|pad|pin1|pin2|supply|vdd sg13_lv_pmos L=0.13u W=1.12u AS=0.41165p
+ AD=0.3864p PS=2.12u PD=2.93u rfmode=0
M$45449 VDD|in|pad|pin1|pin2|supply|vdd \$2325 \$2387
+ VDD|in|pad|pin1|pin2|supply|vdd sg13_lv_pmos L=0.13u W=1.12u AS=0.41165p
+ AD=0.4088p PS=2.12u PD=2.97u rfmode=0
M$45450 VDD|in|pad|pin1|pin2|supply|vdd \$2248 \$2434
+ VDD|in|pad|pin1|pin2|supply|vdd sg13_lv_pmos L=0.13u W=1.12u AS=0.3808p
+ AD=0.3808p PS=2.92u PD=2.92u rfmode=0
M$45451 \$2394 \$2387 \$2388 VDD|in|pad|pin1|pin2|supply|vdd sg13_lv_pmos
+ L=0.13u W=1u AS=0.34p AD=0.2048p PS=2.68u PD=1.63u rfmode=0
M$45452 \$2388 \$2386 \$2392 VDD|in|pad|pin1|pin2|supply|vdd sg13_lv_pmos
+ L=0.13u W=0.42u AS=0.2048p AD=0.09345p PS=1.63u PD=0.865u rfmode=0
M$45453 VDD|in|pad|pin1|pin2|supply|vdd \$2389 \$2392
+ VDD|in|pad|pin1|pin2|supply|vdd sg13_lv_pmos L=0.13u W=0.42u AS=0.204p
+ AD=0.09345p PS=1.835u PD=0.865u rfmode=0
M$45454 VDD|in|pad|pin1|pin2|supply|vdd \$2370 \$2389
+ VDD|in|pad|pin1|pin2|supply|vdd sg13_lv_pmos L=0.13u W=0.42u AS=0.204p
+ AD=0.0798p PS=1.835u PD=0.8u rfmode=0
M$45455 VDD|in|pad|pin1|pin2|supply|vdd \$2388 \$2389
+ VDD|in|pad|pin1|pin2|supply|vdd sg13_lv_pmos L=0.13u W=0.42u AS=0.4659p
+ AD=0.0798p PS=3.65u PD=0.8u rfmode=0
M$45456 \$2146 \$2470 VDD|in|pad|pin1|pin2|supply|vdd
+ VDD|in|pad|pin1|pin2|supply|vdd sg13_lv_pmos L=0.13u W=1.12u AS=0.3808p
+ AD=0.3808p PS=2.92u PD=2.92u rfmode=0
M$45457 VDD|in|pad|pin1|pin2|supply|vdd \$2471 \$2453
+ VDD|in|pad|pin1|pin2|supply|vdd sg13_lv_pmos L=0.5u W=1u AS=0.2254p AD=0.34p
+ PS=1.53u PD=2.68u rfmode=0
M$45458 \$2470 \$2453 VDD|in|pad|pin1|pin2|supply|vdd
+ VDD|in|pad|pin1|pin2|supply|vdd sg13_lv_pmos L=0.13u W=1.12u AS=0.4256p
+ AD=0.2254p PS=3u PD=1.53u rfmode=0
M$45459 VDD|in|pad|pin1|pin2|supply|vdd \$2383 \$2435
+ VDD|in|pad|pin1|pin2|supply|vdd sg13_lv_pmos L=0.13u W=0.42u AS=0.1523p
+ AD=0.1428p PS=1.38u PD=1.52u rfmode=0
M$45460 \$2471 \$2435 VDD|in|pad|pin1|pin2|supply|vdd
+ VDD|in|pad|pin1|pin2|supply|vdd sg13_lv_pmos L=0.5u W=1u AS=0.34p AD=0.1523p
+ PS=2.68u PD=1.38u rfmode=0
M$45461 \$2454 \$2375 VDD|in|pad|pin1|pin2|supply|vdd
+ VDD|in|pad|pin1|pin2|supply|vdd sg13_lv_pmos L=0.13u W=0.84u AS=0.2856p
+ AD=0.253p PS=2.36u PD=1.53u rfmode=0
M$45462 VDD|in|pad|pin1|pin2|supply|vdd \$2375 \$2492
+ VDD|in|pad|pin1|pin2|supply|vdd sg13_lv_pmos L=0.13u W=1u AS=0.253p
+ AD=0.3325p PS=1.53u PD=1.665u rfmode=0
M$45463 \$2492 \$2472 \$2436 VDD|in|pad|pin1|pin2|supply|vdd sg13_lv_pmos
+ L=0.13u W=1u AS=0.3325p AD=0.2225p PS=1.665u PD=1.445u rfmode=0
M$45464 \$2436 \$2384 \$2491 VDD|in|pad|pin1|pin2|supply|vdd sg13_lv_pmos
+ L=0.13u W=1u AS=0.2225p AD=0.2975p PS=1.445u PD=1.595u rfmode=0
M$45465 \$2491 \$2454 VDD|in|pad|pin1|pin2|supply|vdd
+ VDD|in|pad|pin1|pin2|supply|vdd sg13_lv_pmos L=0.13u W=1u AS=0.2975p
+ AD=0.2198p PS=1.595u PD=1.52u rfmode=0
M$45466 VDD|in|pad|pin1|pin2|supply|vdd \$2436 \$2437
+ VDD|in|pad|pin1|pin2|supply|vdd sg13_lv_pmos L=0.13u W=1.12u AS=0.2198p
+ AD=0.6048p PS=1.52u PD=3.32u rfmode=0
M$45467 VDD|in|pad|pin1|pin2|supply|vdd \$2437 \$2438
+ VDD|in|pad|pin1|pin2|supply|vdd sg13_lv_pmos L=0.13u W=0.42u AS=0.1428p
+ AD=0.0798p PS=1.52u PD=0.8u rfmode=0
M$45468 VDD|in|pad|pin1|pin2|supply|vdd \$2371 \$2438
+ VDD|in|pad|pin1|pin2|supply|vdd sg13_lv_pmos L=0.13u W=0.42u AS=0.3623875p
+ AD=0.0798p PS=2.605u PD=0.8u rfmode=0
M$45469 VDD|in|pad|pin1|pin2|supply|vdd \$2482 \$2439
+ VDD|in|pad|pin1|pin2|supply|vdd sg13_lv_pmos L=0.13u W=1u AS=0.3623875p
+ AD=0.34p PS=2.605u PD=2.68u rfmode=0
M$45470 \$2456 \$2440 VDD|in|pad|pin1|pin2|supply|vdd
+ VDD|in|pad|pin1|pin2|supply|vdd sg13_lv_pmos L=0.13u W=1.12u AS=0.3864p
+ AD=0.41165p PS=2.93u PD=2.12u rfmode=0
M$45471 VDD|in|pad|pin1|pin2|supply|vdd \$2256 \$2440
+ VDD|in|pad|pin1|pin2|supply|vdd sg13_lv_pmos L=0.13u W=1.12u AS=0.41165p
+ AD=0.4088p PS=2.12u PD=2.97u rfmode=0
M$45472 \$2457 \$2456 \$2493 VDD|in|pad|pin1|pin2|supply|vdd sg13_lv_pmos
+ L=0.13u W=0.42u AS=0.2048p AD=0.09345p PS=1.63u PD=0.865u rfmode=0
M$45473 \$2493 \$2442 VDD|in|pad|pin1|pin2|supply|vdd
+ VDD|in|pad|pin1|pin2|supply|vdd sg13_lv_pmos L=0.13u W=0.42u AS=0.09345p
+ AD=0.204p PS=0.865u PD=1.835u rfmode=0
M$45474 VDD|in|pad|pin1|pin2|supply|vdd \$2371 \$2442
+ VDD|in|pad|pin1|pin2|supply|vdd sg13_lv_pmos L=0.13u W=0.42u AS=0.204p
+ AD=0.0798p PS=1.835u PD=0.8u rfmode=0
M$45475 \$2442 \$2457 VDD|in|pad|pin1|pin2|supply|vdd
+ VDD|in|pad|pin1|pin2|supply|vdd sg13_lv_pmos L=0.13u W=0.42u AS=0.0798p
+ AD=0.4659p PS=0.8u PD=3.65u rfmode=0
M$45476 \$2439 \$2440 \$2457 VDD|in|pad|pin1|pin2|supply|vdd sg13_lv_pmos
+ L=0.13u W=1u AS=0.34p AD=0.2048p PS=2.68u PD=1.63u rfmode=0
M$45477 \$2443 \$2457 VDD|in|pad|pin1|pin2|supply|vdd
+ VDD|in|pad|pin1|pin2|supply|vdd sg13_lv_pmos L=0.13u W=1.12u AS=0.3864p
+ AD=0.2128p PS=2.93u PD=1.5u rfmode=0
M$45478 VDD|in|pad|pin1|pin2|supply|vdd \$2443 \$2472
+ VDD|in|pad|pin1|pin2|supply|vdd sg13_lv_pmos L=0.13u W=1.12u AS=0.2128p
+ AD=0.3808p PS=1.5u PD=2.92u rfmode=0
M$45504 VDD|in|pad|pin1|pin2|supply|vdd \$2472 \$2458
+ VDD|in|pad|pin1|pin2|supply|vdd sg13_lv_pmos L=0.13u W=0.84u AS=0.2114p
+ AD=0.2856p PS=1.54u PD=2.36u rfmode=0
M$45505 VDD|in|pad|pin1|pin2|supply|vdd \$2458 \$889
+ VDD|in|pad|pin1|pin2|supply|vdd sg13_lv_pmos L=0.13u W=1.12u AS=0.2114p
+ AD=0.42p PS=1.54u PD=2.99u rfmode=0
M$45528 \$2481 \$2422 VDD|in|pad|pin1|pin2|supply|vdd
+ VDD|in|pad|pin1|pin2|supply|vdd sg13_lv_pmos L=0.13u W=0.42u AS=0.147p
+ AD=0.1563p PS=1.54u PD=1.22u rfmode=0
M$45529 VDD|in|pad|pin1|pin2|supply|vdd \$2424 \$2487
+ VDD|in|pad|pin1|pin2|supply|vdd sg13_lv_pmos L=0.13u W=0.42u AS=0.1563p
+ AD=0.063p PS=1.22u PD=0.72u rfmode=0
M$45530 \$2487 \$2425 \$2481 VDD|in|pad|pin1|pin2|supply|vdd sg13_lv_pmos
+ L=0.13u W=0.42u AS=0.063p AD=0.0798p PS=0.72u PD=0.8u rfmode=0
M$45531 \$2481 \$2446 \$2423 VDD|in|pad|pin1|pin2|supply|vdd sg13_lv_pmos
+ L=0.13u W=0.42u AS=0.0798p AD=0.1428p PS=0.8u PD=1.52u rfmode=0
M$45533 \$2500 \$2528 VDD|in|pad|pin1|pin2|supply|vdd
+ VDD|in|pad|pin1|pin2|supply|vdd sg13_lv_pmos L=0.13u W=1.12u AS=0.6048p
+ AD=0.2198p PS=3.32u PD=1.52u rfmode=0
M$45534 VDD|in|pad|pin1|pin2|supply|vdd \$2496 \$2524
+ VDD|in|pad|pin1|pin2|supply|vdd sg13_lv_pmos L=0.13u W=1u AS=0.2198p
+ AD=0.2975p PS=1.52u PD=1.595u rfmode=0
M$45535 \$2524 \$2106 \$2528 VDD|in|pad|pin1|pin2|supply|vdd sg13_lv_pmos
+ L=0.13u W=1u AS=0.2975p AD=0.2225p PS=1.595u PD=1.445u rfmode=0
M$45536 \$2528 \$2529 \$2523 VDD|in|pad|pin1|pin2|supply|vdd sg13_lv_pmos
+ L=0.13u W=1u AS=0.2225p AD=0.3325p PS=1.445u PD=1.665u rfmode=0
M$45537 \$2523 \$2520 VDD|in|pad|pin1|pin2|supply|vdd
+ VDD|in|pad|pin1|pin2|supply|vdd sg13_lv_pmos L=0.13u W=1u AS=0.3325p
+ AD=0.253p PS=1.665u PD=1.53u rfmode=0
M$45538 VDD|in|pad|pin1|pin2|supply|vdd \$2520 \$2496
+ VDD|in|pad|pin1|pin2|supply|vdd sg13_lv_pmos L=0.13u W=0.84u AS=0.253p
+ AD=0.2856p PS=1.53u PD=2.36u rfmode=0
M$45543 \$2179 \$2400 VDD|in|pad|pin1|pin2|supply|vdd
+ VDD|in|pad|pin1|pin2|supply|vdd sg13_lv_pmos L=0.13u W=1.12u AS=0.3808p
+ AD=0.3808p PS=2.92u PD=2.92u rfmode=0
M$45544 VDD|in|pad|pin1|pin2|supply|vdd \$2429 \$2501
+ VDD|in|pad|pin1|pin2|supply|vdd sg13_lv_pmos L=0.13u W=0.84u AS=0.2114p
+ AD=0.2856p PS=1.54u PD=2.36u rfmode=0
M$45545 \$2248 \$2501 VDD|in|pad|pin1|pin2|supply|vdd
+ VDD|in|pad|pin1|pin2|supply|vdd sg13_lv_pmos L=0.13u W=1.12u AS=0.42p
+ AD=0.2114p PS=2.99u PD=1.54u rfmode=0
M$45546 VDD|in|pad|pin1|pin2|supply|vdd \$2451 \$2497
+ VDD|in|pad|pin1|pin2|supply|vdd sg13_lv_pmos L=0.13u W=0.42u AS=0.1428p
+ AD=0.0798p PS=1.52u PD=0.8u rfmode=0
M$45547 VDD|in|pad|pin1|pin2|supply|vdd \$2498 \$2497
+ VDD|in|pad|pin1|pin2|supply|vdd sg13_lv_pmos L=0.13u W=0.42u AS=0.3623875p
+ AD=0.0798p PS=2.605u PD=0.8u rfmode=0
M$45548 VDD|in|pad|pin1|pin2|supply|vdd \$2502 \$2521
+ VDD|in|pad|pin1|pin2|supply|vdd sg13_lv_pmos L=0.13u W=1u AS=0.3623875p
+ AD=0.34p PS=2.605u PD=2.68u rfmode=0
M$45549 VDD|in|pad|pin1|pin2|supply|vdd \$2498 \$2502
+ VDD|in|pad|pin1|pin2|supply|vdd sg13_lv_pmos L=0.13u W=0.42u AS=0.1563p
+ AD=0.147p PS=1.22u PD=1.54u rfmode=0
M$45550 VDD|in|pad|pin1|pin2|supply|vdd \$2521 \$2518
+ VDD|in|pad|pin1|pin2|supply|vdd sg13_lv_pmos L=0.13u W=0.42u AS=0.1563p
+ AD=0.063p PS=1.22u PD=0.72u rfmode=0
M$45551 \$2518 \$2511 \$2502 VDD|in|pad|pin1|pin2|supply|vdd sg13_lv_pmos
+ L=0.13u W=0.42u AS=0.063p AD=0.0798p PS=0.72u PD=0.8u rfmode=0
M$45552 \$2502 \$2510 \$2497 VDD|in|pad|pin1|pin2|supply|vdd sg13_lv_pmos
+ L=0.13u W=0.42u AS=0.0798p AD=0.1428p PS=0.8u PD=1.52u rfmode=0
M$45553 VDD|in|pad|pin1|pin2|supply|vdd \$2511 \$2510
+ VDD|in|pad|pin1|pin2|supply|vdd sg13_lv_pmos L=0.13u W=1.12u AS=0.41165p
+ AD=0.3864p PS=2.12u PD=2.93u rfmode=0
M$45554 VDD|in|pad|pin1|pin2|supply|vdd \$2530 \$2511
+ VDD|in|pad|pin1|pin2|supply|vdd sg13_lv_pmos L=0.13u W=1.12u AS=0.41165p
+ AD=0.4088p PS=2.12u PD=2.97u rfmode=0
M$45555 \$2521 \$2511 \$2512 VDD|in|pad|pin1|pin2|supply|vdd sg13_lv_pmos
+ L=0.13u W=1u AS=0.34p AD=0.2048p PS=2.68u PD=1.63u rfmode=0
M$45556 \$2512 \$2510 \$2525 VDD|in|pad|pin1|pin2|supply|vdd sg13_lv_pmos
+ L=0.13u W=0.42u AS=0.2048p AD=0.09345p PS=1.63u PD=0.865u rfmode=0
M$45557 VDD|in|pad|pin1|pin2|supply|vdd \$2513 \$2525
+ VDD|in|pad|pin1|pin2|supply|vdd sg13_lv_pmos L=0.13u W=0.42u AS=0.204p
+ AD=0.09345p PS=1.835u PD=0.865u rfmode=0
M$45558 VDD|in|pad|pin1|pin2|supply|vdd \$2498 \$2513
+ VDD|in|pad|pin1|pin2|supply|vdd sg13_lv_pmos L=0.13u W=0.42u AS=0.204p
+ AD=0.0798p PS=1.835u PD=0.8u rfmode=0
M$45559 VDD|in|pad|pin1|pin2|supply|vdd \$2512 \$2513
+ VDD|in|pad|pin1|pin2|supply|vdd sg13_lv_pmos L=0.13u W=0.42u AS=0.4659p
+ AD=0.0798p PS=3.65u PD=0.8u rfmode=0
M$45560 \$2503 \$2512 VDD|in|pad|pin1|pin2|supply|vdd
+ VDD|in|pad|pin1|pin2|supply|vdd sg13_lv_pmos L=0.13u W=1.12u AS=0.3864p
+ AD=0.2128p PS=2.93u PD=1.5u rfmode=0
M$45561 VDD|in|pad|pin1|pin2|supply|vdd \$2503 \$2393
+ VDD|in|pad|pin1|pin2|supply|vdd sg13_lv_pmos L=0.13u W=1.12u AS=0.2128p
+ AD=0.3808p PS=1.5u PD=2.92u rfmode=0
M$45562 VDD|in|pad|pin1|pin2|supply|vdd \$2400 \$2370
+ VDD|in|pad|pin1|pin2|supply|vdd sg13_lv_pmos L=0.13u W=1.12u AS=0.3808p
+ AD=0.3808p PS=2.92u PD=2.92u rfmode=0
M$45563 VDD|in|pad|pin1|pin2|supply|vdd \$2431 \$2504
+ VDD|in|pad|pin1|pin2|supply|vdd sg13_lv_pmos L=0.13u W=1.12u AS=0.3808p
+ AD=0.2128p PS=2.92u PD=1.5u rfmode=0
M$45564 \$2504 \$2532 VDD|in|pad|pin1|pin2|supply|vdd
+ VDD|in|pad|pin1|pin2|supply|vdd sg13_lv_pmos L=0.13u W=1.12u AS=0.2128p
+ AD=0.3808p PS=1.5u PD=2.92u rfmode=0
M$45565 VDD|in|pad|pin1|pin2|supply|vdd \$2532 \$2526
+ VDD|in|pad|pin1|pin2|supply|vdd sg13_lv_pmos L=0.15u W=1.12u AS=0.3808p
+ AD=0.2128p PS=2.92u PD=1.5u rfmode=0
M$45566 \$2526 \$2586 \$2505 VDD|in|pad|pin1|pin2|supply|vdd sg13_lv_pmos
+ L=0.15u W=1.12u AS=0.2128p AD=0.2128p PS=1.5u PD=1.5u rfmode=0
M$45567 \$2505 \$2504 VDD|in|pad|pin1|pin2|supply|vdd
+ VDD|in|pad|pin1|pin2|supply|vdd sg13_lv_pmos L=0.15u W=1.12u AS=0.2128p
+ AD=0.3808p PS=1.5u PD=2.92u rfmode=0
M$45568 VDD|in|pad|pin1|pin2|supply|vdd \$2505 \$2499
+ VDD|in|pad|pin1|pin2|supply|vdd sg13_lv_pmos L=0.13u W=0.42u AS=0.1428p
+ AD=0.0798p PS=1.52u PD=0.8u rfmode=0
M$45569 VDD|in|pad|pin1|pin2|supply|vdd \$2434 \$2499
+ VDD|in|pad|pin1|pin2|supply|vdd sg13_lv_pmos L=0.13u W=0.42u AS=0.3623875p
+ AD=0.0798p PS=2.605u PD=0.8u rfmode=0
M$45570 VDD|in|pad|pin1|pin2|supply|vdd \$2506 \$2522
+ VDD|in|pad|pin1|pin2|supply|vdd sg13_lv_pmos L=0.13u W=1u AS=0.3623875p
+ AD=0.34p PS=2.605u PD=2.68u rfmode=0
M$45571 VDD|in|pad|pin1|pin2|supply|vdd \$2434 \$2506
+ VDD|in|pad|pin1|pin2|supply|vdd sg13_lv_pmos L=0.13u W=0.42u AS=0.1563p
+ AD=0.147p PS=1.22u PD=1.54u rfmode=0
M$45572 VDD|in|pad|pin1|pin2|supply|vdd \$2522 \$2519
+ VDD|in|pad|pin1|pin2|supply|vdd sg13_lv_pmos L=0.13u W=0.42u AS=0.1563p
+ AD=0.063p PS=1.22u PD=0.72u rfmode=0
M$45573 \$2519 \$2515 \$2506 VDD|in|pad|pin1|pin2|supply|vdd sg13_lv_pmos
+ L=0.13u W=0.42u AS=0.063p AD=0.0798p PS=0.72u PD=0.8u rfmode=0
M$45574 \$2506 \$2514 \$2499 VDD|in|pad|pin1|pin2|supply|vdd sg13_lv_pmos
+ L=0.13u W=0.42u AS=0.0798p AD=0.1428p PS=0.8u PD=1.52u rfmode=0
M$45575 VDD|in|pad|pin1|pin2|supply|vdd \$2515 \$2514
+ VDD|in|pad|pin1|pin2|supply|vdd sg13_lv_pmos L=0.13u W=1.12u AS=0.41165p
+ AD=0.3864p PS=2.12u PD=2.93u rfmode=0
M$45576 VDD|in|pad|pin1|pin2|supply|vdd \$2530 \$2515
+ VDD|in|pad|pin1|pin2|supply|vdd sg13_lv_pmos L=0.13u W=1.12u AS=0.41165p
+ AD=0.4088p PS=2.12u PD=2.97u rfmode=0
M$45577 \$2522 \$2515 \$2516 VDD|in|pad|pin1|pin2|supply|vdd sg13_lv_pmos
+ L=0.13u W=1u AS=0.34p AD=0.2048p PS=2.68u PD=1.63u rfmode=0
M$45578 \$2516 \$2514 \$2527 VDD|in|pad|pin1|pin2|supply|vdd sg13_lv_pmos
+ L=0.13u W=0.42u AS=0.2048p AD=0.09345p PS=1.63u PD=0.865u rfmode=0
M$45579 VDD|in|pad|pin1|pin2|supply|vdd \$2517 \$2527
+ VDD|in|pad|pin1|pin2|supply|vdd sg13_lv_pmos L=0.13u W=0.42u AS=0.204p
+ AD=0.09345p PS=1.835u PD=0.865u rfmode=0
M$45580 VDD|in|pad|pin1|pin2|supply|vdd \$2434 \$2517
+ VDD|in|pad|pin1|pin2|supply|vdd sg13_lv_pmos L=0.13u W=0.42u AS=0.204p
+ AD=0.0798p PS=1.835u PD=0.8u rfmode=0
M$45581 VDD|in|pad|pin1|pin2|supply|vdd \$2516 \$2517
+ VDD|in|pad|pin1|pin2|supply|vdd sg13_lv_pmos L=0.13u W=0.42u AS=0.4659p
+ AD=0.0798p PS=3.65u PD=0.8u rfmode=0
M$45582 \$2507 \$2516 VDD|in|pad|pin1|pin2|supply|vdd
+ VDD|in|pad|pin1|pin2|supply|vdd sg13_lv_pmos L=0.13u W=1.12u AS=0.3864p
+ AD=0.2128p PS=2.93u PD=1.5u rfmode=0
M$45583 VDD|in|pad|pin1|pin2|supply|vdd \$2507 \$2532
+ VDD|in|pad|pin1|pin2|supply|vdd sg13_lv_pmos L=0.13u W=1.12u AS=0.2128p
+ AD=0.3808p PS=1.5u PD=2.92u rfmode=0
M$45586 VDD|in|pad|pin1|pin2|supply|vdd \$2097 \$2508
+ VDD|in|pad|pin1|pin2|supply|vdd sg13_lv_pmos L=0.13u W=0.84u AS=0.2114p
+ AD=0.2856p PS=1.54u PD=2.36u rfmode=0
M$45587 \$2390 \$2508 VDD|in|pad|pin1|pin2|supply|vdd
+ VDD|in|pad|pin1|pin2|supply|vdd sg13_lv_pmos L=0.13u W=1.12u AS=0.42p
+ AD=0.2114p PS=2.99u PD=1.54u rfmode=0
M$45590 \$2482 \$2371 VDD|in|pad|pin1|pin2|supply|vdd
+ VDD|in|pad|pin1|pin2|supply|vdd sg13_lv_pmos L=0.13u W=0.42u AS=0.147p
+ AD=0.1563p PS=1.54u PD=1.22u rfmode=0
M$45591 VDD|in|pad|pin1|pin2|supply|vdd \$2439 \$2494
+ VDD|in|pad|pin1|pin2|supply|vdd sg13_lv_pmos L=0.13u W=0.42u AS=0.1563p
+ AD=0.063p PS=1.22u PD=0.72u rfmode=0
M$45592 \$2494 \$2440 \$2482 VDD|in|pad|pin1|pin2|supply|vdd sg13_lv_pmos
+ L=0.13u W=0.42u AS=0.063p AD=0.0798p PS=0.72u PD=0.8u rfmode=0
M$45593 \$2482 \$2456 \$2438 VDD|in|pad|pin1|pin2|supply|vdd sg13_lv_pmos
+ L=0.13u W=0.42u AS=0.0798p AD=0.1428p PS=0.8u PD=1.52u rfmode=0
M$45595 VDD|in|pad|pin1|pin2|supply|vdd \$2098 \$2509
+ VDD|in|pad|pin1|pin2|supply|vdd sg13_lv_pmos L=0.13u W=1.12u AS=0.3808p
+ AD=0.3808p PS=2.92u PD=2.92u rfmode=0
M$45646 VDD|in|pad|pin1|pin2|supply|vdd \$2205 \$2551
+ VDD|in|pad|pin1|pin2|supply|vdd sg13_lv_pmos L=0.13u W=1.12u AS=0.3808p
+ AD=0.3808p PS=2.92u PD=2.92u rfmode=0
M$45647 VDD|in|pad|pin1|pin2|supply|vdd \$2500 \$2565
+ VDD|in|pad|pin1|pin2|supply|vdd sg13_lv_pmos L=0.13u W=0.42u AS=0.1428p
+ AD=0.0798p PS=1.52u PD=0.8u rfmode=0
M$45648 VDD|in|pad|pin1|pin2|supply|vdd \$2551 \$2565
+ VDD|in|pad|pin1|pin2|supply|vdd sg13_lv_pmos L=0.13u W=0.42u AS=0.3623875p
+ AD=0.0798p PS=2.605u PD=0.8u rfmode=0
M$45649 VDD|in|pad|pin1|pin2|supply|vdd \$2583 \$2549
+ VDD|in|pad|pin1|pin2|supply|vdd sg13_lv_pmos L=0.13u W=1u AS=0.3623875p
+ AD=0.34p PS=2.605u PD=2.68u rfmode=0
M$45650 \$2566 \$2552 VDD|in|pad|pin1|pin2|supply|vdd
+ VDD|in|pad|pin1|pin2|supply|vdd sg13_lv_pmos L=0.13u W=1.12u AS=0.3864p
+ AD=0.41165p PS=2.93u PD=2.12u rfmode=0
M$45651 VDD|in|pad|pin1|pin2|supply|vdd \$2247 \$2552
+ VDD|in|pad|pin1|pin2|supply|vdd sg13_lv_pmos L=0.13u W=1.12u AS=0.41165p
+ AD=0.4088p PS=2.12u PD=2.97u rfmode=0
M$45652 \$2567 \$2566 \$2591 VDD|in|pad|pin1|pin2|supply|vdd sg13_lv_pmos
+ L=0.13u W=0.42u AS=0.2048p AD=0.09345p PS=1.63u PD=0.865u rfmode=0
M$45653 \$2591 \$2554 VDD|in|pad|pin1|pin2|supply|vdd
+ VDD|in|pad|pin1|pin2|supply|vdd sg13_lv_pmos L=0.13u W=0.42u AS=0.09345p
+ AD=0.204p PS=0.865u PD=1.835u rfmode=0
M$45654 VDD|in|pad|pin1|pin2|supply|vdd \$2551 \$2554
+ VDD|in|pad|pin1|pin2|supply|vdd sg13_lv_pmos L=0.13u W=0.42u AS=0.204p
+ AD=0.0798p PS=1.835u PD=0.8u rfmode=0
M$45655 \$2554 \$2567 VDD|in|pad|pin1|pin2|supply|vdd
+ VDD|in|pad|pin1|pin2|supply|vdd sg13_lv_pmos L=0.13u W=0.42u AS=0.0798p
+ AD=0.4659p PS=0.8u PD=3.65u rfmode=0
M$45656 \$2549 \$2552 \$2567 VDD|in|pad|pin1|pin2|supply|vdd sg13_lv_pmos
+ L=0.13u W=1u AS=0.34p AD=0.2048p PS=2.68u PD=1.63u rfmode=0
M$45657 \$2555 \$2567 VDD|in|pad|pin1|pin2|supply|vdd
+ VDD|in|pad|pin1|pin2|supply|vdd sg13_lv_pmos L=0.13u W=1.12u AS=0.3864p
+ AD=0.2128p PS=2.93u PD=1.5u rfmode=0
M$45658 VDD|in|pad|pin1|pin2|supply|vdd \$2555 \$2529
+ VDD|in|pad|pin1|pin2|supply|vdd sg13_lv_pmos L=0.13u W=1.12u AS=0.2128p
+ AD=0.3808p PS=1.5u PD=2.92u rfmode=0
M$45661 VDD|in|pad|pin1|pin2|supply|vdd \$2248 \$2498
+ VDD|in|pad|pin1|pin2|supply|vdd sg13_lv_pmos L=0.13u W=1.12u AS=0.3808p
+ AD=0.3808p PS=2.92u PD=2.92u rfmode=0
M$45664 \$2556 \$2584 \$2597 VDD|in|pad|pin1|pin2|supply|vdd sg13_lv_pmos
+ L=0.13u W=1.12u AS=0.3808p AD=0.1176p PS=2.92u PD=1.33u rfmode=0
M$45665 \$2597 \$2585 VDD|in|pad|pin1|pin2|supply|vdd
+ VDD|in|pad|pin1|pin2|supply|vdd sg13_lv_pmos L=0.13u W=1.12u AS=0.1176p
+ AD=0.4032p PS=1.33u PD=2.96u rfmode=0
M$45666 VDD|in|pad|pin1|pin2|supply|vdd \$2613 \$2596
+ VDD|in|pad|pin1|pin2|supply|vdd sg13_lv_pmos L=0.13u W=1.12u AS=0.3808p
+ AD=0.2464p PS=2.92u PD=1.56u rfmode=0
M$45667 \$2596 \$2585 \$2595 VDD|in|pad|pin1|pin2|supply|vdd sg13_lv_pmos
+ L=0.13u W=1.12u AS=0.2464p AD=0.2128p PS=1.56u PD=1.5u rfmode=0
M$45668 \$2595 \$2586 \$2520 VDD|in|pad|pin1|pin2|supply|vdd sg13_lv_pmos
+ L=0.13u W=1.12u AS=0.2128p AD=0.3808p PS=1.5u PD=2.92u rfmode=0
M$45669 VDD|in|pad|pin1|pin2|supply|vdd \$2568 \$2598
+ VDD|in|pad|pin1|pin2|supply|vdd sg13_lv_pmos L=0.13u W=1.12u AS=0.4032p
+ AD=0.1176p PS=2.96u PD=1.33u rfmode=0
M$45670 \$2598 \$2586 \$2558 VDD|in|pad|pin1|pin2|supply|vdd sg13_lv_pmos
+ L=0.13u W=1.12u AS=0.1176p AD=0.3808p PS=1.33u PD=2.92u rfmode=0
M$45673 \$2586 \$2569 VDD|in|pad|pin1|pin2|supply|vdd
+ VDD|in|pad|pin1|pin2|supply|vdd sg13_lv_pmos L=0.13u W=1.12u AS=0.42p
+ AD=0.2114p PS=2.99u PD=1.54u rfmode=0
M$45674 VDD|in|pad|pin1|pin2|supply|vdd \$2379 \$2569
+ VDD|in|pad|pin1|pin2|supply|vdd sg13_lv_pmos L=0.13u W=0.84u AS=0.2114p
+ AD=0.2856p PS=1.54u PD=2.36u rfmode=0
M$45679 \$2530 \$2570 VDD|in|pad|pin1|pin2|supply|vdd
+ VDD|in|pad|pin1|pin2|supply|vdd sg13_lv_pmos L=0.13u W=1.12u AS=0.42p
+ AD=0.2114p PS=2.99u PD=1.54u rfmode=0
M$45680 VDD|in|pad|pin1|pin2|supply|vdd \$2099 \$2570
+ VDD|in|pad|pin1|pin2|supply|vdd sg13_lv_pmos L=0.13u W=0.84u AS=0.2114p
+ AD=0.2856p PS=1.54u PD=2.36u rfmode=0
M$45686 \$2559 \$2520 \$2600 VDD|in|pad|pin1|pin2|supply|vdd sg13_lv_pmos
+ L=0.13u W=1.12u AS=0.3808p AD=0.1176p PS=2.92u PD=1.33u rfmode=0
M$45687 \$2600 \$2587 VDD|in|pad|pin1|pin2|supply|vdd
+ VDD|in|pad|pin1|pin2|supply|vdd sg13_lv_pmos L=0.13u W=1.12u AS=0.1176p
+ AD=0.4032p PS=1.33u PD=2.96u rfmode=0
M$45688 \$2589 \$2106 VDD|in|pad|pin1|pin2|supply|vdd
+ VDD|in|pad|pin1|pin2|supply|vdd sg13_lv_pmos L=0.13u W=1.12u AS=0.3808p
+ AD=0.2128p PS=2.92u PD=1.5u rfmode=0
M$45689 VDD|in|pad|pin1|pin2|supply|vdd \$2520 \$2589
+ VDD|in|pad|pin1|pin2|supply|vdd sg13_lv_pmos L=0.13u W=1.12u AS=0.2128p
+ AD=0.2128p PS=1.5u PD=1.5u rfmode=0
M$45690 \$2589 \$2559 \$2571 VDD|in|pad|pin1|pin2|supply|vdd sg13_lv_pmos
+ L=0.13u W=1.12u AS=0.2128p AD=0.3808p PS=1.5u PD=2.92u rfmode=0
M$45691 VDD|in|pad|pin1|pin2|supply|vdd \$2571 \$2573
+ VDD|in|pad|pin1|pin2|supply|vdd sg13_lv_pmos L=0.13u W=0.42u AS=0.1428p
+ AD=0.0798p PS=1.52u PD=0.8u rfmode=0
M$45692 VDD|in|pad|pin1|pin2|supply|vdd \$2509 \$2573
+ VDD|in|pad|pin1|pin2|supply|vdd sg13_lv_pmos L=0.13u W=0.42u AS=0.3623875p
+ AD=0.0798p PS=2.605u PD=0.8u rfmode=0
M$45693 VDD|in|pad|pin1|pin2|supply|vdd \$2588 \$2550
+ VDD|in|pad|pin1|pin2|supply|vdd sg13_lv_pmos L=0.13u W=1u AS=0.3623875p
+ AD=0.34p PS=2.605u PD=2.68u rfmode=0
M$45694 \$2574 \$2560 VDD|in|pad|pin1|pin2|supply|vdd
+ VDD|in|pad|pin1|pin2|supply|vdd sg13_lv_pmos L=0.13u W=1.12u AS=0.3864p
+ AD=0.41165p PS=2.93u PD=2.12u rfmode=0
M$45695 VDD|in|pad|pin1|pin2|supply|vdd \$2256 \$2560
+ VDD|in|pad|pin1|pin2|supply|vdd sg13_lv_pmos L=0.13u W=1.12u AS=0.41165p
+ AD=0.4088p PS=2.12u PD=2.97u rfmode=0
M$45696 \$2575 \$2574 \$2590 VDD|in|pad|pin1|pin2|supply|vdd sg13_lv_pmos
+ L=0.13u W=0.42u AS=0.2048p AD=0.09345p PS=1.63u PD=0.865u rfmode=0
M$45697 \$2590 \$2562 VDD|in|pad|pin1|pin2|supply|vdd
+ VDD|in|pad|pin1|pin2|supply|vdd sg13_lv_pmos L=0.13u W=0.42u AS=0.09345p
+ AD=0.204p PS=0.865u PD=1.835u rfmode=0
M$45698 VDD|in|pad|pin1|pin2|supply|vdd \$2509 \$2562
+ VDD|in|pad|pin1|pin2|supply|vdd sg13_lv_pmos L=0.13u W=0.42u AS=0.204p
+ AD=0.0798p PS=1.835u PD=0.8u rfmode=0
M$45699 \$2562 \$2575 VDD|in|pad|pin1|pin2|supply|vdd
+ VDD|in|pad|pin1|pin2|supply|vdd sg13_lv_pmos L=0.13u W=0.42u AS=0.0798p
+ AD=0.4659p PS=0.8u PD=3.65u rfmode=0
M$45700 \$2550 \$2560 \$2575 VDD|in|pad|pin1|pin2|supply|vdd sg13_lv_pmos
+ L=0.13u W=1u AS=0.34p AD=0.2048p PS=2.68u PD=1.63u rfmode=0
M$45701 \$2563 \$2575 VDD|in|pad|pin1|pin2|supply|vdd
+ VDD|in|pad|pin1|pin2|supply|vdd sg13_lv_pmos L=0.13u W=1.12u AS=0.3864p
+ AD=0.2128p PS=2.93u PD=1.5u rfmode=0
M$45702 VDD|in|pad|pin1|pin2|supply|vdd \$2563 \$2587
+ VDD|in|pad|pin1|pin2|supply|vdd sg13_lv_pmos L=0.13u W=1.12u AS=0.2128p
+ AD=0.3808p PS=1.5u PD=2.92u rfmode=0
M$45726 VDD|in|pad|pin1|pin2|supply|vdd \$2529 \$2608
+ VDD|in|pad|pin1|pin2|supply|vdd sg13_lv_pmos L=0.13u W=0.84u AS=0.2114p
+ AD=0.2856p PS=1.54u PD=2.36u rfmode=0
M$45727 \$884 \$2608 VDD|in|pad|pin1|pin2|supply|vdd
+ VDD|in|pad|pin1|pin2|supply|vdd sg13_lv_pmos L=0.13u W=1.12u AS=0.42p
+ AD=0.2114p PS=2.99u PD=1.54u rfmode=0
M$45742 \$2609 \$2631 \$2610 VDD|in|pad|pin1|pin2|supply|vdd sg13_lv_pmos
+ L=0.13u W=1.12u AS=0.3808p AD=0.2128p PS=2.92u PD=1.5u rfmode=0
M$45743 \$2610 \$2131 VDD|in|pad|pin1|pin2|supply|vdd
+ VDD|in|pad|pin1|pin2|supply|vdd sg13_lv_pmos L=0.13u W=1.12u AS=0.2128p
+ AD=0.2128p PS=1.5u PD=1.5u rfmode=0
M$45744 VDD|in|pad|pin1|pin2|supply|vdd \$2106 \$2610
+ VDD|in|pad|pin1|pin2|supply|vdd sg13_lv_pmos L=0.13u W=1.12u AS=0.2128p
+ AD=0.3808p PS=1.5u PD=2.92u rfmode=0
M$45753 \$2583 \$2551 VDD|in|pad|pin1|pin2|supply|vdd
+ VDD|in|pad|pin1|pin2|supply|vdd sg13_lv_pmos L=0.13u W=0.42u AS=0.147p
+ AD=0.1563p PS=1.54u PD=1.22u rfmode=0
M$45754 VDD|in|pad|pin1|pin2|supply|vdd \$2549 \$2592
+ VDD|in|pad|pin1|pin2|supply|vdd sg13_lv_pmos L=0.13u W=0.42u AS=0.1563p
+ AD=0.063p PS=1.22u PD=0.72u rfmode=0
M$45755 \$2592 \$2552 \$2583 VDD|in|pad|pin1|pin2|supply|vdd sg13_lv_pmos
+ L=0.13u W=0.42u AS=0.063p AD=0.0798p PS=0.72u PD=0.8u rfmode=0
M$45756 \$2583 \$2566 \$2565 VDD|in|pad|pin1|pin2|supply|vdd sg13_lv_pmos
+ L=0.13u W=0.42u AS=0.0798p AD=0.1428p PS=0.8u PD=1.52u rfmode=0
M$45758 VDD|in|pad|pin1|pin2|supply|vdd \$2520 \$2624
+ VDD|in|pad|pin1|pin2|supply|vdd sg13_lv_pmos L=0.13u W=0.84u AS=0.2198p
+ AD=0.2856p PS=1.53u PD=2.36u rfmode=0
M$45759 VDD|in|pad|pin1|pin2|supply|vdd \$2645 \$2611
+ VDD|in|pad|pin1|pin2|supply|vdd sg13_lv_pmos L=0.13u W=1.12u AS=0.2198p
+ AD=0.2128p PS=1.53u PD=1.5u rfmode=0
M$45760 \$2611 \$2624 VDD|in|pad|pin1|pin2|supply|vdd
+ VDD|in|pad|pin1|pin2|supply|vdd sg13_lv_pmos L=0.13u W=1.12u AS=0.2128p
+ AD=0.3808p PS=1.5u PD=2.92u rfmode=0
M$45761 VDD|in|pad|pin1|pin2|supply|vdd \$2633 \$2626
+ VDD|in|pad|pin1|pin2|supply|vdd sg13_lv_pmos L=0.13u W=1.12u AS=0.41165p
+ AD=0.3864p PS=2.12u PD=2.93u rfmode=0
M$45762 VDD|in|pad|pin1|pin2|supply|vdd \$2530 \$2633
+ VDD|in|pad|pin1|pin2|supply|vdd sg13_lv_pmos L=0.13u W=1.12u AS=0.41165p
+ AD=0.4088p PS=2.12u PD=2.97u rfmode=0
M$45763 \$2612 \$2634 VDD|in|pad|pin1|pin2|supply|vdd
+ VDD|in|pad|pin1|pin2|supply|vdd sg13_lv_pmos L=0.13u W=1.12u AS=0.3864p
+ AD=0.2128p PS=2.93u PD=1.5u rfmode=0
M$45764 VDD|in|pad|pin1|pin2|supply|vdd \$2612 \$2613
+ VDD|in|pad|pin1|pin2|supply|vdd sg13_lv_pmos L=0.13u W=1.12u AS=0.2128p
+ AD=0.3808p PS=1.5u PD=2.92u rfmode=0
M$45765 VDD|in|pad|pin1|pin2|supply|vdd \$2585 \$2606
+ VDD|in|pad|pin1|pin2|supply|vdd sg13_lv_pmos L=0.13u W=1.12u AS=0.3808p
+ AD=0.2716p PS=2.92u PD=1.605u rfmode=0
M$45766 \$2606 \$2431 \$2645 VDD|in|pad|pin1|pin2|supply|vdd sg13_lv_pmos
+ L=0.13u W=1.12u AS=0.2716p AD=0.2128p PS=1.605u PD=1.5u rfmode=0
M$45767 \$2645 \$2613 \$2606 VDD|in|pad|pin1|pin2|supply|vdd sg13_lv_pmos
+ L=0.13u W=1.12u AS=0.2128p AD=0.2744p PS=1.5u PD=1.61u rfmode=0
M$45768 \$2606 \$2558 VDD|in|pad|pin1|pin2|supply|vdd
+ VDD|in|pad|pin1|pin2|supply|vdd sg13_lv_pmos L=0.13u W=1.12u AS=0.2744p
+ AD=0.3808p PS=1.61u PD=2.92u rfmode=0
M$45769 \$2557 \$2586 \$2599 VDD|in|pad|pin1|pin2|supply|vdd sg13_lv_pmos
+ L=0.13u W=0.84u AS=0.2856p AD=0.1596p PS=2.36u PD=1.22u rfmode=0
M$45770 VDD|in|pad|pin1|pin2|supply|vdd \$2568 \$2599
+ VDD|in|pad|pin1|pin2|supply|vdd sg13_lv_pmos L=0.13u W=0.84u AS=0.2226p
+ AD=0.1596p PS=1.535u PD=1.22u rfmode=0
M$45771 VDD|in|pad|pin1|pin2|supply|vdd \$2557 \$2584
+ VDD|in|pad|pin1|pin2|supply|vdd sg13_lv_pmos L=0.13u W=1.12u AS=0.2226p
+ AD=0.3976p PS=1.535u PD=2.95u rfmode=0
M$45772 VDD|in|pad|pin1|pin2|supply|vdd \$2647 \$2585
+ VDD|in|pad|pin1|pin2|supply|vdd sg13_lv_pmos L=0.13u W=1.12u AS=0.3808p
+ AD=0.2128p PS=2.92u PD=1.5u rfmode=0
M$45773 \$2585 \$2532 VDD|in|pad|pin1|pin2|supply|vdd
+ VDD|in|pad|pin1|pin2|supply|vdd sg13_lv_pmos L=0.13u W=1.12u AS=0.2128p
+ AD=0.3808p PS=1.5u PD=2.92u rfmode=0
M$45774 VDD|in|pad|pin1|pin2|supply|vdd \$2647 \$2642
+ VDD|in|pad|pin1|pin2|supply|vdd sg13_lv_pmos L=0.13u W=1.12u AS=0.3808p
+ AD=0.2464p PS=2.92u PD=1.56u rfmode=0
M$45775 \$2642 \$2532 \$2641 VDD|in|pad|pin1|pin2|supply|vdd sg13_lv_pmos
+ L=0.13u W=1.12u AS=0.2464p AD=0.2128p PS=1.56u PD=1.5u rfmode=0
M$45776 \$2641 \$2584 \$2375 VDD|in|pad|pin1|pin2|supply|vdd sg13_lv_pmos
+ L=0.13u W=1.12u AS=0.2128p AD=0.3808p PS=1.5u PD=2.92u rfmode=0
M$45777 \$2614 \$2431 VDD|in|pad|pin1|pin2|supply|vdd
+ VDD|in|pad|pin1|pin2|supply|vdd sg13_lv_pmos L=0.13u W=1u AS=0.34p AD=0.19p
+ PS=2.68u PD=1.38u rfmode=0
M$45778 VDD|in|pad|pin1|pin2|supply|vdd \$2647 \$2614
+ VDD|in|pad|pin1|pin2|supply|vdd sg13_lv_pmos L=0.13u W=1u AS=0.19p AD=0.2125p
+ PS=1.38u PD=1.425u rfmode=0
M$45779 \$2614 \$2648 \$2615 VDD|in|pad|pin1|pin2|supply|vdd sg13_lv_pmos
+ L=0.13u W=1u AS=0.2125p AD=0.35p PS=1.425u PD=2.7u rfmode=0
M$45780 VDD|in|pad|pin1|pin2|supply|vdd \$2615 \$2616
+ VDD|in|pad|pin1|pin2|supply|vdd sg13_lv_pmos L=0.13u W=1.12u AS=0.3808p
+ AD=0.3808p PS=2.92u PD=2.92u rfmode=0
M$45781 \$2617 \$2098 VDD|in|pad|pin1|pin2|supply|vdd
+ VDD|in|pad|pin1|pin2|supply|vdd sg13_lv_pmos L=0.13u W=1.12u AS=0.3808p
+ AD=0.3808p PS=2.92u PD=2.92u rfmode=0
M$45782 VDD|in|pad|pin1|pin2|supply|vdd \$2637 \$2628
+ VDD|in|pad|pin1|pin2|supply|vdd sg13_lv_pmos L=0.13u W=1.12u AS=0.41165p
+ AD=0.3864p PS=2.12u PD=2.93u rfmode=0
M$45783 VDD|in|pad|pin1|pin2|supply|vdd \$2530 \$2637
+ VDD|in|pad|pin1|pin2|supply|vdd sg13_lv_pmos L=0.13u W=1.12u AS=0.41165p
+ AD=0.4088p PS=2.12u PD=2.97u rfmode=0
M$45784 \$2618 \$2638 VDD|in|pad|pin1|pin2|supply|vdd
+ VDD|in|pad|pin1|pin2|supply|vdd sg13_lv_pmos L=0.13u W=1.12u AS=0.3864p
+ AD=0.2128p PS=2.93u PD=1.5u rfmode=0
M$45785 VDD|in|pad|pin1|pin2|supply|vdd \$2618 \$2647
+ VDD|in|pad|pin1|pin2|supply|vdd sg13_lv_pmos L=0.13u W=1.12u AS=0.2128p
+ AD=0.3808p PS=1.5u PD=2.92u rfmode=0
M$45786 VDD|in|pad|pin1|pin2|supply|vdd \$2650 \$2644
+ VDD|in|pad|pin1|pin2|supply|vdd sg13_lv_pmos L=0.13u W=1.12u AS=0.4032p
+ AD=0.1176p PS=2.96u PD=1.33u rfmode=0
M$45787 \$2644 \$2520 \$2619 VDD|in|pad|pin1|pin2|supply|vdd sg13_lv_pmos
+ L=0.13u W=1.12u AS=0.1176p AD=0.3808p PS=1.33u PD=2.92u rfmode=0
M$45788 \$2620 \$2619 \$2621 VDD|in|pad|pin1|pin2|supply|vdd sg13_lv_pmos
+ L=0.13u W=1.12u AS=0.3808p AD=0.2128p PS=2.92u PD=1.5u rfmode=0
M$45789 \$2621 \$2520 VDD|in|pad|pin1|pin2|supply|vdd
+ VDD|in|pad|pin1|pin2|supply|vdd sg13_lv_pmos L=0.13u W=1.12u AS=0.2128p
+ AD=0.2128p PS=1.5u PD=1.5u rfmode=0
M$45790 VDD|in|pad|pin1|pin2|supply|vdd \$2106 \$2621
+ VDD|in|pad|pin1|pin2|supply|vdd sg13_lv_pmos L=0.13u W=1.12u AS=0.2128p
+ AD=0.3808p PS=1.5u PD=2.92u rfmode=0
M$45795 \$2588 \$2509 VDD|in|pad|pin1|pin2|supply|vdd
+ VDD|in|pad|pin1|pin2|supply|vdd sg13_lv_pmos L=0.13u W=0.42u AS=0.147p
+ AD=0.1563p PS=1.54u PD=1.22u rfmode=0
M$45796 VDD|in|pad|pin1|pin2|supply|vdd \$2550 \$2602
+ VDD|in|pad|pin1|pin2|supply|vdd sg13_lv_pmos L=0.13u W=0.42u AS=0.1563p
+ AD=0.063p PS=1.22u PD=0.72u rfmode=0
M$45797 \$2602 \$2560 \$2588 VDD|in|pad|pin1|pin2|supply|vdd sg13_lv_pmos
+ L=0.13u W=0.42u AS=0.063p AD=0.0798p PS=0.72u PD=0.8u rfmode=0
M$45798 \$2588 \$2574 \$2573 VDD|in|pad|pin1|pin2|supply|vdd sg13_lv_pmos
+ L=0.13u W=0.42u AS=0.0798p AD=0.1428p PS=0.8u PD=1.52u rfmode=0
M$45805 VDD|in|pad|pin1|pin2|supply|vdd \$2651 \$2622
+ VDD|in|pad|pin1|pin2|supply|vdd sg13_lv_pmos L=0.13u W=1.12u AS=0.3808p
+ AD=0.3808p PS=2.92u PD=2.92u rfmode=0
M$45826 \$2623 \$2587 VDD|in|pad|pin1|pin2|supply|vdd
+ VDD|in|pad|pin1|pin2|supply|vdd sg13_lv_pmos L=0.13u W=0.84u AS=0.2856p
+ AD=0.2114p PS=2.36u PD=1.54u rfmode=0
M$45827 VDD|in|pad|pin1|pin2|supply|vdd \$2623 \$890
+ VDD|in|pad|pin1|pin2|supply|vdd sg13_lv_pmos L=0.13u W=1.12u AS=0.2114p
+ AD=0.42p PS=1.54u PD=2.99u rfmode=0
M$45842 VDD|in|pad|pin1|pin2|supply|vdd \$2205 \$2725
+ VDD|in|pad|pin1|pin2|supply|vdd sg13_lv_pmos L=0.13u W=1.12u AS=0.3808p
+ AD=0.3808p PS=2.92u PD=2.92u rfmode=0
M$45843 VDD|in|pad|pin1|pin2|supply|vdd \$2609 \$2682
+ VDD|in|pad|pin1|pin2|supply|vdd sg13_lv_pmos L=0.13u W=0.42u AS=0.1428p
+ AD=0.0798p PS=1.52u PD=0.8u rfmode=0
M$45844 VDD|in|pad|pin1|pin2|supply|vdd \$2725 \$2682
+ VDD|in|pad|pin1|pin2|supply|vdd sg13_lv_pmos L=0.13u W=0.42u AS=0.3623875p
+ AD=0.0798p PS=2.605u PD=0.8u rfmode=0
M$45845 VDD|in|pad|pin1|pin2|supply|vdd \$2724 \$2675
+ VDD|in|pad|pin1|pin2|supply|vdd sg13_lv_pmos L=0.13u W=1u AS=0.3623875p
+ AD=0.34p PS=2.605u PD=2.68u rfmode=0
M$45846 \$2732 \$2676 VDD|in|pad|pin1|pin2|supply|vdd
+ VDD|in|pad|pin1|pin2|supply|vdd sg13_lv_pmos L=0.13u W=1.12u AS=0.3864p
+ AD=0.41165p PS=2.93u PD=2.12u rfmode=0
M$45847 VDD|in|pad|pin1|pin2|supply|vdd \$2247 \$2676
+ VDD|in|pad|pin1|pin2|supply|vdd sg13_lv_pmos L=0.13u W=1.12u AS=0.41165p
+ AD=0.4088p PS=2.12u PD=2.97u rfmode=0
M$45848 \$2703 \$2732 \$2737 VDD|in|pad|pin1|pin2|supply|vdd sg13_lv_pmos
+ L=0.13u W=0.42u AS=0.2048p AD=0.09345p PS=1.63u PD=0.865u rfmode=0
M$45849 \$2737 \$2685 VDD|in|pad|pin1|pin2|supply|vdd
+ VDD|in|pad|pin1|pin2|supply|vdd sg13_lv_pmos L=0.13u W=0.42u AS=0.09345p
+ AD=0.204p PS=0.865u PD=1.835u rfmode=0
M$45850 VDD|in|pad|pin1|pin2|supply|vdd \$2725 \$2685
+ VDD|in|pad|pin1|pin2|supply|vdd sg13_lv_pmos L=0.13u W=0.42u AS=0.204p
+ AD=0.0798p PS=1.835u PD=0.8u rfmode=0
M$45851 \$2685 \$2703 VDD|in|pad|pin1|pin2|supply|vdd
+ VDD|in|pad|pin1|pin2|supply|vdd sg13_lv_pmos L=0.13u W=0.42u AS=0.0798p
+ AD=0.4659p PS=0.8u PD=3.65u rfmode=0
M$45852 \$2675 \$2676 \$2703 VDD|in|pad|pin1|pin2|supply|vdd sg13_lv_pmos
+ L=0.13u W=1u AS=0.34p AD=0.2048p PS=2.68u PD=1.63u rfmode=0
M$45853 \$2686 \$2703 VDD|in|pad|pin1|pin2|supply|vdd
+ VDD|in|pad|pin1|pin2|supply|vdd sg13_lv_pmos L=0.13u W=1.12u AS=0.3864p
+ AD=0.2128p PS=2.93u PD=1.5u rfmode=0
M$45854 VDD|in|pad|pin1|pin2|supply|vdd \$2686 \$2687
+ VDD|in|pad|pin1|pin2|supply|vdd sg13_lv_pmos L=0.13u W=1.12u AS=0.2128p
+ AD=0.3808p PS=1.5u PD=2.92u rfmode=0
M$45857 \$2688 \$2726 \$2733 VDD|in|pad|pin1|pin2|supply|vdd sg13_lv_pmos
+ L=0.13u W=1.12u AS=0.3808p AD=0.2128p PS=2.92u PD=1.5u rfmode=0
M$45858 \$2733 \$2390 VDD|in|pad|pin1|pin2|supply|vdd
+ VDD|in|pad|pin1|pin2|supply|vdd sg13_lv_pmos L=0.13u W=1.12u AS=0.2128p
+ AD=0.2128p PS=1.5u PD=1.5u rfmode=0
M$45859 VDD|in|pad|pin1|pin2|supply|vdd \$2727 \$2733
+ VDD|in|pad|pin1|pin2|supply|vdd sg13_lv_pmos L=0.13u W=1.12u AS=0.2128p
+ AD=0.3808p PS=1.5u PD=2.92u rfmode=0
M$45861 VDD|in|pad|pin1|pin2|supply|vdd \$2611 \$2604
+ VDD|in|pad|pin1|pin2|supply|vdd sg13_lv_pmos L=0.13u W=0.42u AS=0.1428p
+ AD=0.0798p PS=1.52u PD=0.8u rfmode=0
M$45862 VDD|in|pad|pin1|pin2|supply|vdd \$2605 \$2604
+ VDD|in|pad|pin1|pin2|supply|vdd sg13_lv_pmos L=0.13u W=0.42u AS=0.3623875p
+ AD=0.0798p PS=2.605u PD=0.8u rfmode=0
M$45863 VDD|in|pad|pin1|pin2|supply|vdd \$2625 \$2632
+ VDD|in|pad|pin1|pin2|supply|vdd sg13_lv_pmos L=0.13u W=1u AS=0.3623875p
+ AD=0.34p PS=2.605u PD=2.68u rfmode=0
M$45864 VDD|in|pad|pin1|pin2|supply|vdd \$2248 \$2605
+ VDD|in|pad|pin1|pin2|supply|vdd sg13_lv_pmos L=0.13u W=1.12u AS=0.3808p
+ AD=0.3808p PS=2.92u PD=2.92u rfmode=0
M$45867 VDD|in|pad|pin1|pin2|supply|vdd \$2605 \$2625
+ VDD|in|pad|pin1|pin2|supply|vdd sg13_lv_pmos L=0.13u W=0.42u AS=0.1563p
+ AD=0.147p PS=1.22u PD=1.54u rfmode=0
M$45868 VDD|in|pad|pin1|pin2|supply|vdd \$2632 \$2629
+ VDD|in|pad|pin1|pin2|supply|vdd sg13_lv_pmos L=0.13u W=0.42u AS=0.1563p
+ AD=0.063p PS=1.22u PD=0.72u rfmode=0
M$45869 \$2629 \$2633 \$2625 VDD|in|pad|pin1|pin2|supply|vdd sg13_lv_pmos
+ L=0.13u W=0.42u AS=0.063p AD=0.0798p PS=0.72u PD=0.8u rfmode=0
M$45870 \$2625 \$2626 \$2604 VDD|in|pad|pin1|pin2|supply|vdd sg13_lv_pmos
+ L=0.13u W=0.42u AS=0.0798p AD=0.1428p PS=0.8u PD=1.52u rfmode=0
M$45873 \$2632 \$2633 \$2634 VDD|in|pad|pin1|pin2|supply|vdd sg13_lv_pmos
+ L=0.13u W=1u AS=0.34p AD=0.2048p PS=2.68u PD=1.63u rfmode=0
M$45874 \$2634 \$2626 \$2640 VDD|in|pad|pin1|pin2|supply|vdd sg13_lv_pmos
+ L=0.13u W=0.42u AS=0.2048p AD=0.09345p PS=1.63u PD=0.865u rfmode=0
M$45875 VDD|in|pad|pin1|pin2|supply|vdd \$2635 \$2640
+ VDD|in|pad|pin1|pin2|supply|vdd sg13_lv_pmos L=0.13u W=0.42u AS=0.204p
+ AD=0.09345p PS=1.835u PD=0.865u rfmode=0
M$45876 VDD|in|pad|pin1|pin2|supply|vdd \$2605 \$2635
+ VDD|in|pad|pin1|pin2|supply|vdd sg13_lv_pmos L=0.13u W=0.42u AS=0.204p
+ AD=0.0798p PS=1.835u PD=0.8u rfmode=0
M$45877 VDD|in|pad|pin1|pin2|supply|vdd \$2634 \$2635
+ VDD|in|pad|pin1|pin2|supply|vdd sg13_lv_pmos L=0.13u W=0.42u AS=0.4659p
+ AD=0.0798p PS=3.65u PD=0.8u rfmode=0
M$45880 VDD|in|pad|pin1|pin2|supply|vdd \$2568 \$2747
+ VDD|in|pad|pin1|pin2|supply|vdd sg13_lv_pmos L=0.13u W=1.12u AS=0.3808p
+ AD=0.2464p PS=2.92u PD=1.56u rfmode=0
M$45881 \$2747 \$2586 \$2746 VDD|in|pad|pin1|pin2|supply|vdd sg13_lv_pmos
+ L=0.13u W=1.12u AS=0.2464p AD=0.2128p PS=1.56u PD=1.5u rfmode=0
M$45882 \$2746 \$2728 \$2131 VDD|in|pad|pin1|pin2|supply|vdd sg13_lv_pmos
+ L=0.13u W=1.12u AS=0.2128p AD=0.3808p PS=1.5u PD=2.92u rfmode=0
M$45883 VDD|in|pad|pin1|pin2|supply|vdd \$2613 \$2745
+ VDD|in|pad|pin1|pin2|supply|vdd sg13_lv_pmos L=0.13u W=1.12u AS=0.3808p
+ AD=0.2464p PS=2.92u PD=1.56u rfmode=0
M$45884 \$2745 \$2379 \$2744 VDD|in|pad|pin1|pin2|supply|vdd sg13_lv_pmos
+ L=0.13u W=1.12u AS=0.2464p AD=0.2128p PS=1.56u PD=1.5u rfmode=0
M$45885 \$2744 \$2728 \$2727 VDD|in|pad|pin1|pin2|supply|vdd sg13_lv_pmos
+ L=0.13u W=1.12u AS=0.2128p AD=0.3808p PS=1.5u PD=2.92u rfmode=0
M$45886 VDD|in|pad|pin1|pin2|supply|vdd \$2532 \$2704
+ VDD|in|pad|pin1|pin2|supply|vdd sg13_lv_pmos L=0.13u W=0.84u AS=0.2198p
+ AD=0.2856p PS=1.53u PD=2.36u rfmode=0
M$45887 VDD|in|pad|pin1|pin2|supply|vdd \$2704 \$2728
+ VDD|in|pad|pin1|pin2|supply|vdd sg13_lv_pmos L=0.13u W=1.12u AS=0.3808p
+ AD=0.2128p PS=2.92u PD=1.5u rfmode=0
M$45888 \$2728 \$2647 VDD|in|pad|pin1|pin2|supply|vdd
+ VDD|in|pad|pin1|pin2|supply|vdd sg13_lv_pmos L=0.13u W=1.12u AS=0.2128p
+ AD=0.2198p PS=1.5u PD=1.53u rfmode=0
M$45889 \$2734 \$2728 VDD|in|pad|pin1|pin2|supply|vdd
+ VDD|in|pad|pin1|pin2|supply|vdd sg13_lv_pmos L=0.13u W=1.12u AS=0.3808p
+ AD=0.2128p PS=2.92u PD=1.5u rfmode=0
M$45890 VDD|in|pad|pin1|pin2|supply|vdd \$2689 \$2734
+ VDD|in|pad|pin1|pin2|supply|vdd sg13_lv_pmos L=0.13u W=1.12u AS=0.2128p
+ AD=0.2128p PS=1.5u PD=1.5u rfmode=0
M$45891 \$2734 \$2586 \$2648 VDD|in|pad|pin1|pin2|supply|vdd sg13_lv_pmos
+ L=0.13u W=1.12u AS=0.2128p AD=0.3808p PS=1.5u PD=2.92u rfmode=0
M$45892 \$2705 \$2647 VDD|in|pad|pin1|pin2|supply|vdd
+ VDD|in|pad|pin1|pin2|supply|vdd sg13_lv_pmos L=0.13u W=0.84u AS=0.2856p
+ AD=0.2198p PS=2.36u PD=1.53u rfmode=0
M$45893 VDD|in|pad|pin1|pin2|supply|vdd \$2532 \$2689
+ VDD|in|pad|pin1|pin2|supply|vdd sg13_lv_pmos L=0.13u W=1.12u AS=0.2198p
+ AD=0.2128p PS=1.53u PD=1.5u rfmode=0
M$45894 \$2689 \$2705 VDD|in|pad|pin1|pin2|supply|vdd
+ VDD|in|pad|pin1|pin2|supply|vdd sg13_lv_pmos L=0.13u W=1.12u AS=0.2128p
+ AD=0.3808p PS=1.5u PD=2.92u rfmode=0
M$45895 \$2690 \$2689 \$2750 VDD|in|pad|pin1|pin2|supply|vdd sg13_lv_pmos
+ L=0.13u W=1.12u AS=0.3808p AD=0.1176p PS=2.92u PD=1.33u rfmode=0
M$45896 \$2750 \$2584 VDD|in|pad|pin1|pin2|supply|vdd
+ VDD|in|pad|pin1|pin2|supply|vdd sg13_lv_pmos L=0.13u W=1.12u AS=0.1176p
+ AD=0.4032p PS=1.33u PD=2.96u rfmode=0
M$45899 VDD|in|pad|pin1|pin2|supply|vdd \$2616 \$2607
+ VDD|in|pad|pin1|pin2|supply|vdd sg13_lv_pmos L=0.13u W=0.42u AS=0.1428p
+ AD=0.0798p PS=1.52u PD=0.8u rfmode=0
M$45900 VDD|in|pad|pin1|pin2|supply|vdd \$2617 \$2607
+ VDD|in|pad|pin1|pin2|supply|vdd sg13_lv_pmos L=0.13u W=0.42u AS=0.3623875p
+ AD=0.0798p PS=2.605u PD=0.8u rfmode=0
M$45901 VDD|in|pad|pin1|pin2|supply|vdd \$2627 \$2636
+ VDD|in|pad|pin1|pin2|supply|vdd sg13_lv_pmos L=0.13u W=1u AS=0.3623875p
+ AD=0.34p PS=2.605u PD=2.68u rfmode=0
M$45902 VDD|in|pad|pin1|pin2|supply|vdd \$2617 \$2627
+ VDD|in|pad|pin1|pin2|supply|vdd sg13_lv_pmos L=0.13u W=0.42u AS=0.1563p
+ AD=0.147p PS=1.22u PD=1.54u rfmode=0
M$45903 VDD|in|pad|pin1|pin2|supply|vdd \$2636 \$2630
+ VDD|in|pad|pin1|pin2|supply|vdd sg13_lv_pmos L=0.13u W=0.42u AS=0.1563p
+ AD=0.063p PS=1.22u PD=0.72u rfmode=0
M$45904 \$2630 \$2637 \$2627 VDD|in|pad|pin1|pin2|supply|vdd sg13_lv_pmos
+ L=0.13u W=0.42u AS=0.063p AD=0.0798p PS=0.72u PD=0.8u rfmode=0
M$45905 \$2627 \$2628 \$2607 VDD|in|pad|pin1|pin2|supply|vdd sg13_lv_pmos
+ L=0.13u W=0.42u AS=0.0798p AD=0.1428p PS=0.8u PD=1.52u rfmode=0
M$45910 \$2636 \$2637 \$2638 VDD|in|pad|pin1|pin2|supply|vdd sg13_lv_pmos
+ L=0.13u W=1u AS=0.34p AD=0.2048p PS=2.68u PD=1.63u rfmode=0
M$45911 \$2638 \$2628 \$2643 VDD|in|pad|pin1|pin2|supply|vdd sg13_lv_pmos
+ L=0.13u W=0.42u AS=0.2048p AD=0.09345p PS=1.63u PD=0.865u rfmode=0
M$45912 VDD|in|pad|pin1|pin2|supply|vdd \$2639 \$2643
+ VDD|in|pad|pin1|pin2|supply|vdd sg13_lv_pmos L=0.13u W=0.42u AS=0.204p
+ AD=0.09345p PS=1.835u PD=0.865u rfmode=0
M$45913 VDD|in|pad|pin1|pin2|supply|vdd \$2617 \$2639
+ VDD|in|pad|pin1|pin2|supply|vdd sg13_lv_pmos L=0.13u W=0.42u AS=0.204p
+ AD=0.0798p PS=1.835u PD=0.8u rfmode=0
M$45914 VDD|in|pad|pin1|pin2|supply|vdd \$2638 \$2639
+ VDD|in|pad|pin1|pin2|supply|vdd sg13_lv_pmos L=0.13u W=0.42u AS=0.4659p
+ AD=0.0798p PS=3.65u PD=0.8u rfmode=0
M$45917 VDD|in|pad|pin1|pin2|supply|vdd \$2098 \$2730
+ VDD|in|pad|pin1|pin2|supply|vdd sg13_lv_pmos L=0.13u W=1.12u AS=0.3808p
+ AD=0.3808p PS=2.92u PD=2.92u rfmode=0
M$45918 VDD|in|pad|pin1|pin2|supply|vdd \$2620 \$2691
+ VDD|in|pad|pin1|pin2|supply|vdd sg13_lv_pmos L=0.13u W=0.42u AS=0.1428p
+ AD=0.0798p PS=1.52u PD=0.8u rfmode=0
M$45919 VDD|in|pad|pin1|pin2|supply|vdd \$2730 \$2691
+ VDD|in|pad|pin1|pin2|supply|vdd sg13_lv_pmos L=0.13u W=0.42u AS=0.3623875p
+ AD=0.0798p PS=2.605u PD=0.8u rfmode=0
M$45920 VDD|in|pad|pin1|pin2|supply|vdd \$2729 \$2677
+ VDD|in|pad|pin1|pin2|supply|vdd sg13_lv_pmos L=0.13u W=1u AS=0.3623875p
+ AD=0.34p PS=2.605u PD=2.68u rfmode=0
M$45921 \$2735 \$2678 VDD|in|pad|pin1|pin2|supply|vdd
+ VDD|in|pad|pin1|pin2|supply|vdd sg13_lv_pmos L=0.13u W=1.12u AS=0.3864p
+ AD=0.41165p PS=2.93u PD=2.12u rfmode=0
M$45922 VDD|in|pad|pin1|pin2|supply|vdd \$2256 \$2678
+ VDD|in|pad|pin1|pin2|supply|vdd sg13_lv_pmos L=0.13u W=1.12u AS=0.41165p
+ AD=0.4088p PS=2.12u PD=2.97u rfmode=0
M$45923 \$2706 \$2735 \$2739 VDD|in|pad|pin1|pin2|supply|vdd sg13_lv_pmos
+ L=0.13u W=0.42u AS=0.2048p AD=0.09345p PS=1.63u PD=0.865u rfmode=0
M$45924 \$2739 \$2694 VDD|in|pad|pin1|pin2|supply|vdd
+ VDD|in|pad|pin1|pin2|supply|vdd sg13_lv_pmos L=0.13u W=0.42u AS=0.09345p
+ AD=0.204p PS=0.865u PD=1.835u rfmode=0
M$45925 VDD|in|pad|pin1|pin2|supply|vdd \$2730 \$2694
+ VDD|in|pad|pin1|pin2|supply|vdd sg13_lv_pmos L=0.13u W=0.42u AS=0.204p
+ AD=0.0798p PS=1.835u PD=0.8u rfmode=0
M$45926 \$2694 \$2706 VDD|in|pad|pin1|pin2|supply|vdd
+ VDD|in|pad|pin1|pin2|supply|vdd sg13_lv_pmos L=0.13u W=0.42u AS=0.0798p
+ AD=0.4659p PS=0.8u PD=3.65u rfmode=0
M$45927 \$2677 \$2678 \$2706 VDD|in|pad|pin1|pin2|supply|vdd sg13_lv_pmos
+ L=0.13u W=1u AS=0.34p AD=0.2048p PS=2.68u PD=1.63u rfmode=0
M$45928 \$2695 \$2706 VDD|in|pad|pin1|pin2|supply|vdd
+ VDD|in|pad|pin1|pin2|supply|vdd sg13_lv_pmos L=0.13u W=1.12u AS=0.3864p
+ AD=0.2128p PS=2.93u PD=1.5u rfmode=0
M$45929 VDD|in|pad|pin1|pin2|supply|vdd \$2695 \$2650
+ VDD|in|pad|pin1|pin2|supply|vdd sg13_lv_pmos L=0.13u W=1.12u AS=0.2128p
+ AD=0.3808p PS=1.5u PD=2.92u rfmode=0
M$45930 \$2696 \$2727 VDD|in|pad|pin1|pin2|supply|vdd
+ VDD|in|pad|pin1|pin2|supply|vdd sg13_lv_pmos L=0.13u W=0.84u AS=0.2856p
+ AD=0.253p PS=2.36u PD=1.53u rfmode=0
M$45931 VDD|in|pad|pin1|pin2|supply|vdd \$2727 \$2754
+ VDD|in|pad|pin1|pin2|supply|vdd sg13_lv_pmos L=0.13u W=1u AS=0.253p
+ AD=0.3325p PS=1.53u PD=1.665u rfmode=0
M$45932 \$2754 \$2707 \$2679 VDD|in|pad|pin1|pin2|supply|vdd sg13_lv_pmos
+ L=0.13u W=1u AS=0.3325p AD=0.2225p PS=1.665u PD=1.445u rfmode=0
M$45933 \$2679 \$2384 \$2758 VDD|in|pad|pin1|pin2|supply|vdd sg13_lv_pmos
+ L=0.13u W=1u AS=0.2225p AD=0.2975p PS=1.445u PD=1.595u rfmode=0
M$45934 \$2758 \$2696 VDD|in|pad|pin1|pin2|supply|vdd
+ VDD|in|pad|pin1|pin2|supply|vdd sg13_lv_pmos L=0.13u W=1u AS=0.2975p
+ AD=0.2198p PS=1.595u PD=1.52u rfmode=0
M$45935 VDD|in|pad|pin1|pin2|supply|vdd \$2679 \$2697
+ VDD|in|pad|pin1|pin2|supply|vdd sg13_lv_pmos L=0.13u W=1.12u AS=0.2198p
+ AD=0.6048p PS=1.52u PD=3.32u rfmode=0
M$45936 VDD|in|pad|pin1|pin2|supply|vdd \$2697 \$2698
+ VDD|in|pad|pin1|pin2|supply|vdd sg13_lv_pmos L=0.13u W=0.42u AS=0.1428p
+ AD=0.0798p PS=1.52u PD=0.8u rfmode=0
M$45937 VDD|in|pad|pin1|pin2|supply|vdd \$2622 \$2698
+ VDD|in|pad|pin1|pin2|supply|vdd sg13_lv_pmos L=0.13u W=0.42u AS=0.3623875p
+ AD=0.0798p PS=2.605u PD=0.8u rfmode=0
M$45938 VDD|in|pad|pin1|pin2|supply|vdd \$2731 \$2680
+ VDD|in|pad|pin1|pin2|supply|vdd sg13_lv_pmos L=0.13u W=1u AS=0.3623875p
+ AD=0.34p PS=2.605u PD=2.68u rfmode=0
M$45939 \$2736 \$2681 VDD|in|pad|pin1|pin2|supply|vdd
+ VDD|in|pad|pin1|pin2|supply|vdd sg13_lv_pmos L=0.13u W=1.12u AS=0.3864p
+ AD=0.41165p PS=2.93u PD=2.12u rfmode=0
M$45940 VDD|in|pad|pin1|pin2|supply|vdd \$2256 \$2681
+ VDD|in|pad|pin1|pin2|supply|vdd sg13_lv_pmos L=0.13u W=1.12u AS=0.41165p
+ AD=0.4088p PS=2.12u PD=2.97u rfmode=0
M$45941 \$2708 \$2736 \$2738 VDD|in|pad|pin1|pin2|supply|vdd sg13_lv_pmos
+ L=0.13u W=0.42u AS=0.2048p AD=0.09345p PS=1.63u PD=0.865u rfmode=0
M$45942 \$2738 \$2701 VDD|in|pad|pin1|pin2|supply|vdd
+ VDD|in|pad|pin1|pin2|supply|vdd sg13_lv_pmos L=0.13u W=0.42u AS=0.09345p
+ AD=0.204p PS=0.865u PD=1.835u rfmode=0
M$45943 VDD|in|pad|pin1|pin2|supply|vdd \$2622 \$2701
+ VDD|in|pad|pin1|pin2|supply|vdd sg13_lv_pmos L=0.13u W=0.42u AS=0.204p
+ AD=0.0798p PS=1.835u PD=0.8u rfmode=0
M$45944 \$2701 \$2708 VDD|in|pad|pin1|pin2|supply|vdd
+ VDD|in|pad|pin1|pin2|supply|vdd sg13_lv_pmos L=0.13u W=0.42u AS=0.0798p
+ AD=0.4659p PS=0.8u PD=3.65u rfmode=0
M$45945 \$2680 \$2681 \$2708 VDD|in|pad|pin1|pin2|supply|vdd sg13_lv_pmos
+ L=0.13u W=1u AS=0.34p AD=0.2048p PS=2.68u PD=1.63u rfmode=0
M$45946 \$2702 \$2708 VDD|in|pad|pin1|pin2|supply|vdd
+ VDD|in|pad|pin1|pin2|supply|vdd sg13_lv_pmos L=0.13u W=1.12u AS=0.3864p
+ AD=0.2128p PS=2.93u PD=1.5u rfmode=0
M$45947 VDD|in|pad|pin1|pin2|supply|vdd \$2702 \$2707
+ VDD|in|pad|pin1|pin2|supply|vdd sg13_lv_pmos L=0.13u W=1.12u AS=0.2128p
+ AD=0.3808p PS=1.5u PD=2.92u rfmode=0
M$45963 VDD|in|pad|pin1|pin2|supply|vdd \$2788 \$2760
+ VDD|in|pad|pin1|pin2|supply|vdd sg13_lv_pmos L=0.13u W=0.84u AS=0.2114p
+ AD=0.2856p PS=1.54u PD=2.36u rfmode=0
M$45964 \$883 \$2760 VDD|in|pad|pin1|pin2|supply|vdd
+ VDD|in|pad|pin1|pin2|supply|vdd sg13_lv_pmos L=0.13u W=1.12u AS=0.42p
+ AD=0.2114p PS=2.99u PD=1.54u rfmode=0
M$45979 \$2724 \$2725 VDD|in|pad|pin1|pin2|supply|vdd
+ VDD|in|pad|pin1|pin2|supply|vdd sg13_lv_pmos L=0.13u W=0.42u AS=0.147p
+ AD=0.1563p PS=1.54u PD=1.22u rfmode=0
M$45980 VDD|in|pad|pin1|pin2|supply|vdd \$2675 \$2740
+ VDD|in|pad|pin1|pin2|supply|vdd sg13_lv_pmos L=0.13u W=0.42u AS=0.1563p
+ AD=0.063p PS=1.22u PD=0.72u rfmode=0
M$45981 \$2740 \$2676 \$2724 VDD|in|pad|pin1|pin2|supply|vdd sg13_lv_pmos
+ L=0.13u W=0.42u AS=0.063p AD=0.0798p PS=0.72u PD=0.8u rfmode=0
M$45982 \$2724 \$2732 \$2682 VDD|in|pad|pin1|pin2|supply|vdd sg13_lv_pmos
+ L=0.13u W=0.42u AS=0.0798p AD=0.1428p PS=0.8u PD=1.52u rfmode=0
M$45983 \$2631 \$2131 \$2803 VDD|in|pad|pin1|pin2|supply|vdd sg13_lv_pmos
+ L=0.13u W=1.12u AS=0.3808p AD=0.1176p PS=2.92u PD=1.33u rfmode=0
M$45984 \$2803 \$2687 VDD|in|pad|pin1|pin2|supply|vdd
+ VDD|in|pad|pin1|pin2|supply|vdd sg13_lv_pmos L=0.13u W=1.12u AS=0.1176p
+ AD=0.4032p PS=1.33u PD=2.96u rfmode=0
M$45987 \$2761 \$2248 VDD|in|pad|pin1|pin2|supply|vdd
+ VDD|in|pad|pin1|pin2|supply|vdd sg13_lv_pmos L=0.13u W=1.12u AS=0.3808p
+ AD=0.3808p PS=2.92u PD=2.92u rfmode=0
M$45988 VDD|in|pad|pin1|pin2|supply|vdd \$2688 \$2762
+ VDD|in|pad|pin1|pin2|supply|vdd sg13_lv_pmos L=0.13u W=0.42u AS=0.1428p
+ AD=0.0798p PS=1.52u PD=0.8u rfmode=0
M$45989 VDD|in|pad|pin1|pin2|supply|vdd \$2761 \$2762
+ VDD|in|pad|pin1|pin2|supply|vdd sg13_lv_pmos L=0.13u W=0.42u AS=0.3623875p
+ AD=0.0798p PS=2.605u PD=0.8u rfmode=0
M$45990 VDD|in|pad|pin1|pin2|supply|vdd \$2763 \$2789
+ VDD|in|pad|pin1|pin2|supply|vdd sg13_lv_pmos L=0.13u W=1u AS=0.3623875p
+ AD=0.34p PS=2.605u PD=2.68u rfmode=0
M$45991 VDD|in|pad|pin1|pin2|supply|vdd \$2791 \$2790
+ VDD|in|pad|pin1|pin2|supply|vdd sg13_lv_pmos L=0.13u W=1.12u AS=0.41165p
+ AD=0.3864p PS=2.12u PD=2.93u rfmode=0
M$45992 VDD|in|pad|pin1|pin2|supply|vdd \$2247 \$2791
+ VDD|in|pad|pin1|pin2|supply|vdd sg13_lv_pmos L=0.13u W=1.12u AS=0.41165p
+ AD=0.4088p PS=2.12u PD=2.97u rfmode=0
M$45993 \$2789 \$2791 \$2792 VDD|in|pad|pin1|pin2|supply|vdd sg13_lv_pmos
+ L=0.13u W=1u AS=0.34p AD=0.2048p PS=2.68u PD=1.63u rfmode=0
M$45994 \$2792 \$2790 \$2804 VDD|in|pad|pin1|pin2|supply|vdd sg13_lv_pmos
+ L=0.13u W=0.42u AS=0.2048p AD=0.09345p PS=1.63u PD=0.865u rfmode=0
M$45995 VDD|in|pad|pin1|pin2|supply|vdd \$2793 \$2804
+ VDD|in|pad|pin1|pin2|supply|vdd sg13_lv_pmos L=0.13u W=0.42u AS=0.204p
+ AD=0.09345p PS=1.835u PD=0.865u rfmode=0
M$45996 VDD|in|pad|pin1|pin2|supply|vdd \$2761 \$2793
+ VDD|in|pad|pin1|pin2|supply|vdd sg13_lv_pmos L=0.13u W=0.42u AS=0.204p
+ AD=0.0798p PS=1.835u PD=0.8u rfmode=0
M$45997 VDD|in|pad|pin1|pin2|supply|vdd \$2792 \$2793
+ VDD|in|pad|pin1|pin2|supply|vdd sg13_lv_pmos L=0.13u W=0.42u AS=0.4659p
+ AD=0.0798p PS=3.65u PD=0.8u rfmode=0
M$45998 \$2764 \$2792 VDD|in|pad|pin1|pin2|supply|vdd
+ VDD|in|pad|pin1|pin2|supply|vdd sg13_lv_pmos L=0.13u W=1.12u AS=0.3864p
+ AD=0.2128p PS=2.93u PD=1.5u rfmode=0
M$45999 VDD|in|pad|pin1|pin2|supply|vdd \$2764 \$2788
+ VDD|in|pad|pin1|pin2|supply|vdd sg13_lv_pmos L=0.13u W=1.12u AS=0.2128p
+ AD=0.3808p PS=1.5u PD=2.92u rfmode=0
M$46000 VDD|in|pad|pin1|pin2|supply|vdd \$2788 \$2805
+ VDD|in|pad|pin1|pin2|supply|vdd sg13_lv_pmos L=0.13u W=1.12u AS=0.4032p
+ AD=0.1176p PS=2.96u PD=1.33u rfmode=0
M$46001 \$2805 \$2727 \$2726 VDD|in|pad|pin1|pin2|supply|vdd sg13_lv_pmos
+ L=0.13u W=1.12u AS=0.1176p AD=0.3808p PS=1.33u PD=2.92u rfmode=0
M$46010 \$2568 \$2613 VDD|in|pad|pin1|pin2|supply|vdd
+ VDD|in|pad|pin1|pin2|supply|vdd sg13_lv_pmos L=0.13u W=1.12u AS=0.3808p
+ AD=0.3808p PS=2.92u PD=2.92u rfmode=0
M$46011 VDD|in|pad|pin1|pin2|supply|vdd \$2613 \$2807
+ VDD|in|pad|pin1|pin2|supply|vdd sg13_lv_pmos L=0.13u W=1.12u AS=0.3808p
+ AD=0.2464p PS=2.92u PD=1.56u rfmode=0
M$46012 \$2807 \$2647 \$2806 VDD|in|pad|pin1|pin2|supply|vdd sg13_lv_pmos
+ L=0.13u W=1.12u AS=0.2464p AD=0.2128p PS=1.56u PD=1.5u rfmode=0
M$46013 \$2806 \$2586 \$2765 VDD|in|pad|pin1|pin2|supply|vdd sg13_lv_pmos
+ L=0.13u W=1.12u AS=0.2128p AD=0.3808p PS=1.5u PD=2.92u rfmode=0
M$46014 VDD|in|pad|pin1|pin2|supply|vdd \$2613 \$2810
+ VDD|in|pad|pin1|pin2|supply|vdd sg13_lv_pmos L=0.13u W=1.12u AS=0.3808p
+ AD=0.2464p PS=2.92u PD=1.56u rfmode=0
M$46015 \$2810 \$2586 \$2809 VDD|in|pad|pin1|pin2|supply|vdd sg13_lv_pmos
+ L=0.13u W=1.12u AS=0.2464p AD=0.2128p PS=1.56u PD=1.5u rfmode=0
M$46016 \$2809 \$2689 \$2766 VDD|in|pad|pin1|pin2|supply|vdd sg13_lv_pmos
+ L=0.13u W=1.12u AS=0.2128p AD=0.3808p PS=1.5u PD=2.92u rfmode=0
M$46017 VDD|in|pad|pin1|pin2|supply|vdd \$2689 \$2808
+ VDD|in|pad|pin1|pin2|supply|vdd sg13_lv_pmos L=0.13u W=1.12u AS=0.4032p
+ AD=0.1176p PS=2.96u PD=1.33u rfmode=0
M$46018 \$2808 \$2390 \$2767 VDD|in|pad|pin1|pin2|supply|vdd sg13_lv_pmos
+ L=0.13u W=1.12u AS=0.1176p AD=0.3808p PS=1.33u PD=2.92u rfmode=0
M$46023 VDD|in|pad|pin1|pin2|supply|vdd \$2647 \$2812
+ VDD|in|pad|pin1|pin2|supply|vdd sg13_lv_pmos L=0.13u W=1.12u AS=0.3808p
+ AD=0.2464p PS=2.92u PD=1.56u rfmode=0
M$46024 \$2812 \$2532 \$2811 VDD|in|pad|pin1|pin2|supply|vdd sg13_lv_pmos
+ L=0.13u W=1.12u AS=0.2464p AD=0.2128p PS=1.56u PD=1.5u rfmode=0
M$46025 \$2811 \$2384 \$2768 VDD|in|pad|pin1|pin2|supply|vdd sg13_lv_pmos
+ L=0.13u W=1.12u AS=0.2128p AD=0.3808p PS=1.5u PD=2.92u rfmode=0
M$46026 VDD|in|pad|pin1|pin2|supply|vdd \$2765 \$2813
+ VDD|in|pad|pin1|pin2|supply|vdd sg13_lv_pmos L=0.15u W=1.12u AS=0.3808p
+ AD=0.2128p PS=2.92u PD=1.5u rfmode=0
M$46027 \$2813 \$2131 \$2769 VDD|in|pad|pin1|pin2|supply|vdd sg13_lv_pmos
+ L=0.15u W=1.12u AS=0.2128p AD=0.2128p PS=1.5u PD=1.5u rfmode=0
M$46028 \$2769 \$2768 VDD|in|pad|pin1|pin2|supply|vdd
+ VDD|in|pad|pin1|pin2|supply|vdd sg13_lv_pmos L=0.15u W=1.12u AS=0.2128p
+ AD=0.3808p PS=1.5u PD=2.92u rfmode=0
M$46034 \$2729 \$2730 VDD|in|pad|pin1|pin2|supply|vdd
+ VDD|in|pad|pin1|pin2|supply|vdd sg13_lv_pmos L=0.13u W=0.42u AS=0.147p
+ AD=0.1563p PS=1.54u PD=1.22u rfmode=0
M$46035 VDD|in|pad|pin1|pin2|supply|vdd \$2677 \$2753
+ VDD|in|pad|pin1|pin2|supply|vdd sg13_lv_pmos L=0.13u W=0.42u AS=0.1563p
+ AD=0.063p PS=1.22u PD=0.72u rfmode=0
M$46036 \$2753 \$2678 \$2729 VDD|in|pad|pin1|pin2|supply|vdd sg13_lv_pmos
+ L=0.13u W=0.42u AS=0.063p AD=0.0798p PS=0.72u PD=0.8u rfmode=0
M$46037 \$2729 \$2735 \$2691 VDD|in|pad|pin1|pin2|supply|vdd sg13_lv_pmos
+ L=0.13u W=0.42u AS=0.0798p AD=0.1428p PS=0.8u PD=1.52u rfmode=0
M$46038 \$2770 \$2800 VDD|in|pad|pin1|pin2|supply|vdd
+ VDD|in|pad|pin1|pin2|supply|vdd sg13_lv_pmos L=0.13u W=1.12u AS=0.6048p
+ AD=0.2198p PS=3.32u PD=1.52u rfmode=0
M$46039 VDD|in|pad|pin1|pin2|supply|vdd \$2759 \$2814
+ VDD|in|pad|pin1|pin2|supply|vdd sg13_lv_pmos L=0.13u W=1u AS=0.2198p
+ AD=0.2975p PS=1.52u PD=1.595u rfmode=0
M$46040 \$2814 \$2384 \$2800 VDD|in|pad|pin1|pin2|supply|vdd sg13_lv_pmos
+ L=0.13u W=1u AS=0.2975p AD=0.2225p PS=1.595u PD=1.445u rfmode=0
M$46041 \$2800 \$2801 \$2815 VDD|in|pad|pin1|pin2|supply|vdd sg13_lv_pmos
+ L=0.13u W=1u AS=0.2225p AD=0.3325p PS=1.445u PD=1.665u rfmode=0
M$46042 \$2815 \$2727 VDD|in|pad|pin1|pin2|supply|vdd
+ VDD|in|pad|pin1|pin2|supply|vdd sg13_lv_pmos L=0.13u W=1u AS=0.3325p
+ AD=0.253p PS=1.665u PD=1.53u rfmode=0
M$46043 VDD|in|pad|pin1|pin2|supply|vdd \$2727 \$2759
+ VDD|in|pad|pin1|pin2|supply|vdd sg13_lv_pmos L=0.13u W=0.84u AS=0.253p
+ AD=0.2856p PS=1.53u PD=2.36u rfmode=0
M$46047 VDD|in|pad|pin1|pin2|supply|vdd \$2766 \$2771
+ VDD|in|pad|pin1|pin2|supply|vdd sg13_lv_pmos L=0.13u W=0.84u AS=0.253p
+ AD=0.2856p PS=1.53u PD=2.36u rfmode=0
M$46048 VDD|in|pad|pin1|pin2|supply|vdd \$2766 \$2817
+ VDD|in|pad|pin1|pin2|supply|vdd sg13_lv_pmos L=0.13u W=1u AS=0.253p
+ AD=0.3325p PS=1.53u PD=1.665u rfmode=0
M$46049 \$2817 \$2802 \$2772 VDD|in|pad|pin1|pin2|supply|vdd sg13_lv_pmos
+ L=0.13u W=1u AS=0.3325p AD=0.2225p PS=1.665u PD=1.445u rfmode=0
M$46050 \$2772 \$2384 \$2816 VDD|in|pad|pin1|pin2|supply|vdd sg13_lv_pmos
+ L=0.13u W=1u AS=0.2225p AD=0.2975p PS=1.445u PD=1.595u rfmode=0
M$46051 VDD|in|pad|pin1|pin2|supply|vdd \$2771 \$2816
+ VDD|in|pad|pin1|pin2|supply|vdd sg13_lv_pmos L=0.13u W=1u AS=0.2198p
+ AD=0.2975p PS=1.52u PD=1.595u rfmode=0
M$46052 VDD|in|pad|pin1|pin2|supply|vdd \$2772 \$2773
+ VDD|in|pad|pin1|pin2|supply|vdd sg13_lv_pmos L=0.13u W=1.12u AS=0.2198p
+ AD=0.6048p PS=1.52u PD=3.32u rfmode=0
M$46053 \$2774 \$2429 VDD|in|pad|pin1|pin2|supply|vdd
+ VDD|in|pad|pin1|pin2|supply|vdd sg13_lv_pmos L=0.13u W=0.84u AS=0.2856p
+ AD=0.2114p PS=2.36u PD=1.54u rfmode=0
M$46054 VDD|in|pad|pin1|pin2|supply|vdd \$2774 \$2651
+ VDD|in|pad|pin1|pin2|supply|vdd sg13_lv_pmos L=0.13u W=1.12u AS=0.2114p
+ AD=0.42p PS=1.54u PD=2.99u rfmode=0
M$46055 \$2731 \$2622 VDD|in|pad|pin1|pin2|supply|vdd
+ VDD|in|pad|pin1|pin2|supply|vdd sg13_lv_pmos L=0.13u W=0.42u AS=0.147p
+ AD=0.1563p PS=1.54u PD=1.22u rfmode=0
M$46056 VDD|in|pad|pin1|pin2|supply|vdd \$2680 \$2757
+ VDD|in|pad|pin1|pin2|supply|vdd sg13_lv_pmos L=0.13u W=0.42u AS=0.1563p
+ AD=0.063p PS=1.22u PD=0.72u rfmode=0
M$46057 \$2757 \$2681 \$2731 VDD|in|pad|pin1|pin2|supply|vdd sg13_lv_pmos
+ L=0.13u W=0.42u AS=0.063p AD=0.0798p PS=0.72u PD=0.8u rfmode=0
M$46058 \$2731 \$2736 \$2698 VDD|in|pad|pin1|pin2|supply|vdd sg13_lv_pmos
+ L=0.13u W=0.42u AS=0.0798p AD=0.1428p PS=0.8u PD=1.52u rfmode=0
M$46079 \$2775 \$2707 VDD|in|pad|pin1|pin2|supply|vdd
+ VDD|in|pad|pin1|pin2|supply|vdd sg13_lv_pmos L=0.13u W=0.84u AS=0.2856p
+ AD=0.2114p PS=2.36u PD=1.54u rfmode=0
M$46080 VDD|in|pad|pin1|pin2|supply|vdd \$2775 \$891
+ VDD|in|pad|pin1|pin2|supply|vdd sg13_lv_pmos L=0.13u W=1.12u AS=0.2114p
+ AD=0.42p PS=1.54u PD=2.99u rfmode=0
M$46101 VDD|in|pad|pin1|pin2|supply|vdd \$2905 \$2873
+ VDD|in|pad|pin1|pin2|supply|vdd sg13_lv_pmos L=0.13u W=0.42u AS=0.1428p
+ AD=0.0798p PS=1.52u PD=0.8u rfmode=0
M$46102 VDD|in|pad|pin1|pin2|supply|vdd \$2907 \$2873
+ VDD|in|pad|pin1|pin2|supply|vdd sg13_lv_pmos L=0.13u W=0.42u AS=0.3623875p
+ AD=0.0798p PS=2.605u PD=0.8u rfmode=0
M$46103 VDD|in|pad|pin1|pin2|supply|vdd \$2906 \$2837
+ VDD|in|pad|pin1|pin2|supply|vdd sg13_lv_pmos L=0.13u W=1u AS=0.3623875p
+ AD=0.34p PS=2.605u PD=2.68u rfmode=0
M$46104 VDD|in|pad|pin1|pin2|supply|vdd \$2761 \$2763
+ VDD|in|pad|pin1|pin2|supply|vdd sg13_lv_pmos L=0.13u W=0.42u AS=0.1563p
+ AD=0.147p PS=1.22u PD=1.54u rfmode=0
M$46105 VDD|in|pad|pin1|pin2|supply|vdd \$2789 \$2796
+ VDD|in|pad|pin1|pin2|supply|vdd sg13_lv_pmos L=0.13u W=0.42u AS=0.1563p
+ AD=0.063p PS=1.22u PD=0.72u rfmode=0
M$46106 \$2796 \$2791 \$2763 VDD|in|pad|pin1|pin2|supply|vdd sg13_lv_pmos
+ L=0.13u W=0.42u AS=0.063p AD=0.0798p PS=0.72u PD=0.8u rfmode=0
M$46107 \$2763 \$2790 \$2762 VDD|in|pad|pin1|pin2|supply|vdd sg13_lv_pmos
+ L=0.13u W=0.42u AS=0.0798p AD=0.1428p PS=0.8u PD=1.52u rfmode=0
M$46108 \$2874 \$2838 VDD|in|pad|pin1|pin2|supply|vdd
+ VDD|in|pad|pin1|pin2|supply|vdd sg13_lv_pmos L=0.13u W=1.12u AS=0.3864p
+ AD=0.41165p PS=2.93u PD=2.12u rfmode=0
M$46109 VDD|in|pad|pin1|pin2|supply|vdd \$2247 \$2838
+ VDD|in|pad|pin1|pin2|supply|vdd sg13_lv_pmos L=0.13u W=1.12u AS=0.41165p
+ AD=0.4088p PS=2.12u PD=2.97u rfmode=0
M$46110 \$2875 \$2874 \$2919 VDD|in|pad|pin1|pin2|supply|vdd sg13_lv_pmos
+ L=0.13u W=0.42u AS=0.2048p AD=0.09345p PS=1.63u PD=0.865u rfmode=0
M$46111 \$2919 \$2840 VDD|in|pad|pin1|pin2|supply|vdd
+ VDD|in|pad|pin1|pin2|supply|vdd sg13_lv_pmos L=0.13u W=0.42u AS=0.09345p
+ AD=0.204p PS=0.865u PD=1.835u rfmode=0
M$46112 VDD|in|pad|pin1|pin2|supply|vdd \$2907 \$2840
+ VDD|in|pad|pin1|pin2|supply|vdd sg13_lv_pmos L=0.13u W=0.42u AS=0.204p
+ AD=0.0798p PS=1.835u PD=0.8u rfmode=0
M$46113 \$2840 \$2875 VDD|in|pad|pin1|pin2|supply|vdd
+ VDD|in|pad|pin1|pin2|supply|vdd sg13_lv_pmos L=0.13u W=0.42u AS=0.0798p
+ AD=0.4659p PS=0.8u PD=3.65u rfmode=0
M$46114 \$2837 \$2838 \$2875 VDD|in|pad|pin1|pin2|supply|vdd sg13_lv_pmos
+ L=0.13u W=1u AS=0.34p AD=0.2048p PS=2.68u PD=1.63u rfmode=0
M$46115 \$2841 \$2875 VDD|in|pad|pin1|pin2|supply|vdd
+ VDD|in|pad|pin1|pin2|supply|vdd sg13_lv_pmos L=0.13u W=1.12u AS=0.3864p
+ AD=0.2128p PS=2.93u PD=1.5u rfmode=0
M$46116 VDD|in|pad|pin1|pin2|supply|vdd \$2841 \$2842
+ VDD|in|pad|pin1|pin2|supply|vdd sg13_lv_pmos L=0.13u W=1.12u AS=0.2128p
+ AD=0.3808p PS=1.5u PD=2.92u rfmode=0
M$46117 VDD|in|pad|pin1|pin2|supply|vdd \$2205 \$2843
+ VDD|in|pad|pin1|pin2|supply|vdd sg13_lv_pmos L=0.13u W=1.12u AS=0.3808p
+ AD=0.3808p PS=2.92u PD=2.92u rfmode=0
M$46122 VDD|in|pad|pin1|pin2|supply|vdd \$2375 \$2876
+ VDD|in|pad|pin1|pin2|supply|vdd sg13_lv_pmos L=0.13u W=0.84u AS=0.253p
+ AD=0.2856p PS=1.53u PD=2.36u rfmode=0
M$46123 VDD|in|pad|pin1|pin2|supply|vdd \$2876 \$2937
+ VDD|in|pad|pin1|pin2|supply|vdd sg13_lv_pmos L=0.13u W=1u AS=0.2198p
+ AD=0.2975p PS=1.52u PD=1.595u rfmode=0
M$46124 \$2937 \$2390 \$2845 VDD|in|pad|pin1|pin2|supply|vdd sg13_lv_pmos
+ L=0.13u W=1u AS=0.2975p AD=0.2225p PS=1.595u PD=1.445u rfmode=0
M$46125 \$2845 \$2908 \$2936 VDD|in|pad|pin1|pin2|supply|vdd sg13_lv_pmos
+ L=0.13u W=1u AS=0.2225p AD=0.3325p PS=1.445u PD=1.665u rfmode=0
M$46126 \$2936 \$2375 VDD|in|pad|pin1|pin2|supply|vdd
+ VDD|in|pad|pin1|pin2|supply|vdd sg13_lv_pmos L=0.13u W=1u AS=0.3325p
+ AD=0.253p PS=1.665u PD=1.53u rfmode=0
M$46127 \$2844 \$2845 VDD|in|pad|pin1|pin2|supply|vdd
+ VDD|in|pad|pin1|pin2|supply|vdd sg13_lv_pmos L=0.13u W=1.12u AS=0.6048p
+ AD=0.2198p PS=3.32u PD=1.52u rfmode=0
M$46132 VDD|in|pad|pin1|pin2|supply|vdd \$2909 \$2846
+ VDD|in|pad|pin1|pin2|supply|vdd sg13_lv_pmos L=0.13u W=1.12u AS=0.3808p
+ AD=0.3808p PS=2.92u PD=2.92u rfmode=0
M$46133 VDD|in|pad|pin1|pin2|supply|vdd \$2846 \$2939
+ VDD|in|pad|pin1|pin2|supply|vdd sg13_lv_pmos L=0.15u W=1.12u AS=0.3808p
+ AD=0.2128p PS=2.92u PD=1.5u rfmode=0
M$46134 \$2939 \$2766 \$2877 VDD|in|pad|pin1|pin2|supply|vdd sg13_lv_pmos
+ L=0.15u W=1.12u AS=0.2128p AD=0.2128p PS=1.5u PD=1.5u rfmode=0
M$46135 \$2877 \$2910 VDD|in|pad|pin1|pin2|supply|vdd
+ VDD|in|pad|pin1|pin2|supply|vdd sg13_lv_pmos L=0.15u W=1.12u AS=0.2128p
+ AD=0.3808p PS=1.5u PD=2.92u rfmode=0
M$46136 VDD|in|pad|pin1|pin2|supply|vdd \$2767 \$2910
+ VDD|in|pad|pin1|pin2|supply|vdd sg13_lv_pmos L=0.15u W=1.12u AS=0.3808p
+ AD=0.2128p PS=2.92u PD=1.5u rfmode=0
M$46137 \$2910 \$2131 \$2938 VDD|in|pad|pin1|pin2|supply|vdd sg13_lv_pmos
+ L=0.15u W=1.12u AS=0.2128p AD=0.2128p PS=1.5u PD=1.5u rfmode=0
M$46138 \$2938 \$2765 VDD|in|pad|pin1|pin2|supply|vdd
+ VDD|in|pad|pin1|pin2|supply|vdd sg13_lv_pmos L=0.15u W=1.12u AS=0.2128p
+ AD=0.3808p PS=1.5u PD=2.92u rfmode=0
M$46142 \$2878 \$2765 VDD|in|pad|pin1|pin2|supply|vdd
+ VDD|in|pad|pin1|pin2|supply|vdd sg13_lv_pmos L=0.13u W=0.84u AS=0.2856p
+ AD=0.2618p PS=2.36u PD=1.63u rfmode=0
M$46143 VDD|in|pad|pin1|pin2|supply|vdd \$2878 \$2941
+ VDD|in|pad|pin1|pin2|supply|vdd sg13_lv_pmos L=0.13u W=1.12u AS=0.2618p
+ AD=0.1176p PS=1.63u PD=1.33u rfmode=0
M$46144 \$2941 \$2532 \$2849 VDD|in|pad|pin1|pin2|supply|vdd sg13_lv_pmos
+ L=0.13u W=1.12u AS=0.1176p AD=0.3808p PS=1.33u PD=2.92u rfmode=0
M$46145 VDD|in|pad|pin1|pin2|supply|vdd \$2911 \$2940
+ VDD|in|pad|pin1|pin2|supply|vdd sg13_lv_pmos L=0.15u W=1.12u AS=0.3808p
+ AD=0.2128p PS=2.92u PD=1.5u rfmode=0
M$46146 \$2940 \$2849 \$2851 VDD|in|pad|pin1|pin2|supply|vdd sg13_lv_pmos
+ L=0.15u W=1.12u AS=0.2128p AD=0.2128p PS=1.5u PD=1.5u rfmode=0
M$46147 \$2851 \$2769 VDD|in|pad|pin1|pin2|supply|vdd
+ VDD|in|pad|pin1|pin2|supply|vdd sg13_lv_pmos L=0.15u W=1.12u AS=0.2128p
+ AD=0.3808p PS=1.5u PD=2.92u rfmode=0
M$46148 \$2852 \$2098 VDD|in|pad|pin1|pin2|supply|vdd
+ VDD|in|pad|pin1|pin2|supply|vdd sg13_lv_pmos L=0.13u W=1.12u AS=0.3808p
+ AD=0.3808p PS=2.92u PD=2.92u rfmode=0
M$46151 VDD|in|pad|pin1|pin2|supply|vdd \$2098 \$2853
+ VDD|in|pad|pin1|pin2|supply|vdd sg13_lv_pmos L=0.13u W=1.12u AS=0.3808p
+ AD=0.3808p PS=2.92u PD=2.92u rfmode=0
M$46152 VDD|in|pad|pin1|pin2|supply|vdd \$2770 \$2880
+ VDD|in|pad|pin1|pin2|supply|vdd sg13_lv_pmos L=0.13u W=0.42u AS=0.1428p
+ AD=0.0798p PS=1.52u PD=0.8u rfmode=0
M$46153 VDD|in|pad|pin1|pin2|supply|vdd \$2853 \$2880
+ VDD|in|pad|pin1|pin2|supply|vdd sg13_lv_pmos L=0.13u W=0.42u AS=0.3623875p
+ AD=0.0798p PS=2.605u PD=0.8u rfmode=0
M$46154 VDD|in|pad|pin1|pin2|supply|vdd \$2912 \$2854
+ VDD|in|pad|pin1|pin2|supply|vdd sg13_lv_pmos L=0.13u W=1u AS=0.3623875p
+ AD=0.34p PS=2.605u PD=2.68u rfmode=0
M$46155 \$2881 \$2855 VDD|in|pad|pin1|pin2|supply|vdd
+ VDD|in|pad|pin1|pin2|supply|vdd sg13_lv_pmos L=0.13u W=1.12u AS=0.3864p
+ AD=0.41165p PS=2.93u PD=2.12u rfmode=0
M$46156 VDD|in|pad|pin1|pin2|supply|vdd \$2256 \$2855
+ VDD|in|pad|pin1|pin2|supply|vdd sg13_lv_pmos L=0.13u W=1.12u AS=0.41165p
+ AD=0.4088p PS=2.12u PD=2.97u rfmode=0
M$46157 \$2882 \$2881 \$2920 VDD|in|pad|pin1|pin2|supply|vdd sg13_lv_pmos
+ L=0.13u W=0.42u AS=0.2048p AD=0.09345p PS=1.63u PD=0.865u rfmode=0
M$46158 \$2920 \$2857 VDD|in|pad|pin1|pin2|supply|vdd
+ VDD|in|pad|pin1|pin2|supply|vdd sg13_lv_pmos L=0.13u W=0.42u AS=0.09345p
+ AD=0.204p PS=0.865u PD=1.835u rfmode=0
M$46159 VDD|in|pad|pin1|pin2|supply|vdd \$2853 \$2857
+ VDD|in|pad|pin1|pin2|supply|vdd sg13_lv_pmos L=0.13u W=0.42u AS=0.204p
+ AD=0.0798p PS=1.835u PD=0.8u rfmode=0
M$46160 \$2857 \$2882 VDD|in|pad|pin1|pin2|supply|vdd
+ VDD|in|pad|pin1|pin2|supply|vdd sg13_lv_pmos L=0.13u W=0.42u AS=0.0798p
+ AD=0.4659p PS=0.8u PD=3.65u rfmode=0
M$46161 \$2854 \$2855 \$2882 VDD|in|pad|pin1|pin2|supply|vdd sg13_lv_pmos
+ L=0.13u W=1u AS=0.34p AD=0.2048p PS=2.68u PD=1.63u rfmode=0
M$46162 \$2858 \$2882 VDD|in|pad|pin1|pin2|supply|vdd
+ VDD|in|pad|pin1|pin2|supply|vdd sg13_lv_pmos L=0.13u W=1.12u AS=0.3864p
+ AD=0.2128p PS=2.93u PD=1.5u rfmode=0
M$46163 VDD|in|pad|pin1|pin2|supply|vdd \$2858 \$2801
+ VDD|in|pad|pin1|pin2|supply|vdd sg13_lv_pmos L=0.13u W=1.12u AS=0.2128p
+ AD=0.3808p PS=1.5u PD=2.92u rfmode=0
M$46164 \$2859 \$2651 VDD|in|pad|pin1|pin2|supply|vdd
+ VDD|in|pad|pin1|pin2|supply|vdd sg13_lv_pmos L=0.13u W=1.12u AS=0.3808p
+ AD=0.3808p PS=2.92u PD=2.92u rfmode=0
M$46165 VDD|in|pad|pin1|pin2|supply|vdd \$2651 \$2913
+ VDD|in|pad|pin1|pin2|supply|vdd sg13_lv_pmos L=0.13u W=1.12u AS=0.3808p
+ AD=0.3808p PS=2.92u PD=2.92u rfmode=0
M$46166 VDD|in|pad|pin1|pin2|supply|vdd \$2773 \$2884
+ VDD|in|pad|pin1|pin2|supply|vdd sg13_lv_pmos L=0.13u W=0.42u AS=0.1428p
+ AD=0.0798p PS=1.52u PD=0.8u rfmode=0
M$46167 VDD|in|pad|pin1|pin2|supply|vdd \$2913 \$2884
+ VDD|in|pad|pin1|pin2|supply|vdd sg13_lv_pmos L=0.13u W=0.42u AS=0.3623875p
+ AD=0.0798p PS=2.605u PD=0.8u rfmode=0
M$46168 VDD|in|pad|pin1|pin2|supply|vdd \$2914 \$2860
+ VDD|in|pad|pin1|pin2|supply|vdd sg13_lv_pmos L=0.13u W=1u AS=0.3623875p
+ AD=0.34p PS=2.605u PD=2.68u rfmode=0
M$46169 \$2885 \$2861 VDD|in|pad|pin1|pin2|supply|vdd
+ VDD|in|pad|pin1|pin2|supply|vdd sg13_lv_pmos L=0.13u W=1.12u AS=0.3864p
+ AD=0.41165p PS=2.93u PD=2.12u rfmode=0
M$46170 VDD|in|pad|pin1|pin2|supply|vdd \$2915 \$2861
+ VDD|in|pad|pin1|pin2|supply|vdd sg13_lv_pmos L=0.13u W=1.12u AS=0.41165p
+ AD=0.4088p PS=2.12u PD=2.97u rfmode=0
M$46171 \$2886 \$2885 \$2921 VDD|in|pad|pin1|pin2|supply|vdd sg13_lv_pmos
+ L=0.13u W=0.42u AS=0.2048p AD=0.09345p PS=1.63u PD=0.865u rfmode=0
M$46172 \$2921 \$2863 VDD|in|pad|pin1|pin2|supply|vdd
+ VDD|in|pad|pin1|pin2|supply|vdd sg13_lv_pmos L=0.13u W=0.42u AS=0.09345p
+ AD=0.204p PS=0.865u PD=1.835u rfmode=0
M$46173 VDD|in|pad|pin1|pin2|supply|vdd \$2913 \$2863
+ VDD|in|pad|pin1|pin2|supply|vdd sg13_lv_pmos L=0.13u W=0.42u AS=0.204p
+ AD=0.0798p PS=1.835u PD=0.8u rfmode=0
M$46174 \$2863 \$2886 VDD|in|pad|pin1|pin2|supply|vdd
+ VDD|in|pad|pin1|pin2|supply|vdd sg13_lv_pmos L=0.13u W=0.42u AS=0.0798p
+ AD=0.4659p PS=0.8u PD=3.65u rfmode=0
M$46175 \$2860 \$2861 \$2886 VDD|in|pad|pin1|pin2|supply|vdd sg13_lv_pmos
+ L=0.13u W=1u AS=0.34p AD=0.2048p PS=2.68u PD=1.63u rfmode=0
M$46176 \$2864 \$2886 VDD|in|pad|pin1|pin2|supply|vdd
+ VDD|in|pad|pin1|pin2|supply|vdd sg13_lv_pmos L=0.13u W=1.12u AS=0.3864p
+ AD=0.2128p PS=2.93u PD=1.5u rfmode=0
M$46177 VDD|in|pad|pin1|pin2|supply|vdd \$2864 \$2802
+ VDD|in|pad|pin1|pin2|supply|vdd sg13_lv_pmos L=0.13u W=1.12u AS=0.2128p
+ AD=0.3808p PS=1.5u PD=2.92u rfmode=0
M$46179 VDD|in|pad|pin1|pin2|supply|vdd \$2651 \$2865
+ VDD|in|pad|pin1|pin2|supply|vdd sg13_lv_pmos L=0.13u W=1.12u AS=0.3808p
+ AD=0.3808p PS=2.92u PD=2.92u rfmode=0
M$46180 VDD|in|pad|pin1|pin2|supply|vdd \$3322 \$2888
+ VDD|in|pad|pin1|pin2|supply|vdd sg13_lv_pmos L=0.13u W=0.42u AS=0.1428p
+ AD=0.0798p PS=1.52u PD=0.8u rfmode=0
M$46181 VDD|in|pad|pin1|pin2|supply|vdd \$2865 \$2888
+ VDD|in|pad|pin1|pin2|supply|vdd sg13_lv_pmos L=0.13u W=0.42u AS=0.3623875p
+ AD=0.0798p PS=2.605u PD=0.8u rfmode=0
M$46182 VDD|in|pad|pin1|pin2|supply|vdd \$2916 \$2866
+ VDD|in|pad|pin1|pin2|supply|vdd sg13_lv_pmos L=0.13u W=1u AS=0.3623875p
+ AD=0.34p PS=2.605u PD=2.68u rfmode=0
M$46183 \$2889 \$2867 VDD|in|pad|pin1|pin2|supply|vdd
+ VDD|in|pad|pin1|pin2|supply|vdd sg13_lv_pmos L=0.13u W=1.12u AS=0.3864p
+ AD=0.41165p PS=2.93u PD=2.12u rfmode=0
M$46184 VDD|in|pad|pin1|pin2|supply|vdd \$2915 \$2867
+ VDD|in|pad|pin1|pin2|supply|vdd sg13_lv_pmos L=0.13u W=1.12u AS=0.41165p
+ AD=0.4088p PS=2.12u PD=2.97u rfmode=0
M$46185 \$2890 \$2889 \$2922 VDD|in|pad|pin1|pin2|supply|vdd sg13_lv_pmos
+ L=0.13u W=0.42u AS=0.2048p AD=0.09345p PS=1.63u PD=0.865u rfmode=0
M$46186 \$2922 \$2869 VDD|in|pad|pin1|pin2|supply|vdd
+ VDD|in|pad|pin1|pin2|supply|vdd sg13_lv_pmos L=0.13u W=0.42u AS=0.09345p
+ AD=0.204p PS=0.865u PD=1.835u rfmode=0
M$46187 VDD|in|pad|pin1|pin2|supply|vdd \$2865 \$2869
+ VDD|in|pad|pin1|pin2|supply|vdd sg13_lv_pmos L=0.13u W=0.42u AS=0.204p
+ AD=0.0798p PS=1.835u PD=0.8u rfmode=0
M$46188 \$2869 \$2890 VDD|in|pad|pin1|pin2|supply|vdd
+ VDD|in|pad|pin1|pin2|supply|vdd sg13_lv_pmos L=0.13u W=0.42u AS=0.0798p
+ AD=0.4659p PS=0.8u PD=3.65u rfmode=0
M$46189 \$2866 \$2867 \$2890 VDD|in|pad|pin1|pin2|supply|vdd sg13_lv_pmos
+ L=0.13u W=1u AS=0.34p AD=0.2048p PS=2.68u PD=1.63u rfmode=0
M$46190 \$2870 \$2890 VDD|in|pad|pin1|pin2|supply|vdd
+ VDD|in|pad|pin1|pin2|supply|vdd sg13_lv_pmos L=0.13u W=1.12u AS=0.3864p
+ AD=0.2128p PS=2.93u PD=1.5u rfmode=0
M$46191 VDD|in|pad|pin1|pin2|supply|vdd \$2870 \$2871
+ VDD|in|pad|pin1|pin2|supply|vdd sg13_lv_pmos L=0.13u W=1.12u AS=0.2128p
+ AD=0.3808p PS=1.5u PD=2.92u rfmode=0
M$46197 VDD X10|dout[11] \$2917 VDD sg13_lv_pmos L=0.13u W=1u AS=0.2086p
+ AD=0.34p PS=1.5u PD=2.68u rfmode=0
M$46198 VDD \$2917 \$2935 VDD sg13_lv_pmos L=0.13u W=2.24u AS=0.4214p
+ AD=0.9464p PS=3u PD=5.05u rfmode=0
M$46221 VDD|in|pad|pin1|pin2|supply|vdd \$2248 \$2907
+ VDD|in|pad|pin1|pin2|supply|vdd sg13_lv_pmos L=0.13u W=1.12u AS=0.3808p
+ AD=0.3808p PS=2.92u PD=2.92u rfmode=0
M$46222 \$2906 \$2907 VDD|in|pad|pin1|pin2|supply|vdd
+ VDD|in|pad|pin1|pin2|supply|vdd sg13_lv_pmos L=0.13u W=0.42u AS=0.147p
+ AD=0.1563p PS=1.54u PD=1.22u rfmode=0
M$46223 VDD|in|pad|pin1|pin2|supply|vdd \$2837 \$2933
+ VDD|in|pad|pin1|pin2|supply|vdd sg13_lv_pmos L=0.13u W=0.42u AS=0.1563p
+ AD=0.063p PS=1.22u PD=0.72u rfmode=0
M$46224 \$2933 \$2838 \$2906 VDD|in|pad|pin1|pin2|supply|vdd sg13_lv_pmos
+ L=0.13u W=0.42u AS=0.063p AD=0.0798p PS=0.72u PD=0.8u rfmode=0
M$46225 \$2906 \$2874 \$2873 VDD|in|pad|pin1|pin2|supply|vdd sg13_lv_pmos
+ L=0.13u W=0.42u AS=0.0798p AD=0.1428p PS=0.8u PD=1.52u rfmode=0
M$46226 \$2905 \$3211 VDD|in|pad|pin1|pin2|supply|vdd
+ VDD|in|pad|pin1|pin2|supply|vdd sg13_lv_pmos L=0.13u W=1.12u AS=0.6048p
+ AD=0.2198p PS=3.32u PD=1.52u rfmode=0
M$46227 VDD|in|pad|pin1|pin2|supply|vdd \$2958 \$3200
+ VDD|in|pad|pin1|pin2|supply|vdd sg13_lv_pmos L=0.13u W=1u AS=0.2198p
+ AD=0.2975p PS=1.52u PD=1.595u rfmode=0
M$46228 \$3200 \$2390 \$3211 VDD|in|pad|pin1|pin2|supply|vdd sg13_lv_pmos
+ L=0.13u W=1u AS=0.2975p AD=0.2225p PS=1.595u PD=1.445u rfmode=0
M$46229 \$3211 \$2842 \$3199 VDD|in|pad|pin1|pin2|supply|vdd sg13_lv_pmos
+ L=0.13u W=1u AS=0.2225p AD=0.3325p PS=1.445u PD=1.665u rfmode=0
M$46230 \$3199 \$2690 VDD|in|pad|pin1|pin2|supply|vdd
+ VDD|in|pad|pin1|pin2|supply|vdd sg13_lv_pmos L=0.13u W=1u AS=0.3325p
+ AD=0.253p PS=1.665u PD=1.53u rfmode=0
M$46231 VDD|in|pad|pin1|pin2|supply|vdd \$2690 \$2958
+ VDD|in|pad|pin1|pin2|supply|vdd sg13_lv_pmos L=0.13u W=0.84u AS=0.253p
+ AD=0.2856p PS=1.53u PD=2.36u rfmode=0
M$46232 VDD|in|pad|pin1|pin2|supply|vdd \$3319 \$3034
+ VDD|in|pad|pin1|pin2|supply|vdd sg13_lv_pmos L=0.13u W=0.42u AS=0.1428p
+ AD=0.0798p PS=1.52u PD=0.8u rfmode=0
M$46233 VDD|in|pad|pin1|pin2|supply|vdd \$2843 \$3034
+ VDD|in|pad|pin1|pin2|supply|vdd sg13_lv_pmos L=0.13u W=0.42u AS=0.3623875p
+ AD=0.0798p PS=2.605u PD=0.8u rfmode=0
M$46234 VDD|in|pad|pin1|pin2|supply|vdd \$3035 \$3186
+ VDD|in|pad|pin1|pin2|supply|vdd sg13_lv_pmos L=0.13u W=1u AS=0.3623875p
+ AD=0.34p PS=2.605u PD=2.68u rfmode=0
M$46235 VDD|in|pad|pin1|pin2|supply|vdd \$2843 \$3035
+ VDD|in|pad|pin1|pin2|supply|vdd sg13_lv_pmos L=0.13u W=0.42u AS=0.1563p
+ AD=0.147p PS=1.22u PD=1.54u rfmode=0
M$46236 VDD|in|pad|pin1|pin2|supply|vdd \$3186 \$3180
+ VDD|in|pad|pin1|pin2|supply|vdd sg13_lv_pmos L=0.13u W=0.42u AS=0.1563p
+ AD=0.063p PS=1.22u PD=0.72u rfmode=0
M$46237 \$3180 \$3141 \$3035 VDD|in|pad|pin1|pin2|supply|vdd sg13_lv_pmos
+ L=0.13u W=0.42u AS=0.063p AD=0.0798p PS=0.72u PD=0.8u rfmode=0
M$46238 \$3035 \$3140 \$3034 VDD|in|pad|pin1|pin2|supply|vdd sg13_lv_pmos
+ L=0.13u W=0.42u AS=0.0798p AD=0.1428p PS=0.8u PD=1.52u rfmode=0
M$46239 VDD|in|pad|pin1|pin2|supply|vdd \$3141 \$3140
+ VDD|in|pad|pin1|pin2|supply|vdd sg13_lv_pmos L=0.13u W=1.12u AS=0.41165p
+ AD=0.3864p PS=2.12u PD=2.93u rfmode=0
M$46240 VDD|in|pad|pin1|pin2|supply|vdd \$2247 \$3141
+ VDD|in|pad|pin1|pin2|supply|vdd sg13_lv_pmos L=0.13u W=1.12u AS=0.41165p
+ AD=0.4088p PS=2.12u PD=2.97u rfmode=0
M$46241 \$3186 \$3141 \$3142 VDD|in|pad|pin1|pin2|supply|vdd sg13_lv_pmos
+ L=0.13u W=1u AS=0.34p AD=0.2048p PS=2.68u PD=1.63u rfmode=0
M$46242 \$3142 \$3140 \$3201 VDD|in|pad|pin1|pin2|supply|vdd sg13_lv_pmos
+ L=0.13u W=0.42u AS=0.2048p AD=0.09345p PS=1.63u PD=0.865u rfmode=0
M$46243 VDD|in|pad|pin1|pin2|supply|vdd \$3143 \$3201
+ VDD|in|pad|pin1|pin2|supply|vdd sg13_lv_pmos L=0.13u W=0.42u AS=0.204p
+ AD=0.09345p PS=1.835u PD=0.865u rfmode=0
M$46244 VDD|in|pad|pin1|pin2|supply|vdd \$2843 \$3143
+ VDD|in|pad|pin1|pin2|supply|vdd sg13_lv_pmos L=0.13u W=0.42u AS=0.204p
+ AD=0.0798p PS=1.835u PD=0.8u rfmode=0
M$46245 VDD|in|pad|pin1|pin2|supply|vdd \$3142 \$3143
+ VDD|in|pad|pin1|pin2|supply|vdd sg13_lv_pmos L=0.13u W=0.42u AS=0.4659p
+ AD=0.0798p PS=3.65u PD=0.8u rfmode=0
M$46246 \$3036 \$3142 VDD|in|pad|pin1|pin2|supply|vdd
+ VDD|in|pad|pin1|pin2|supply|vdd sg13_lv_pmos L=0.13u W=1.12u AS=0.3864p
+ AD=0.2128p PS=2.93u PD=1.5u rfmode=0
M$46247 VDD|in|pad|pin1|pin2|supply|vdd \$3036 \$3392
+ VDD|in|pad|pin1|pin2|supply|vdd sg13_lv_pmos L=0.13u W=1.12u AS=0.2128p
+ AD=0.3808p PS=1.5u PD=2.92u rfmode=0
M$46248 VDD|in|pad|pin1|pin2|supply|vdd \$2844 \$3037
+ VDD|in|pad|pin1|pin2|supply|vdd sg13_lv_pmos L=0.13u W=0.42u AS=0.1428p
+ AD=0.0798p PS=1.52u PD=0.8u rfmode=0
M$46249 VDD|in|pad|pin1|pin2|supply|vdd \$2959 \$3037
+ VDD|in|pad|pin1|pin2|supply|vdd sg13_lv_pmos L=0.13u W=0.42u AS=0.3623875p
+ AD=0.0798p PS=2.605u PD=0.8u rfmode=0
M$46250 VDD|in|pad|pin1|pin2|supply|vdd \$3038 \$3187
+ VDD|in|pad|pin1|pin2|supply|vdd sg13_lv_pmos L=0.13u W=1u AS=0.3623875p
+ AD=0.34p PS=2.605u PD=2.68u rfmode=0
M$46251 VDD|in|pad|pin1|pin2|supply|vdd \$2959 \$3038
+ VDD|in|pad|pin1|pin2|supply|vdd sg13_lv_pmos L=0.13u W=0.42u AS=0.1563p
+ AD=0.147p PS=1.22u PD=1.54u rfmode=0
M$46252 VDD|in|pad|pin1|pin2|supply|vdd \$3187 \$3181
+ VDD|in|pad|pin1|pin2|supply|vdd sg13_lv_pmos L=0.13u W=0.42u AS=0.1563p
+ AD=0.063p PS=1.22u PD=0.72u rfmode=0
M$46253 \$3181 \$3145 \$3038 VDD|in|pad|pin1|pin2|supply|vdd sg13_lv_pmos
+ L=0.13u W=0.42u AS=0.063p AD=0.0798p PS=0.72u PD=0.8u rfmode=0
M$46254 \$3038 \$3144 \$3037 VDD|in|pad|pin1|pin2|supply|vdd sg13_lv_pmos
+ L=0.13u W=0.42u AS=0.0798p AD=0.1428p PS=0.8u PD=1.52u rfmode=0
M$46255 VDD|in|pad|pin1|pin2|supply|vdd \$3145 \$3144
+ VDD|in|pad|pin1|pin2|supply|vdd sg13_lv_pmos L=0.13u W=1.12u AS=0.41165p
+ AD=0.3864p PS=2.12u PD=2.93u rfmode=0
M$46256 VDD|in|pad|pin1|pin2|supply|vdd \$2530 \$3145
+ VDD|in|pad|pin1|pin2|supply|vdd sg13_lv_pmos L=0.13u W=1.12u AS=0.41165p
+ AD=0.4088p PS=2.12u PD=2.97u rfmode=0
M$46257 \$3187 \$3145 \$3146 VDD|in|pad|pin1|pin2|supply|vdd sg13_lv_pmos
+ L=0.13u W=1u AS=0.34p AD=0.2048p PS=2.68u PD=1.63u rfmode=0
M$46258 \$3146 \$3144 \$3202 VDD|in|pad|pin1|pin2|supply|vdd sg13_lv_pmos
+ L=0.13u W=0.42u AS=0.2048p AD=0.09345p PS=1.63u PD=0.865u rfmode=0
M$46259 VDD|in|pad|pin1|pin2|supply|vdd \$3147 \$3202
+ VDD|in|pad|pin1|pin2|supply|vdd sg13_lv_pmos L=0.13u W=0.42u AS=0.204p
+ AD=0.09345p PS=1.835u PD=0.865u rfmode=0
M$46260 VDD|in|pad|pin1|pin2|supply|vdd \$2959 \$3147
+ VDD|in|pad|pin1|pin2|supply|vdd sg13_lv_pmos L=0.13u W=0.42u AS=0.204p
+ AD=0.0798p PS=1.835u PD=0.8u rfmode=0
M$46261 VDD|in|pad|pin1|pin2|supply|vdd \$3146 \$3147
+ VDD|in|pad|pin1|pin2|supply|vdd sg13_lv_pmos L=0.13u W=0.42u AS=0.4659p
+ AD=0.0798p PS=3.65u PD=0.8u rfmode=0
M$46262 \$3039 \$3146 VDD|in|pad|pin1|pin2|supply|vdd
+ VDD|in|pad|pin1|pin2|supply|vdd sg13_lv_pmos L=0.13u W=1.12u AS=0.3864p
+ AD=0.2128p PS=2.93u PD=1.5u rfmode=0
M$46263 VDD|in|pad|pin1|pin2|supply|vdd \$3039 \$2908
+ VDD|in|pad|pin1|pin2|supply|vdd sg13_lv_pmos L=0.13u W=1.12u AS=0.2128p
+ AD=0.3808p PS=1.5u PD=2.92u rfmode=0
M$46264 VDD|in|pad|pin1|pin2|supply|vdd \$2877 \$3040
+ VDD|in|pad|pin1|pin2|supply|vdd sg13_lv_pmos L=0.13u W=0.42u AS=0.1428p
+ AD=0.0798p PS=1.52u PD=0.8u rfmode=0
M$46265 VDD|in|pad|pin1|pin2|supply|vdd \$2960 \$3040
+ VDD|in|pad|pin1|pin2|supply|vdd sg13_lv_pmos L=0.13u W=0.42u AS=0.3623875p
+ AD=0.0798p PS=2.605u PD=0.8u rfmode=0
M$46266 VDD|in|pad|pin1|pin2|supply|vdd \$3041 \$3188
+ VDD|in|pad|pin1|pin2|supply|vdd sg13_lv_pmos L=0.13u W=1u AS=0.3623875p
+ AD=0.34p PS=2.605u PD=2.68u rfmode=0
M$46267 VDD|in|pad|pin1|pin2|supply|vdd \$2960 \$3041
+ VDD|in|pad|pin1|pin2|supply|vdd sg13_lv_pmos L=0.13u W=0.42u AS=0.1563p
+ AD=0.147p PS=1.22u PD=1.54u rfmode=0
M$46268 VDD|in|pad|pin1|pin2|supply|vdd \$3188 \$3182
+ VDD|in|pad|pin1|pin2|supply|vdd sg13_lv_pmos L=0.13u W=0.42u AS=0.1563p
+ AD=0.063p PS=1.22u PD=0.72u rfmode=0
M$46269 \$3182 \$3149 \$3041 VDD|in|pad|pin1|pin2|supply|vdd sg13_lv_pmos
+ L=0.13u W=0.42u AS=0.063p AD=0.0798p PS=0.72u PD=0.8u rfmode=0
M$46270 \$3041 \$3148 \$3040 VDD|in|pad|pin1|pin2|supply|vdd sg13_lv_pmos
+ L=0.13u W=0.42u AS=0.0798p AD=0.1428p PS=0.8u PD=1.52u rfmode=0
M$46271 VDD|in|pad|pin1|pin2|supply|vdd \$3149 \$3148
+ VDD|in|pad|pin1|pin2|supply|vdd sg13_lv_pmos L=0.13u W=1.12u AS=0.41165p
+ AD=0.3864p PS=2.12u PD=2.93u rfmode=0
M$46272 VDD|in|pad|pin1|pin2|supply|vdd \$2530 \$3149
+ VDD|in|pad|pin1|pin2|supply|vdd sg13_lv_pmos L=0.13u W=1.12u AS=0.41165p
+ AD=0.4088p PS=2.12u PD=2.97u rfmode=0
M$46273 \$3188 \$3149 \$3150 VDD|in|pad|pin1|pin2|supply|vdd sg13_lv_pmos
+ L=0.13u W=1u AS=0.34p AD=0.2048p PS=2.68u PD=1.63u rfmode=0
M$46274 \$3150 \$3148 \$3203 VDD|in|pad|pin1|pin2|supply|vdd sg13_lv_pmos
+ L=0.13u W=0.42u AS=0.2048p AD=0.09345p PS=1.63u PD=0.865u rfmode=0
M$46275 VDD|in|pad|pin1|pin2|supply|vdd \$3151 \$3203
+ VDD|in|pad|pin1|pin2|supply|vdd sg13_lv_pmos L=0.13u W=0.42u AS=0.204p
+ AD=0.09345p PS=1.835u PD=0.865u rfmode=0
M$46276 VDD|in|pad|pin1|pin2|supply|vdd \$2960 \$3151
+ VDD|in|pad|pin1|pin2|supply|vdd sg13_lv_pmos L=0.13u W=0.42u AS=0.204p
+ AD=0.0798p PS=1.835u PD=0.8u rfmode=0
M$46277 VDD|in|pad|pin1|pin2|supply|vdd \$3150 \$3151
+ VDD|in|pad|pin1|pin2|supply|vdd sg13_lv_pmos L=0.13u W=0.42u AS=0.4659p
+ AD=0.0798p PS=3.65u PD=0.8u rfmode=0
M$46278 \$3042 \$3150 VDD|in|pad|pin1|pin2|supply|vdd
+ VDD|in|pad|pin1|pin2|supply|vdd sg13_lv_pmos L=0.13u W=1.12u AS=0.3864p
+ AD=0.2128p PS=2.93u PD=1.5u rfmode=0
M$46279 VDD|in|pad|pin1|pin2|supply|vdd \$3042 \$2909
+ VDD|in|pad|pin1|pin2|supply|vdd sg13_lv_pmos L=0.13u W=1.12u AS=0.2128p
+ AD=0.3808p PS=1.5u PD=2.92u rfmode=0
M$46280 VDD|in|pad|pin1|pin2|supply|vdd \$2851 \$3043
+ VDD|in|pad|pin1|pin2|supply|vdd sg13_lv_pmos L=0.13u W=0.42u AS=0.1428p
+ AD=0.0798p PS=1.52u PD=0.8u rfmode=0
M$46281 VDD|in|pad|pin1|pin2|supply|vdd \$2852 \$3043
+ VDD|in|pad|pin1|pin2|supply|vdd sg13_lv_pmos L=0.13u W=0.42u AS=0.3623875p
+ AD=0.0798p PS=2.605u PD=0.8u rfmode=0
M$46282 VDD|in|pad|pin1|pin2|supply|vdd \$3044 \$3189
+ VDD|in|pad|pin1|pin2|supply|vdd sg13_lv_pmos L=0.13u W=1u AS=0.3623875p
+ AD=0.34p PS=2.605u PD=2.68u rfmode=0
M$46283 VDD|in|pad|pin1|pin2|supply|vdd \$2852 \$3044
+ VDD|in|pad|pin1|pin2|supply|vdd sg13_lv_pmos L=0.13u W=0.42u AS=0.1563p
+ AD=0.147p PS=1.22u PD=1.54u rfmode=0
M$46284 VDD|in|pad|pin1|pin2|supply|vdd \$3189 \$3183
+ VDD|in|pad|pin1|pin2|supply|vdd sg13_lv_pmos L=0.13u W=0.42u AS=0.1563p
+ AD=0.063p PS=1.22u PD=0.72u rfmode=0
M$46285 \$3183 \$3153 \$3044 VDD|in|pad|pin1|pin2|supply|vdd sg13_lv_pmos
+ L=0.13u W=0.42u AS=0.063p AD=0.0798p PS=0.72u PD=0.8u rfmode=0
M$46286 \$3044 \$3152 \$3043 VDD|in|pad|pin1|pin2|supply|vdd sg13_lv_pmos
+ L=0.13u W=0.42u AS=0.0798p AD=0.1428p PS=0.8u PD=1.52u rfmode=0
M$46287 VDD|in|pad|pin1|pin2|supply|vdd \$3153 \$3152
+ VDD|in|pad|pin1|pin2|supply|vdd sg13_lv_pmos L=0.13u W=1.12u AS=0.41165p
+ AD=0.3864p PS=2.12u PD=2.93u rfmode=0
M$46288 VDD|in|pad|pin1|pin2|supply|vdd \$2256 \$3153
+ VDD|in|pad|pin1|pin2|supply|vdd sg13_lv_pmos L=0.13u W=1.12u AS=0.41165p
+ AD=0.4088p PS=2.12u PD=2.97u rfmode=0
M$46289 \$3189 \$3153 \$3154 VDD|in|pad|pin1|pin2|supply|vdd sg13_lv_pmos
+ L=0.13u W=1u AS=0.34p AD=0.2048p PS=2.68u PD=1.63u rfmode=0
M$46290 \$3154 \$3152 \$3204 VDD|in|pad|pin1|pin2|supply|vdd sg13_lv_pmos
+ L=0.13u W=0.42u AS=0.2048p AD=0.09345p PS=1.63u PD=0.865u rfmode=0
M$46291 VDD|in|pad|pin1|pin2|supply|vdd \$3155 \$3204
+ VDD|in|pad|pin1|pin2|supply|vdd sg13_lv_pmos L=0.13u W=0.42u AS=0.204p
+ AD=0.09345p PS=1.835u PD=0.865u rfmode=0
M$46292 VDD|in|pad|pin1|pin2|supply|vdd \$2852 \$3155
+ VDD|in|pad|pin1|pin2|supply|vdd sg13_lv_pmos L=0.13u W=0.42u AS=0.204p
+ AD=0.0798p PS=1.835u PD=0.8u rfmode=0
M$46293 VDD|in|pad|pin1|pin2|supply|vdd \$3154 \$3155
+ VDD|in|pad|pin1|pin2|supply|vdd sg13_lv_pmos L=0.13u W=0.42u AS=0.4659p
+ AD=0.0798p PS=3.65u PD=0.8u rfmode=0
M$46294 \$3045 \$3154 VDD|in|pad|pin1|pin2|supply|vdd
+ VDD|in|pad|pin1|pin2|supply|vdd sg13_lv_pmos L=0.13u W=1.12u AS=0.3864p
+ AD=0.2128p PS=2.93u PD=1.5u rfmode=0
M$46295 VDD|in|pad|pin1|pin2|supply|vdd \$3045 \$3046
+ VDD|in|pad|pin1|pin2|supply|vdd sg13_lv_pmos L=0.13u W=1.12u AS=0.2128p
+ AD=0.3808p PS=1.5u PD=2.92u rfmode=0
M$46296 \$2912 \$2853 VDD|in|pad|pin1|pin2|supply|vdd
+ VDD|in|pad|pin1|pin2|supply|vdd sg13_lv_pmos L=0.13u W=0.42u AS=0.147p
+ AD=0.1563p PS=1.54u PD=1.22u rfmode=0
M$46297 VDD|in|pad|pin1|pin2|supply|vdd \$2854 \$2928
+ VDD|in|pad|pin1|pin2|supply|vdd sg13_lv_pmos L=0.13u W=0.42u AS=0.1563p
+ AD=0.063p PS=1.22u PD=0.72u rfmode=0
M$46298 \$2928 \$2855 \$2912 VDD|in|pad|pin1|pin2|supply|vdd sg13_lv_pmos
+ L=0.13u W=0.42u AS=0.063p AD=0.0798p PS=0.72u PD=0.8u rfmode=0
M$46299 \$2912 \$2881 \$2880 VDD|in|pad|pin1|pin2|supply|vdd sg13_lv_pmos
+ L=0.13u W=0.42u AS=0.0798p AD=0.1428p PS=0.8u PD=1.52u rfmode=0
M$46302 VDD|in|pad|pin1|pin2|supply|vdd \$2766 \$3047
+ VDD|in|pad|pin1|pin2|supply|vdd sg13_lv_pmos L=0.13u W=0.84u AS=0.253p
+ AD=0.2856p PS=1.53u PD=2.36u rfmode=0
M$46303 VDD|in|pad|pin1|pin2|supply|vdd \$2766 \$3206
+ VDD|in|pad|pin1|pin2|supply|vdd sg13_lv_pmos L=0.13u W=1u AS=0.253p
+ AD=0.3325p PS=1.53u PD=1.665u rfmode=0
M$46304 \$3206 \$3216 \$3048 VDD|in|pad|pin1|pin2|supply|vdd sg13_lv_pmos
+ L=0.13u W=1u AS=0.3325p AD=0.2225p PS=1.665u PD=1.445u rfmode=0
M$46305 \$3048 \$2384 \$3205 VDD|in|pad|pin1|pin2|supply|vdd sg13_lv_pmos
+ L=0.13u W=1u AS=0.2225p AD=0.2975p PS=1.445u PD=1.595u rfmode=0
M$46306 VDD|in|pad|pin1|pin2|supply|vdd \$3047 \$3205
+ VDD|in|pad|pin1|pin2|supply|vdd sg13_lv_pmos L=0.13u W=1u AS=0.2198p
+ AD=0.2975p PS=1.52u PD=1.595u rfmode=0
M$46307 VDD|in|pad|pin1|pin2|supply|vdd \$3048 \$3049
+ VDD|in|pad|pin1|pin2|supply|vdd sg13_lv_pmos L=0.13u W=1.12u AS=0.2198p
+ AD=0.6048p PS=1.52u PD=3.32u rfmode=0
M$46308 VDD|in|pad|pin1|pin2|supply|vdd \$3049 \$3050
+ VDD|in|pad|pin1|pin2|supply|vdd sg13_lv_pmos L=0.13u W=0.42u AS=0.1428p
+ AD=0.0798p PS=1.52u PD=0.8u rfmode=0
M$46309 VDD|in|pad|pin1|pin2|supply|vdd \$2859 \$3050
+ VDD|in|pad|pin1|pin2|supply|vdd sg13_lv_pmos L=0.13u W=0.42u AS=0.3623875p
+ AD=0.0798p PS=2.605u PD=0.8u rfmode=0
M$46310 VDD|in|pad|pin1|pin2|supply|vdd \$3051 \$3190
+ VDD|in|pad|pin1|pin2|supply|vdd sg13_lv_pmos L=0.13u W=1u AS=0.3623875p
+ AD=0.34p PS=2.605u PD=2.68u rfmode=0
M$46311 VDD|in|pad|pin1|pin2|supply|vdd \$2859 \$3051
+ VDD|in|pad|pin1|pin2|supply|vdd sg13_lv_pmos L=0.13u W=0.42u AS=0.1563p
+ AD=0.147p PS=1.22u PD=1.54u rfmode=0
M$46312 VDD|in|pad|pin1|pin2|supply|vdd \$3190 \$3184
+ VDD|in|pad|pin1|pin2|supply|vdd sg13_lv_pmos L=0.13u W=0.42u AS=0.1563p
+ AD=0.063p PS=1.22u PD=0.72u rfmode=0
M$46313 \$3184 \$3157 \$3051 VDD|in|pad|pin1|pin2|supply|vdd sg13_lv_pmos
+ L=0.13u W=0.42u AS=0.063p AD=0.0798p PS=0.72u PD=0.8u rfmode=0
M$46314 \$3051 \$3156 \$3050 VDD|in|pad|pin1|pin2|supply|vdd sg13_lv_pmos
+ L=0.13u W=0.42u AS=0.0798p AD=0.1428p PS=0.8u PD=1.52u rfmode=0
M$46315 VDD|in|pad|pin1|pin2|supply|vdd \$3157 \$3156
+ VDD|in|pad|pin1|pin2|supply|vdd sg13_lv_pmos L=0.13u W=1.12u AS=0.41165p
+ AD=0.3864p PS=2.12u PD=2.93u rfmode=0
M$46316 VDD|in|pad|pin1|pin2|supply|vdd \$2915 \$3157
+ VDD|in|pad|pin1|pin2|supply|vdd sg13_lv_pmos L=0.13u W=1.12u AS=0.41165p
+ AD=0.4088p PS=2.12u PD=2.97u rfmode=0
M$46317 \$2914 \$2913 VDD|in|pad|pin1|pin2|supply|vdd
+ VDD|in|pad|pin1|pin2|supply|vdd sg13_lv_pmos L=0.13u W=0.42u AS=0.147p
+ AD=0.1563p PS=1.54u PD=1.22u rfmode=0
M$46318 VDD|in|pad|pin1|pin2|supply|vdd \$2860 \$2925
+ VDD|in|pad|pin1|pin2|supply|vdd sg13_lv_pmos L=0.13u W=0.42u AS=0.1563p
+ AD=0.063p PS=1.22u PD=0.72u rfmode=0
M$46319 \$2925 \$2861 \$2914 VDD|in|pad|pin1|pin2|supply|vdd sg13_lv_pmos
+ L=0.13u W=0.42u AS=0.063p AD=0.0798p PS=0.72u PD=0.8u rfmode=0
M$46320 \$2914 \$2885 \$2884 VDD|in|pad|pin1|pin2|supply|vdd sg13_lv_pmos
+ L=0.13u W=0.42u AS=0.0798p AD=0.1428p PS=0.8u PD=1.52u rfmode=0
M$46321 \$3190 \$3157 \$3158 VDD|in|pad|pin1|pin2|supply|vdd sg13_lv_pmos
+ L=0.13u W=1u AS=0.34p AD=0.2048p PS=2.68u PD=1.63u rfmode=0
M$46322 \$3158 \$3156 \$3207 VDD|in|pad|pin1|pin2|supply|vdd sg13_lv_pmos
+ L=0.13u W=0.42u AS=0.2048p AD=0.09345p PS=1.63u PD=0.865u rfmode=0
M$46323 VDD|in|pad|pin1|pin2|supply|vdd \$3159 \$3207
+ VDD|in|pad|pin1|pin2|supply|vdd sg13_lv_pmos L=0.13u W=0.42u AS=0.204p
+ AD=0.09345p PS=1.835u PD=0.865u rfmode=0
M$46324 VDD|in|pad|pin1|pin2|supply|vdd \$2859 \$3159
+ VDD|in|pad|pin1|pin2|supply|vdd sg13_lv_pmos L=0.13u W=0.42u AS=0.204p
+ AD=0.0798p PS=1.835u PD=0.8u rfmode=0
M$46325 VDD|in|pad|pin1|pin2|supply|vdd \$3158 \$3159
+ VDD|in|pad|pin1|pin2|supply|vdd sg13_lv_pmos L=0.13u W=0.42u AS=0.4659p
+ AD=0.0798p PS=3.65u PD=0.8u rfmode=0
M$46326 \$3052 \$3158 VDD|in|pad|pin1|pin2|supply|vdd
+ VDD|in|pad|pin1|pin2|supply|vdd sg13_lv_pmos L=0.13u W=1.12u AS=0.3864p
+ AD=0.2128p PS=2.93u PD=1.5u rfmode=0
M$46327 VDD|in|pad|pin1|pin2|supply|vdd \$3052 \$3216
+ VDD|in|pad|pin1|pin2|supply|vdd sg13_lv_pmos L=0.13u W=1.12u AS=0.2128p
+ AD=0.3808p PS=1.5u PD=2.92u rfmode=0
M$46330 VDD|in|pad|pin1|pin2|supply|vdd \$2849 \$3053
+ VDD|in|pad|pin1|pin2|supply|vdd sg13_lv_pmos L=0.13u W=0.84u AS=0.253p
+ AD=0.2856p PS=1.53u PD=2.36u rfmode=0
M$46331 VDD|in|pad|pin1|pin2|supply|vdd \$2849 \$3209
+ VDD|in|pad|pin1|pin2|supply|vdd sg13_lv_pmos L=0.13u W=1u AS=0.253p
+ AD=0.3325p PS=1.53u PD=1.665u rfmode=0
M$46332 \$3209 \$3059 \$3054 VDD|in|pad|pin1|pin2|supply|vdd sg13_lv_pmos
+ L=0.13u W=1u AS=0.3325p AD=0.2225p PS=1.665u PD=1.445u rfmode=0
M$46333 \$3054 \$2384 \$3208 VDD|in|pad|pin1|pin2|supply|vdd sg13_lv_pmos
+ L=0.13u W=1u AS=0.2225p AD=0.2975p PS=1.445u PD=1.595u rfmode=0
M$46334 VDD|in|pad|pin1|pin2|supply|vdd \$3053 \$3208
+ VDD|in|pad|pin1|pin2|supply|vdd sg13_lv_pmos L=0.13u W=1u AS=0.2198p
+ AD=0.2975p PS=1.52u PD=1.595u rfmode=0
M$46335 VDD|in|pad|pin1|pin2|supply|vdd \$3054 \$3055
+ VDD|in|pad|pin1|pin2|supply|vdd sg13_lv_pmos L=0.13u W=1.12u AS=0.2198p
+ AD=0.6048p PS=1.52u PD=3.32u rfmode=0
M$46336 VDD|in|pad|pin1|pin2|supply|vdd \$3055 \$3056
+ VDD|in|pad|pin1|pin2|supply|vdd sg13_lv_pmos L=0.13u W=0.42u AS=0.1428p
+ AD=0.0798p PS=1.52u PD=0.8u rfmode=0
M$46337 VDD|in|pad|pin1|pin2|supply|vdd \$2961 \$3056
+ VDD|in|pad|pin1|pin2|supply|vdd sg13_lv_pmos L=0.13u W=0.42u AS=0.3623875p
+ AD=0.0798p PS=2.605u PD=0.8u rfmode=0
M$46338 VDD|in|pad|pin1|pin2|supply|vdd \$3057 \$3191
+ VDD|in|pad|pin1|pin2|supply|vdd sg13_lv_pmos L=0.13u W=1u AS=0.3623875p
+ AD=0.34p PS=2.605u PD=2.68u rfmode=0
M$46339 VDD|in|pad|pin1|pin2|supply|vdd \$2961 \$3057
+ VDD|in|pad|pin1|pin2|supply|vdd sg13_lv_pmos L=0.13u W=0.42u AS=0.1563p
+ AD=0.147p PS=1.22u PD=1.54u rfmode=0
M$46340 VDD|in|pad|pin1|pin2|supply|vdd \$3191 \$3185
+ VDD|in|pad|pin1|pin2|supply|vdd sg13_lv_pmos L=0.13u W=0.42u AS=0.1563p
+ AD=0.063p PS=1.22u PD=0.72u rfmode=0
M$46341 \$3185 \$3161 \$3057 VDD|in|pad|pin1|pin2|supply|vdd sg13_lv_pmos
+ L=0.13u W=0.42u AS=0.063p AD=0.0798p PS=0.72u PD=0.8u rfmode=0
M$46342 \$3057 \$3160 \$3056 VDD|in|pad|pin1|pin2|supply|vdd sg13_lv_pmos
+ L=0.13u W=0.42u AS=0.0798p AD=0.1428p PS=0.8u PD=1.52u rfmode=0
M$46343 \$2916 \$2865 VDD|in|pad|pin1|pin2|supply|vdd
+ VDD|in|pad|pin1|pin2|supply|vdd sg13_lv_pmos L=0.13u W=0.42u AS=0.147p
+ AD=0.1563p PS=1.54u PD=1.22u rfmode=0
M$46344 VDD|in|pad|pin1|pin2|supply|vdd \$2866 \$2924
+ VDD|in|pad|pin1|pin2|supply|vdd sg13_lv_pmos L=0.13u W=0.42u AS=0.1563p
+ AD=0.063p PS=1.22u PD=0.72u rfmode=0
M$46345 \$2924 \$2867 \$2916 VDD|in|pad|pin1|pin2|supply|vdd sg13_lv_pmos
+ L=0.13u W=0.42u AS=0.063p AD=0.0798p PS=0.72u PD=0.8u rfmode=0
M$46346 \$2916 \$2889 \$2888 VDD|in|pad|pin1|pin2|supply|vdd sg13_lv_pmos
+ L=0.13u W=0.42u AS=0.0798p AD=0.1428p PS=0.8u PD=1.52u rfmode=0
M$46347 VDD|in|pad|pin1|pin2|supply|vdd \$3161 \$3160
+ VDD|in|pad|pin1|pin2|supply|vdd sg13_lv_pmos L=0.13u W=1.12u AS=0.41165p
+ AD=0.3864p PS=2.12u PD=2.93u rfmode=0
M$46348 VDD|in|pad|pin1|pin2|supply|vdd \$2915 \$3161
+ VDD|in|pad|pin1|pin2|supply|vdd sg13_lv_pmos L=0.13u W=1.12u AS=0.41165p
+ AD=0.4088p PS=2.12u PD=2.97u rfmode=0
M$46349 \$3191 \$3161 \$3162 VDD|in|pad|pin1|pin2|supply|vdd sg13_lv_pmos
+ L=0.13u W=1u AS=0.34p AD=0.2048p PS=2.68u PD=1.63u rfmode=0
M$46350 \$3162 \$3160 \$3210 VDD|in|pad|pin1|pin2|supply|vdd sg13_lv_pmos
+ L=0.13u W=0.42u AS=0.2048p AD=0.09345p PS=1.63u PD=0.865u rfmode=0
M$46351 VDD|in|pad|pin1|pin2|supply|vdd \$3163 \$3210
+ VDD|in|pad|pin1|pin2|supply|vdd sg13_lv_pmos L=0.13u W=0.42u AS=0.204p
+ AD=0.09345p PS=1.835u PD=0.865u rfmode=0
M$46352 VDD|in|pad|pin1|pin2|supply|vdd \$2961 \$3163
+ VDD|in|pad|pin1|pin2|supply|vdd sg13_lv_pmos L=0.13u W=0.42u AS=0.204p
+ AD=0.0798p PS=1.835u PD=0.8u rfmode=0
M$46353 VDD|in|pad|pin1|pin2|supply|vdd \$3162 \$3163
+ VDD|in|pad|pin1|pin2|supply|vdd sg13_lv_pmos L=0.13u W=0.42u AS=0.4659p
+ AD=0.0798p PS=3.65u PD=0.8u rfmode=0
M$46354 \$3058 \$3162 VDD|in|pad|pin1|pin2|supply|vdd
+ VDD|in|pad|pin1|pin2|supply|vdd sg13_lv_pmos L=0.13u W=1.12u AS=0.3864p
+ AD=0.2128p PS=2.93u PD=1.5u rfmode=0
M$46355 VDD|in|pad|pin1|pin2|supply|vdd \$3058 \$3059
+ VDD|in|pad|pin1|pin2|supply|vdd sg13_lv_pmos L=0.13u W=1.12u AS=0.2128p
+ AD=0.3808p PS=1.5u PD=2.92u rfmode=0
M$46361 VDD \$2963 \$3060 VDD sg13_lv_pmos L=0.13u W=2.24u AS=0.616p AD=0.4312p
+ PS=4.46u PD=3.01u rfmode=0
M$46363 VDD VDD \$3060 VDD sg13_lv_pmos L=0.13u W=2.24u AS=0.4312p AD=0.6048p
+ PS=3.01u PD=4.44u rfmode=0
M$46365 \$3061 \$2943 VDD VDD sg13_lv_pmos L=0.13u W=1.12u AS=0.3864p
+ AD=0.431025p PS=2.93u PD=2.145u rfmode=0
M$46366 VDD CLK|clk|core|fclk_in|p2c|ui_p2c[6] \$2943 VDD sg13_lv_pmos L=0.13u
+ W=1.12u AS=0.431025p AD=0.3808p PS=2.145u PD=2.92u rfmode=0
M$46367 VDD \$2969 \$2970 VDD sg13_lv_pmos L=0.13u W=2.24u AS=0.5964p
+ AD=0.5964p PS=4.425u PD=4.425u rfmode=0
M$46369 VDD \$2972 \$3064 VDD sg13_lv_pmos L=0.13u W=2.24u AS=0.616p AD=0.4312p
+ PS=4.46u PD=3.01u rfmode=0
M$46371 VDD VDD \$3064 VDD sg13_lv_pmos L=0.13u W=2.24u AS=0.4312p AD=0.6048p
+ PS=3.01u PD=4.44u rfmode=0
M$46373 \$3065 \$2945 VDD VDD sg13_lv_pmos L=0.13u W=1.12u AS=0.3864p
+ AD=0.431025p PS=2.93u PD=2.145u rfmode=0
M$46374 VDD CLK|clk|core|fclk_in|p2c|ui_p2c[6] \$2945 VDD sg13_lv_pmos L=0.13u
+ W=1.12u AS=0.431025p AD=0.3808p PS=2.145u PD=2.92u rfmode=0
M$46375 VDD \$2978 \$2979 VDD sg13_lv_pmos L=0.13u W=2.24u AS=0.5964p
+ AD=0.5964p PS=4.425u PD=4.425u rfmode=0
M$46377 VDD \$2981 \$3068 VDD sg13_lv_pmos L=0.13u W=2.24u AS=0.616p AD=0.4312p
+ PS=4.46u PD=3.01u rfmode=0
M$46379 VDD VDD \$3068 VDD sg13_lv_pmos L=0.13u W=2.24u AS=0.4312p AD=0.6048p
+ PS=3.01u PD=4.44u rfmode=0
M$46381 \$3069 \$2947 VDD VDD sg13_lv_pmos L=0.13u W=1.12u AS=0.3864p
+ AD=0.431025p PS=2.93u PD=2.145u rfmode=0
M$46382 VDD CLK|clk|core|fclk_in|p2c|ui_p2c[6] \$2947 VDD sg13_lv_pmos L=0.13u
+ W=1.12u AS=0.431025p AD=0.3808p PS=2.145u PD=2.92u rfmode=0
M$46383 VDD \$2987 \$2988 VDD sg13_lv_pmos L=0.13u W=2.24u AS=0.5964p
+ AD=0.5964p PS=4.425u PD=4.425u rfmode=0
M$46385 VDD \$2990 \$3072 VDD sg13_lv_pmos L=0.13u W=2.24u AS=0.616p AD=0.4312p
+ PS=4.46u PD=3.01u rfmode=0
M$46387 VDD VDD \$3072 VDD sg13_lv_pmos L=0.13u W=2.24u AS=0.4312p AD=0.6048p
+ PS=3.01u PD=4.44u rfmode=0
M$46389 \$3073 \$2949 VDD VDD sg13_lv_pmos L=0.13u W=1.12u AS=0.3864p
+ AD=0.431025p PS=2.93u PD=2.145u rfmode=0
M$46390 VDD CLK|clk|core|fclk_in|p2c|ui_p2c[6] \$2949 VDD sg13_lv_pmos L=0.13u
+ W=1.12u AS=0.431025p AD=0.3808p PS=2.145u PD=2.92u rfmode=0
M$46391 VDD \$2996 \$2997 VDD sg13_lv_pmos L=0.13u W=2.24u AS=0.5964p
+ AD=0.5964p PS=4.425u PD=4.425u rfmode=0
M$46393 VDD \$2999 \$3076 VDD sg13_lv_pmos L=0.13u W=2.24u AS=0.616p AD=0.4312p
+ PS=4.46u PD=3.01u rfmode=0
M$46395 VDD VDD \$3076 VDD sg13_lv_pmos L=0.13u W=2.24u AS=0.4312p AD=0.6048p
+ PS=3.01u PD=4.44u rfmode=0
M$46397 \$3077 \$2951 VDD VDD sg13_lv_pmos L=0.13u W=1.12u AS=0.3864p
+ AD=0.431025p PS=2.93u PD=2.145u rfmode=0
M$46398 VDD CLK|clk|core|fclk_in|p2c|ui_p2c[6] \$2951 VDD sg13_lv_pmos L=0.13u
+ W=1.12u AS=0.431025p AD=0.3808p PS=2.145u PD=2.92u rfmode=0
M$46399 VDD \$3005 \$3006 VDD sg13_lv_pmos L=0.13u W=2.24u AS=0.5964p
+ AD=0.5964p PS=4.425u PD=4.425u rfmode=0
M$46401 VDD \$3008 \$3080 VDD sg13_lv_pmos L=0.13u W=2.24u AS=0.616p AD=0.4312p
+ PS=4.46u PD=3.01u rfmode=0
M$46403 VDD VDD \$3080 VDD sg13_lv_pmos L=0.13u W=2.24u AS=0.4312p AD=0.6048p
+ PS=3.01u PD=4.44u rfmode=0
M$46405 \$3081 \$2953 VDD VDD sg13_lv_pmos L=0.13u W=1.12u AS=0.3864p
+ AD=0.431025p PS=2.93u PD=2.145u rfmode=0
M$46406 VDD CLK|clk|core|fclk_in|p2c|ui_p2c[6] \$2953 VDD sg13_lv_pmos L=0.13u
+ W=1.12u AS=0.431025p AD=0.3808p PS=2.145u PD=2.92u rfmode=0
M$46407 VDD \$3014 \$3015 VDD sg13_lv_pmos L=0.13u W=2.24u AS=0.5964p
+ AD=0.5964p PS=4.425u PD=4.425u rfmode=0
M$46409 VDD \$3017 \$3084 VDD sg13_lv_pmos L=0.13u W=2.24u AS=0.616p AD=0.4312p
+ PS=4.46u PD=3.01u rfmode=0
M$46411 VDD VDD \$3084 VDD sg13_lv_pmos L=0.13u W=2.24u AS=0.4312p AD=0.6048p
+ PS=3.01u PD=4.44u rfmode=0
M$46413 \$3085 \$2955 VDD VDD sg13_lv_pmos L=0.13u W=1.12u AS=0.3864p
+ AD=0.431025p PS=2.93u PD=2.145u rfmode=0
M$46414 VDD CLK|clk|core|fclk_in|p2c|ui_p2c[6] \$2955 VDD sg13_lv_pmos L=0.13u
+ W=1.12u AS=0.431025p AD=0.3808p PS=2.145u PD=2.92u rfmode=0
M$46415 VDD \$3023 \$3024 VDD sg13_lv_pmos L=0.13u W=2.24u AS=0.5964p
+ AD=0.5964p PS=4.425u PD=4.425u rfmode=0
M$46417 VDD \$3026 \$3088 VDD sg13_lv_pmos L=0.13u W=2.24u AS=0.616p AD=0.4312p
+ PS=4.46u PD=3.01u rfmode=0
M$46419 VDD VDD \$3088 VDD sg13_lv_pmos L=0.13u W=2.24u AS=0.4312p AD=0.6048p
+ PS=3.01u PD=4.44u rfmode=0
M$46421 \$3089 \$2957 VDD VDD sg13_lv_pmos L=0.13u W=1.12u AS=0.3864p
+ AD=0.431025p PS=2.93u PD=2.145u rfmode=0
M$46422 VDD CLK|clk|core|fclk_in|p2c|ui_p2c[6] \$2957 VDD sg13_lv_pmos L=0.13u
+ W=1.12u AS=0.431025p AD=0.3808p PS=2.145u PD=2.92u rfmode=0
M$46423 VDD \$3032 \$3033 VDD sg13_lv_pmos L=0.13u W=2.24u AS=0.5964p
+ AD=0.5964p PS=4.425u PD=4.425u rfmode=0
M$46425 \$2962 \$3192 \$3279 VDD sg13_lv_pmos L=0.13u W=0.84u AS=0.2856p
+ AD=0.1596p PS=2.36u PD=1.22u rfmode=0
M$46426 VDD \$3416 \$3279 VDD sg13_lv_pmos L=0.13u W=0.84u AS=0.2226p
+ AD=0.1596p PS=1.535u PD=1.22u rfmode=0
M$46427 VDD \$2962 \$2963 VDD sg13_lv_pmos L=0.13u W=2.24u AS=0.4746p
+ AD=0.6776p PS=3.105u PD=4.57u rfmode=0
M$46429 VDD \$3060 \$2965 VDD sg13_lv_pmos L=0.13u W=0.42u AS=0.1428p
+ AD=0.0798p PS=1.52u PD=0.8u rfmode=0
M$46430 VDD VDD \$2965 VDD sg13_lv_pmos L=0.13u W=0.42u AS=0.3623875p
+ AD=0.0798p PS=2.605u PD=0.8u rfmode=0
M$46431 VDD \$3164 \$2942 VDD sg13_lv_pmos L=0.13u W=1u AS=0.3623875p AD=0.34p
+ PS=2.605u PD=2.68u rfmode=0
M$46432 \$3062 \$3061 \$3261 VDD sg13_lv_pmos L=0.13u W=0.42u AS=0.19115p
+ AD=0.0525p PS=1.565u PD=0.67u rfmode=0
M$46433 \$3261 \$3165 VDD VDD sg13_lv_pmos L=0.13u W=0.42u AS=0.0525p
+ AD=0.25605p PS=0.67u PD=1.935u rfmode=0
M$46434 VDD VDD \$3165 VDD sg13_lv_pmos L=0.13u W=0.42u AS=0.25605p AD=0.0798p
+ PS=1.935u PD=0.8u rfmode=0
M$46435 VDD \$3062 \$3165 VDD sg13_lv_pmos L=0.13u W=0.42u AS=0.2014p
+ AD=0.0798p PS=1.53u PD=0.8u rfmode=0
M$46436 VDD \$3062 \$2969 VDD sg13_lv_pmos L=0.13u W=1u AS=0.2083p AD=0.34p
+ PS=1.5u PD=2.68u rfmode=0
M$46437 VDD \$3062 \$2968 VDD sg13_lv_pmos L=0.13u W=2.24u AS=0.4142p
+ AD=0.4211p PS=3.03u PD=3u rfmode=0
M$46439 \$2942 \$2943 \$3062 VDD sg13_lv_pmos L=0.13u W=1u AS=0.34p AD=0.19115p
+ PS=2.68u PD=1.565u rfmode=0
M$46440 \$2971 \$3193 \$3283 VDD sg13_lv_pmos L=0.13u W=0.84u AS=0.2856p
+ AD=0.1596p PS=2.36u PD=1.22u rfmode=0
M$46441 VDD \$3416 \$3283 VDD sg13_lv_pmos L=0.13u W=0.84u AS=0.2226p
+ AD=0.1596p PS=1.535u PD=1.22u rfmode=0
M$46442 VDD \$2971 \$2972 VDD sg13_lv_pmos L=0.13u W=2.24u AS=0.4746p
+ AD=0.6776p PS=3.105u PD=4.57u rfmode=0
M$46444 VDD \$3064 \$2974 VDD sg13_lv_pmos L=0.13u W=0.42u AS=0.1428p
+ AD=0.0798p PS=1.52u PD=0.8u rfmode=0
M$46445 VDD VDD \$2974 VDD sg13_lv_pmos L=0.13u W=0.42u AS=0.3623875p
+ AD=0.0798p PS=2.605u PD=0.8u rfmode=0
M$46446 VDD \$3166 \$2944 VDD sg13_lv_pmos L=0.13u W=1u AS=0.3623875p AD=0.34p
+ PS=2.605u PD=2.68u rfmode=0
M$46447 \$3066 \$3065 \$3257 VDD sg13_lv_pmos L=0.13u W=0.42u AS=0.19115p
+ AD=0.0525p PS=1.565u PD=0.67u rfmode=0
M$46448 \$3257 \$3167 VDD VDD sg13_lv_pmos L=0.13u W=0.42u AS=0.0525p
+ AD=0.25605p PS=0.67u PD=1.935u rfmode=0
M$46449 VDD VDD \$3167 VDD sg13_lv_pmos L=0.13u W=0.42u AS=0.25605p AD=0.0798p
+ PS=1.935u PD=0.8u rfmode=0
M$46450 VDD \$3066 \$3167 VDD sg13_lv_pmos L=0.13u W=0.42u AS=0.2014p
+ AD=0.0798p PS=1.53u PD=0.8u rfmode=0
M$46451 VDD \$3066 \$2978 VDD sg13_lv_pmos L=0.13u W=1u AS=0.2083p AD=0.34p
+ PS=1.5u PD=2.68u rfmode=0
M$46452 VDD \$3066 \$2977 VDD sg13_lv_pmos L=0.13u W=2.24u AS=0.4142p
+ AD=0.4211p PS=3.03u PD=3u rfmode=0
M$46454 \$2944 \$2945 \$3066 VDD sg13_lv_pmos L=0.13u W=1u AS=0.34p AD=0.19115p
+ PS=2.68u PD=1.565u rfmode=0
M$46455 \$2980 \$3194 \$3286 VDD sg13_lv_pmos L=0.13u W=0.84u AS=0.2856p
+ AD=0.1596p PS=2.36u PD=1.22u rfmode=0
M$46456 VDD \$3416 \$3286 VDD sg13_lv_pmos L=0.13u W=0.84u AS=0.2226p
+ AD=0.1596p PS=1.535u PD=1.22u rfmode=0
M$46457 VDD \$2980 \$2981 VDD sg13_lv_pmos L=0.13u W=2.24u AS=0.4746p
+ AD=0.6776p PS=3.105u PD=4.57u rfmode=0
M$46459 VDD \$3068 \$2983 VDD sg13_lv_pmos L=0.13u W=0.42u AS=0.1428p
+ AD=0.0798p PS=1.52u PD=0.8u rfmode=0
M$46460 VDD VDD \$2983 VDD sg13_lv_pmos L=0.13u W=0.42u AS=0.3623875p
+ AD=0.0798p PS=2.605u PD=0.8u rfmode=0
M$46461 VDD \$3168 \$2946 VDD sg13_lv_pmos L=0.13u W=1u AS=0.3623875p AD=0.34p
+ PS=2.605u PD=2.68u rfmode=0
M$46462 \$3070 \$3069 \$3253 VDD sg13_lv_pmos L=0.13u W=0.42u AS=0.19115p
+ AD=0.0525p PS=1.565u PD=0.67u rfmode=0
M$46463 \$3253 \$3169 VDD VDD sg13_lv_pmos L=0.13u W=0.42u AS=0.0525p
+ AD=0.25605p PS=0.67u PD=1.935u rfmode=0
M$46464 VDD VDD \$3169 VDD sg13_lv_pmos L=0.13u W=0.42u AS=0.25605p AD=0.0798p
+ PS=1.935u PD=0.8u rfmode=0
M$46465 VDD \$3070 \$3169 VDD sg13_lv_pmos L=0.13u W=0.42u AS=0.2014p
+ AD=0.0798p PS=1.53u PD=0.8u rfmode=0
M$46466 VDD \$3070 \$2987 VDD sg13_lv_pmos L=0.13u W=1u AS=0.2083p AD=0.34p
+ PS=1.5u PD=2.68u rfmode=0
M$46467 VDD \$3070 \$2986 VDD sg13_lv_pmos L=0.13u W=2.24u AS=0.4142p
+ AD=0.4211p PS=3.03u PD=3u rfmode=0
M$46469 \$2946 \$2947 \$3070 VDD sg13_lv_pmos L=0.13u W=1u AS=0.34p AD=0.19115p
+ PS=2.68u PD=1.565u rfmode=0
M$46470 \$2989 \$3195 \$3288 VDD sg13_lv_pmos L=0.13u W=0.84u AS=0.2856p
+ AD=0.1596p PS=2.36u PD=1.22u rfmode=0
M$46471 VDD \$3416 \$3288 VDD sg13_lv_pmos L=0.13u W=0.84u AS=0.2226p
+ AD=0.1596p PS=1.535u PD=1.22u rfmode=0
M$46472 VDD \$2989 \$2990 VDD sg13_lv_pmos L=0.13u W=2.24u AS=0.4746p
+ AD=0.6776p PS=3.105u PD=4.57u rfmode=0
M$46474 VDD \$3072 \$2992 VDD sg13_lv_pmos L=0.13u W=0.42u AS=0.1428p
+ AD=0.0798p PS=1.52u PD=0.8u rfmode=0
M$46475 VDD VDD \$2992 VDD sg13_lv_pmos L=0.13u W=0.42u AS=0.3623875p
+ AD=0.0798p PS=2.605u PD=0.8u rfmode=0
M$46476 VDD \$3170 \$2948 VDD sg13_lv_pmos L=0.13u W=1u AS=0.3623875p AD=0.34p
+ PS=2.605u PD=2.68u rfmode=0
M$46477 \$3074 \$3073 \$3249 VDD sg13_lv_pmos L=0.13u W=0.42u AS=0.19115p
+ AD=0.0525p PS=1.565u PD=0.67u rfmode=0
M$46478 \$3249 \$3171 VDD VDD sg13_lv_pmos L=0.13u W=0.42u AS=0.0525p
+ AD=0.25605p PS=0.67u PD=1.935u rfmode=0
M$46479 VDD VDD \$3171 VDD sg13_lv_pmos L=0.13u W=0.42u AS=0.25605p AD=0.0798p
+ PS=1.935u PD=0.8u rfmode=0
M$46480 VDD \$3074 \$3171 VDD sg13_lv_pmos L=0.13u W=0.42u AS=0.2014p
+ AD=0.0798p PS=1.53u PD=0.8u rfmode=0
M$46481 VDD \$3074 \$2996 VDD sg13_lv_pmos L=0.13u W=1u AS=0.2083p AD=0.34p
+ PS=1.5u PD=2.68u rfmode=0
M$46482 VDD \$3074 \$2995 VDD sg13_lv_pmos L=0.13u W=2.24u AS=0.4142p
+ AD=0.4211p PS=3.03u PD=3u rfmode=0
M$46484 \$2948 \$2949 \$3074 VDD sg13_lv_pmos L=0.13u W=1u AS=0.34p AD=0.19115p
+ PS=2.68u PD=1.565u rfmode=0
M$46485 \$2998 \$3196 \$3290 VDD sg13_lv_pmos L=0.13u W=0.84u AS=0.2856p
+ AD=0.1596p PS=2.36u PD=1.22u rfmode=0
M$46486 VDD \$3416 \$3290 VDD sg13_lv_pmos L=0.13u W=0.84u AS=0.2226p
+ AD=0.1596p PS=1.535u PD=1.22u rfmode=0
M$46487 VDD \$2998 \$2999 VDD sg13_lv_pmos L=0.13u W=2.24u AS=0.4746p
+ AD=0.6776p PS=3.105u PD=4.57u rfmode=0
M$46489 VDD \$3076 \$3001 VDD sg13_lv_pmos L=0.13u W=0.42u AS=0.1428p
+ AD=0.0798p PS=1.52u PD=0.8u rfmode=0
M$46490 VDD VDD \$3001 VDD sg13_lv_pmos L=0.13u W=0.42u AS=0.3623875p
+ AD=0.0798p PS=2.605u PD=0.8u rfmode=0
M$46491 VDD \$3172 \$2950 VDD sg13_lv_pmos L=0.13u W=1u AS=0.3623875p AD=0.34p
+ PS=2.605u PD=2.68u rfmode=0
M$46492 \$3078 \$3077 \$3245 VDD sg13_lv_pmos L=0.13u W=0.42u AS=0.19115p
+ AD=0.0525p PS=1.565u PD=0.67u rfmode=0
M$46493 \$3245 \$3173 VDD VDD sg13_lv_pmos L=0.13u W=0.42u AS=0.0525p
+ AD=0.25605p PS=0.67u PD=1.935u rfmode=0
M$46494 VDD VDD \$3173 VDD sg13_lv_pmos L=0.13u W=0.42u AS=0.25605p AD=0.0798p
+ PS=1.935u PD=0.8u rfmode=0
M$46495 VDD \$3078 \$3173 VDD sg13_lv_pmos L=0.13u W=0.42u AS=0.2014p
+ AD=0.0798p PS=1.53u PD=0.8u rfmode=0
M$46496 VDD \$3078 \$3005 VDD sg13_lv_pmos L=0.13u W=1u AS=0.2083p AD=0.34p
+ PS=1.5u PD=2.68u rfmode=0
M$46497 VDD \$3078 \$3004 VDD sg13_lv_pmos L=0.13u W=2.24u AS=0.4142p
+ AD=0.4211p PS=3.03u PD=3u rfmode=0
M$46499 \$2950 \$2951 \$3078 VDD sg13_lv_pmos L=0.13u W=1u AS=0.34p AD=0.19115p
+ PS=2.68u PD=1.565u rfmode=0
M$46500 \$3007 \$3197 \$3292 VDD sg13_lv_pmos L=0.13u W=0.84u AS=0.2856p
+ AD=0.1596p PS=2.36u PD=1.22u rfmode=0
M$46501 VDD \$3416 \$3292 VDD sg13_lv_pmos L=0.13u W=0.84u AS=0.2226p
+ AD=0.1596p PS=1.535u PD=1.22u rfmode=0
M$46502 VDD \$3007 \$3008 VDD sg13_lv_pmos L=0.13u W=2.24u AS=0.4746p
+ AD=0.6776p PS=3.105u PD=4.57u rfmode=0
M$46504 VDD \$3080 \$3010 VDD sg13_lv_pmos L=0.13u W=0.42u AS=0.1428p
+ AD=0.0798p PS=1.52u PD=0.8u rfmode=0
M$46505 VDD VDD \$3010 VDD sg13_lv_pmos L=0.13u W=0.42u AS=0.3623875p
+ AD=0.0798p PS=2.605u PD=0.8u rfmode=0
M$46506 VDD \$3174 \$2952 VDD sg13_lv_pmos L=0.13u W=1u AS=0.3623875p AD=0.34p
+ PS=2.605u PD=2.68u rfmode=0
M$46507 \$3082 \$3081 \$3241 VDD sg13_lv_pmos L=0.13u W=0.42u AS=0.19115p
+ AD=0.0525p PS=1.565u PD=0.67u rfmode=0
M$46508 \$3241 \$3175 VDD VDD sg13_lv_pmos L=0.13u W=0.42u AS=0.0525p
+ AD=0.25605p PS=0.67u PD=1.935u rfmode=0
M$46509 VDD VDD \$3175 VDD sg13_lv_pmos L=0.13u W=0.42u AS=0.25605p AD=0.0798p
+ PS=1.935u PD=0.8u rfmode=0
M$46510 VDD \$3082 \$3175 VDD sg13_lv_pmos L=0.13u W=0.42u AS=0.2014p
+ AD=0.0798p PS=1.53u PD=0.8u rfmode=0
M$46511 VDD \$3082 \$3014 VDD sg13_lv_pmos L=0.13u W=1u AS=0.2083p AD=0.34p
+ PS=1.5u PD=2.68u rfmode=0
M$46512 VDD \$3082 \$3013 VDD sg13_lv_pmos L=0.13u W=2.24u AS=0.4142p
+ AD=0.4211p PS=3.03u PD=3u rfmode=0
M$46514 \$2952 \$2953 \$3082 VDD sg13_lv_pmos L=0.13u W=1u AS=0.34p AD=0.19115p
+ PS=2.68u PD=1.565u rfmode=0
M$46515 \$3016 \$3198 \$3281 VDD sg13_lv_pmos L=0.13u W=0.84u AS=0.2856p
+ AD=0.1596p PS=2.36u PD=1.22u rfmode=0
M$46516 VDD \$3416 \$3281 VDD sg13_lv_pmos L=0.13u W=0.84u AS=0.2226p
+ AD=0.1596p PS=1.535u PD=1.22u rfmode=0
M$46517 VDD \$3016 \$3017 VDD sg13_lv_pmos L=0.13u W=2.24u AS=0.4746p
+ AD=0.6776p PS=3.105u PD=4.57u rfmode=0
M$46519 VDD \$3084 \$3019 VDD sg13_lv_pmos L=0.13u W=0.42u AS=0.1428p
+ AD=0.0798p PS=1.52u PD=0.8u rfmode=0
M$46520 VDD VDD \$3019 VDD sg13_lv_pmos L=0.13u W=0.42u AS=0.3623875p
+ AD=0.0798p PS=2.605u PD=0.8u rfmode=0
M$46521 VDD \$3176 \$2954 VDD sg13_lv_pmos L=0.13u W=1u AS=0.3623875p AD=0.34p
+ PS=2.605u PD=2.68u rfmode=0
M$46522 \$3086 \$3085 \$3237 VDD sg13_lv_pmos L=0.13u W=0.42u AS=0.19115p
+ AD=0.0525p PS=1.565u PD=0.67u rfmode=0
M$46523 \$3237 \$3177 VDD VDD sg13_lv_pmos L=0.13u W=0.42u AS=0.0525p
+ AD=0.25605p PS=0.67u PD=1.935u rfmode=0
M$46524 VDD VDD \$3177 VDD sg13_lv_pmos L=0.13u W=0.42u AS=0.25605p AD=0.0798p
+ PS=1.935u PD=0.8u rfmode=0
M$46525 VDD \$3086 \$3177 VDD sg13_lv_pmos L=0.13u W=0.42u AS=0.2014p
+ AD=0.0798p PS=1.53u PD=0.8u rfmode=0
M$46526 VDD \$3086 \$3023 VDD sg13_lv_pmos L=0.13u W=1u AS=0.2083p AD=0.34p
+ PS=1.5u PD=2.68u rfmode=0
M$46527 VDD \$3086 \$3022 VDD sg13_lv_pmos L=0.13u W=2.24u AS=0.4142p
+ AD=0.4211p PS=3.03u PD=3u rfmode=0
M$46529 \$2954 \$2955 \$3086 VDD sg13_lv_pmos L=0.13u W=1u AS=0.34p AD=0.19115p
+ PS=2.68u PD=1.565u rfmode=0
M$46530 \$3025 VSS|anode|cathode|vss \$3276 VDD sg13_lv_pmos L=0.13u W=0.84u
+ AS=0.2856p AD=0.1596p PS=2.36u PD=1.22u rfmode=0
M$46531 VDD \$3416 \$3276 VDD sg13_lv_pmos L=0.13u W=0.84u AS=0.2226p
+ AD=0.1596p PS=1.535u PD=1.22u rfmode=0
M$46532 VDD \$3025 \$3026 VDD sg13_lv_pmos L=0.13u W=2.24u AS=0.4746p
+ AD=0.6776p PS=3.105u PD=4.57u rfmode=0
M$46534 VDD \$3088 \$3028 VDD sg13_lv_pmos L=0.13u W=0.42u AS=0.1428p
+ AD=0.0798p PS=1.52u PD=0.8u rfmode=0
M$46535 VDD VDD \$3028 VDD sg13_lv_pmos L=0.13u W=0.42u AS=0.3623875p
+ AD=0.0798p PS=2.605u PD=0.8u rfmode=0
M$46536 VDD \$3178 \$2956 VDD sg13_lv_pmos L=0.13u W=1u AS=0.3623875p AD=0.34p
+ PS=2.605u PD=2.68u rfmode=0
M$46537 \$3090 \$3089 \$3233 VDD sg13_lv_pmos L=0.13u W=0.42u AS=0.19115p
+ AD=0.0525p PS=1.565u PD=0.67u rfmode=0
M$46538 \$3233 \$3179 VDD VDD sg13_lv_pmos L=0.13u W=0.42u AS=0.0525p
+ AD=0.25605p PS=0.67u PD=1.935u rfmode=0
M$46539 VDD VDD \$3179 VDD sg13_lv_pmos L=0.13u W=0.42u AS=0.25605p AD=0.0798p
+ PS=1.935u PD=0.8u rfmode=0
M$46540 VDD \$3090 \$3179 VDD sg13_lv_pmos L=0.13u W=0.42u AS=0.2014p
+ AD=0.0798p PS=1.53u PD=0.8u rfmode=0
M$46541 VDD \$3090 \$3032 VDD sg13_lv_pmos L=0.13u W=1u AS=0.2083p AD=0.34p
+ PS=1.5u PD=2.68u rfmode=0
M$46542 VDD \$3090 \$3031 VDD sg13_lv_pmos L=0.13u W=2.24u AS=0.4142p
+ AD=0.4211p PS=3.03u PD=3u rfmode=0
M$46544 \$2956 \$2957 \$3090 VDD sg13_lv_pmos L=0.13u W=1u AS=0.34p AD=0.19115p
+ PS=2.68u PD=1.565u rfmode=0
M$46545 \$882 \$3323 VDD|in|pad|pin1|pin2|supply|vdd
+ VDD|in|pad|pin1|pin2|supply|vdd sg13_lv_pmos L=0.13u W=1.12u AS=0.42p
+ AD=0.2114p PS=2.99u PD=1.54u rfmode=0
M$46546 VDD|in|pad|pin1|pin2|supply|vdd \$2909 \$3323
+ VDD|in|pad|pin1|pin2|supply|vdd sg13_lv_pmos L=0.13u W=0.84u AS=0.2114p
+ AD=0.2856p PS=1.54u PD=2.36u rfmode=0
M$46547 \$881 \$3324 VDD|in|pad|pin1|pin2|supply|vdd
+ VDD|in|pad|pin1|pin2|supply|vdd sg13_lv_pmos L=0.13u W=1.12u AS=0.42p
+ AD=0.2114p PS=2.99u PD=1.54u rfmode=0
M$46548 VDD|in|pad|pin1|pin2|supply|vdd \$3046 \$3324
+ VDD|in|pad|pin1|pin2|supply|vdd sg13_lv_pmos L=0.13u W=0.84u AS=0.2114p
+ AD=0.2856p PS=1.54u PD=2.36u rfmode=0
M$46551 D0|c2p|core|i|uo_c2p[8] \$3325 VDD|in|pad|pin1|pin2|supply|vdd
+ VDD|in|pad|pin1|pin2|supply|vdd sg13_lv_pmos L=0.13u W=1.12u AS=0.42p
+ AD=0.2114p PS=2.99u PD=1.54u rfmode=0
M$46552 VDD|in|pad|pin1|pin2|supply|vdd \$3392 \$3325
+ VDD|in|pad|pin1|pin2|supply|vdd sg13_lv_pmos L=0.13u W=0.84u AS=0.2114p
+ AD=0.2856p PS=1.54u PD=2.36u rfmode=0
M$46563 D1|c2p|core|i|uo_c2p[7] \$3326 VDD|in|pad|pin1|pin2|supply|vdd
+ VDD|in|pad|pin1|pin2|supply|vdd sg13_lv_pmos L=0.13u W=1.12u AS=0.42p
+ AD=0.2114p PS=2.99u PD=1.54u rfmode=0
M$46564 VDD|in|pad|pin1|pin2|supply|vdd \$2687 \$3326
+ VDD|in|pad|pin1|pin2|supply|vdd sg13_lv_pmos L=0.13u W=0.84u AS=0.2114p
+ AD=0.2856p PS=1.54u PD=2.36u rfmode=0
M$46574 D2|c2p|core|i|uo_c2p[6] \$3327 VDD|in|pad|pin1|pin2|supply|vdd
+ VDD|in|pad|pin1|pin2|supply|vdd sg13_lv_pmos L=0.13u W=1.12u AS=0.42p
+ AD=0.2114p PS=2.99u PD=1.54u rfmode=0
M$46575 VDD|in|pad|pin1|pin2|supply|vdd \$2842 \$3327
+ VDD|in|pad|pin1|pin2|supply|vdd sg13_lv_pmos L=0.13u W=0.84u AS=0.2114p
+ AD=0.2856p PS=1.54u PD=2.36u rfmode=0
M$46576 VDD|in|pad|pin1|pin2|supply|vdd \$2556 \$3328
+ VDD|in|pad|pin1|pin2|supply|vdd sg13_lv_pmos L=0.13u W=0.84u AS=0.253p
+ AD=0.2856p PS=1.53u PD=2.36u rfmode=0
M$46577 VDD|in|pad|pin1|pin2|supply|vdd \$3328 \$3408
+ VDD|in|pad|pin1|pin2|supply|vdd sg13_lv_pmos L=0.13u W=1u AS=0.2198p
+ AD=0.2975p PS=1.52u PD=1.595u rfmode=0
M$46578 \$3408 \$2390 \$3320 VDD|in|pad|pin1|pin2|supply|vdd sg13_lv_pmos
+ L=0.13u W=1u AS=0.2975p AD=0.2225p PS=1.595u PD=1.445u rfmode=0
M$46579 \$3320 \$3392 \$3407 VDD|in|pad|pin1|pin2|supply|vdd sg13_lv_pmos
+ L=0.13u W=1u AS=0.2225p AD=0.3325p PS=1.445u PD=1.665u rfmode=0
M$46580 \$3407 \$2556 VDD|in|pad|pin1|pin2|supply|vdd
+ VDD|in|pad|pin1|pin2|supply|vdd sg13_lv_pmos L=0.13u W=1u AS=0.3325p
+ AD=0.253p PS=1.665u PD=1.53u rfmode=0
M$46581 \$3319 \$3320 VDD|in|pad|pin1|pin2|supply|vdd
+ VDD|in|pad|pin1|pin2|supply|vdd sg13_lv_pmos L=0.13u W=1.12u AS=0.6048p
+ AD=0.2198p PS=3.32u PD=1.52u rfmode=0
M$46585 VDD|in|pad|pin1|pin2|supply|vdd \$2248 \$2959
+ VDD|in|pad|pin1|pin2|supply|vdd sg13_lv_pmos L=0.13u W=1.12u AS=0.3808p
+ AD=0.3808p PS=2.92u PD=2.92u rfmode=0
M$46589 D3|c2p|core|i|uo_c2p[5] \$3329 VDD|in|pad|pin1|pin2|supply|vdd
+ VDD|in|pad|pin1|pin2|supply|vdd sg13_lv_pmos L=0.13u W=1.12u AS=0.42p
+ AD=0.2114p PS=2.99u PD=1.54u rfmode=0
M$46590 VDD|in|pad|pin1|pin2|supply|vdd \$2908 \$3329
+ VDD|in|pad|pin1|pin2|supply|vdd sg13_lv_pmos L=0.13u W=0.84u AS=0.2114p
+ AD=0.2856p PS=1.54u PD=2.36u rfmode=0
M$46593 VDD|in|pad|pin1|pin2|supply|vdd \$2248 \$2960
+ VDD|in|pad|pin1|pin2|supply|vdd sg13_lv_pmos L=0.13u W=1.12u AS=0.3808p
+ AD=0.3808p PS=2.92u PD=2.92u rfmode=0
M$46600 VDD|in|pad|pin1|pin2|supply|vdd \$3046 \$2911
+ VDD|in|pad|pin1|pin2|supply|vdd sg13_lv_pmos L=0.13u W=1.12u AS=0.3808p
+ AD=0.3808p PS=2.92u PD=2.92u rfmode=0
M$46601 D4|c2p|core|i|uo_c2p[4] \$3330 VDD|in|pad|pin1|pin2|supply|vdd
+ VDD|in|pad|pin1|pin2|supply|vdd sg13_lv_pmos L=0.13u W=1.12u AS=0.42p
+ AD=0.2114p PS=2.99u PD=1.54u rfmode=0
M$46602 VDD|in|pad|pin1|pin2|supply|vdd \$2650 \$3330
+ VDD|in|pad|pin1|pin2|supply|vdd sg13_lv_pmos L=0.13u W=0.84u AS=0.2114p
+ AD=0.2856p PS=1.54u PD=2.36u rfmode=0
M$46613 D5|c2p|core|i|uo_c2p[3] \$3331 VDD|in|pad|pin1|pin2|supply|vdd
+ VDD|in|pad|pin1|pin2|supply|vdd sg13_lv_pmos L=0.13u W=1.12u AS=0.42p
+ AD=0.2114p PS=2.99u PD=1.54u rfmode=0
M$46614 VDD|in|pad|pin1|pin2|supply|vdd \$2801 \$3331
+ VDD|in|pad|pin1|pin2|supply|vdd sg13_lv_pmos L=0.13u W=0.84u AS=0.2114p
+ AD=0.2856p PS=1.54u PD=2.36u rfmode=0
M$46618 \$2915 \$3332 VDD|in|pad|pin1|pin2|supply|vdd
+ VDD|in|pad|pin1|pin2|supply|vdd sg13_lv_pmos L=0.13u W=1.12u AS=0.42p
+ AD=0.2114p PS=2.99u PD=1.54u rfmode=0
M$46619 VDD|in|pad|pin1|pin2|supply|vdd \$2099 \$3332
+ VDD|in|pad|pin1|pin2|supply|vdd sg13_lv_pmos L=0.13u W=0.84u AS=0.2114p
+ AD=0.2856p PS=1.54u PD=2.36u rfmode=0
M$46624 VDD|in|pad|pin1|pin2|supply|vdd \$3216 \$3333
+ VDD|in|pad|pin1|pin2|supply|vdd sg13_lv_pmos L=0.13u W=0.84u AS=0.2114p
+ AD=0.2856p PS=1.54u PD=2.36u rfmode=0
M$46625 VDD|in|pad|pin1|pin2|supply|vdd \$3333 D6|c2p|core|i|uo_c2p[2]
+ VDD|in|pad|pin1|pin2|supply|vdd sg13_lv_pmos L=0.13u W=1.12u AS=0.2114p
+ AD=0.42p PS=1.54u PD=2.99u rfmode=0
M$46626 \$3334 \$2849 VDD|in|pad|pin1|pin2|supply|vdd
+ VDD|in|pad|pin1|pin2|supply|vdd sg13_lv_pmos L=0.13u W=0.84u AS=0.2856p
+ AD=0.253p PS=2.36u PD=1.53u rfmode=0
M$46627 VDD|in|pad|pin1|pin2|supply|vdd \$2849 \$3410
+ VDD|in|pad|pin1|pin2|supply|vdd sg13_lv_pmos L=0.13u W=1u AS=0.253p
+ AD=0.3325p PS=1.53u PD=1.665u rfmode=0
M$46628 \$3410 \$2871 \$3321 VDD|in|pad|pin1|pin2|supply|vdd sg13_lv_pmos
+ L=0.13u W=1u AS=0.3325p AD=0.2225p PS=1.665u PD=1.445u rfmode=0
M$46629 \$3321 \$2384 \$3409 VDD|in|pad|pin1|pin2|supply|vdd sg13_lv_pmos
+ L=0.13u W=1u AS=0.2225p AD=0.2975p PS=1.445u PD=1.595u rfmode=0
M$46630 \$3409 \$3334 VDD|in|pad|pin1|pin2|supply|vdd
+ VDD|in|pad|pin1|pin2|supply|vdd sg13_lv_pmos L=0.13u W=1u AS=0.2975p
+ AD=0.2198p PS=1.595u PD=1.52u rfmode=0
M$46631 VDD|in|pad|pin1|pin2|supply|vdd \$3321 \$3322
+ VDD|in|pad|pin1|pin2|supply|vdd sg13_lv_pmos L=0.13u W=1.12u AS=0.2198p
+ AD=0.6048p PS=1.52u PD=3.32u rfmode=0
M$46632 VDD|in|pad|pin1|pin2|supply|vdd \$2651 \$2961
+ VDD|in|pad|pin1|pin2|supply|vdd sg13_lv_pmos L=0.13u W=1.12u AS=0.3808p
+ AD=0.3808p PS=2.92u PD=2.92u rfmode=0
M$46641 D7|c2p|core|i|uo_c2p[1] \$3335 VDD|in|pad|pin1|pin2|supply|vdd
+ VDD|in|pad|pin1|pin2|supply|vdd sg13_lv_pmos L=0.13u W=1.12u AS=0.42p
+ AD=0.2114p PS=2.99u PD=1.54u rfmode=0
M$46642 VDD|in|pad|pin1|pin2|supply|vdd \$3059 \$3335
+ VDD|in|pad|pin1|pin2|supply|vdd sg13_lv_pmos L=0.13u W=0.84u AS=0.2114p
+ AD=0.2856p PS=1.54u PD=2.36u rfmode=0
M$46643 VDD|in|pad|pin1|pin2|supply|vdd \$2871 \$3336
+ VDD|in|pad|pin1|pin2|supply|vdd sg13_lv_pmos L=0.13u W=0.84u AS=0.2114p
+ AD=0.2856p PS=1.54u PD=2.36u rfmode=0
M$46644 VDD|in|pad|pin1|pin2|supply|vdd \$3336 \$893
+ VDD|in|pad|pin1|pin2|supply|vdd sg13_lv_pmos L=0.13u W=1.12u AS=0.2114p
+ AD=0.42p PS=1.54u PD=2.99u rfmode=0
M$46645 VDD|in|pad|pin1|pin2|supply|vdd \$2802 \$3337
+ VDD|in|pad|pin1|pin2|supply|vdd sg13_lv_pmos L=0.13u W=0.84u AS=0.2114p
+ AD=0.2856p PS=1.54u PD=2.36u rfmode=0
M$46646 VDD|in|pad|pin1|pin2|supply|vdd \$3337 \$892
+ VDD|in|pad|pin1|pin2|supply|vdd sg13_lv_pmos L=0.13u W=1.12u AS=0.2114p
+ AD=0.42p PS=1.54u PD=2.99u rfmode=0
M$46647 \$3413 X9|dout[10] \$3437 VDD sg13_lv_pmos L=0.13u W=0.84u AS=0.2856p
+ AD=0.1596p PS=2.36u PD=1.22u rfmode=0
M$46648 VDD X10|dout[11] \$3437 VDD sg13_lv_pmos L=0.13u W=0.84u AS=0.2226p
+ AD=0.1596p PS=1.535u PD=1.22u rfmode=0
M$46649 VDD \$3413 \$3414 VDD sg13_lv_pmos L=0.13u W=2.24u AS=0.4746p
+ AD=0.6776p PS=3.105u PD=4.57u rfmode=0
M$46651 \$3393 X9|dout[10] \$3411 VDD sg13_lv_pmos L=0.13u W=0.84u AS=0.2856p
+ AD=0.1596p PS=2.36u PD=1.22u rfmode=0
M$46652 \$3411 X8|dout[9] VDD VDD sg13_lv_pmos L=0.13u W=0.84u AS=0.1596p
+ AD=0.2226p PS=1.22u PD=1.535u rfmode=0
M$46653 VDD \$3393 \$3394 VDD sg13_lv_pmos L=0.13u W=2.24u AS=0.4746p
+ AD=0.6776p PS=3.105u PD=4.57u rfmode=0
M$46655 VDD X8|dout[9] \$3268 VDD sg13_lv_pmos L=0.13u W=0.84u AS=0.2856p
+ AD=0.1596p PS=2.36u PD=1.22u rfmode=0
M$46656 VDD X9|dout[10] \$3268 VDD sg13_lv_pmos L=0.13u W=0.84u AS=0.1918p
+ AD=0.1596p PS=1.5u PD=1.22u rfmode=0
M$46657 VDD \$3268 \$3269 VDD sg13_lv_pmos L=0.13u W=2.24u AS=0.4046p
+ AD=0.6384p PS=3u PD=4.5u rfmode=0
M$46659 VDD X9|dout[10] \$3438 VDD sg13_lv_pmos L=0.13u W=0.84u AS=0.2856p
+ AD=0.1596p PS=2.36u PD=1.22u rfmode=0
M$46660 \$3438 X10|dout[11] VDD VDD sg13_lv_pmos L=0.13u W=0.84u AS=0.1596p
+ AD=0.1918p PS=1.22u PD=1.5u rfmode=0
M$46661 VDD \$3438 \$3439 VDD sg13_lv_pmos L=0.13u W=2.24u AS=0.4046p
+ AD=0.6384p PS=3u PD=4.5u rfmode=0
M$46663 \$3415 X8|dout[9] \$3436 VDD sg13_lv_pmos L=0.13u W=0.84u AS=0.2856p
+ AD=0.1596p PS=2.36u PD=1.22u rfmode=0
M$46664 VDD \$3414 \$3436 VDD sg13_lv_pmos L=0.13u W=0.84u AS=0.2226p
+ AD=0.1596p PS=1.535u PD=1.22u rfmode=0
M$46665 VDD \$3415 \$3416 VDD sg13_lv_pmos L=0.13u W=2.24u AS=0.4746p
+ AD=0.6776p PS=3.105u PD=4.57u rfmode=0
M$46667 \$3220 X10|dout[11] \$3343 VDD sg13_lv_pmos L=0.13u W=0.84u AS=0.2856p
+ AD=0.1596p PS=2.36u PD=1.22u rfmode=0
M$46668 VDD \$3269 \$3343 VDD sg13_lv_pmos L=0.13u W=0.84u AS=0.2226p
+ AD=0.1596p PS=1.535u PD=1.22u rfmode=0
M$46669 VDD \$3220 \$3221 VDD sg13_lv_pmos L=0.13u W=2.24u AS=0.4746p
+ AD=0.6776p PS=3.105u PD=4.57u rfmode=0
M$46671 VDD X10|dout[11] \$3395 VDD sg13_lv_pmos L=0.13u W=0.84u AS=0.2856p
+ AD=0.1596p PS=2.36u PD=1.22u rfmode=0
M$46672 \$3395 \$3394 VDD VDD sg13_lv_pmos L=0.13u W=0.84u AS=0.1596p
+ AD=0.1918p PS=1.22u PD=1.5u rfmode=0
M$46673 VDD \$3395 \$3396 VDD sg13_lv_pmos L=0.13u W=2.24u AS=0.4046p
+ AD=0.6384p PS=3u PD=4.5u rfmode=0
M$46675 \$3164 VDD VDD VDD sg13_lv_pmos L=0.13u W=0.42u AS=0.147p AD=0.1563p
+ PS=1.54u PD=1.22u rfmode=0
M$46676 VDD \$2942 \$3282 VDD sg13_lv_pmos L=0.13u W=0.42u AS=0.1563p
+ AD=0.0546p PS=1.22u PD=0.68u rfmode=0
M$46677 \$3282 \$2943 \$3164 VDD sg13_lv_pmos L=0.13u W=0.42u AS=0.0546p
+ AD=0.0798p PS=0.68u PD=0.8u rfmode=0
M$46678 \$3164 \$3061 \$2965 VDD sg13_lv_pmos L=0.13u W=0.42u AS=0.0798p
+ AD=0.1428p PS=0.8u PD=1.52u rfmode=0
M$46679 \$3166 VDD VDD VDD sg13_lv_pmos L=0.13u W=0.42u AS=0.147p AD=0.1563p
+ PS=1.54u PD=1.22u rfmode=0
M$46680 VDD \$2944 \$3284 VDD sg13_lv_pmos L=0.13u W=0.42u AS=0.1563p
+ AD=0.0546p PS=1.22u PD=0.68u rfmode=0
M$46681 \$3284 \$2945 \$3166 VDD sg13_lv_pmos L=0.13u W=0.42u AS=0.0546p
+ AD=0.0798p PS=0.68u PD=0.8u rfmode=0
M$46682 \$3166 \$3065 \$2974 VDD sg13_lv_pmos L=0.13u W=0.42u AS=0.0798p
+ AD=0.1428p PS=0.8u PD=1.52u rfmode=0
M$46683 \$3168 VDD VDD VDD sg13_lv_pmos L=0.13u W=0.42u AS=0.147p AD=0.1563p
+ PS=1.54u PD=1.22u rfmode=0
M$46684 VDD \$2946 \$3287 VDD sg13_lv_pmos L=0.13u W=0.42u AS=0.1563p
+ AD=0.0546p PS=1.22u PD=0.68u rfmode=0
M$46685 \$3287 \$2947 \$3168 VDD sg13_lv_pmos L=0.13u W=0.42u AS=0.0546p
+ AD=0.0798p PS=0.68u PD=0.8u rfmode=0
M$46686 \$3168 \$3069 \$2983 VDD sg13_lv_pmos L=0.13u W=0.42u AS=0.0798p
+ AD=0.1428p PS=0.8u PD=1.52u rfmode=0
M$46687 \$3170 VDD VDD VDD sg13_lv_pmos L=0.13u W=0.42u AS=0.147p AD=0.1563p
+ PS=1.54u PD=1.22u rfmode=0
M$46688 VDD \$2948 \$3289 VDD sg13_lv_pmos L=0.13u W=0.42u AS=0.1563p
+ AD=0.0546p PS=1.22u PD=0.68u rfmode=0
M$46689 \$3289 \$2949 \$3170 VDD sg13_lv_pmos L=0.13u W=0.42u AS=0.0546p
+ AD=0.0798p PS=0.68u PD=0.8u rfmode=0
M$46690 \$3170 \$3073 \$2992 VDD sg13_lv_pmos L=0.13u W=0.42u AS=0.0798p
+ AD=0.1428p PS=0.8u PD=1.52u rfmode=0
M$46691 \$3172 VDD VDD VDD sg13_lv_pmos L=0.13u W=0.42u AS=0.147p AD=0.1563p
+ PS=1.54u PD=1.22u rfmode=0
M$46692 VDD \$2950 \$3291 VDD sg13_lv_pmos L=0.13u W=0.42u AS=0.1563p
+ AD=0.0546p PS=1.22u PD=0.68u rfmode=0
M$46693 \$3291 \$2951 \$3172 VDD sg13_lv_pmos L=0.13u W=0.42u AS=0.0546p
+ AD=0.0798p PS=0.68u PD=0.8u rfmode=0
M$46694 \$3172 \$3077 \$3001 VDD sg13_lv_pmos L=0.13u W=0.42u AS=0.0798p
+ AD=0.1428p PS=0.8u PD=1.52u rfmode=0
M$46695 \$3174 VDD VDD VDD sg13_lv_pmos L=0.13u W=0.42u AS=0.147p AD=0.1563p
+ PS=1.54u PD=1.22u rfmode=0
M$46696 VDD \$2952 \$3285 VDD sg13_lv_pmos L=0.13u W=0.42u AS=0.1563p
+ AD=0.0546p PS=1.22u PD=0.68u rfmode=0
M$46697 \$3285 \$2953 \$3174 VDD sg13_lv_pmos L=0.13u W=0.42u AS=0.0546p
+ AD=0.0798p PS=0.68u PD=0.8u rfmode=0
M$46698 \$3174 \$3081 \$3010 VDD sg13_lv_pmos L=0.13u W=0.42u AS=0.0798p
+ AD=0.1428p PS=0.8u PD=1.52u rfmode=0
M$46699 \$3176 VDD VDD VDD sg13_lv_pmos L=0.13u W=0.42u AS=0.147p AD=0.1563p
+ PS=1.54u PD=1.22u rfmode=0
M$46700 VDD \$2954 \$3280 VDD sg13_lv_pmos L=0.13u W=0.42u AS=0.1563p
+ AD=0.0546p PS=1.22u PD=0.68u rfmode=0
M$46701 \$3280 \$2955 \$3176 VDD sg13_lv_pmos L=0.13u W=0.42u AS=0.0546p
+ AD=0.0798p PS=0.68u PD=0.8u rfmode=0
M$46702 \$3176 \$3085 \$3019 VDD sg13_lv_pmos L=0.13u W=0.42u AS=0.0798p
+ AD=0.1428p PS=0.8u PD=1.52u rfmode=0
M$46703 \$3178 VDD VDD VDD sg13_lv_pmos L=0.13u W=0.42u AS=0.147p AD=0.1563p
+ PS=1.54u PD=1.22u rfmode=0
M$46704 VDD \$2956 \$3275 VDD sg13_lv_pmos L=0.13u W=0.42u AS=0.1563p
+ AD=0.0546p PS=1.22u PD=0.68u rfmode=0
M$46705 \$3275 \$2957 \$3178 VDD sg13_lv_pmos L=0.13u W=0.42u AS=0.0546p
+ AD=0.0798p PS=0.68u PD=0.8u rfmode=0
M$46706 \$3178 \$3089 \$3028 VDD sg13_lv_pmos L=0.13u W=0.42u AS=0.0798p
+ AD=0.1428p PS=0.8u PD=1.52u rfmode=0
M$46707 VDD \$3449 \$3504 VDD sg13_lv_pmos L=0.13u W=2.24u AS=0.616p AD=0.4312p
+ PS=4.46u PD=3.01u rfmode=0
M$46709 VDD \$3416 \$3504 VDD sg13_lv_pmos L=0.13u W=2.24u AS=0.4312p
+ AD=0.6048p PS=3.01u PD=4.44u rfmode=0
M$46711 \$3618 \$3451 VDD VDD sg13_lv_pmos L=0.13u W=1.12u AS=0.3864p
+ AD=0.431025p PS=2.93u PD=2.145u rfmode=0
M$46712 VDD CLK|clk|core|fclk_in|p2c|ui_p2c[6] \$3451 VDD sg13_lv_pmos L=0.13u
+ W=1.12u AS=0.431025p AD=0.3808p PS=2.145u PD=2.92u rfmode=0
M$46713 VDD \$3453 \$3454 VDD sg13_lv_pmos L=0.13u W=2.24u AS=0.5964p
+ AD=0.5964p PS=4.425u PD=4.425u rfmode=0
M$46715 VDD \$3456 \$3510 VDD sg13_lv_pmos L=0.13u W=2.24u AS=0.616p AD=0.4312p
+ PS=4.46u PD=3.01u rfmode=0
M$46717 VDD \$3416 \$3510 VDD sg13_lv_pmos L=0.13u W=2.24u AS=0.4312p
+ AD=0.6048p PS=3.01u PD=4.44u rfmode=0
M$46719 \$3620 \$3458 VDD VDD sg13_lv_pmos L=0.13u W=1.12u AS=0.3864p
+ AD=0.431025p PS=2.93u PD=2.145u rfmode=0
M$46720 VDD CLK|clk|core|fclk_in|p2c|ui_p2c[6] \$3458 VDD sg13_lv_pmos L=0.13u
+ W=1.12u AS=0.431025p AD=0.3808p PS=2.145u PD=2.92u rfmode=0
M$46721 VDD \$3460 \$3461 VDD sg13_lv_pmos L=0.13u W=2.24u AS=0.5964p
+ AD=0.5964p PS=4.425u PD=4.425u rfmode=0
M$46723 VDD \$3463 \$3516 VDD sg13_lv_pmos L=0.13u W=2.24u AS=0.616p AD=0.4312p
+ PS=4.46u PD=3.01u rfmode=0
M$46725 VDD \$3416 \$3516 VDD sg13_lv_pmos L=0.13u W=2.24u AS=0.4312p
+ AD=0.6048p PS=3.01u PD=4.44u rfmode=0
M$46727 \$3622 \$3465 VDD VDD sg13_lv_pmos L=0.13u W=1.12u AS=0.3864p
+ AD=0.431025p PS=2.93u PD=2.145u rfmode=0
M$46728 VDD CLK|clk|core|fclk_in|p2c|ui_p2c[6] \$3465 VDD sg13_lv_pmos L=0.13u
+ W=1.12u AS=0.431025p AD=0.3808p PS=2.145u PD=2.92u rfmode=0
M$46729 VDD \$3467 \$3468 VDD sg13_lv_pmos L=0.13u W=2.24u AS=0.5964p
+ AD=0.5964p PS=4.425u PD=4.425u rfmode=0
M$46731 VDD \$3470 \$3522 VDD sg13_lv_pmos L=0.13u W=2.24u AS=0.616p AD=0.4312p
+ PS=4.46u PD=3.01u rfmode=0
M$46733 VDD \$3416 \$3522 VDD sg13_lv_pmos L=0.13u W=2.24u AS=0.4312p
+ AD=0.6048p PS=3.01u PD=4.44u rfmode=0
M$46735 \$3624 \$3472 VDD VDD sg13_lv_pmos L=0.13u W=1.12u AS=0.3864p
+ AD=0.431025p PS=2.93u PD=2.145u rfmode=0
M$46736 VDD CLK|clk|core|fclk_in|p2c|ui_p2c[6] \$3472 VDD sg13_lv_pmos L=0.13u
+ W=1.12u AS=0.431025p AD=0.3808p PS=2.145u PD=2.92u rfmode=0
M$46737 VDD \$3474 \$3475 VDD sg13_lv_pmos L=0.13u W=2.24u AS=0.5964p
+ AD=0.5964p PS=4.425u PD=4.425u rfmode=0
M$46739 VDD \$3477 \$3528 VDD sg13_lv_pmos L=0.13u W=2.24u AS=0.616p AD=0.4312p
+ PS=4.46u PD=3.01u rfmode=0
M$46741 VDD \$3416 \$3528 VDD sg13_lv_pmos L=0.13u W=2.24u AS=0.4312p
+ AD=0.6048p PS=3.01u PD=4.44u rfmode=0
M$46743 \$3626 \$3479 VDD VDD sg13_lv_pmos L=0.13u W=1.12u AS=0.3864p
+ AD=0.431025p PS=2.93u PD=2.145u rfmode=0
M$46744 VDD CLK|clk|core|fclk_in|p2c|ui_p2c[6] \$3479 VDD sg13_lv_pmos L=0.13u
+ W=1.12u AS=0.431025p AD=0.3808p PS=2.145u PD=2.92u rfmode=0
M$46745 VDD \$3481 \$3482 VDD sg13_lv_pmos L=0.13u W=2.24u AS=0.5964p
+ AD=0.5964p PS=4.425u PD=4.425u rfmode=0
M$46747 VDD \$3484 \$3534 VDD sg13_lv_pmos L=0.13u W=2.24u AS=0.616p AD=0.4312p
+ PS=4.46u PD=3.01u rfmode=0
M$46749 VDD \$3416 \$3534 VDD sg13_lv_pmos L=0.13u W=2.24u AS=0.4312p
+ AD=0.6048p PS=3.01u PD=4.44u rfmode=0
M$46751 \$3628 \$3486 VDD VDD sg13_lv_pmos L=0.13u W=1.12u AS=0.3864p
+ AD=0.431025p PS=2.93u PD=2.145u rfmode=0
M$46752 VDD CLK|clk|core|fclk_in|p2c|ui_p2c[6] \$3486 VDD sg13_lv_pmos L=0.13u
+ W=1.12u AS=0.431025p AD=0.3808p PS=2.145u PD=2.92u rfmode=0
M$46753 VDD \$3488 \$3489 VDD sg13_lv_pmos L=0.13u W=2.24u AS=0.5964p
+ AD=0.5964p PS=4.425u PD=4.425u rfmode=0
M$46755 VDD \$3491 \$3540 VDD sg13_lv_pmos L=0.13u W=2.24u AS=0.616p AD=0.4312p
+ PS=4.46u PD=3.01u rfmode=0
M$46757 VDD \$3416 \$3540 VDD sg13_lv_pmos L=0.13u W=2.24u AS=0.4312p
+ AD=0.6048p PS=3.01u PD=4.44u rfmode=0
M$46759 \$3630 \$3493 VDD VDD sg13_lv_pmos L=0.13u W=1.12u AS=0.3864p
+ AD=0.431025p PS=2.93u PD=2.145u rfmode=0
M$46760 VDD CLK|clk|core|fclk_in|p2c|ui_p2c[6] \$3493 VDD sg13_lv_pmos L=0.13u
+ W=1.12u AS=0.431025p AD=0.3808p PS=2.145u PD=2.92u rfmode=0
M$46761 VDD \$3495 \$3496 VDD sg13_lv_pmos L=0.13u W=2.24u AS=0.5964p
+ AD=0.5964p PS=4.425u PD=4.425u rfmode=0
M$46763 VDD \$3498 \$3546 VDD sg13_lv_pmos L=0.13u W=2.24u AS=0.616p AD=0.4312p
+ PS=4.46u PD=3.01u rfmode=0
M$46765 VDD \$3416 \$3546 VDD sg13_lv_pmos L=0.13u W=2.24u AS=0.4312p
+ AD=0.6048p PS=3.01u PD=4.44u rfmode=0
M$46767 \$3632 \$3500 VDD VDD sg13_lv_pmos L=0.13u W=1.12u AS=0.3864p
+ AD=0.431025p PS=2.93u PD=2.145u rfmode=0
M$46768 VDD CLK|clk|core|fclk_in|p2c|ui_p2c[6] \$3500 VDD sg13_lv_pmos L=0.13u
+ W=1.12u AS=0.431025p AD=0.3808p PS=2.145u PD=2.92u rfmode=0
M$46769 VDD \$3502 \$3503 VDD sg13_lv_pmos L=0.13u W=2.24u AS=0.5964p
+ AD=0.5964p PS=4.425u PD=4.425u rfmode=0
M$46771 \$3448 \$3192 \$3668 VDD sg13_lv_pmos L=0.13u W=0.84u AS=0.2856p
+ AD=0.1596p PS=2.36u PD=1.22u rfmode=0
M$46772 VDD \$3414 \$3668 VDD sg13_lv_pmos L=0.13u W=0.84u AS=0.2226p
+ AD=0.1596p PS=1.535u PD=1.22u rfmode=0
M$46773 VDD \$3448 \$3449 VDD sg13_lv_pmos L=0.13u W=2.24u AS=0.4746p
+ AD=0.6776p PS=3.105u PD=4.57u rfmode=0
M$46775 VDD \$3504 \$3505 VDD sg13_lv_pmos L=0.13u W=0.42u AS=0.1428p
+ AD=0.0798p PS=1.52u PD=0.8u rfmode=0
M$46776 VDD VDD \$3505 VDD sg13_lv_pmos L=0.13u W=0.42u AS=0.3623875p
+ AD=0.0798p PS=2.605u PD=0.8u rfmode=0
M$46777 VDD \$3610 \$3440 VDD sg13_lv_pmos L=0.13u W=1u AS=0.3623875p AD=0.34p
+ PS=2.605u PD=2.68u rfmode=0
M$46778 \$3508 \$3618 \$3635 VDD sg13_lv_pmos L=0.13u W=0.42u AS=0.19115p
+ AD=0.0525p PS=1.565u PD=0.67u rfmode=0
M$46779 \$3635 \$3576 VDD VDD sg13_lv_pmos L=0.13u W=0.42u AS=0.0525p
+ AD=0.25605p PS=0.67u PD=1.935u rfmode=0
M$46780 VDD VDD \$3576 VDD sg13_lv_pmos L=0.13u W=0.42u AS=0.25605p AD=0.0798p
+ PS=1.935u PD=0.8u rfmode=0
M$46781 VDD \$3508 \$3576 VDD sg13_lv_pmos L=0.13u W=0.42u AS=0.2014p
+ AD=0.0798p PS=1.53u PD=0.8u rfmode=0
M$46782 VDD \$3508 \$3453 VDD sg13_lv_pmos L=0.13u W=1u AS=0.2083p AD=0.34p
+ PS=1.5u PD=2.68u rfmode=0
M$46783 VDD \$3508 \$3452 VDD sg13_lv_pmos L=0.13u W=2.24u AS=0.4142p
+ AD=0.4211p PS=3.03u PD=3u rfmode=0
M$46785 \$3440 \$3451 \$3508 VDD sg13_lv_pmos L=0.13u W=1u AS=0.34p AD=0.19115p
+ PS=2.68u PD=1.565u rfmode=0
M$46786 \$3455 \$3193 \$3670 VDD sg13_lv_pmos L=0.13u W=0.84u AS=0.2856p
+ AD=0.1596p PS=2.36u PD=1.22u rfmode=0
M$46787 VDD \$3414 \$3670 VDD sg13_lv_pmos L=0.13u W=0.84u AS=0.2226p
+ AD=0.1596p PS=1.535u PD=1.22u rfmode=0
M$46788 VDD \$3455 \$3456 VDD sg13_lv_pmos L=0.13u W=2.24u AS=0.4746p
+ AD=0.6776p PS=3.105u PD=4.57u rfmode=0
M$46790 VDD \$3510 \$3511 VDD sg13_lv_pmos L=0.13u W=0.42u AS=0.1428p
+ AD=0.0798p PS=1.52u PD=0.8u rfmode=0
M$46791 VDD VDD \$3511 VDD sg13_lv_pmos L=0.13u W=0.42u AS=0.3623875p
+ AD=0.0798p PS=2.605u PD=0.8u rfmode=0
M$46792 VDD \$3611 \$3441 VDD sg13_lv_pmos L=0.13u W=1u AS=0.3623875p AD=0.34p
+ PS=2.605u PD=2.68u rfmode=0
M$46793 \$3514 \$3620 \$3639 VDD sg13_lv_pmos L=0.13u W=0.42u AS=0.19115p
+ AD=0.0525p PS=1.565u PD=0.67u rfmode=0
M$46794 \$3639 \$3577 VDD VDD sg13_lv_pmos L=0.13u W=0.42u AS=0.0525p
+ AD=0.25605p PS=0.67u PD=1.935u rfmode=0
M$46795 VDD VDD \$3577 VDD sg13_lv_pmos L=0.13u W=0.42u AS=0.25605p AD=0.0798p
+ PS=1.935u PD=0.8u rfmode=0
M$46796 VDD \$3514 \$3577 VDD sg13_lv_pmos L=0.13u W=0.42u AS=0.2014p
+ AD=0.0798p PS=1.53u PD=0.8u rfmode=0
M$46797 VDD \$3514 \$3460 VDD sg13_lv_pmos L=0.13u W=1u AS=0.2083p AD=0.34p
+ PS=1.5u PD=2.68u rfmode=0
M$46798 VDD \$3514 \$3459 VDD sg13_lv_pmos L=0.13u W=2.24u AS=0.4142p
+ AD=0.4211p PS=3.03u PD=3u rfmode=0
M$46800 \$3441 \$3458 \$3514 VDD sg13_lv_pmos L=0.13u W=1u AS=0.34p AD=0.19115p
+ PS=2.68u PD=1.565u rfmode=0
M$46801 \$3462 \$3194 \$3672 VDD sg13_lv_pmos L=0.13u W=0.84u AS=0.2856p
+ AD=0.1596p PS=2.36u PD=1.22u rfmode=0
M$46802 VDD \$3414 \$3672 VDD sg13_lv_pmos L=0.13u W=0.84u AS=0.2226p
+ AD=0.1596p PS=1.535u PD=1.22u rfmode=0
M$46803 VDD \$3462 \$3463 VDD sg13_lv_pmos L=0.13u W=2.24u AS=0.4746p
+ AD=0.6776p PS=3.105u PD=4.57u rfmode=0
M$46805 VDD \$3516 \$3517 VDD sg13_lv_pmos L=0.13u W=0.42u AS=0.1428p
+ AD=0.0798p PS=1.52u PD=0.8u rfmode=0
M$46806 VDD VDD \$3517 VDD sg13_lv_pmos L=0.13u W=0.42u AS=0.3623875p
+ AD=0.0798p PS=2.605u PD=0.8u rfmode=0
M$46807 VDD \$3612 \$3442 VDD sg13_lv_pmos L=0.13u W=1u AS=0.3623875p AD=0.34p
+ PS=2.605u PD=2.68u rfmode=0
M$46808 \$3520 \$3622 \$3643 VDD sg13_lv_pmos L=0.13u W=0.42u AS=0.19115p
+ AD=0.0525p PS=1.565u PD=0.67u rfmode=0
M$46809 \$3643 \$3578 VDD VDD sg13_lv_pmos L=0.13u W=0.42u AS=0.0525p
+ AD=0.25605p PS=0.67u PD=1.935u rfmode=0
M$46810 VDD VDD \$3578 VDD sg13_lv_pmos L=0.13u W=0.42u AS=0.25605p AD=0.0798p
+ PS=1.935u PD=0.8u rfmode=0
M$46811 VDD \$3520 \$3578 VDD sg13_lv_pmos L=0.13u W=0.42u AS=0.2014p
+ AD=0.0798p PS=1.53u PD=0.8u rfmode=0
M$46812 VDD \$3520 \$3467 VDD sg13_lv_pmos L=0.13u W=1u AS=0.2083p AD=0.34p
+ PS=1.5u PD=2.68u rfmode=0
M$46813 VDD \$3520 \$3466 VDD sg13_lv_pmos L=0.13u W=2.24u AS=0.4142p
+ AD=0.4211p PS=3.03u PD=3u rfmode=0
M$46815 \$3442 \$3465 \$3520 VDD sg13_lv_pmos L=0.13u W=1u AS=0.34p AD=0.19115p
+ PS=2.68u PD=1.565u rfmode=0
M$46816 \$3469 \$3195 \$3674 VDD sg13_lv_pmos L=0.13u W=0.84u AS=0.2856p
+ AD=0.1596p PS=2.36u PD=1.22u rfmode=0
M$46817 VDD \$3414 \$3674 VDD sg13_lv_pmos L=0.13u W=0.84u AS=0.2226p
+ AD=0.1596p PS=1.535u PD=1.22u rfmode=0
M$46818 VDD \$3469 \$3470 VDD sg13_lv_pmos L=0.13u W=2.24u AS=0.4746p
+ AD=0.6776p PS=3.105u PD=4.57u rfmode=0
M$46820 VDD \$3522 \$3523 VDD sg13_lv_pmos L=0.13u W=0.42u AS=0.1428p
+ AD=0.0798p PS=1.52u PD=0.8u rfmode=0
M$46821 VDD VDD \$3523 VDD sg13_lv_pmos L=0.13u W=0.42u AS=0.3623875p
+ AD=0.0798p PS=2.605u PD=0.8u rfmode=0
M$46822 VDD \$3613 \$3443 VDD sg13_lv_pmos L=0.13u W=1u AS=0.3623875p AD=0.34p
+ PS=2.605u PD=2.68u rfmode=0
M$46823 \$3526 \$3624 \$3647 VDD sg13_lv_pmos L=0.13u W=0.42u AS=0.19115p
+ AD=0.0525p PS=1.565u PD=0.67u rfmode=0
M$46824 \$3647 \$3579 VDD VDD sg13_lv_pmos L=0.13u W=0.42u AS=0.0525p
+ AD=0.25605p PS=0.67u PD=1.935u rfmode=0
M$46825 VDD VDD \$3579 VDD sg13_lv_pmos L=0.13u W=0.42u AS=0.25605p AD=0.0798p
+ PS=1.935u PD=0.8u rfmode=0
M$46826 VDD \$3526 \$3579 VDD sg13_lv_pmos L=0.13u W=0.42u AS=0.2014p
+ AD=0.0798p PS=1.53u PD=0.8u rfmode=0
M$46827 VDD \$3526 \$3474 VDD sg13_lv_pmos L=0.13u W=1u AS=0.2083p AD=0.34p
+ PS=1.5u PD=2.68u rfmode=0
M$46828 VDD \$3526 \$3473 VDD sg13_lv_pmos L=0.13u W=2.24u AS=0.4142p
+ AD=0.4211p PS=3.03u PD=3u rfmode=0
M$46830 \$3443 \$3472 \$3526 VDD sg13_lv_pmos L=0.13u W=1u AS=0.34p AD=0.19115p
+ PS=2.68u PD=1.565u rfmode=0
M$46831 \$3476 \$3196 \$3676 VDD sg13_lv_pmos L=0.13u W=0.84u AS=0.2856p
+ AD=0.1596p PS=2.36u PD=1.22u rfmode=0
M$46832 VDD \$3414 \$3676 VDD sg13_lv_pmos L=0.13u W=0.84u AS=0.2226p
+ AD=0.1596p PS=1.535u PD=1.22u rfmode=0
M$46833 VDD \$3476 \$3477 VDD sg13_lv_pmos L=0.13u W=2.24u AS=0.4746p
+ AD=0.6776p PS=3.105u PD=4.57u rfmode=0
M$46835 VDD \$3528 \$3529 VDD sg13_lv_pmos L=0.13u W=0.42u AS=0.1428p
+ AD=0.0798p PS=1.52u PD=0.8u rfmode=0
M$46836 VDD VDD \$3529 VDD sg13_lv_pmos L=0.13u W=0.42u AS=0.3623875p
+ AD=0.0798p PS=2.605u PD=0.8u rfmode=0
M$46837 VDD \$3614 \$3444 VDD sg13_lv_pmos L=0.13u W=1u AS=0.3623875p AD=0.34p
+ PS=2.605u PD=2.68u rfmode=0
M$46838 \$3532 \$3626 \$3651 VDD sg13_lv_pmos L=0.13u W=0.42u AS=0.19115p
+ AD=0.0525p PS=1.565u PD=0.67u rfmode=0
M$46839 \$3651 \$3580 VDD VDD sg13_lv_pmos L=0.13u W=0.42u AS=0.0525p
+ AD=0.25605p PS=0.67u PD=1.935u rfmode=0
M$46840 VDD VDD \$3580 VDD sg13_lv_pmos L=0.13u W=0.42u AS=0.25605p AD=0.0798p
+ PS=1.935u PD=0.8u rfmode=0
M$46841 VDD \$3532 \$3580 VDD sg13_lv_pmos L=0.13u W=0.42u AS=0.2014p
+ AD=0.0798p PS=1.53u PD=0.8u rfmode=0
M$46842 VDD \$3532 \$3481 VDD sg13_lv_pmos L=0.13u W=1u AS=0.2083p AD=0.34p
+ PS=1.5u PD=2.68u rfmode=0
M$46843 VDD \$3532 \$3480 VDD sg13_lv_pmos L=0.13u W=2.24u AS=0.4142p
+ AD=0.4211p PS=3.03u PD=3u rfmode=0
M$46845 \$3444 \$3479 \$3532 VDD sg13_lv_pmos L=0.13u W=1u AS=0.34p AD=0.19115p
+ PS=2.68u PD=1.565u rfmode=0
M$46846 \$3483 \$3197 \$3678 VDD sg13_lv_pmos L=0.13u W=0.84u AS=0.2856p
+ AD=0.1596p PS=2.36u PD=1.22u rfmode=0
M$46847 VDD \$3414 \$3678 VDD sg13_lv_pmos L=0.13u W=0.84u AS=0.2226p
+ AD=0.1596p PS=1.535u PD=1.22u rfmode=0
M$46848 VDD \$3483 \$3484 VDD sg13_lv_pmos L=0.13u W=2.24u AS=0.4746p
+ AD=0.6776p PS=3.105u PD=4.57u rfmode=0
M$46850 VDD \$3534 \$3535 VDD sg13_lv_pmos L=0.13u W=0.42u AS=0.1428p
+ AD=0.0798p PS=1.52u PD=0.8u rfmode=0
M$46851 VDD VDD \$3535 VDD sg13_lv_pmos L=0.13u W=0.42u AS=0.3623875p
+ AD=0.0798p PS=2.605u PD=0.8u rfmode=0
M$46852 VDD \$3615 \$3445 VDD sg13_lv_pmos L=0.13u W=1u AS=0.3623875p AD=0.34p
+ PS=2.605u PD=2.68u rfmode=0
M$46853 \$3538 \$3628 \$3660 VDD sg13_lv_pmos L=0.13u W=0.42u AS=0.19115p
+ AD=0.0525p PS=1.565u PD=0.67u rfmode=0
M$46854 \$3660 \$3581 VDD VDD sg13_lv_pmos L=0.13u W=0.42u AS=0.0525p
+ AD=0.25605p PS=0.67u PD=1.935u rfmode=0
M$46855 VDD VDD \$3581 VDD sg13_lv_pmos L=0.13u W=0.42u AS=0.25605p AD=0.0798p
+ PS=1.935u PD=0.8u rfmode=0
M$46856 VDD \$3538 \$3581 VDD sg13_lv_pmos L=0.13u W=0.42u AS=0.2014p
+ AD=0.0798p PS=1.53u PD=0.8u rfmode=0
M$46857 VDD \$3538 \$3488 VDD sg13_lv_pmos L=0.13u W=1u AS=0.2083p AD=0.34p
+ PS=1.5u PD=2.68u rfmode=0
M$46858 VDD \$3538 \$3487 VDD sg13_lv_pmos L=0.13u W=2.24u AS=0.4142p
+ AD=0.4211p PS=3.03u PD=3u rfmode=0
M$46860 \$3445 \$3486 \$3538 VDD sg13_lv_pmos L=0.13u W=1u AS=0.34p AD=0.19115p
+ PS=2.68u PD=1.565u rfmode=0
M$46861 \$3490 \$3198 \$3680 VDD sg13_lv_pmos L=0.13u W=0.84u AS=0.2856p
+ AD=0.1596p PS=2.36u PD=1.22u rfmode=0
M$46862 VDD \$3414 \$3680 VDD sg13_lv_pmos L=0.13u W=0.84u AS=0.2226p
+ AD=0.1596p PS=1.535u PD=1.22u rfmode=0
M$46863 VDD \$3490 \$3491 VDD sg13_lv_pmos L=0.13u W=2.24u AS=0.4746p
+ AD=0.6776p PS=3.105u PD=4.57u rfmode=0
M$46865 VDD \$3540 \$3541 VDD sg13_lv_pmos L=0.13u W=0.42u AS=0.1428p
+ AD=0.0798p PS=1.52u PD=0.8u rfmode=0
M$46866 VDD VDD \$3541 VDD sg13_lv_pmos L=0.13u W=0.42u AS=0.3623875p
+ AD=0.0798p PS=2.605u PD=0.8u rfmode=0
M$46867 VDD \$3616 \$3446 VDD sg13_lv_pmos L=0.13u W=1u AS=0.3623875p AD=0.34p
+ PS=2.605u PD=2.68u rfmode=0
M$46868 \$3544 \$3630 \$3665 VDD sg13_lv_pmos L=0.13u W=0.42u AS=0.19115p
+ AD=0.0525p PS=1.565u PD=0.67u rfmode=0
M$46869 \$3665 \$3582 VDD VDD sg13_lv_pmos L=0.13u W=0.42u AS=0.0525p
+ AD=0.25605p PS=0.67u PD=1.935u rfmode=0
M$46870 VDD VDD \$3582 VDD sg13_lv_pmos L=0.13u W=0.42u AS=0.25605p AD=0.0798p
+ PS=1.935u PD=0.8u rfmode=0
M$46871 VDD \$3544 \$3582 VDD sg13_lv_pmos L=0.13u W=0.42u AS=0.2014p
+ AD=0.0798p PS=1.53u PD=0.8u rfmode=0
M$46872 VDD \$3544 \$3495 VDD sg13_lv_pmos L=0.13u W=1u AS=0.2083p AD=0.34p
+ PS=1.5u PD=2.68u rfmode=0
M$46873 VDD \$3544 \$3494 VDD sg13_lv_pmos L=0.13u W=2.24u AS=0.4142p
+ AD=0.4211p PS=3.03u PD=3u rfmode=0
M$46875 \$3446 \$3493 \$3544 VDD sg13_lv_pmos L=0.13u W=1u AS=0.34p AD=0.19115p
+ PS=2.68u PD=1.565u rfmode=0
M$46876 \$3497 VSS|anode|cathode|vss \$3682 VDD sg13_lv_pmos L=0.13u W=0.84u
+ AS=0.2856p AD=0.1596p PS=2.36u PD=1.22u rfmode=0
M$46877 VDD \$3414 \$3682 VDD sg13_lv_pmos L=0.13u W=0.84u AS=0.2226p
+ AD=0.1596p PS=1.535u PD=1.22u rfmode=0
M$46878 VDD \$3497 \$3498 VDD sg13_lv_pmos L=0.13u W=2.24u AS=0.4746p
+ AD=0.6776p PS=3.105u PD=4.57u rfmode=0
M$46880 VDD \$3546 \$3547 VDD sg13_lv_pmos L=0.13u W=0.42u AS=0.1428p
+ AD=0.0798p PS=1.52u PD=0.8u rfmode=0
M$46881 VDD VDD \$3547 VDD sg13_lv_pmos L=0.13u W=0.42u AS=0.3623875p
+ AD=0.0798p PS=2.605u PD=0.8u rfmode=0
M$46882 VDD \$3617 \$3447 VDD sg13_lv_pmos L=0.13u W=1u AS=0.3623875p AD=0.34p
+ PS=2.605u PD=2.68u rfmode=0
M$46883 \$3550 \$3632 \$3657 VDD sg13_lv_pmos L=0.13u W=0.42u AS=0.19115p
+ AD=0.0525p PS=1.565u PD=0.67u rfmode=0
M$46884 \$3657 \$3583 VDD VDD sg13_lv_pmos L=0.13u W=0.42u AS=0.0525p
+ AD=0.25605p PS=0.67u PD=1.935u rfmode=0
M$46885 VDD VDD \$3583 VDD sg13_lv_pmos L=0.13u W=0.42u AS=0.25605p AD=0.0798p
+ PS=1.935u PD=0.8u rfmode=0
M$46886 VDD \$3550 \$3583 VDD sg13_lv_pmos L=0.13u W=0.42u AS=0.2014p
+ AD=0.0798p PS=1.53u PD=0.8u rfmode=0
M$46887 VDD \$3550 \$3502 VDD sg13_lv_pmos L=0.13u W=1u AS=0.2083p AD=0.34p
+ PS=1.5u PD=2.68u rfmode=0
M$46888 VDD \$3550 \$3501 VDD sg13_lv_pmos L=0.13u W=2.24u AS=0.4142p
+ AD=0.4211p PS=3.03u PD=3u rfmode=0
M$46890 \$3447 \$3500 \$3550 VDD sg13_lv_pmos L=0.13u W=1u AS=0.34p AD=0.19115p
+ PS=2.68u PD=1.565u rfmode=0
M$46891 VDD X8|dout[9] \$3688 VDD sg13_lv_pmos L=0.13u W=0.84u AS=0.2856p
+ AD=0.1596p PS=2.36u PD=1.22u rfmode=0
M$46892 VDD X9|dout[10] \$3688 VDD sg13_lv_pmos L=0.13u W=0.84u AS=0.1918p
+ AD=0.1596p PS=1.5u PD=1.22u rfmode=0
M$46893 VDD \$3688 \$3684 VDD sg13_lv_pmos L=0.13u W=2.24u AS=0.4046p
+ AD=0.6384p PS=3u PD=4.5u rfmode=0
M$46895 VDD X10|dout[11] \$3689 VDD sg13_lv_pmos L=0.13u W=0.84u AS=0.2856p
+ AD=0.1596p PS=2.36u PD=1.22u rfmode=0
M$46896 VDD \$3684 \$3689 VDD sg13_lv_pmos L=0.13u W=0.84u AS=0.1918p
+ AD=0.1596p PS=1.5u PD=1.22u rfmode=0
M$46897 VDD \$3689 \$3685 VDD sg13_lv_pmos L=0.13u W=2.24u AS=0.4046p
+ AD=0.6384p PS=3u PD=4.5u rfmode=0
M$46899 VDD \$3752 \$3802 VDD sg13_lv_pmos L=0.13u W=2.24u AS=0.616p AD=0.4312p
+ PS=4.46u PD=3.01u rfmode=0
M$46901 VDD \$3414 \$3802 VDD sg13_lv_pmos L=0.13u W=2.24u AS=0.4312p
+ AD=0.6048p PS=3.01u PD=4.44u rfmode=0
M$46903 VDD \$3802 \$3803 VDD sg13_lv_pmos L=0.13u W=0.42u AS=0.1428p
+ AD=0.0798p PS=1.52u PD=0.8u rfmode=0
M$46904 VDD VDD \$3803 VDD sg13_lv_pmos L=0.13u W=0.42u AS=0.3623875p
+ AD=0.0798p PS=2.605u PD=0.8u rfmode=0
M$46905 VDD \$3913 \$3753 VDD sg13_lv_pmos L=0.13u W=1u AS=0.3623875p AD=0.34p
+ PS=2.605u PD=2.68u rfmode=0
M$46906 \$3610 VDD VDD VDD sg13_lv_pmos L=0.13u W=0.42u AS=0.147p AD=0.1563p
+ PS=1.54u PD=1.22u rfmode=0
M$46907 VDD \$3440 \$3669 VDD sg13_lv_pmos L=0.13u W=0.42u AS=0.1563p
+ AD=0.0546p PS=1.22u PD=0.68u rfmode=0
M$46908 \$3669 \$3451 \$3610 VDD sg13_lv_pmos L=0.13u W=0.42u AS=0.0546p
+ AD=0.0798p PS=0.68u PD=0.8u rfmode=0
M$46909 \$3610 \$3618 \$3505 VDD sg13_lv_pmos L=0.13u W=0.42u AS=0.0798p
+ AD=0.1428p PS=0.8u PD=1.52u rfmode=0
M$46910 \$3929 \$3754 VDD VDD sg13_lv_pmos L=0.13u W=1.12u AS=0.3864p
+ AD=0.431025p PS=2.93u PD=2.145u rfmode=0
M$46911 VDD CLK|clk|core|fclk_in|p2c|ui_p2c[6] \$3754 VDD sg13_lv_pmos L=0.13u
+ W=1.12u AS=0.431025p AD=0.3808p PS=2.145u PD=2.92u rfmode=0
M$46912 \$3873 \$3929 \$3946 VDD sg13_lv_pmos L=0.13u W=0.42u AS=0.19115p
+ AD=0.0525p PS=1.565u PD=0.67u rfmode=0
M$46913 \$3946 \$3914 VDD VDD sg13_lv_pmos L=0.13u W=0.42u AS=0.0525p
+ AD=0.25605p PS=0.67u PD=1.935u rfmode=0
M$46914 VDD VDD \$3914 VDD sg13_lv_pmos L=0.13u W=0.42u AS=0.25605p AD=0.0798p
+ PS=1.935u PD=0.8u rfmode=0
M$46915 VDD \$3873 \$3914 VDD sg13_lv_pmos L=0.13u W=0.42u AS=0.2014p
+ AD=0.0798p PS=1.53u PD=0.8u rfmode=0
M$46916 VDD \$3873 \$3756 VDD sg13_lv_pmos L=0.13u W=1u AS=0.2083p AD=0.34p
+ PS=1.5u PD=2.68u rfmode=0
M$46917 VDD \$3873 \$3755 VDD sg13_lv_pmos L=0.13u W=2.24u AS=0.4142p
+ AD=0.4211p PS=3.03u PD=3u rfmode=0
M$46919 \$3753 \$3754 \$3873 VDD sg13_lv_pmos L=0.13u W=1u AS=0.34p AD=0.19115p
+ PS=2.68u PD=1.565u rfmode=0
M$46920 VDD \$3756 \$3806 VDD sg13_lv_pmos L=0.13u W=2.24u AS=0.5964p
+ AD=0.5964p PS=4.425u PD=4.425u rfmode=0
M$46922 VDD \$3758 \$3809 VDD sg13_lv_pmos L=0.13u W=2.24u AS=0.616p AD=0.4312p
+ PS=4.46u PD=3.01u rfmode=0
M$46924 VDD \$3414 \$3809 VDD sg13_lv_pmos L=0.13u W=2.24u AS=0.4312p
+ AD=0.6048p PS=3.01u PD=4.44u rfmode=0
M$46926 VDD \$3809 \$3810 VDD sg13_lv_pmos L=0.13u W=0.42u AS=0.1428p
+ AD=0.0798p PS=1.52u PD=0.8u rfmode=0
M$46927 VDD VDD \$3810 VDD sg13_lv_pmos L=0.13u W=0.42u AS=0.3623875p
+ AD=0.0798p PS=2.605u PD=0.8u rfmode=0
M$46928 VDD \$3915 \$3759 VDD sg13_lv_pmos L=0.13u W=1u AS=0.3623875p AD=0.34p
+ PS=2.605u PD=2.68u rfmode=0
M$46929 \$3611 VDD VDD VDD sg13_lv_pmos L=0.13u W=0.42u AS=0.147p AD=0.1563p
+ PS=1.54u PD=1.22u rfmode=0
M$46930 VDD \$3441 \$3671 VDD sg13_lv_pmos L=0.13u W=0.42u AS=0.1563p
+ AD=0.0546p PS=1.22u PD=0.68u rfmode=0
M$46931 \$3671 \$3458 \$3611 VDD sg13_lv_pmos L=0.13u W=0.42u AS=0.0546p
+ AD=0.0798p PS=0.68u PD=0.8u rfmode=0
M$46932 \$3611 \$3620 \$3511 VDD sg13_lv_pmos L=0.13u W=0.42u AS=0.0798p
+ AD=0.1428p PS=0.8u PD=1.52u rfmode=0
M$46933 \$3931 \$3760 VDD VDD sg13_lv_pmos L=0.13u W=1.12u AS=0.3864p
+ AD=0.431025p PS=2.93u PD=2.145u rfmode=0
M$46934 VDD CLK|clk|core|fclk_in|p2c|ui_p2c[6] \$3760 VDD sg13_lv_pmos L=0.13u
+ W=1.12u AS=0.431025p AD=0.3808p PS=2.145u PD=2.92u rfmode=0
M$46935 \$3874 \$3931 \$3950 VDD sg13_lv_pmos L=0.13u W=0.42u AS=0.19115p
+ AD=0.0525p PS=1.565u PD=0.67u rfmode=0
M$46936 \$3950 \$3916 VDD VDD sg13_lv_pmos L=0.13u W=0.42u AS=0.0525p
+ AD=0.25605p PS=0.67u PD=1.935u rfmode=0
M$46937 VDD VDD \$3916 VDD sg13_lv_pmos L=0.13u W=0.42u AS=0.25605p AD=0.0798p
+ PS=1.935u PD=0.8u rfmode=0
M$46938 VDD \$3874 \$3916 VDD sg13_lv_pmos L=0.13u W=0.42u AS=0.2014p
+ AD=0.0798p PS=1.53u PD=0.8u rfmode=0
M$46939 VDD \$3874 \$3762 VDD sg13_lv_pmos L=0.13u W=1u AS=0.2083p AD=0.34p
+ PS=1.5u PD=2.68u rfmode=0
M$46940 VDD \$3874 \$3761 VDD sg13_lv_pmos L=0.13u W=2.24u AS=0.4142p
+ AD=0.4211p PS=3.03u PD=3u rfmode=0
M$46942 \$3759 \$3760 \$3874 VDD sg13_lv_pmos L=0.13u W=1u AS=0.34p AD=0.19115p
+ PS=2.68u PD=1.565u rfmode=0
M$46943 VDD \$3762 \$3813 VDD sg13_lv_pmos L=0.13u W=2.24u AS=0.5964p
+ AD=0.5964p PS=4.425u PD=4.425u rfmode=0
M$46945 VDD \$3764 \$3816 VDD sg13_lv_pmos L=0.13u W=2.24u AS=0.616p AD=0.4312p
+ PS=4.46u PD=3.01u rfmode=0
M$46947 VDD \$3414 \$3816 VDD sg13_lv_pmos L=0.13u W=2.24u AS=0.4312p
+ AD=0.6048p PS=3.01u PD=4.44u rfmode=0
M$46949 VDD \$3816 \$3817 VDD sg13_lv_pmos L=0.13u W=0.42u AS=0.1428p
+ AD=0.0798p PS=1.52u PD=0.8u rfmode=0
M$46950 VDD VDD \$3817 VDD sg13_lv_pmos L=0.13u W=0.42u AS=0.3623875p
+ AD=0.0798p PS=2.605u PD=0.8u rfmode=0
M$46951 VDD \$3917 \$3765 VDD sg13_lv_pmos L=0.13u W=1u AS=0.3623875p AD=0.34p
+ PS=2.605u PD=2.68u rfmode=0
M$46952 \$3612 VDD VDD VDD sg13_lv_pmos L=0.13u W=0.42u AS=0.147p AD=0.1563p
+ PS=1.54u PD=1.22u rfmode=0
M$46953 VDD \$3442 \$3673 VDD sg13_lv_pmos L=0.13u W=0.42u AS=0.1563p
+ AD=0.0546p PS=1.22u PD=0.68u rfmode=0
M$46954 \$3673 \$3465 \$3612 VDD sg13_lv_pmos L=0.13u W=0.42u AS=0.0546p
+ AD=0.0798p PS=0.68u PD=0.8u rfmode=0
M$46955 \$3612 \$3622 \$3517 VDD sg13_lv_pmos L=0.13u W=0.42u AS=0.0798p
+ AD=0.1428p PS=0.8u PD=1.52u rfmode=0
M$46956 \$3933 \$3766 VDD VDD sg13_lv_pmos L=0.13u W=1.12u AS=0.3864p
+ AD=0.431025p PS=2.93u PD=2.145u rfmode=0
M$46957 VDD CLK|clk|core|fclk_in|p2c|ui_p2c[6] \$3766 VDD sg13_lv_pmos L=0.13u
+ W=1.12u AS=0.431025p AD=0.3808p PS=2.145u PD=2.92u rfmode=0
M$46958 \$3875 \$3933 \$3956 VDD sg13_lv_pmos L=0.13u W=0.42u AS=0.19115p
+ AD=0.0525p PS=1.565u PD=0.67u rfmode=0
M$46959 \$3956 \$3918 VDD VDD sg13_lv_pmos L=0.13u W=0.42u AS=0.0525p
+ AD=0.25605p PS=0.67u PD=1.935u rfmode=0
M$46960 VDD VDD \$3918 VDD sg13_lv_pmos L=0.13u W=0.42u AS=0.25605p AD=0.0798p
+ PS=1.935u PD=0.8u rfmode=0
M$46961 VDD \$3875 \$3918 VDD sg13_lv_pmos L=0.13u W=0.42u AS=0.2014p
+ AD=0.0798p PS=1.53u PD=0.8u rfmode=0
M$46962 VDD \$3875 \$3768 VDD sg13_lv_pmos L=0.13u W=1u AS=0.2083p AD=0.34p
+ PS=1.5u PD=2.68u rfmode=0
M$46963 VDD \$3875 \$3767 VDD sg13_lv_pmos L=0.13u W=2.24u AS=0.4142p
+ AD=0.4211p PS=3.03u PD=3u rfmode=0
M$46965 \$3765 \$3766 \$3875 VDD sg13_lv_pmos L=0.13u W=1u AS=0.34p AD=0.19115p
+ PS=2.68u PD=1.565u rfmode=0
M$46966 VDD \$3768 \$3820 VDD sg13_lv_pmos L=0.13u W=2.24u AS=0.5964p
+ AD=0.5964p PS=4.425u PD=4.425u rfmode=0
M$46968 VDD \$3770 \$3823 VDD sg13_lv_pmos L=0.13u W=2.24u AS=0.616p AD=0.4312p
+ PS=4.46u PD=3.01u rfmode=0
M$46970 VDD \$3414 \$3823 VDD sg13_lv_pmos L=0.13u W=2.24u AS=0.4312p
+ AD=0.6048p PS=3.01u PD=4.44u rfmode=0
M$46972 VDD \$3823 \$3824 VDD sg13_lv_pmos L=0.13u W=0.42u AS=0.1428p
+ AD=0.0798p PS=1.52u PD=0.8u rfmode=0
M$46973 VDD VDD \$3824 VDD sg13_lv_pmos L=0.13u W=0.42u AS=0.3623875p
+ AD=0.0798p PS=2.605u PD=0.8u rfmode=0
M$46974 VDD \$3919 \$3771 VDD sg13_lv_pmos L=0.13u W=1u AS=0.3623875p AD=0.34p
+ PS=2.605u PD=2.68u rfmode=0
M$46975 \$3613 VDD VDD VDD sg13_lv_pmos L=0.13u W=0.42u AS=0.147p AD=0.1563p
+ PS=1.54u PD=1.22u rfmode=0
M$46976 VDD \$3443 \$3675 VDD sg13_lv_pmos L=0.13u W=0.42u AS=0.1563p
+ AD=0.0546p PS=1.22u PD=0.68u rfmode=0
M$46977 \$3675 \$3472 \$3613 VDD sg13_lv_pmos L=0.13u W=0.42u AS=0.0546p
+ AD=0.0798p PS=0.68u PD=0.8u rfmode=0
M$46978 \$3613 \$3624 \$3523 VDD sg13_lv_pmos L=0.13u W=0.42u AS=0.0798p
+ AD=0.1428p PS=0.8u PD=1.52u rfmode=0
M$46979 \$3935 \$3772 VDD VDD sg13_lv_pmos L=0.13u W=1.12u AS=0.3864p
+ AD=0.431025p PS=2.93u PD=2.145u rfmode=0
M$46980 VDD CLK|clk|core|fclk_in|p2c|ui_p2c[6] \$3772 VDD sg13_lv_pmos L=0.13u
+ W=1.12u AS=0.431025p AD=0.3808p PS=2.145u PD=2.92u rfmode=0
M$46981 \$3876 \$3935 \$3961 VDD sg13_lv_pmos L=0.13u W=0.42u AS=0.19115p
+ AD=0.0525p PS=1.565u PD=0.67u rfmode=0
M$46982 \$3961 \$3920 VDD VDD sg13_lv_pmos L=0.13u W=0.42u AS=0.0525p
+ AD=0.25605p PS=0.67u PD=1.935u rfmode=0
M$46983 VDD VDD \$3920 VDD sg13_lv_pmos L=0.13u W=0.42u AS=0.25605p AD=0.0798p
+ PS=1.935u PD=0.8u rfmode=0
M$46984 VDD \$3876 \$3920 VDD sg13_lv_pmos L=0.13u W=0.42u AS=0.2014p
+ AD=0.0798p PS=1.53u PD=0.8u rfmode=0
M$46985 VDD \$3876 \$3774 VDD sg13_lv_pmos L=0.13u W=1u AS=0.2083p AD=0.34p
+ PS=1.5u PD=2.68u rfmode=0
M$46986 VDD \$3876 \$3773 VDD sg13_lv_pmos L=0.13u W=2.24u AS=0.4142p
+ AD=0.4211p PS=3.03u PD=3u rfmode=0
M$46988 \$3771 \$3772 \$3876 VDD sg13_lv_pmos L=0.13u W=1u AS=0.34p AD=0.19115p
+ PS=2.68u PD=1.565u rfmode=0
M$46989 VDD \$3774 \$3827 VDD sg13_lv_pmos L=0.13u W=2.24u AS=0.5964p
+ AD=0.5964p PS=4.425u PD=4.425u rfmode=0
M$46991 VDD \$3776 \$3830 VDD sg13_lv_pmos L=0.13u W=2.24u AS=0.616p AD=0.4312p
+ PS=4.46u PD=3.01u rfmode=0
M$46993 VDD \$3414 \$3830 VDD sg13_lv_pmos L=0.13u W=2.24u AS=0.4312p
+ AD=0.6048p PS=3.01u PD=4.44u rfmode=0
M$46995 VDD \$3830 \$3831 VDD sg13_lv_pmos L=0.13u W=0.42u AS=0.1428p
+ AD=0.0798p PS=1.52u PD=0.8u rfmode=0
M$46996 VDD VDD \$3831 VDD sg13_lv_pmos L=0.13u W=0.42u AS=0.3623875p
+ AD=0.0798p PS=2.605u PD=0.8u rfmode=0
M$46997 VDD \$3921 \$3777 VDD sg13_lv_pmos L=0.13u W=1u AS=0.3623875p AD=0.34p
+ PS=2.605u PD=2.68u rfmode=0
M$46998 \$3614 VDD VDD VDD sg13_lv_pmos L=0.13u W=0.42u AS=0.147p AD=0.1563p
+ PS=1.54u PD=1.22u rfmode=0
M$46999 VDD \$3444 \$3677 VDD sg13_lv_pmos L=0.13u W=0.42u AS=0.1563p
+ AD=0.0546p PS=1.22u PD=0.68u rfmode=0
M$47000 \$3677 \$3479 \$3614 VDD sg13_lv_pmos L=0.13u W=0.42u AS=0.0546p
+ AD=0.0798p PS=0.68u PD=0.8u rfmode=0
M$47001 \$3614 \$3626 \$3529 VDD sg13_lv_pmos L=0.13u W=0.42u AS=0.0798p
+ AD=0.1428p PS=0.8u PD=1.52u rfmode=0
M$47002 \$3937 \$3778 VDD VDD sg13_lv_pmos L=0.13u W=1.12u AS=0.3864p
+ AD=0.431025p PS=2.93u PD=2.145u rfmode=0
M$47003 VDD CLK|clk|core|fclk_in|p2c|ui_p2c[6] \$3778 VDD sg13_lv_pmos L=0.13u
+ W=1.12u AS=0.431025p AD=0.3808p PS=2.145u PD=2.92u rfmode=0
M$47004 \$3877 \$3937 \$3965 VDD sg13_lv_pmos L=0.13u W=0.42u AS=0.19115p
+ AD=0.0525p PS=1.565u PD=0.67u rfmode=0
M$47005 \$3965 \$3922 VDD VDD sg13_lv_pmos L=0.13u W=0.42u AS=0.0525p
+ AD=0.25605p PS=0.67u PD=1.935u rfmode=0
M$47006 VDD VDD \$3922 VDD sg13_lv_pmos L=0.13u W=0.42u AS=0.25605p AD=0.0798p
+ PS=1.935u PD=0.8u rfmode=0
M$47007 VDD \$3877 \$3922 VDD sg13_lv_pmos L=0.13u W=0.42u AS=0.2014p
+ AD=0.0798p PS=1.53u PD=0.8u rfmode=0
M$47008 VDD \$3877 \$3780 VDD sg13_lv_pmos L=0.13u W=1u AS=0.2083p AD=0.34p
+ PS=1.5u PD=2.68u rfmode=0
M$47009 VDD \$3877 \$3779 VDD sg13_lv_pmos L=0.13u W=2.24u AS=0.4142p
+ AD=0.4211p PS=3.03u PD=3u rfmode=0
M$47011 \$3777 \$3778 \$3877 VDD sg13_lv_pmos L=0.13u W=1u AS=0.34p AD=0.19115p
+ PS=2.68u PD=1.565u rfmode=0
M$47012 VDD \$3780 \$3834 VDD sg13_lv_pmos L=0.13u W=2.24u AS=0.5964p
+ AD=0.5964p PS=4.425u PD=4.425u rfmode=0
M$47014 VDD \$3782 \$3837 VDD sg13_lv_pmos L=0.13u W=2.24u AS=0.616p AD=0.4312p
+ PS=4.46u PD=3.01u rfmode=0
M$47016 VDD \$3414 \$3837 VDD sg13_lv_pmos L=0.13u W=2.24u AS=0.4312p
+ AD=0.6048p PS=3.01u PD=4.44u rfmode=0
M$47018 VDD \$3837 \$3838 VDD sg13_lv_pmos L=0.13u W=0.42u AS=0.1428p
+ AD=0.0798p PS=1.52u PD=0.8u rfmode=0
M$47019 VDD VDD \$3838 VDD sg13_lv_pmos L=0.13u W=0.42u AS=0.3623875p
+ AD=0.0798p PS=2.605u PD=0.8u rfmode=0
M$47020 VDD \$3923 \$3783 VDD sg13_lv_pmos L=0.13u W=1u AS=0.3623875p AD=0.34p
+ PS=2.605u PD=2.68u rfmode=0
M$47021 \$3615 VDD VDD VDD sg13_lv_pmos L=0.13u W=0.42u AS=0.147p AD=0.1563p
+ PS=1.54u PD=1.22u rfmode=0
M$47022 VDD \$3445 \$3679 VDD sg13_lv_pmos L=0.13u W=0.42u AS=0.1563p
+ AD=0.0546p PS=1.22u PD=0.68u rfmode=0
M$47023 \$3679 \$3486 \$3615 VDD sg13_lv_pmos L=0.13u W=0.42u AS=0.0546p
+ AD=0.0798p PS=0.68u PD=0.8u rfmode=0
M$47024 \$3615 \$3628 \$3535 VDD sg13_lv_pmos L=0.13u W=0.42u AS=0.0798p
+ AD=0.1428p PS=0.8u PD=1.52u rfmode=0
M$47025 \$3939 \$3784 VDD VDD sg13_lv_pmos L=0.13u W=1.12u AS=0.3864p
+ AD=0.431025p PS=2.93u PD=2.145u rfmode=0
M$47026 VDD CLK|clk|core|fclk_in|p2c|ui_p2c[6] \$3784 VDD sg13_lv_pmos L=0.13u
+ W=1.12u AS=0.431025p AD=0.3808p PS=2.145u PD=2.92u rfmode=0
M$47027 \$3878 \$3939 \$3971 VDD sg13_lv_pmos L=0.13u W=0.42u AS=0.19115p
+ AD=0.0525p PS=1.565u PD=0.67u rfmode=0
M$47028 \$3971 \$3924 VDD VDD sg13_lv_pmos L=0.13u W=0.42u AS=0.0525p
+ AD=0.25605p PS=0.67u PD=1.935u rfmode=0
M$47029 VDD VDD \$3924 VDD sg13_lv_pmos L=0.13u W=0.42u AS=0.25605p AD=0.0798p
+ PS=1.935u PD=0.8u rfmode=0
M$47030 VDD \$3878 \$3924 VDD sg13_lv_pmos L=0.13u W=0.42u AS=0.2014p
+ AD=0.0798p PS=1.53u PD=0.8u rfmode=0
M$47031 VDD \$3878 \$3786 VDD sg13_lv_pmos L=0.13u W=1u AS=0.2083p AD=0.34p
+ PS=1.5u PD=2.68u rfmode=0
M$47032 VDD \$3878 \$3785 VDD sg13_lv_pmos L=0.13u W=2.24u AS=0.4142p
+ AD=0.4211p PS=3.03u PD=3u rfmode=0
M$47034 \$3783 \$3784 \$3878 VDD sg13_lv_pmos L=0.13u W=1u AS=0.34p AD=0.19115p
+ PS=2.68u PD=1.565u rfmode=0
M$47035 VDD \$3786 \$3841 VDD sg13_lv_pmos L=0.13u W=2.24u AS=0.5964p
+ AD=0.5964p PS=4.425u PD=4.425u rfmode=0
M$47037 VDD \$3788 \$3844 VDD sg13_lv_pmos L=0.13u W=2.24u AS=0.616p AD=0.4312p
+ PS=4.46u PD=3.01u rfmode=0
M$47039 VDD \$3414 \$3844 VDD sg13_lv_pmos L=0.13u W=2.24u AS=0.4312p
+ AD=0.6048p PS=3.01u PD=4.44u rfmode=0
M$47041 VDD \$3844 \$3845 VDD sg13_lv_pmos L=0.13u W=0.42u AS=0.1428p
+ AD=0.0798p PS=1.52u PD=0.8u rfmode=0
M$47042 VDD VDD \$3845 VDD sg13_lv_pmos L=0.13u W=0.42u AS=0.3623875p
+ AD=0.0798p PS=2.605u PD=0.8u rfmode=0
M$47043 VDD \$3925 \$3789 VDD sg13_lv_pmos L=0.13u W=1u AS=0.3623875p AD=0.34p
+ PS=2.605u PD=2.68u rfmode=0
M$47044 \$3616 VDD VDD VDD sg13_lv_pmos L=0.13u W=0.42u AS=0.147p AD=0.1563p
+ PS=1.54u PD=1.22u rfmode=0
M$47045 VDD \$3446 \$3681 VDD sg13_lv_pmos L=0.13u W=0.42u AS=0.1563p
+ AD=0.0546p PS=1.22u PD=0.68u rfmode=0
M$47046 \$3681 \$3493 \$3616 VDD sg13_lv_pmos L=0.13u W=0.42u AS=0.0546p
+ AD=0.0798p PS=0.68u PD=0.8u rfmode=0
M$47047 \$3616 \$3630 \$3541 VDD sg13_lv_pmos L=0.13u W=0.42u AS=0.0798p
+ AD=0.1428p PS=0.8u PD=1.52u rfmode=0
M$47048 \$3941 \$3790 VDD VDD sg13_lv_pmos L=0.13u W=1.12u AS=0.3864p
+ AD=0.431025p PS=2.93u PD=2.145u rfmode=0
M$47049 VDD CLK|clk|core|fclk_in|p2c|ui_p2c[6] \$3790 VDD sg13_lv_pmos L=0.13u
+ W=1.12u AS=0.431025p AD=0.3808p PS=2.145u PD=2.92u rfmode=0
M$47050 \$3879 \$3941 \$3976 VDD sg13_lv_pmos L=0.13u W=0.42u AS=0.19115p
+ AD=0.0525p PS=1.565u PD=0.67u rfmode=0
M$47051 \$3976 \$3926 VDD VDD sg13_lv_pmos L=0.13u W=0.42u AS=0.0525p
+ AD=0.25605p PS=0.67u PD=1.935u rfmode=0
M$47052 VDD VDD \$3926 VDD sg13_lv_pmos L=0.13u W=0.42u AS=0.25605p AD=0.0798p
+ PS=1.935u PD=0.8u rfmode=0
M$47053 VDD \$3879 \$3926 VDD sg13_lv_pmos L=0.13u W=0.42u AS=0.2014p
+ AD=0.0798p PS=1.53u PD=0.8u rfmode=0
M$47054 VDD \$3879 \$3792 VDD sg13_lv_pmos L=0.13u W=1u AS=0.2083p AD=0.34p
+ PS=1.5u PD=2.68u rfmode=0
M$47055 VDD \$3879 \$3791 VDD sg13_lv_pmos L=0.13u W=2.24u AS=0.4142p
+ AD=0.4211p PS=3.03u PD=3u rfmode=0
M$47057 \$3789 \$3790 \$3879 VDD sg13_lv_pmos L=0.13u W=1u AS=0.34p AD=0.19115p
+ PS=2.68u PD=1.565u rfmode=0
M$47058 VDD \$3792 \$3848 VDD sg13_lv_pmos L=0.13u W=2.24u AS=0.5964p
+ AD=0.5964p PS=4.425u PD=4.425u rfmode=0
M$47060 VDD \$3794 \$3851 VDD sg13_lv_pmos L=0.13u W=2.24u AS=0.616p AD=0.4312p
+ PS=4.46u PD=3.01u rfmode=0
M$47062 VDD \$3414 \$3851 VDD sg13_lv_pmos L=0.13u W=2.24u AS=0.4312p
+ AD=0.6048p PS=3.01u PD=4.44u rfmode=0
M$47064 VDD \$3851 \$3852 VDD sg13_lv_pmos L=0.13u W=0.42u AS=0.1428p
+ AD=0.0798p PS=1.52u PD=0.8u rfmode=0
M$47065 VDD VDD \$3852 VDD sg13_lv_pmos L=0.13u W=0.42u AS=0.3623875p
+ AD=0.0798p PS=2.605u PD=0.8u rfmode=0
M$47066 VDD \$3927 \$3795 VDD sg13_lv_pmos L=0.13u W=1u AS=0.3623875p AD=0.34p
+ PS=2.605u PD=2.68u rfmode=0
M$47067 \$3617 VDD VDD VDD sg13_lv_pmos L=0.13u W=0.42u AS=0.147p AD=0.1563p
+ PS=1.54u PD=1.22u rfmode=0
M$47068 VDD \$3447 \$3683 VDD sg13_lv_pmos L=0.13u W=0.42u AS=0.1563p
+ AD=0.0546p PS=1.22u PD=0.68u rfmode=0
M$47069 \$3683 \$3500 \$3617 VDD sg13_lv_pmos L=0.13u W=0.42u AS=0.0546p
+ AD=0.0798p PS=0.68u PD=0.8u rfmode=0
M$47070 \$3617 \$3632 \$3547 VDD sg13_lv_pmos L=0.13u W=0.42u AS=0.0798p
+ AD=0.1428p PS=0.8u PD=1.52u rfmode=0
M$47071 \$3943 \$3796 VDD VDD sg13_lv_pmos L=0.13u W=1.12u AS=0.3864p
+ AD=0.431025p PS=2.93u PD=2.145u rfmode=0
M$47072 VDD CLK|clk|core|fclk_in|p2c|ui_p2c[6] \$3796 VDD sg13_lv_pmos L=0.13u
+ W=1.12u AS=0.431025p AD=0.3808p PS=2.145u PD=2.92u rfmode=0
M$47073 \$3880 \$3943 \$3980 VDD sg13_lv_pmos L=0.13u W=0.42u AS=0.19115p
+ AD=0.0525p PS=1.565u PD=0.67u rfmode=0
M$47074 \$3980 \$3928 VDD VDD sg13_lv_pmos L=0.13u W=0.42u AS=0.0525p
+ AD=0.25605p PS=0.67u PD=1.935u rfmode=0
M$47075 VDD VDD \$3928 VDD sg13_lv_pmos L=0.13u W=0.42u AS=0.25605p AD=0.0798p
+ PS=1.935u PD=0.8u rfmode=0
M$47076 VDD \$3880 \$3928 VDD sg13_lv_pmos L=0.13u W=0.42u AS=0.2014p
+ AD=0.0798p PS=1.53u PD=0.8u rfmode=0
M$47077 VDD \$3880 \$3798 VDD sg13_lv_pmos L=0.13u W=1u AS=0.2083p AD=0.34p
+ PS=1.5u PD=2.68u rfmode=0
M$47078 VDD \$3880 \$3797 VDD sg13_lv_pmos L=0.13u W=2.24u AS=0.4142p
+ AD=0.4211p PS=3.03u PD=3u rfmode=0
M$47080 \$3795 \$3796 \$3880 VDD sg13_lv_pmos L=0.13u W=1u AS=0.34p AD=0.19115p
+ PS=2.68u PD=1.565u rfmode=0
M$47081 VDD \$3798 \$3855 VDD sg13_lv_pmos L=0.13u W=2.24u AS=0.5964p
+ AD=0.5964p PS=4.425u PD=4.425u rfmode=0
M$47083 \$3751 \$3192 \$3985 VDD sg13_lv_pmos L=0.13u W=0.84u AS=0.2856p
+ AD=0.1596p PS=2.36u PD=1.22u rfmode=0
M$47084 VDD \$3221 \$3985 VDD sg13_lv_pmos L=0.13u W=0.84u AS=0.2226p
+ AD=0.1596p PS=1.535u PD=1.22u rfmode=0
M$47085 VDD \$3751 \$3752 VDD sg13_lv_pmos L=0.13u W=2.24u AS=0.4746p
+ AD=0.6776p PS=3.105u PD=4.57u rfmode=0
M$47087 VDD \$4046 \$4133 VDD sg13_lv_pmos L=0.13u W=2.24u AS=0.616p AD=0.4312p
+ PS=4.46u PD=3.01u rfmode=0
M$47089 VDD \$3221 \$4133 VDD sg13_lv_pmos L=0.13u W=2.24u AS=0.4312p
+ AD=0.6048p PS=3.01u PD=4.44u rfmode=0
M$47091 \$3913 VDD VDD VDD sg13_lv_pmos L=0.13u W=0.42u AS=0.147p AD=0.1563p
+ PS=1.54u PD=1.22u rfmode=0
M$47092 VDD \$3753 \$3945 VDD sg13_lv_pmos L=0.13u W=0.42u AS=0.1563p
+ AD=0.0546p PS=1.22u PD=0.68u rfmode=0
M$47093 \$3945 \$3754 \$3913 VDD sg13_lv_pmos L=0.13u W=0.42u AS=0.0546p
+ AD=0.0798p PS=0.68u PD=0.8u rfmode=0
M$47094 \$3913 \$3929 \$3803 VDD sg13_lv_pmos L=0.13u W=0.42u AS=0.0798p
+ AD=0.1428p PS=0.8u PD=1.52u rfmode=0
M$47095 \$4134 \$4048 VDD VDD sg13_lv_pmos L=0.13u W=1.12u AS=0.3864p
+ AD=0.431025p PS=2.93u PD=2.145u rfmode=0
M$47096 VDD CLK|clk|core|fclk_in|p2c|ui_p2c[6] \$4048 VDD sg13_lv_pmos L=0.13u
+ W=1.12u AS=0.431025p AD=0.3808p PS=2.145u PD=2.92u rfmode=0
M$47097 VDD \$4082 \$4083 VDD sg13_lv_pmos L=0.13u W=2.24u AS=0.5964p
+ AD=0.5964p PS=4.425u PD=4.425u rfmode=0
M$47099 \$3757 \$3193 \$3986 VDD sg13_lv_pmos L=0.13u W=0.84u AS=0.2856p
+ AD=0.1596p PS=2.36u PD=1.22u rfmode=0
M$47100 VDD \$3221 \$3986 VDD sg13_lv_pmos L=0.13u W=0.84u AS=0.2226p
+ AD=0.1596p PS=1.535u PD=1.22u rfmode=0
M$47101 VDD \$3757 \$3758 VDD sg13_lv_pmos L=0.13u W=2.24u AS=0.4746p
+ AD=0.6776p PS=3.105u PD=4.57u rfmode=0
M$47103 VDD \$4050 \$4137 VDD sg13_lv_pmos L=0.13u W=2.24u AS=0.616p AD=0.4312p
+ PS=4.46u PD=3.01u rfmode=0
M$47105 VDD \$3221 \$4137 VDD sg13_lv_pmos L=0.13u W=2.24u AS=0.4312p
+ AD=0.6048p PS=3.01u PD=4.44u rfmode=0
M$47107 \$3915 VDD VDD VDD sg13_lv_pmos L=0.13u W=0.42u AS=0.147p AD=0.1563p
+ PS=1.54u PD=1.22u rfmode=0
M$47108 VDD \$3759 \$3951 VDD sg13_lv_pmos L=0.13u W=0.42u AS=0.1563p
+ AD=0.0546p PS=1.22u PD=0.68u rfmode=0
M$47109 \$3951 \$3760 \$3915 VDD sg13_lv_pmos L=0.13u W=0.42u AS=0.0546p
+ AD=0.0798p PS=0.68u PD=0.8u rfmode=0
M$47110 \$3915 \$3931 \$3810 VDD sg13_lv_pmos L=0.13u W=0.42u AS=0.0798p
+ AD=0.1428p PS=0.8u PD=1.52u rfmode=0
M$47111 \$4138 \$4052 VDD VDD sg13_lv_pmos L=0.13u W=1.12u AS=0.3864p
+ AD=0.431025p PS=2.93u PD=2.145u rfmode=0
M$47112 VDD CLK|clk|core|fclk_in|p2c|ui_p2c[6] \$4052 VDD sg13_lv_pmos L=0.13u
+ W=1.12u AS=0.431025p AD=0.3808p PS=2.145u PD=2.92u rfmode=0
M$47113 VDD \$4089 \$4090 VDD sg13_lv_pmos L=0.13u W=2.24u AS=0.5964p
+ AD=0.5964p PS=4.425u PD=4.425u rfmode=0
M$47115 \$3763 \$3194 \$3987 VDD sg13_lv_pmos L=0.13u W=0.84u AS=0.2856p
+ AD=0.1596p PS=2.36u PD=1.22u rfmode=0
M$47116 VDD \$3221 \$3987 VDD sg13_lv_pmos L=0.13u W=0.84u AS=0.2226p
+ AD=0.1596p PS=1.535u PD=1.22u rfmode=0
M$47117 VDD \$3763 \$3764 VDD sg13_lv_pmos L=0.13u W=2.24u AS=0.4746p
+ AD=0.6776p PS=3.105u PD=4.57u rfmode=0
M$47119 VDD \$4054 \$4141 VDD sg13_lv_pmos L=0.13u W=2.24u AS=0.616p AD=0.4312p
+ PS=4.46u PD=3.01u rfmode=0
M$47121 VDD \$3221 \$4141 VDD sg13_lv_pmos L=0.13u W=2.24u AS=0.4312p
+ AD=0.6048p PS=3.01u PD=4.44u rfmode=0
M$47123 \$3917 VDD VDD VDD sg13_lv_pmos L=0.13u W=0.42u AS=0.147p AD=0.1563p
+ PS=1.54u PD=1.22u rfmode=0
M$47124 VDD \$3765 \$3955 VDD sg13_lv_pmos L=0.13u W=0.42u AS=0.1563p
+ AD=0.0546p PS=1.22u PD=0.68u rfmode=0
M$47125 \$3955 \$3766 \$3917 VDD sg13_lv_pmos L=0.13u W=0.42u AS=0.0546p
+ AD=0.0798p PS=0.68u PD=0.8u rfmode=0
M$47126 \$3917 \$3933 \$3817 VDD sg13_lv_pmos L=0.13u W=0.42u AS=0.0798p
+ AD=0.1428p PS=0.8u PD=1.52u rfmode=0
M$47127 \$4142 \$4056 VDD VDD sg13_lv_pmos L=0.13u W=1.12u AS=0.3864p
+ AD=0.431025p PS=2.93u PD=2.145u rfmode=0
M$47128 VDD CLK|clk|core|fclk_in|p2c|ui_p2c[6] \$4056 VDD sg13_lv_pmos L=0.13u
+ W=1.12u AS=0.431025p AD=0.3808p PS=2.145u PD=2.92u rfmode=0
M$47129 VDD \$4096 \$4097 VDD sg13_lv_pmos L=0.13u W=2.24u AS=0.5964p
+ AD=0.5964p PS=4.425u PD=4.425u rfmode=0
M$47131 \$3769 \$3195 \$3988 VDD sg13_lv_pmos L=0.13u W=0.84u AS=0.2856p
+ AD=0.1596p PS=2.36u PD=1.22u rfmode=0
M$47132 VDD \$3221 \$3988 VDD sg13_lv_pmos L=0.13u W=0.84u AS=0.2226p
+ AD=0.1596p PS=1.535u PD=1.22u rfmode=0
M$47133 VDD \$3769 \$3770 VDD sg13_lv_pmos L=0.13u W=2.24u AS=0.4746p
+ AD=0.6776p PS=3.105u PD=4.57u rfmode=0
M$47135 VDD \$4058 \$4145 VDD sg13_lv_pmos L=0.13u W=2.24u AS=0.616p AD=0.4312p
+ PS=4.46u PD=3.01u rfmode=0
M$47137 VDD \$3221 \$4145 VDD sg13_lv_pmos L=0.13u W=2.24u AS=0.4312p
+ AD=0.6048p PS=3.01u PD=4.44u rfmode=0
M$47139 \$3919 VDD VDD VDD sg13_lv_pmos L=0.13u W=0.42u AS=0.147p AD=0.1563p
+ PS=1.54u PD=1.22u rfmode=0
M$47140 VDD \$3771 \$3960 VDD sg13_lv_pmos L=0.13u W=0.42u AS=0.1563p
+ AD=0.0546p PS=1.22u PD=0.68u rfmode=0
M$47141 \$3960 \$3772 \$3919 VDD sg13_lv_pmos L=0.13u W=0.42u AS=0.0546p
+ AD=0.0798p PS=0.68u PD=0.8u rfmode=0
M$47142 \$3919 \$3935 \$3824 VDD sg13_lv_pmos L=0.13u W=0.42u AS=0.0798p
+ AD=0.1428p PS=0.8u PD=1.52u rfmode=0
M$47143 \$4146 \$4060 VDD VDD sg13_lv_pmos L=0.13u W=1.12u AS=0.3864p
+ AD=0.431025p PS=2.93u PD=2.145u rfmode=0
M$47144 VDD CLK|clk|core|fclk_in|p2c|ui_p2c[6] \$4060 VDD sg13_lv_pmos L=0.13u
+ W=1.12u AS=0.431025p AD=0.3808p PS=2.145u PD=2.92u rfmode=0
M$47145 VDD \$4103 \$4104 VDD sg13_lv_pmos L=0.13u W=2.24u AS=0.5964p
+ AD=0.5964p PS=4.425u PD=4.425u rfmode=0
M$47147 \$3775 \$3196 \$3989 VDD sg13_lv_pmos L=0.13u W=0.84u AS=0.2856p
+ AD=0.1596p PS=2.36u PD=1.22u rfmode=0
M$47148 VDD \$3221 \$3989 VDD sg13_lv_pmos L=0.13u W=0.84u AS=0.2226p
+ AD=0.1596p PS=1.535u PD=1.22u rfmode=0
M$47149 VDD \$3775 \$3776 VDD sg13_lv_pmos L=0.13u W=2.24u AS=0.4746p
+ AD=0.6776p PS=3.105u PD=4.57u rfmode=0
M$47151 VDD \$4062 \$4149 VDD sg13_lv_pmos L=0.13u W=2.24u AS=0.616p AD=0.4312p
+ PS=4.46u PD=3.01u rfmode=0
M$47153 VDD \$3221 \$4149 VDD sg13_lv_pmos L=0.13u W=2.24u AS=0.4312p
+ AD=0.6048p PS=3.01u PD=4.44u rfmode=0
M$47155 \$3921 VDD VDD VDD sg13_lv_pmos L=0.13u W=0.42u AS=0.147p AD=0.1563p
+ PS=1.54u PD=1.22u rfmode=0
M$47156 VDD \$3777 \$3966 VDD sg13_lv_pmos L=0.13u W=0.42u AS=0.1563p
+ AD=0.0546p PS=1.22u PD=0.68u rfmode=0
M$47157 \$3966 \$3778 \$3921 VDD sg13_lv_pmos L=0.13u W=0.42u AS=0.0546p
+ AD=0.0798p PS=0.68u PD=0.8u rfmode=0
M$47158 \$3921 \$3937 \$3831 VDD sg13_lv_pmos L=0.13u W=0.42u AS=0.0798p
+ AD=0.1428p PS=0.8u PD=1.52u rfmode=0
M$47159 \$4150 \$4064 VDD VDD sg13_lv_pmos L=0.13u W=1.12u AS=0.3864p
+ AD=0.431025p PS=2.93u PD=2.145u rfmode=0
M$47160 VDD CLK|clk|core|fclk_in|p2c|ui_p2c[6] \$4064 VDD sg13_lv_pmos L=0.13u
+ W=1.12u AS=0.431025p AD=0.3808p PS=2.145u PD=2.92u rfmode=0
M$47161 VDD \$4110 \$4111 VDD sg13_lv_pmos L=0.13u W=2.24u AS=0.5964p
+ AD=0.5964p PS=4.425u PD=4.425u rfmode=0
M$47163 \$3781 \$3197 \$3990 VDD sg13_lv_pmos L=0.13u W=0.84u AS=0.2856p
+ AD=0.1596p PS=2.36u PD=1.22u rfmode=0
M$47164 VDD \$3221 \$3990 VDD sg13_lv_pmos L=0.13u W=0.84u AS=0.2226p
+ AD=0.1596p PS=1.535u PD=1.22u rfmode=0
M$47165 VDD \$3781 \$3782 VDD sg13_lv_pmos L=0.13u W=2.24u AS=0.4746p
+ AD=0.6776p PS=3.105u PD=4.57u rfmode=0
M$47167 VDD \$4066 \$4153 VDD sg13_lv_pmos L=0.13u W=2.24u AS=0.616p AD=0.4312p
+ PS=4.46u PD=3.01u rfmode=0
M$47169 VDD \$3221 \$4153 VDD sg13_lv_pmos L=0.13u W=2.24u AS=0.4312p
+ AD=0.6048p PS=3.01u PD=4.44u rfmode=0
M$47171 \$3923 VDD VDD VDD sg13_lv_pmos L=0.13u W=0.42u AS=0.147p AD=0.1563p
+ PS=1.54u PD=1.22u rfmode=0
M$47172 VDD \$3783 \$3970 VDD sg13_lv_pmos L=0.13u W=0.42u AS=0.1563p
+ AD=0.0546p PS=1.22u PD=0.68u rfmode=0
M$47173 \$3970 \$3784 \$3923 VDD sg13_lv_pmos L=0.13u W=0.42u AS=0.0546p
+ AD=0.0798p PS=0.68u PD=0.8u rfmode=0
M$47174 \$3923 \$3939 \$3838 VDD sg13_lv_pmos L=0.13u W=0.42u AS=0.0798p
+ AD=0.1428p PS=0.8u PD=1.52u rfmode=0
M$47175 \$4154 \$4068 VDD VDD sg13_lv_pmos L=0.13u W=1.12u AS=0.3864p
+ AD=0.431025p PS=2.93u PD=2.145u rfmode=0
M$47176 VDD CLK|clk|core|fclk_in|p2c|ui_p2c[6] \$4068 VDD sg13_lv_pmos L=0.13u
+ W=1.12u AS=0.431025p AD=0.3808p PS=2.145u PD=2.92u rfmode=0
M$47177 VDD \$4117 \$4118 VDD sg13_lv_pmos L=0.13u W=2.24u AS=0.5964p
+ AD=0.5964p PS=4.425u PD=4.425u rfmode=0
M$47179 \$3787 \$3198 \$3991 VDD sg13_lv_pmos L=0.13u W=0.84u AS=0.2856p
+ AD=0.1596p PS=2.36u PD=1.22u rfmode=0
M$47180 VDD \$3221 \$3991 VDD sg13_lv_pmos L=0.13u W=0.84u AS=0.2226p
+ AD=0.1596p PS=1.535u PD=1.22u rfmode=0
M$47181 VDD \$3787 \$3788 VDD sg13_lv_pmos L=0.13u W=2.24u AS=0.4746p
+ AD=0.6776p PS=3.105u PD=4.57u rfmode=0
M$47183 VDD \$4070 \$4157 VDD sg13_lv_pmos L=0.13u W=2.24u AS=0.616p AD=0.4312p
+ PS=4.46u PD=3.01u rfmode=0
M$47185 VDD \$3221 \$4157 VDD sg13_lv_pmos L=0.13u W=2.24u AS=0.4312p
+ AD=0.6048p PS=3.01u PD=4.44u rfmode=0
M$47187 \$3925 VDD VDD VDD sg13_lv_pmos L=0.13u W=0.42u AS=0.147p AD=0.1563p
+ PS=1.54u PD=1.22u rfmode=0
M$47188 VDD \$3789 \$3975 VDD sg13_lv_pmos L=0.13u W=0.42u AS=0.1563p
+ AD=0.0546p PS=1.22u PD=0.68u rfmode=0
M$47189 \$3975 \$3790 \$3925 VDD sg13_lv_pmos L=0.13u W=0.42u AS=0.0546p
+ AD=0.0798p PS=0.68u PD=0.8u rfmode=0
M$47190 \$3925 \$3941 \$3845 VDD sg13_lv_pmos L=0.13u W=0.42u AS=0.0798p
+ AD=0.1428p PS=0.8u PD=1.52u rfmode=0
M$47191 \$4158 \$4072 VDD VDD sg13_lv_pmos L=0.13u W=1.12u AS=0.3864p
+ AD=0.431025p PS=2.93u PD=2.145u rfmode=0
M$47192 VDD CLK|clk|core|fclk_in|p2c|ui_p2c[6] \$4072 VDD sg13_lv_pmos L=0.13u
+ W=1.12u AS=0.431025p AD=0.3808p PS=2.145u PD=2.92u rfmode=0
M$47193 VDD \$4124 \$4125 VDD sg13_lv_pmos L=0.13u W=2.24u AS=0.5964p
+ AD=0.5964p PS=4.425u PD=4.425u rfmode=0
M$47195 \$3793 VSS|anode|cathode|vss \$3992 VDD sg13_lv_pmos L=0.13u W=0.84u
+ AS=0.2856p AD=0.1596p PS=2.36u PD=1.22u rfmode=0
M$47196 VDD \$3221 \$3992 VDD sg13_lv_pmos L=0.13u W=0.84u AS=0.2226p
+ AD=0.1596p PS=1.535u PD=1.22u rfmode=0
M$47197 VDD \$3793 \$3794 VDD sg13_lv_pmos L=0.13u W=2.24u AS=0.4746p
+ AD=0.6776p PS=3.105u PD=4.57u rfmode=0
M$47199 VDD \$4074 \$4161 VDD sg13_lv_pmos L=0.13u W=2.24u AS=0.616p AD=0.4312p
+ PS=4.46u PD=3.01u rfmode=0
M$47201 VDD \$3221 \$4161 VDD sg13_lv_pmos L=0.13u W=2.24u AS=0.4312p
+ AD=0.6048p PS=3.01u PD=4.44u rfmode=0
M$47203 \$3927 VDD VDD VDD sg13_lv_pmos L=0.13u W=0.42u AS=0.147p AD=0.1563p
+ PS=1.54u PD=1.22u rfmode=0
M$47204 VDD \$3795 \$3981 VDD sg13_lv_pmos L=0.13u W=0.42u AS=0.1563p
+ AD=0.0546p PS=1.22u PD=0.68u rfmode=0
M$47205 \$3981 \$3796 \$3927 VDD sg13_lv_pmos L=0.13u W=0.42u AS=0.0546p
+ AD=0.0798p PS=0.68u PD=0.8u rfmode=0
M$47206 \$3927 \$3943 \$3852 VDD sg13_lv_pmos L=0.13u W=0.42u AS=0.0798p
+ AD=0.1428p PS=0.8u PD=1.52u rfmode=0
M$47207 \$4162 \$4076 VDD VDD sg13_lv_pmos L=0.13u W=1.12u AS=0.3864p
+ AD=0.431025p PS=2.93u PD=2.145u rfmode=0
M$47208 VDD CLK|clk|core|fclk_in|p2c|ui_p2c[6] \$4076 VDD sg13_lv_pmos L=0.13u
+ W=1.12u AS=0.431025p AD=0.3808p PS=2.145u PD=2.92u rfmode=0
M$47209 VDD \$4131 \$4132 VDD sg13_lv_pmos L=0.13u W=2.24u AS=0.5964p
+ AD=0.5964p PS=4.425u PD=4.425u rfmode=0
M$47211 \$4045 \$3192 \$4271 VDD sg13_lv_pmos L=0.13u W=0.84u AS=0.2856p
+ AD=0.1596p PS=2.36u PD=1.22u rfmode=0
M$47212 VDD \$2935 \$4271 VDD sg13_lv_pmos L=0.13u W=0.84u AS=0.2226p
+ AD=0.1596p PS=1.535u PD=1.22u rfmode=0
M$47213 VDD \$4045 \$4046 VDD sg13_lv_pmos L=0.13u W=2.24u AS=0.4746p
+ AD=0.6776p PS=3.105u PD=4.57u rfmode=0
M$47215 VDD \$4133 \$4078 VDD sg13_lv_pmos L=0.13u W=0.42u AS=0.1428p
+ AD=0.0798p PS=1.52u PD=0.8u rfmode=0
M$47216 VDD VDD \$4078 VDD sg13_lv_pmos L=0.13u W=0.42u AS=0.3623875p
+ AD=0.0798p PS=2.605u PD=0.8u rfmode=0
M$47217 VDD \$4213 \$4047 VDD sg13_lv_pmos L=0.13u W=1u AS=0.3623875p AD=0.34p
+ PS=2.605u PD=2.68u rfmode=0
M$47218 \$4135 \$4134 \$4239 VDD sg13_lv_pmos L=0.13u W=0.42u AS=0.19115p
+ AD=0.0525p PS=1.565u PD=0.67u rfmode=0
M$47219 \$4239 \$4214 VDD VDD sg13_lv_pmos L=0.13u W=0.42u AS=0.0525p
+ AD=0.25605p PS=0.67u PD=1.935u rfmode=0
M$47220 VDD VDD \$4214 VDD sg13_lv_pmos L=0.13u W=0.42u AS=0.25605p AD=0.0798p
+ PS=1.935u PD=0.8u rfmode=0
M$47221 VDD \$4135 \$4214 VDD sg13_lv_pmos L=0.13u W=0.42u AS=0.2014p
+ AD=0.0798p PS=1.53u PD=0.8u rfmode=0
M$47222 VDD \$4135 \$4082 VDD sg13_lv_pmos L=0.13u W=1u AS=0.2083p AD=0.34p
+ PS=1.5u PD=2.68u rfmode=0
M$47223 VDD \$4135 \$4081 VDD sg13_lv_pmos L=0.13u W=2.24u AS=0.4142p
+ AD=0.4211p PS=3.03u PD=3u rfmode=0
M$47225 \$4047 \$4048 \$4135 VDD sg13_lv_pmos L=0.13u W=1u AS=0.34p AD=0.19115p
+ PS=2.68u PD=1.565u rfmode=0
M$47226 \$4049 \$3193 \$4273 VDD sg13_lv_pmos L=0.13u W=0.84u AS=0.2856p
+ AD=0.1596p PS=2.36u PD=1.22u rfmode=0
M$47227 VDD \$2935 \$4273 VDD sg13_lv_pmos L=0.13u W=0.84u AS=0.2226p
+ AD=0.1596p PS=1.535u PD=1.22u rfmode=0
M$47228 VDD \$4049 \$4050 VDD sg13_lv_pmos L=0.13u W=2.24u AS=0.4746p
+ AD=0.6776p PS=3.105u PD=4.57u rfmode=0
M$47230 VDD \$4137 \$4085 VDD sg13_lv_pmos L=0.13u W=0.42u AS=0.1428p
+ AD=0.0798p PS=1.52u PD=0.8u rfmode=0
M$47231 VDD VDD \$4085 VDD sg13_lv_pmos L=0.13u W=0.42u AS=0.3623875p
+ AD=0.0798p PS=2.605u PD=0.8u rfmode=0
M$47232 VDD \$4215 \$4051 VDD sg13_lv_pmos L=0.13u W=1u AS=0.3623875p AD=0.34p
+ PS=2.605u PD=2.68u rfmode=0
M$47233 \$4139 \$4138 \$4243 VDD sg13_lv_pmos L=0.13u W=0.42u AS=0.19115p
+ AD=0.0525p PS=1.565u PD=0.67u rfmode=0
M$47234 \$4243 \$4216 VDD VDD sg13_lv_pmos L=0.13u W=0.42u AS=0.0525p
+ AD=0.25605p PS=0.67u PD=1.935u rfmode=0
M$47235 VDD VDD \$4216 VDD sg13_lv_pmos L=0.13u W=0.42u AS=0.25605p AD=0.0798p
+ PS=1.935u PD=0.8u rfmode=0
M$47236 VDD \$4139 \$4216 VDD sg13_lv_pmos L=0.13u W=0.42u AS=0.2014p
+ AD=0.0798p PS=1.53u PD=0.8u rfmode=0
M$47237 VDD \$4139 \$4089 VDD sg13_lv_pmos L=0.13u W=1u AS=0.2083p AD=0.34p
+ PS=1.5u PD=2.68u rfmode=0
M$47238 VDD \$4139 \$4088 VDD sg13_lv_pmos L=0.13u W=2.24u AS=0.4142p
+ AD=0.4211p PS=3.03u PD=3u rfmode=0
M$47240 \$4051 \$4052 \$4139 VDD sg13_lv_pmos L=0.13u W=1u AS=0.34p AD=0.19115p
+ PS=2.68u PD=1.565u rfmode=0
M$47241 \$4053 \$3194 \$4275 VDD sg13_lv_pmos L=0.13u W=0.84u AS=0.2856p
+ AD=0.1596p PS=2.36u PD=1.22u rfmode=0
M$47242 VDD \$2935 \$4275 VDD sg13_lv_pmos L=0.13u W=0.84u AS=0.2226p
+ AD=0.1596p PS=1.535u PD=1.22u rfmode=0
M$47243 VDD \$4053 \$4054 VDD sg13_lv_pmos L=0.13u W=2.24u AS=0.4746p
+ AD=0.6776p PS=3.105u PD=4.57u rfmode=0
M$47245 VDD \$4141 \$4092 VDD sg13_lv_pmos L=0.13u W=0.42u AS=0.1428p
+ AD=0.0798p PS=1.52u PD=0.8u rfmode=0
M$47246 VDD VDD \$4092 VDD sg13_lv_pmos L=0.13u W=0.42u AS=0.3623875p
+ AD=0.0798p PS=2.605u PD=0.8u rfmode=0
M$47247 VDD \$4217 \$4055 VDD sg13_lv_pmos L=0.13u W=1u AS=0.3623875p AD=0.34p
+ PS=2.605u PD=2.68u rfmode=0
M$47248 \$4143 \$4142 \$4247 VDD sg13_lv_pmos L=0.13u W=0.42u AS=0.19115p
+ AD=0.0525p PS=1.565u PD=0.67u rfmode=0
M$47249 \$4247 \$4218 VDD VDD sg13_lv_pmos L=0.13u W=0.42u AS=0.0525p
+ AD=0.25605p PS=0.67u PD=1.935u rfmode=0
M$47250 VDD VDD \$4218 VDD sg13_lv_pmos L=0.13u W=0.42u AS=0.25605p AD=0.0798p
+ PS=1.935u PD=0.8u rfmode=0
M$47251 VDD \$4143 \$4218 VDD sg13_lv_pmos L=0.13u W=0.42u AS=0.2014p
+ AD=0.0798p PS=1.53u PD=0.8u rfmode=0
M$47252 VDD \$4143 \$4096 VDD sg13_lv_pmos L=0.13u W=1u AS=0.2083p AD=0.34p
+ PS=1.5u PD=2.68u rfmode=0
M$47253 VDD \$4143 \$4095 VDD sg13_lv_pmos L=0.13u W=2.24u AS=0.4142p
+ AD=0.4211p PS=3.03u PD=3u rfmode=0
M$47255 \$4055 \$4056 \$4143 VDD sg13_lv_pmos L=0.13u W=1u AS=0.34p AD=0.19115p
+ PS=2.68u PD=1.565u rfmode=0
M$47256 \$4057 \$3195 \$4278 VDD sg13_lv_pmos L=0.13u W=0.84u AS=0.2856p
+ AD=0.1596p PS=2.36u PD=1.22u rfmode=0
M$47257 VDD \$2935 \$4278 VDD sg13_lv_pmos L=0.13u W=0.84u AS=0.2226p
+ AD=0.1596p PS=1.535u PD=1.22u rfmode=0
M$47258 VDD \$4057 \$4058 VDD sg13_lv_pmos L=0.13u W=2.24u AS=0.4746p
+ AD=0.6776p PS=3.105u PD=4.57u rfmode=0
M$47260 VDD \$4145 \$4099 VDD sg13_lv_pmos L=0.13u W=0.42u AS=0.1428p
+ AD=0.0798p PS=1.52u PD=0.8u rfmode=0
M$47261 VDD VDD \$4099 VDD sg13_lv_pmos L=0.13u W=0.42u AS=0.3623875p
+ AD=0.0798p PS=2.605u PD=0.8u rfmode=0
M$47262 VDD \$4219 \$4059 VDD sg13_lv_pmos L=0.13u W=1u AS=0.3623875p AD=0.34p
+ PS=2.605u PD=2.68u rfmode=0
M$47263 \$4147 \$4146 \$4251 VDD sg13_lv_pmos L=0.13u W=0.42u AS=0.19115p
+ AD=0.0525p PS=1.565u PD=0.67u rfmode=0
M$47264 \$4251 \$4220 VDD VDD sg13_lv_pmos L=0.13u W=0.42u AS=0.0525p
+ AD=0.25605p PS=0.67u PD=1.935u rfmode=0
M$47265 VDD VDD \$4220 VDD sg13_lv_pmos L=0.13u W=0.42u AS=0.25605p AD=0.0798p
+ PS=1.935u PD=0.8u rfmode=0
M$47266 VDD \$4147 \$4220 VDD sg13_lv_pmos L=0.13u W=0.42u AS=0.2014p
+ AD=0.0798p PS=1.53u PD=0.8u rfmode=0
M$47267 VDD \$4147 \$4103 VDD sg13_lv_pmos L=0.13u W=1u AS=0.2083p AD=0.34p
+ PS=1.5u PD=2.68u rfmode=0
M$47268 VDD \$4147 \$4102 VDD sg13_lv_pmos L=0.13u W=2.24u AS=0.4142p
+ AD=0.4211p PS=3.03u PD=3u rfmode=0
M$47270 \$4059 \$4060 \$4147 VDD sg13_lv_pmos L=0.13u W=1u AS=0.34p AD=0.19115p
+ PS=2.68u PD=1.565u rfmode=0
M$47271 \$4061 \$3196 \$4279 VDD sg13_lv_pmos L=0.13u W=0.84u AS=0.2856p
+ AD=0.1596p PS=2.36u PD=1.22u rfmode=0
M$47272 VDD \$2935 \$4279 VDD sg13_lv_pmos L=0.13u W=0.84u AS=0.2226p
+ AD=0.1596p PS=1.535u PD=1.22u rfmode=0
M$47273 VDD \$4061 \$4062 VDD sg13_lv_pmos L=0.13u W=2.24u AS=0.4746p
+ AD=0.6776p PS=3.105u PD=4.57u rfmode=0
M$47275 VDD \$4149 \$4106 VDD sg13_lv_pmos L=0.13u W=0.42u AS=0.1428p
+ AD=0.0798p PS=1.52u PD=0.8u rfmode=0
M$47276 VDD VDD \$4106 VDD sg13_lv_pmos L=0.13u W=0.42u AS=0.3623875p
+ AD=0.0798p PS=2.605u PD=0.8u rfmode=0
M$47277 VDD \$4221 \$4063 VDD sg13_lv_pmos L=0.13u W=1u AS=0.3623875p AD=0.34p
+ PS=2.605u PD=2.68u rfmode=0
M$47278 \$4151 \$4150 \$4258 VDD sg13_lv_pmos L=0.13u W=0.42u AS=0.19115p
+ AD=0.0525p PS=1.565u PD=0.67u rfmode=0
M$47279 \$4258 \$4222 VDD VDD sg13_lv_pmos L=0.13u W=0.42u AS=0.0525p
+ AD=0.25605p PS=0.67u PD=1.935u rfmode=0
M$47280 VDD VDD \$4222 VDD sg13_lv_pmos L=0.13u W=0.42u AS=0.25605p AD=0.0798p
+ PS=1.935u PD=0.8u rfmode=0
M$47281 VDD \$4151 \$4222 VDD sg13_lv_pmos L=0.13u W=0.42u AS=0.2014p
+ AD=0.0798p PS=1.53u PD=0.8u rfmode=0
M$47282 VDD \$4151 \$4110 VDD sg13_lv_pmos L=0.13u W=1u AS=0.2083p AD=0.34p
+ PS=1.5u PD=2.68u rfmode=0
M$47283 VDD \$4151 \$4109 VDD sg13_lv_pmos L=0.13u W=2.24u AS=0.4142p
+ AD=0.4211p PS=3.03u PD=3u rfmode=0
M$47285 \$4063 \$4064 \$4151 VDD sg13_lv_pmos L=0.13u W=1u AS=0.34p AD=0.19115p
+ PS=2.68u PD=1.565u rfmode=0
M$47286 \$4065 \$3197 \$4281 VDD sg13_lv_pmos L=0.13u W=0.84u AS=0.2856p
+ AD=0.1596p PS=2.36u PD=1.22u rfmode=0
M$47287 VDD \$2935 \$4281 VDD sg13_lv_pmos L=0.13u W=0.84u AS=0.2226p
+ AD=0.1596p PS=1.535u PD=1.22u rfmode=0
M$47288 VDD \$4065 \$4066 VDD sg13_lv_pmos L=0.13u W=2.24u AS=0.4746p
+ AD=0.6776p PS=3.105u PD=4.57u rfmode=0
M$47290 VDD \$4153 \$4113 VDD sg13_lv_pmos L=0.13u W=0.42u AS=0.1428p
+ AD=0.0798p PS=1.52u PD=0.8u rfmode=0
M$47291 VDD VDD \$4113 VDD sg13_lv_pmos L=0.13u W=0.42u AS=0.3623875p
+ AD=0.0798p PS=2.605u PD=0.8u rfmode=0
M$47292 VDD \$4223 \$4067 VDD sg13_lv_pmos L=0.13u W=1u AS=0.3623875p AD=0.34p
+ PS=2.605u PD=2.68u rfmode=0
M$47293 \$4155 \$4154 \$4264 VDD sg13_lv_pmos L=0.13u W=0.42u AS=0.19115p
+ AD=0.0525p PS=1.565u PD=0.67u rfmode=0
M$47294 \$4264 \$4224 VDD VDD sg13_lv_pmos L=0.13u W=0.42u AS=0.0525p
+ AD=0.25605p PS=0.67u PD=1.935u rfmode=0
M$47295 VDD VDD \$4224 VDD sg13_lv_pmos L=0.13u W=0.42u AS=0.25605p AD=0.0798p
+ PS=1.935u PD=0.8u rfmode=0
M$47296 VDD \$4155 \$4224 VDD sg13_lv_pmos L=0.13u W=0.42u AS=0.2014p
+ AD=0.0798p PS=1.53u PD=0.8u rfmode=0
M$47297 VDD \$4155 \$4117 VDD sg13_lv_pmos L=0.13u W=1u AS=0.2083p AD=0.34p
+ PS=1.5u PD=2.68u rfmode=0
M$47298 VDD \$4155 \$4116 VDD sg13_lv_pmos L=0.13u W=2.24u AS=0.4142p
+ AD=0.4211p PS=3.03u PD=3u rfmode=0
M$47300 \$4067 \$4068 \$4155 VDD sg13_lv_pmos L=0.13u W=1u AS=0.34p AD=0.19115p
+ PS=2.68u PD=1.565u rfmode=0
M$47301 \$4069 \$3198 \$4284 VDD sg13_lv_pmos L=0.13u W=0.84u AS=0.2856p
+ AD=0.1596p PS=2.36u PD=1.22u rfmode=0
M$47302 VDD \$2935 \$4284 VDD sg13_lv_pmos L=0.13u W=0.84u AS=0.2226p
+ AD=0.1596p PS=1.535u PD=1.22u rfmode=0
M$47303 VDD \$4069 \$4070 VDD sg13_lv_pmos L=0.13u W=2.24u AS=0.4746p
+ AD=0.6776p PS=3.105u PD=4.57u rfmode=0
M$47305 VDD \$4157 \$4120 VDD sg13_lv_pmos L=0.13u W=0.42u AS=0.1428p
+ AD=0.0798p PS=1.52u PD=0.8u rfmode=0
M$47306 VDD VDD \$4120 VDD sg13_lv_pmos L=0.13u W=0.42u AS=0.3623875p
+ AD=0.0798p PS=2.605u PD=0.8u rfmode=0
M$47307 VDD \$4225 \$4071 VDD sg13_lv_pmos L=0.13u W=1u AS=0.3623875p AD=0.34p
+ PS=2.605u PD=2.68u rfmode=0
M$47308 \$4159 \$4158 \$4270 VDD sg13_lv_pmos L=0.13u W=0.42u AS=0.19115p
+ AD=0.0525p PS=1.565u PD=0.67u rfmode=0
M$47309 \$4270 \$4226 VDD VDD sg13_lv_pmos L=0.13u W=0.42u AS=0.0525p
+ AD=0.25605p PS=0.67u PD=1.935u rfmode=0
M$47310 VDD VDD \$4226 VDD sg13_lv_pmos L=0.13u W=0.42u AS=0.25605p AD=0.0798p
+ PS=1.935u PD=0.8u rfmode=0
M$47311 VDD \$4159 \$4226 VDD sg13_lv_pmos L=0.13u W=0.42u AS=0.2014p
+ AD=0.0798p PS=1.53u PD=0.8u rfmode=0
M$47312 VDD \$4159 \$4124 VDD sg13_lv_pmos L=0.13u W=1u AS=0.2083p AD=0.34p
+ PS=1.5u PD=2.68u rfmode=0
M$47313 VDD \$4159 \$4123 VDD sg13_lv_pmos L=0.13u W=2.24u AS=0.4142p
+ AD=0.4211p PS=3.03u PD=3u rfmode=0
M$47315 \$4071 \$4072 \$4159 VDD sg13_lv_pmos L=0.13u W=1u AS=0.34p AD=0.19115p
+ PS=2.68u PD=1.565u rfmode=0
M$47316 \$4073 VSS|anode|cathode|vss \$4285 VDD sg13_lv_pmos L=0.13u W=0.84u
+ AS=0.2856p AD=0.1596p PS=2.36u PD=1.22u rfmode=0
M$47317 VDD \$2935 \$4285 VDD sg13_lv_pmos L=0.13u W=0.84u AS=0.2226p
+ AD=0.1596p PS=1.535u PD=1.22u rfmode=0
M$47318 VDD \$4073 \$4074 VDD sg13_lv_pmos L=0.13u W=2.24u AS=0.4746p
+ AD=0.6776p PS=3.105u PD=4.57u rfmode=0
M$47320 VDD \$4161 \$4127 VDD sg13_lv_pmos L=0.13u W=0.42u AS=0.1428p
+ AD=0.0798p PS=1.52u PD=0.8u rfmode=0
M$47321 VDD VDD \$4127 VDD sg13_lv_pmos L=0.13u W=0.42u AS=0.3623875p
+ AD=0.0798p PS=2.605u PD=0.8u rfmode=0
M$47322 VDD \$4227 \$4075 VDD sg13_lv_pmos L=0.13u W=1u AS=0.3623875p AD=0.34p
+ PS=2.605u PD=2.68u rfmode=0
M$47323 \$4163 \$4162 \$4261 VDD sg13_lv_pmos L=0.13u W=0.42u AS=0.19115p
+ AD=0.0525p PS=1.565u PD=0.67u rfmode=0
M$47324 \$4261 \$4228 VDD VDD sg13_lv_pmos L=0.13u W=0.42u AS=0.0525p
+ AD=0.25605p PS=0.67u PD=1.935u rfmode=0
M$47325 VDD VDD \$4228 VDD sg13_lv_pmos L=0.13u W=0.42u AS=0.25605p AD=0.0798p
+ PS=1.935u PD=0.8u rfmode=0
M$47326 VDD \$4163 \$4228 VDD sg13_lv_pmos L=0.13u W=0.42u AS=0.2014p
+ AD=0.0798p PS=1.53u PD=0.8u rfmode=0
M$47327 VDD \$4163 \$4131 VDD sg13_lv_pmos L=0.13u W=1u AS=0.2083p AD=0.34p
+ PS=1.5u PD=2.68u rfmode=0
M$47328 VDD \$4163 \$4130 VDD sg13_lv_pmos L=0.13u W=2.24u AS=0.4142p
+ AD=0.4211p PS=3.03u PD=3u rfmode=0
M$47330 \$4075 \$4076 \$4163 VDD sg13_lv_pmos L=0.13u W=1u AS=0.34p AD=0.19115p
+ PS=2.68u PD=1.565u rfmode=0
M$47331 \$4336 D3|c2p|core|i|uo_c2p[5] VDD|in|pad|pin1|pin2|supply|vdd
+ VDD|in|pad|pin1|pin2|supply|vdd sg13_lv_pmos L=0.13u W=4.75u AS=1.615p
+ AD=1.615p PS=10.18u PD=10.18u rfmode=0
M$47332 \$4347 D3|c2p|core|i|uo_c2p[5] VDD|in|pad|pin1|pin2|supply|vdd
+ VDD|in|pad|pin1|pin2|supply|vdd sg13_lv_pmos L=0.13u W=4.75u AS=1.615p
+ AD=1.615p PS=10.18u PD=10.18u rfmode=0
M$47333 VDD \$4363 \$4434 VDD sg13_lv_pmos L=0.13u W=2.24u AS=0.616p AD=0.4312p
+ PS=4.46u PD=3.01u rfmode=0
M$47335 VDD \$2935 \$4434 VDD sg13_lv_pmos L=0.13u W=2.24u AS=0.4312p
+ AD=0.6048p PS=3.01u PD=4.44u rfmode=0
M$47337 VDD \$4434 \$4365 VDD sg13_lv_pmos L=0.13u W=0.42u AS=0.1428p
+ AD=0.0798p PS=1.52u PD=0.8u rfmode=0
M$47338 VDD VDD \$4365 VDD sg13_lv_pmos L=0.13u W=0.42u AS=0.3623875p
+ AD=0.0798p PS=2.605u PD=0.8u rfmode=0
M$47339 VDD \$4492 \$4353 VDD sg13_lv_pmos L=0.13u W=1u AS=0.3623875p AD=0.34p
+ PS=2.605u PD=2.68u rfmode=0
M$47340 \$4213 VDD VDD VDD sg13_lv_pmos L=0.13u W=0.42u AS=0.147p AD=0.1563p
+ PS=1.54u PD=1.22u rfmode=0
M$47341 VDD \$4047 \$4272 VDD sg13_lv_pmos L=0.13u W=0.42u AS=0.1563p
+ AD=0.0546p PS=1.22u PD=0.68u rfmode=0
M$47342 \$4272 \$4048 \$4213 VDD sg13_lv_pmos L=0.13u W=0.42u AS=0.0546p
+ AD=0.0798p PS=0.68u PD=0.8u rfmode=0
M$47343 \$4213 \$4134 \$4078 VDD sg13_lv_pmos L=0.13u W=0.42u AS=0.0798p
+ AD=0.1428p PS=0.8u PD=1.52u rfmode=0
M$47344 \$4493 \$4366 VDD VDD sg13_lv_pmos L=0.13u W=1.12u AS=0.3864p
+ AD=0.431025p PS=2.93u PD=2.145u rfmode=0
M$47345 VDD CLK|clk|core|fclk_in|p2c|ui_p2c[6] \$4366 VDD sg13_lv_pmos L=0.13u
+ W=1.12u AS=0.431025p AD=0.3808p PS=2.145u PD=2.92u rfmode=0
M$47346 \$4436 \$4493 \$4550 VDD sg13_lv_pmos L=0.13u W=0.42u AS=0.19115p
+ AD=0.0525p PS=1.565u PD=0.67u rfmode=0
M$47347 \$4550 \$4494 VDD VDD sg13_lv_pmos L=0.13u W=0.42u AS=0.0525p
+ AD=0.25605p PS=0.67u PD=1.935u rfmode=0
M$47348 VDD VDD \$4494 VDD sg13_lv_pmos L=0.13u W=0.42u AS=0.25605p AD=0.0798p
+ PS=1.935u PD=0.8u rfmode=0
M$47349 VDD \$4436 \$4494 VDD sg13_lv_pmos L=0.13u W=0.42u AS=0.2014p
+ AD=0.0798p PS=1.53u PD=0.8u rfmode=0
M$47350 VDD \$4436 \$4369 VDD sg13_lv_pmos L=0.13u W=1u AS=0.2083p AD=0.34p
+ PS=1.5u PD=2.68u rfmode=0
M$47351 VDD \$4436 \$4368 VDD sg13_lv_pmos L=0.13u W=2.24u AS=0.4142p
+ AD=0.4211p PS=3.03u PD=3u rfmode=0
M$47353 \$4353 \$4366 \$4436 VDD sg13_lv_pmos L=0.13u W=1u AS=0.34p AD=0.19115p
+ PS=2.68u PD=1.565u rfmode=0
M$47354 VDD \$4369 \$4370 VDD sg13_lv_pmos L=0.13u W=2.24u AS=0.5964p
+ AD=0.5964p PS=4.425u PD=4.425u rfmode=0
M$47356 VDD \$4372 \$4438 VDD sg13_lv_pmos L=0.13u W=2.24u AS=0.616p AD=0.4312p
+ PS=4.46u PD=3.01u rfmode=0
M$47358 VDD \$2935 \$4438 VDD sg13_lv_pmos L=0.13u W=2.24u AS=0.4312p
+ AD=0.6048p PS=3.01u PD=4.44u rfmode=0
M$47360 VDD \$4438 \$4374 VDD sg13_lv_pmos L=0.13u W=0.42u AS=0.1428p
+ AD=0.0798p PS=1.52u PD=0.8u rfmode=0
M$47361 VDD VDD \$4374 VDD sg13_lv_pmos L=0.13u W=0.42u AS=0.3623875p
+ AD=0.0798p PS=2.605u PD=0.8u rfmode=0
M$47362 VDD \$4495 \$4354 VDD sg13_lv_pmos L=0.13u W=1u AS=0.3623875p AD=0.34p
+ PS=2.605u PD=2.68u rfmode=0
M$47363 \$4215 VDD VDD VDD sg13_lv_pmos L=0.13u W=0.42u AS=0.147p AD=0.1563p
+ PS=1.54u PD=1.22u rfmode=0
M$47364 VDD \$4051 \$4274 VDD sg13_lv_pmos L=0.13u W=0.42u AS=0.1563p
+ AD=0.0546p PS=1.22u PD=0.68u rfmode=0
M$47365 \$4274 \$4052 \$4215 VDD sg13_lv_pmos L=0.13u W=0.42u AS=0.0546p
+ AD=0.0798p PS=0.68u PD=0.8u rfmode=0
M$47366 \$4215 \$4138 \$4085 VDD sg13_lv_pmos L=0.13u W=0.42u AS=0.0798p
+ AD=0.1428p PS=0.8u PD=1.52u rfmode=0
M$47367 \$4496 \$4375 VDD VDD sg13_lv_pmos L=0.13u W=1.12u AS=0.3864p
+ AD=0.431025p PS=2.93u PD=2.145u rfmode=0
M$47368 VDD CLK|clk|core|fclk_in|p2c|ui_p2c[6] \$4375 VDD sg13_lv_pmos L=0.13u
+ W=1.12u AS=0.431025p AD=0.3808p PS=2.145u PD=2.92u rfmode=0
M$47369 \$4440 \$4496 \$4554 VDD sg13_lv_pmos L=0.13u W=0.42u AS=0.19115p
+ AD=0.0525p PS=1.565u PD=0.67u rfmode=0
M$47370 \$4554 \$4497 VDD VDD sg13_lv_pmos L=0.13u W=0.42u AS=0.0525p
+ AD=0.25605p PS=0.67u PD=1.935u rfmode=0
M$47371 VDD VDD \$4497 VDD sg13_lv_pmos L=0.13u W=0.42u AS=0.25605p AD=0.0798p
+ PS=1.935u PD=0.8u rfmode=0
M$47372 VDD \$4440 \$4497 VDD sg13_lv_pmos L=0.13u W=0.42u AS=0.2014p
+ AD=0.0798p PS=1.53u PD=0.8u rfmode=0
M$47373 VDD \$4440 \$4378 VDD sg13_lv_pmos L=0.13u W=1u AS=0.2083p AD=0.34p
+ PS=1.5u PD=2.68u rfmode=0
M$47374 VDD \$4440 \$4377 VDD sg13_lv_pmos L=0.13u W=2.24u AS=0.4142p
+ AD=0.4211p PS=3.03u PD=3u rfmode=0
M$47376 \$4354 \$4375 \$4440 VDD sg13_lv_pmos L=0.13u W=1u AS=0.34p AD=0.19115p
+ PS=2.68u PD=1.565u rfmode=0
M$47377 VDD \$4378 \$4379 VDD sg13_lv_pmos L=0.13u W=2.24u AS=0.5964p
+ AD=0.5964p PS=4.425u PD=4.425u rfmode=0
M$47379 VDD \$4381 \$4442 VDD sg13_lv_pmos L=0.13u W=2.24u AS=0.616p AD=0.4312p
+ PS=4.46u PD=3.01u rfmode=0
M$47381 VDD \$2935 \$4442 VDD sg13_lv_pmos L=0.13u W=2.24u AS=0.4312p
+ AD=0.6048p PS=3.01u PD=4.44u rfmode=0
M$47383 VDD \$4442 \$4383 VDD sg13_lv_pmos L=0.13u W=0.42u AS=0.1428p
+ AD=0.0798p PS=1.52u PD=0.8u rfmode=0
M$47384 VDD VDD \$4383 VDD sg13_lv_pmos L=0.13u W=0.42u AS=0.3623875p
+ AD=0.0798p PS=2.605u PD=0.8u rfmode=0
M$47385 VDD \$4498 \$4355 VDD sg13_lv_pmos L=0.13u W=1u AS=0.3623875p AD=0.34p
+ PS=2.605u PD=2.68u rfmode=0
M$47386 \$4217 VDD VDD VDD sg13_lv_pmos L=0.13u W=0.42u AS=0.147p AD=0.1563p
+ PS=1.54u PD=1.22u rfmode=0
M$47387 VDD \$4055 \$4276 VDD sg13_lv_pmos L=0.13u W=0.42u AS=0.1563p
+ AD=0.0546p PS=1.22u PD=0.68u rfmode=0
M$47388 \$4276 \$4056 \$4217 VDD sg13_lv_pmos L=0.13u W=0.42u AS=0.0546p
+ AD=0.0798p PS=0.68u PD=0.8u rfmode=0
M$47389 \$4217 \$4142 \$4092 VDD sg13_lv_pmos L=0.13u W=0.42u AS=0.0798p
+ AD=0.1428p PS=0.8u PD=1.52u rfmode=0
M$47390 \$4499 \$4384 VDD VDD sg13_lv_pmos L=0.13u W=1.12u AS=0.3864p
+ AD=0.431025p PS=2.93u PD=2.145u rfmode=0
M$47391 VDD CLK|clk|core|fclk_in|p2c|ui_p2c[6] \$4384 VDD sg13_lv_pmos L=0.13u
+ W=1.12u AS=0.431025p AD=0.3808p PS=2.145u PD=2.92u rfmode=0
M$47392 \$4444 \$4499 \$4558 VDD sg13_lv_pmos L=0.13u W=0.42u AS=0.19115p
+ AD=0.0525p PS=1.565u PD=0.67u rfmode=0
M$47393 \$4558 \$4500 VDD VDD sg13_lv_pmos L=0.13u W=0.42u AS=0.0525p
+ AD=0.25605p PS=0.67u PD=1.935u rfmode=0
M$47394 VDD VDD \$4500 VDD sg13_lv_pmos L=0.13u W=0.42u AS=0.25605p AD=0.0798p
+ PS=1.935u PD=0.8u rfmode=0
M$47395 VDD \$4444 \$4500 VDD sg13_lv_pmos L=0.13u W=0.42u AS=0.2014p
+ AD=0.0798p PS=1.53u PD=0.8u rfmode=0
M$47396 VDD \$4444 \$4387 VDD sg13_lv_pmos L=0.13u W=1u AS=0.2083p AD=0.34p
+ PS=1.5u PD=2.68u rfmode=0
M$47397 VDD \$4444 \$4386 VDD sg13_lv_pmos L=0.13u W=2.24u AS=0.4142p
+ AD=0.4211p PS=3.03u PD=3u rfmode=0
M$47399 \$4355 \$4384 \$4444 VDD sg13_lv_pmos L=0.13u W=1u AS=0.34p AD=0.19115p
+ PS=2.68u PD=1.565u rfmode=0
M$47400 VDD \$4387 \$4388 VDD sg13_lv_pmos L=0.13u W=2.24u AS=0.5964p
+ AD=0.5964p PS=4.425u PD=4.425u rfmode=0
M$47402 VDD \$4390 \$4446 VDD sg13_lv_pmos L=0.13u W=2.24u AS=0.616p AD=0.4312p
+ PS=4.46u PD=3.01u rfmode=0
M$47404 VDD \$2935 \$4446 VDD sg13_lv_pmos L=0.13u W=2.24u AS=0.4312p
+ AD=0.6048p PS=3.01u PD=4.44u rfmode=0
M$47406 VDD \$4446 \$4392 VDD sg13_lv_pmos L=0.13u W=0.42u AS=0.1428p
+ AD=0.0798p PS=1.52u PD=0.8u rfmode=0
M$47407 VDD VDD \$4392 VDD sg13_lv_pmos L=0.13u W=0.42u AS=0.3623875p
+ AD=0.0798p PS=2.605u PD=0.8u rfmode=0
M$47408 VDD \$4501 \$4356 VDD sg13_lv_pmos L=0.13u W=1u AS=0.3623875p AD=0.34p
+ PS=2.605u PD=2.68u rfmode=0
M$47409 \$4219 VDD VDD VDD sg13_lv_pmos L=0.13u W=0.42u AS=0.147p AD=0.1563p
+ PS=1.54u PD=1.22u rfmode=0
M$47410 VDD \$4059 \$4277 VDD sg13_lv_pmos L=0.13u W=0.42u AS=0.1563p
+ AD=0.0546p PS=1.22u PD=0.68u rfmode=0
M$47411 \$4277 \$4060 \$4219 VDD sg13_lv_pmos L=0.13u W=0.42u AS=0.0546p
+ AD=0.0798p PS=0.68u PD=0.8u rfmode=0
M$47412 \$4219 \$4146 \$4099 VDD sg13_lv_pmos L=0.13u W=0.42u AS=0.0798p
+ AD=0.1428p PS=0.8u PD=1.52u rfmode=0
M$47413 \$4502 \$4393 VDD VDD sg13_lv_pmos L=0.13u W=1.12u AS=0.3864p
+ AD=0.431025p PS=2.93u PD=2.145u rfmode=0
M$47414 VDD CLK|clk|core|fclk_in|p2c|ui_p2c[6] \$4393 VDD sg13_lv_pmos L=0.13u
+ W=1.12u AS=0.431025p AD=0.3808p PS=2.145u PD=2.92u rfmode=0
M$47415 \$4448 \$4502 \$4562 VDD sg13_lv_pmos L=0.13u W=0.42u AS=0.19115p
+ AD=0.0525p PS=1.565u PD=0.67u rfmode=0
M$47416 \$4562 \$4503 VDD VDD sg13_lv_pmos L=0.13u W=0.42u AS=0.0525p
+ AD=0.25605p PS=0.67u PD=1.935u rfmode=0
M$47417 VDD VDD \$4503 VDD sg13_lv_pmos L=0.13u W=0.42u AS=0.25605p AD=0.0798p
+ PS=1.935u PD=0.8u rfmode=0
M$47418 VDD \$4448 \$4503 VDD sg13_lv_pmos L=0.13u W=0.42u AS=0.2014p
+ AD=0.0798p PS=1.53u PD=0.8u rfmode=0
M$47419 VDD \$4448 \$4396 VDD sg13_lv_pmos L=0.13u W=1u AS=0.2083p AD=0.34p
+ PS=1.5u PD=2.68u rfmode=0
M$47420 VDD \$4448 \$4395 VDD sg13_lv_pmos L=0.13u W=2.24u AS=0.4142p
+ AD=0.4211p PS=3.03u PD=3u rfmode=0
M$47422 \$4356 \$4393 \$4448 VDD sg13_lv_pmos L=0.13u W=1u AS=0.34p AD=0.19115p
+ PS=2.68u PD=1.565u rfmode=0
M$47423 VDD \$4396 \$4397 VDD sg13_lv_pmos L=0.13u W=2.24u AS=0.5964p
+ AD=0.5964p PS=4.425u PD=4.425u rfmode=0
M$47425 VDD \$4399 \$4450 VDD sg13_lv_pmos L=0.13u W=2.24u AS=0.616p AD=0.4312p
+ PS=4.46u PD=3.01u rfmode=0
M$47427 VDD \$2935 \$4450 VDD sg13_lv_pmos L=0.13u W=2.24u AS=0.4312p
+ AD=0.6048p PS=3.01u PD=4.44u rfmode=0
M$47429 VDD \$4450 \$4401 VDD sg13_lv_pmos L=0.13u W=0.42u AS=0.1428p
+ AD=0.0798p PS=1.52u PD=0.8u rfmode=0
M$47430 VDD VDD \$4401 VDD sg13_lv_pmos L=0.13u W=0.42u AS=0.3623875p
+ AD=0.0798p PS=2.605u PD=0.8u rfmode=0
M$47431 VDD \$4504 \$4357 VDD sg13_lv_pmos L=0.13u W=1u AS=0.3623875p AD=0.34p
+ PS=2.605u PD=2.68u rfmode=0
M$47432 \$4221 VDD VDD VDD sg13_lv_pmos L=0.13u W=0.42u AS=0.147p AD=0.1563p
+ PS=1.54u PD=1.22u rfmode=0
M$47433 VDD \$4063 \$4280 VDD sg13_lv_pmos L=0.13u W=0.42u AS=0.1563p
+ AD=0.0546p PS=1.22u PD=0.68u rfmode=0
M$47434 \$4280 \$4064 \$4221 VDD sg13_lv_pmos L=0.13u W=0.42u AS=0.0546p
+ AD=0.0798p PS=0.68u PD=0.8u rfmode=0
M$47435 \$4221 \$4150 \$4106 VDD sg13_lv_pmos L=0.13u W=0.42u AS=0.0798p
+ AD=0.1428p PS=0.8u PD=1.52u rfmode=0
M$47436 \$4505 \$4402 VDD VDD sg13_lv_pmos L=0.13u W=1.12u AS=0.3864p
+ AD=0.431025p PS=2.93u PD=2.145u rfmode=0
M$47437 VDD CLK|clk|core|fclk_in|p2c|ui_p2c[6] \$4402 VDD sg13_lv_pmos L=0.13u
+ W=1.12u AS=0.431025p AD=0.3808p PS=2.145u PD=2.92u rfmode=0
M$47438 \$4452 \$4505 \$4566 VDD sg13_lv_pmos L=0.13u W=0.42u AS=0.19115p
+ AD=0.0525p PS=1.565u PD=0.67u rfmode=0
M$47439 \$4566 \$4506 VDD VDD sg13_lv_pmos L=0.13u W=0.42u AS=0.0525p
+ AD=0.25605p PS=0.67u PD=1.935u rfmode=0
M$47440 VDD VDD \$4506 VDD sg13_lv_pmos L=0.13u W=0.42u AS=0.25605p AD=0.0798p
+ PS=1.935u PD=0.8u rfmode=0
M$47441 VDD \$4452 \$4506 VDD sg13_lv_pmos L=0.13u W=0.42u AS=0.2014p
+ AD=0.0798p PS=1.53u PD=0.8u rfmode=0
M$47442 VDD \$4452 \$4405 VDD sg13_lv_pmos L=0.13u W=1u AS=0.2083p AD=0.34p
+ PS=1.5u PD=2.68u rfmode=0
M$47443 VDD \$4452 \$4404 VDD sg13_lv_pmos L=0.13u W=2.24u AS=0.4142p
+ AD=0.4211p PS=3.03u PD=3u rfmode=0
M$47445 \$4357 \$4402 \$4452 VDD sg13_lv_pmos L=0.13u W=1u AS=0.34p AD=0.19115p
+ PS=2.68u PD=1.565u rfmode=0
M$47446 VDD \$4405 \$4406 VDD sg13_lv_pmos L=0.13u W=2.24u AS=0.5964p
+ AD=0.5964p PS=4.425u PD=4.425u rfmode=0
M$47448 VDD \$4408 \$4454 VDD sg13_lv_pmos L=0.13u W=2.24u AS=0.616p AD=0.4312p
+ PS=4.46u PD=3.01u rfmode=0
M$47450 VDD \$2935 \$4454 VDD sg13_lv_pmos L=0.13u W=2.24u AS=0.4312p
+ AD=0.6048p PS=3.01u PD=4.44u rfmode=0
M$47452 VDD \$4454 \$4410 VDD sg13_lv_pmos L=0.13u W=0.42u AS=0.1428p
+ AD=0.0798p PS=1.52u PD=0.8u rfmode=0
M$47453 VDD VDD \$4410 VDD sg13_lv_pmos L=0.13u W=0.42u AS=0.3623875p
+ AD=0.0798p PS=2.605u PD=0.8u rfmode=0
M$47454 VDD \$4507 \$4358 VDD sg13_lv_pmos L=0.13u W=1u AS=0.3623875p AD=0.34p
+ PS=2.605u PD=2.68u rfmode=0
M$47455 \$4223 VDD VDD VDD sg13_lv_pmos L=0.13u W=0.42u AS=0.147p AD=0.1563p
+ PS=1.54u PD=1.22u rfmode=0
M$47456 VDD \$4067 \$4282 VDD sg13_lv_pmos L=0.13u W=0.42u AS=0.1563p
+ AD=0.0546p PS=1.22u PD=0.68u rfmode=0
M$47457 \$4282 \$4068 \$4223 VDD sg13_lv_pmos L=0.13u W=0.42u AS=0.0546p
+ AD=0.0798p PS=0.68u PD=0.8u rfmode=0
M$47458 \$4223 \$4154 \$4113 VDD sg13_lv_pmos L=0.13u W=0.42u AS=0.0798p
+ AD=0.1428p PS=0.8u PD=1.52u rfmode=0
M$47459 \$4508 \$4411 VDD VDD sg13_lv_pmos L=0.13u W=1.12u AS=0.3864p
+ AD=0.431025p PS=2.93u PD=2.145u rfmode=0
M$47460 VDD CLK|clk|core|fclk_in|p2c|ui_p2c[6] \$4411 VDD sg13_lv_pmos L=0.13u
+ W=1.12u AS=0.431025p AD=0.3808p PS=2.145u PD=2.92u rfmode=0
M$47461 \$4456 \$4508 \$4570 VDD sg13_lv_pmos L=0.13u W=0.42u AS=0.19115p
+ AD=0.0525p PS=1.565u PD=0.67u rfmode=0
M$47462 \$4570 \$4509 VDD VDD sg13_lv_pmos L=0.13u W=0.42u AS=0.0525p
+ AD=0.25605p PS=0.67u PD=1.935u rfmode=0
M$47463 VDD VDD \$4509 VDD sg13_lv_pmos L=0.13u W=0.42u AS=0.25605p AD=0.0798p
+ PS=1.935u PD=0.8u rfmode=0
M$47464 VDD \$4456 \$4509 VDD sg13_lv_pmos L=0.13u W=0.42u AS=0.2014p
+ AD=0.0798p PS=1.53u PD=0.8u rfmode=0
M$47465 VDD \$4456 \$4414 VDD sg13_lv_pmos L=0.13u W=1u AS=0.2083p AD=0.34p
+ PS=1.5u PD=2.68u rfmode=0
M$47466 VDD \$4456 \$4413 VDD sg13_lv_pmos L=0.13u W=2.24u AS=0.4142p
+ AD=0.4211p PS=3.03u PD=3u rfmode=0
M$47468 \$4358 \$4411 \$4456 VDD sg13_lv_pmos L=0.13u W=1u AS=0.34p AD=0.19115p
+ PS=2.68u PD=1.565u rfmode=0
M$47469 VDD \$4414 \$4415 VDD sg13_lv_pmos L=0.13u W=2.24u AS=0.5964p
+ AD=0.5964p PS=4.425u PD=4.425u rfmode=0
M$47471 VDD \$4417 \$4458 VDD sg13_lv_pmos L=0.13u W=2.24u AS=0.616p AD=0.4312p
+ PS=4.46u PD=3.01u rfmode=0
M$47473 VDD \$2935 \$4458 VDD sg13_lv_pmos L=0.13u W=2.24u AS=0.4312p
+ AD=0.6048p PS=3.01u PD=4.44u rfmode=0
M$47475 VDD \$4458 \$4419 VDD sg13_lv_pmos L=0.13u W=0.42u AS=0.1428p
+ AD=0.0798p PS=1.52u PD=0.8u rfmode=0
M$47476 VDD VDD \$4419 VDD sg13_lv_pmos L=0.13u W=0.42u AS=0.3623875p
+ AD=0.0798p PS=2.605u PD=0.8u rfmode=0
M$47477 VDD \$4510 \$4359 VDD sg13_lv_pmos L=0.13u W=1u AS=0.3623875p AD=0.34p
+ PS=2.605u PD=2.68u rfmode=0
M$47478 \$4225 VDD VDD VDD sg13_lv_pmos L=0.13u W=0.42u AS=0.147p AD=0.1563p
+ PS=1.54u PD=1.22u rfmode=0
M$47479 VDD \$4071 \$4283 VDD sg13_lv_pmos L=0.13u W=0.42u AS=0.1563p
+ AD=0.0546p PS=1.22u PD=0.68u rfmode=0
M$47480 \$4283 \$4072 \$4225 VDD sg13_lv_pmos L=0.13u W=0.42u AS=0.0546p
+ AD=0.0798p PS=0.68u PD=0.8u rfmode=0
M$47481 \$4225 \$4158 \$4120 VDD sg13_lv_pmos L=0.13u W=0.42u AS=0.0798p
+ AD=0.1428p PS=0.8u PD=1.52u rfmode=0
M$47482 \$4511 \$4420 VDD VDD sg13_lv_pmos L=0.13u W=1.12u AS=0.3864p
+ AD=0.431025p PS=2.93u PD=2.145u rfmode=0
M$47483 VDD CLK|clk|core|fclk_in|p2c|ui_p2c[6] \$4420 VDD sg13_lv_pmos L=0.13u
+ W=1.12u AS=0.431025p AD=0.3808p PS=2.145u PD=2.92u rfmode=0
M$47484 \$4460 \$4511 \$4575 VDD sg13_lv_pmos L=0.13u W=0.42u AS=0.19115p
+ AD=0.0525p PS=1.565u PD=0.67u rfmode=0
M$47485 \$4575 \$4512 VDD VDD sg13_lv_pmos L=0.13u W=0.42u AS=0.0525p
+ AD=0.25605p PS=0.67u PD=1.935u rfmode=0
M$47486 VDD VDD \$4512 VDD sg13_lv_pmos L=0.13u W=0.42u AS=0.25605p AD=0.0798p
+ PS=1.935u PD=0.8u rfmode=0
M$47487 VDD \$4460 \$4512 VDD sg13_lv_pmos L=0.13u W=0.42u AS=0.2014p
+ AD=0.0798p PS=1.53u PD=0.8u rfmode=0
M$47488 VDD \$4460 \$4423 VDD sg13_lv_pmos L=0.13u W=1u AS=0.2083p AD=0.34p
+ PS=1.5u PD=2.68u rfmode=0
M$47489 VDD \$4460 \$4422 VDD sg13_lv_pmos L=0.13u W=2.24u AS=0.4142p
+ AD=0.4211p PS=3.03u PD=3u rfmode=0
M$47491 \$4359 \$4420 \$4460 VDD sg13_lv_pmos L=0.13u W=1u AS=0.34p AD=0.19115p
+ PS=2.68u PD=1.565u rfmode=0
M$47492 VDD \$4423 \$4424 VDD sg13_lv_pmos L=0.13u W=2.24u AS=0.5964p
+ AD=0.5964p PS=4.425u PD=4.425u rfmode=0
M$47494 VDD \$4426 \$4462 VDD sg13_lv_pmos L=0.13u W=2.24u AS=0.616p AD=0.4312p
+ PS=4.46u PD=3.01u rfmode=0
M$47496 VDD \$2935 \$4462 VDD sg13_lv_pmos L=0.13u W=2.24u AS=0.4312p
+ AD=0.6048p PS=3.01u PD=4.44u rfmode=0
M$47498 VDD \$4462 \$4428 VDD sg13_lv_pmos L=0.13u W=0.42u AS=0.1428p
+ AD=0.0798p PS=1.52u PD=0.8u rfmode=0
M$47499 VDD VDD \$4428 VDD sg13_lv_pmos L=0.13u W=0.42u AS=0.3623875p
+ AD=0.0798p PS=2.605u PD=0.8u rfmode=0
M$47500 VDD \$4513 \$4360 VDD sg13_lv_pmos L=0.13u W=1u AS=0.3623875p AD=0.34p
+ PS=2.605u PD=2.68u rfmode=0
M$47501 \$4227 VDD VDD VDD sg13_lv_pmos L=0.13u W=0.42u AS=0.147p AD=0.1563p
+ PS=1.54u PD=1.22u rfmode=0
M$47502 VDD \$4075 \$4286 VDD sg13_lv_pmos L=0.13u W=0.42u AS=0.1563p
+ AD=0.0546p PS=1.22u PD=0.68u rfmode=0
M$47503 \$4286 \$4076 \$4227 VDD sg13_lv_pmos L=0.13u W=0.42u AS=0.0546p
+ AD=0.0798p PS=0.68u PD=0.8u rfmode=0
M$47504 \$4227 \$4162 \$4127 VDD sg13_lv_pmos L=0.13u W=0.42u AS=0.0798p
+ AD=0.1428p PS=0.8u PD=1.52u rfmode=0
M$47505 \$4514 \$4429 VDD VDD sg13_lv_pmos L=0.13u W=1.12u AS=0.3864p
+ AD=0.431025p PS=2.93u PD=2.145u rfmode=0
M$47506 VDD CLK|clk|core|fclk_in|p2c|ui_p2c[6] \$4429 VDD sg13_lv_pmos L=0.13u
+ W=1.12u AS=0.431025p AD=0.3808p PS=2.145u PD=2.92u rfmode=0
M$47507 \$4464 \$4514 \$4582 VDD sg13_lv_pmos L=0.13u W=0.42u AS=0.19115p
+ AD=0.0525p PS=1.565u PD=0.67u rfmode=0
M$47508 \$4582 \$4515 VDD VDD sg13_lv_pmos L=0.13u W=0.42u AS=0.0525p
+ AD=0.25605p PS=0.67u PD=1.935u rfmode=0
M$47509 VDD VDD \$4515 VDD sg13_lv_pmos L=0.13u W=0.42u AS=0.25605p AD=0.0798p
+ PS=1.935u PD=0.8u rfmode=0
M$47510 VDD \$4464 \$4515 VDD sg13_lv_pmos L=0.13u W=0.42u AS=0.2014p
+ AD=0.0798p PS=1.53u PD=0.8u rfmode=0
M$47511 VDD \$4464 \$4432 VDD sg13_lv_pmos L=0.13u W=1u AS=0.2083p AD=0.34p
+ PS=1.5u PD=2.68u rfmode=0
M$47512 VDD \$4464 \$4431 VDD sg13_lv_pmos L=0.13u W=2.24u AS=0.4142p
+ AD=0.4211p PS=3.03u PD=3u rfmode=0
M$47514 \$4360 \$4429 \$4464 VDD sg13_lv_pmos L=0.13u W=1u AS=0.34p AD=0.19115p
+ PS=2.68u PD=1.565u rfmode=0
M$47515 VDD \$4432 \$4433 VDD sg13_lv_pmos L=0.13u W=2.24u AS=0.5964p
+ AD=0.5964p PS=4.425u PD=4.425u rfmode=0
M$47517 core|p2c|shift_in|ui_p2c[3] \$4341 VDD|in|pad|pin1|pin2|supply|vdd
+ VDD|in|pad|pin1|pin2|supply|vdd sg13_lv_pmos L=0.13u W=4.75u AS=1.615p
+ AD=1.615p PS=10.18u PD=10.18u rfmode=0
M$47518 \$4362 \$3192 \$4583 VDD sg13_lv_pmos L=0.13u W=0.84u AS=0.2856p
+ AD=0.1596p PS=2.36u PD=1.22u rfmode=0
M$47519 VDD \$3396 \$4583 VDD sg13_lv_pmos L=0.13u W=0.84u AS=0.2226p
+ AD=0.1596p PS=1.535u PD=1.22u rfmode=0
M$47520 VDD \$4362 \$4363 VDD sg13_lv_pmos L=0.13u W=2.24u AS=0.4746p
+ AD=0.6776p PS=3.105u PD=4.57u rfmode=0
M$47522 VDD \$4674 \$4745 VDD sg13_lv_pmos L=0.13u W=2.24u AS=0.616p AD=0.4312p
+ PS=4.46u PD=3.01u rfmode=0
M$47524 VDD \$3396 \$4745 VDD sg13_lv_pmos L=0.13u W=2.24u AS=0.4312p
+ AD=0.6048p PS=3.01u PD=4.44u rfmode=0
M$47526 \$4492 VDD VDD VDD sg13_lv_pmos L=0.13u W=0.42u AS=0.147p AD=0.1563p
+ PS=1.54u PD=1.22u rfmode=0
M$47527 VDD \$4353 \$4584 VDD sg13_lv_pmos L=0.13u W=0.42u AS=0.1563p
+ AD=0.0546p PS=1.22u PD=0.68u rfmode=0
M$47528 \$4584 \$4366 \$4492 VDD sg13_lv_pmos L=0.13u W=0.42u AS=0.0546p
+ AD=0.0798p PS=0.68u PD=0.8u rfmode=0
M$47529 \$4492 \$4493 \$4365 VDD sg13_lv_pmos L=0.13u W=0.42u AS=0.0798p
+ AD=0.1428p PS=0.8u PD=1.52u rfmode=0
M$47530 \$4746 \$4658 VDD VDD sg13_lv_pmos L=0.13u W=1.12u AS=0.3864p
+ AD=0.431025p PS=2.93u PD=2.145u rfmode=0
M$47531 VDD CLK|clk|core|fclk_in|p2c|ui_p2c[6] \$4658 VDD sg13_lv_pmos L=0.13u
+ W=1.12u AS=0.431025p AD=0.3808p PS=2.145u PD=2.92u rfmode=0
M$47532 VDD \$4680 \$4681 VDD sg13_lv_pmos L=0.13u W=2.24u AS=0.5964p
+ AD=0.5964p PS=4.425u PD=4.425u rfmode=0
M$47534 \$4371 \$3193 \$4586 VDD sg13_lv_pmos L=0.13u W=0.84u AS=0.2856p
+ AD=0.1596p PS=2.36u PD=1.22u rfmode=0
M$47535 VDD \$3396 \$4586 VDD sg13_lv_pmos L=0.13u W=0.84u AS=0.2226p
+ AD=0.1596p PS=1.535u PD=1.22u rfmode=0
M$47536 VDD \$4371 \$4372 VDD sg13_lv_pmos L=0.13u W=2.24u AS=0.4746p
+ AD=0.6776p PS=3.105u PD=4.57u rfmode=0
M$47538 VDD \$4683 \$4749 VDD sg13_lv_pmos L=0.13u W=2.24u AS=0.616p AD=0.4312p
+ PS=4.46u PD=3.01u rfmode=0
M$47540 VDD \$3396 \$4749 VDD sg13_lv_pmos L=0.13u W=2.24u AS=0.4312p
+ AD=0.6048p PS=3.01u PD=4.44u rfmode=0
M$47542 \$4495 VDD VDD VDD sg13_lv_pmos L=0.13u W=0.42u AS=0.147p AD=0.1563p
+ PS=1.54u PD=1.22u rfmode=0
M$47543 VDD \$4354 \$4585 VDD sg13_lv_pmos L=0.13u W=0.42u AS=0.1563p
+ AD=0.0546p PS=1.22u PD=0.68u rfmode=0
M$47544 \$4585 \$4375 \$4495 VDD sg13_lv_pmos L=0.13u W=0.42u AS=0.0546p
+ AD=0.0798p PS=0.68u PD=0.8u rfmode=0
M$47545 \$4495 \$4496 \$4374 VDD sg13_lv_pmos L=0.13u W=0.42u AS=0.0798p
+ AD=0.1428p PS=0.8u PD=1.52u rfmode=0
M$47546 \$4750 \$4660 VDD VDD sg13_lv_pmos L=0.13u W=1.12u AS=0.3864p
+ AD=0.431025p PS=2.93u PD=2.145u rfmode=0
M$47547 VDD CLK|clk|core|fclk_in|p2c|ui_p2c[6] \$4660 VDD sg13_lv_pmos L=0.13u
+ W=1.12u AS=0.431025p AD=0.3808p PS=2.145u PD=2.92u rfmode=0
M$47548 VDD \$4689 \$4690 VDD sg13_lv_pmos L=0.13u W=2.24u AS=0.5964p
+ AD=0.5964p PS=4.425u PD=4.425u rfmode=0
M$47550 \$4380 \$3194 \$4587 VDD sg13_lv_pmos L=0.13u W=0.84u AS=0.2856p
+ AD=0.1596p PS=2.36u PD=1.22u rfmode=0
M$47551 VDD \$3396 \$4587 VDD sg13_lv_pmos L=0.13u W=0.84u AS=0.2226p
+ AD=0.1596p PS=1.535u PD=1.22u rfmode=0
M$47552 VDD \$4380 \$4381 VDD sg13_lv_pmos L=0.13u W=2.24u AS=0.4746p
+ AD=0.6776p PS=3.105u PD=4.57u rfmode=0
M$47554 VDD \$4692 \$4753 VDD sg13_lv_pmos L=0.13u W=2.24u AS=0.616p AD=0.4312p
+ PS=4.46u PD=3.01u rfmode=0
M$47556 VDD \$3396 \$4753 VDD sg13_lv_pmos L=0.13u W=2.24u AS=0.4312p
+ AD=0.6048p PS=3.01u PD=4.44u rfmode=0
M$47558 \$4498 VDD VDD VDD sg13_lv_pmos L=0.13u W=0.42u AS=0.147p AD=0.1563p
+ PS=1.54u PD=1.22u rfmode=0
M$47559 VDD \$4355 \$4588 VDD sg13_lv_pmos L=0.13u W=0.42u AS=0.1563p
+ AD=0.0546p PS=1.22u PD=0.68u rfmode=0
M$47560 \$4588 \$4384 \$4498 VDD sg13_lv_pmos L=0.13u W=0.42u AS=0.0546p
+ AD=0.0798p PS=0.68u PD=0.8u rfmode=0
M$47561 \$4498 \$4499 \$4383 VDD sg13_lv_pmos L=0.13u W=0.42u AS=0.0798p
+ AD=0.1428p PS=0.8u PD=1.52u rfmode=0
M$47562 \$4754 \$4662 VDD VDD sg13_lv_pmos L=0.13u W=1.12u AS=0.3864p
+ AD=0.431025p PS=2.93u PD=2.145u rfmode=0
M$47563 VDD CLK|clk|core|fclk_in|p2c|ui_p2c[6] \$4662 VDD sg13_lv_pmos L=0.13u
+ W=1.12u AS=0.431025p AD=0.3808p PS=2.145u PD=2.92u rfmode=0
M$47564 VDD \$4698 \$4699 VDD sg13_lv_pmos L=0.13u W=2.24u AS=0.5964p
+ AD=0.5964p PS=4.425u PD=4.425u rfmode=0
M$47566 \$4389 \$3195 \$4590 VDD sg13_lv_pmos L=0.13u W=0.84u AS=0.2856p
+ AD=0.1596p PS=2.36u PD=1.22u rfmode=0
M$47567 VDD \$3396 \$4590 VDD sg13_lv_pmos L=0.13u W=0.84u AS=0.2226p
+ AD=0.1596p PS=1.535u PD=1.22u rfmode=0
M$47568 VDD \$4389 \$4390 VDD sg13_lv_pmos L=0.13u W=2.24u AS=0.4746p
+ AD=0.6776p PS=3.105u PD=4.57u rfmode=0
M$47570 VDD \$4701 \$4757 VDD sg13_lv_pmos L=0.13u W=2.24u AS=0.616p AD=0.4312p
+ PS=4.46u PD=3.01u rfmode=0
M$47572 VDD \$3396 \$4757 VDD sg13_lv_pmos L=0.13u W=2.24u AS=0.4312p
+ AD=0.6048p PS=3.01u PD=4.44u rfmode=0
M$47574 \$4501 VDD VDD VDD sg13_lv_pmos L=0.13u W=0.42u AS=0.147p AD=0.1563p
+ PS=1.54u PD=1.22u rfmode=0
M$47575 VDD \$4356 \$4589 VDD sg13_lv_pmos L=0.13u W=0.42u AS=0.1563p
+ AD=0.0546p PS=1.22u PD=0.68u rfmode=0
M$47576 \$4589 \$4393 \$4501 VDD sg13_lv_pmos L=0.13u W=0.42u AS=0.0546p
+ AD=0.0798p PS=0.68u PD=0.8u rfmode=0
M$47577 \$4501 \$4502 \$4392 VDD sg13_lv_pmos L=0.13u W=0.42u AS=0.0798p
+ AD=0.1428p PS=0.8u PD=1.52u rfmode=0
M$47578 \$4758 \$4664 VDD VDD sg13_lv_pmos L=0.13u W=1.12u AS=0.3864p
+ AD=0.431025p PS=2.93u PD=2.145u rfmode=0
M$47579 VDD CLK|clk|core|fclk_in|p2c|ui_p2c[6] \$4664 VDD sg13_lv_pmos L=0.13u
+ W=1.12u AS=0.431025p AD=0.3808p PS=2.145u PD=2.92u rfmode=0
M$47580 VDD \$4707 \$4708 VDD sg13_lv_pmos L=0.13u W=2.24u AS=0.5964p
+ AD=0.5964p PS=4.425u PD=4.425u rfmode=0
M$47582 \$4398 \$3196 \$4591 VDD sg13_lv_pmos L=0.13u W=0.84u AS=0.2856p
+ AD=0.1596p PS=2.36u PD=1.22u rfmode=0
M$47583 VDD \$3396 \$4591 VDD sg13_lv_pmos L=0.13u W=0.84u AS=0.2226p
+ AD=0.1596p PS=1.535u PD=1.22u rfmode=0
M$47584 VDD \$4398 \$4399 VDD sg13_lv_pmos L=0.13u W=2.24u AS=0.4746p
+ AD=0.6776p PS=3.105u PD=4.57u rfmode=0
M$47586 VDD \$4710 \$4761 VDD sg13_lv_pmos L=0.13u W=2.24u AS=0.616p AD=0.4312p
+ PS=4.46u PD=3.01u rfmode=0
M$47588 VDD \$3396 \$4761 VDD sg13_lv_pmos L=0.13u W=2.24u AS=0.4312p
+ AD=0.6048p PS=3.01u PD=4.44u rfmode=0
M$47590 \$4504 VDD VDD VDD sg13_lv_pmos L=0.13u W=0.42u AS=0.147p AD=0.1563p
+ PS=1.54u PD=1.22u rfmode=0
M$47591 VDD \$4357 \$4592 VDD sg13_lv_pmos L=0.13u W=0.42u AS=0.1563p
+ AD=0.0546p PS=1.22u PD=0.68u rfmode=0
M$47592 \$4592 \$4402 \$4504 VDD sg13_lv_pmos L=0.13u W=0.42u AS=0.0546p
+ AD=0.0798p PS=0.68u PD=0.8u rfmode=0
M$47593 \$4504 \$4505 \$4401 VDD sg13_lv_pmos L=0.13u W=0.42u AS=0.0798p
+ AD=0.1428p PS=0.8u PD=1.52u rfmode=0
M$47594 \$4762 \$4666 VDD VDD sg13_lv_pmos L=0.13u W=1.12u AS=0.3864p
+ AD=0.431025p PS=2.93u PD=2.145u rfmode=0
M$47595 VDD CLK|clk|core|fclk_in|p2c|ui_p2c[6] \$4666 VDD sg13_lv_pmos L=0.13u
+ W=1.12u AS=0.431025p AD=0.3808p PS=2.145u PD=2.92u rfmode=0
M$47596 VDD \$4716 \$4717 VDD sg13_lv_pmos L=0.13u W=2.24u AS=0.5964p
+ AD=0.5964p PS=4.425u PD=4.425u rfmode=0
M$47598 \$4407 \$3197 \$4593 VDD sg13_lv_pmos L=0.13u W=0.84u AS=0.2856p
+ AD=0.1596p PS=2.36u PD=1.22u rfmode=0
M$47599 VDD \$3396 \$4593 VDD sg13_lv_pmos L=0.13u W=0.84u AS=0.2226p
+ AD=0.1596p PS=1.535u PD=1.22u rfmode=0
M$47600 VDD \$4407 \$4408 VDD sg13_lv_pmos L=0.13u W=2.24u AS=0.4746p
+ AD=0.6776p PS=3.105u PD=4.57u rfmode=0
M$47602 VDD \$4719 \$4765 VDD sg13_lv_pmos L=0.13u W=2.24u AS=0.616p AD=0.4312p
+ PS=4.46u PD=3.01u rfmode=0
M$47604 VDD \$3396 \$4765 VDD sg13_lv_pmos L=0.13u W=2.24u AS=0.4312p
+ AD=0.6048p PS=3.01u PD=4.44u rfmode=0
M$47606 \$4507 VDD VDD VDD sg13_lv_pmos L=0.13u W=0.42u AS=0.147p AD=0.1563p
+ PS=1.54u PD=1.22u rfmode=0
M$47607 VDD \$4358 \$4594 VDD sg13_lv_pmos L=0.13u W=0.42u AS=0.1563p
+ AD=0.0546p PS=1.22u PD=0.68u rfmode=0
M$47608 \$4594 \$4411 \$4507 VDD sg13_lv_pmos L=0.13u W=0.42u AS=0.0546p
+ AD=0.0798p PS=0.68u PD=0.8u rfmode=0
M$47609 \$4507 \$4508 \$4410 VDD sg13_lv_pmos L=0.13u W=0.42u AS=0.0798p
+ AD=0.1428p PS=0.8u PD=1.52u rfmode=0
M$47610 \$4766 \$4668 VDD VDD sg13_lv_pmos L=0.13u W=1.12u AS=0.3864p
+ AD=0.431025p PS=2.93u PD=2.145u rfmode=0
M$47611 VDD CLK|clk|core|fclk_in|p2c|ui_p2c[6] \$4668 VDD sg13_lv_pmos L=0.13u
+ W=1.12u AS=0.431025p AD=0.3808p PS=2.145u PD=2.92u rfmode=0
M$47612 VDD \$4725 \$4726 VDD sg13_lv_pmos L=0.13u W=2.24u AS=0.5964p
+ AD=0.5964p PS=4.425u PD=4.425u rfmode=0
M$47614 \$4416 \$3198 \$4595 VDD sg13_lv_pmos L=0.13u W=0.84u AS=0.2856p
+ AD=0.1596p PS=2.36u PD=1.22u rfmode=0
M$47615 VDD \$3396 \$4595 VDD sg13_lv_pmos L=0.13u W=0.84u AS=0.2226p
+ AD=0.1596p PS=1.535u PD=1.22u rfmode=0
M$47616 VDD \$4416 \$4417 VDD sg13_lv_pmos L=0.13u W=2.24u AS=0.4746p
+ AD=0.6776p PS=3.105u PD=4.57u rfmode=0
M$47618 VDD \$4728 \$4769 VDD sg13_lv_pmos L=0.13u W=2.24u AS=0.616p AD=0.4312p
+ PS=4.46u PD=3.01u rfmode=0
M$47620 VDD \$3396 \$4769 VDD sg13_lv_pmos L=0.13u W=2.24u AS=0.4312p
+ AD=0.6048p PS=3.01u PD=4.44u rfmode=0
M$47622 \$4510 VDD VDD VDD sg13_lv_pmos L=0.13u W=0.42u AS=0.147p AD=0.1563p
+ PS=1.54u PD=1.22u rfmode=0
M$47623 VDD \$4359 \$4596 VDD sg13_lv_pmos L=0.13u W=0.42u AS=0.1563p
+ AD=0.0546p PS=1.22u PD=0.68u rfmode=0
M$47624 \$4596 \$4420 \$4510 VDD sg13_lv_pmos L=0.13u W=0.42u AS=0.0546p
+ AD=0.0798p PS=0.68u PD=0.8u rfmode=0
M$47625 \$4510 \$4511 \$4419 VDD sg13_lv_pmos L=0.13u W=0.42u AS=0.0798p
+ AD=0.1428p PS=0.8u PD=1.52u rfmode=0
M$47626 \$4770 \$4670 VDD VDD sg13_lv_pmos L=0.13u W=1.12u AS=0.3864p
+ AD=0.431025p PS=2.93u PD=2.145u rfmode=0
M$47627 VDD CLK|clk|core|fclk_in|p2c|ui_p2c[6] \$4670 VDD sg13_lv_pmos L=0.13u
+ W=1.12u AS=0.431025p AD=0.3808p PS=2.145u PD=2.92u rfmode=0
M$47628 VDD \$4734 \$4735 VDD sg13_lv_pmos L=0.13u W=2.24u AS=0.5964p
+ AD=0.5964p PS=4.425u PD=4.425u rfmode=0
M$47630 \$4425 VSS|anode|cathode|vss \$4597 VDD sg13_lv_pmos L=0.13u W=0.84u
+ AS=0.2856p AD=0.1596p PS=2.36u PD=1.22u rfmode=0
M$47631 VDD \$3396 \$4597 VDD sg13_lv_pmos L=0.13u W=0.84u AS=0.2226p
+ AD=0.1596p PS=1.535u PD=1.22u rfmode=0
M$47632 VDD \$4425 \$4426 VDD sg13_lv_pmos L=0.13u W=2.24u AS=0.4746p
+ AD=0.6776p PS=3.105u PD=4.57u rfmode=0
M$47634 VDD \$4737 \$4773 VDD sg13_lv_pmos L=0.13u W=2.24u AS=0.616p AD=0.4312p
+ PS=4.46u PD=3.01u rfmode=0
M$47636 VDD \$3396 \$4773 VDD sg13_lv_pmos L=0.13u W=2.24u AS=0.4312p
+ AD=0.6048p PS=3.01u PD=4.44u rfmode=0
M$47638 \$4513 VDD VDD VDD sg13_lv_pmos L=0.13u W=0.42u AS=0.147p AD=0.1563p
+ PS=1.54u PD=1.22u rfmode=0
M$47639 VDD \$4360 \$4600 VDD sg13_lv_pmos L=0.13u W=0.42u AS=0.1563p
+ AD=0.0546p PS=1.22u PD=0.68u rfmode=0
M$47640 \$4600 \$4429 \$4513 VDD sg13_lv_pmos L=0.13u W=0.42u AS=0.0546p
+ AD=0.0798p PS=0.68u PD=0.8u rfmode=0
M$47641 \$4513 \$4514 \$4428 VDD sg13_lv_pmos L=0.13u W=0.42u AS=0.0798p
+ AD=0.1428p PS=0.8u PD=1.52u rfmode=0
M$47642 \$4774 \$4672 VDD VDD sg13_lv_pmos L=0.13u W=1.12u AS=0.3864p
+ AD=0.431025p PS=2.93u PD=2.145u rfmode=0
M$47643 VDD CLK|clk|core|fclk_in|p2c|ui_p2c[6] \$4672 VDD sg13_lv_pmos L=0.13u
+ W=1.12u AS=0.431025p AD=0.3808p PS=2.145u PD=2.92u rfmode=0
M$47644 VDD \$4743 \$4744 VDD sg13_lv_pmos L=0.13u W=2.24u AS=0.5964p
+ AD=0.5964p PS=4.425u PD=4.425u rfmode=0
M$47646 \$4673 \$3192 \$4889 VDD sg13_lv_pmos L=0.13u W=0.84u AS=0.2856p
+ AD=0.1596p PS=2.36u PD=1.22u rfmode=0
M$47647 VDD \$3439 \$4889 VDD sg13_lv_pmos L=0.13u W=0.84u AS=0.2226p
+ AD=0.1596p PS=1.535u PD=1.22u rfmode=0
M$47648 VDD \$4673 \$4674 VDD sg13_lv_pmos L=0.13u W=2.24u AS=0.4746p
+ AD=0.6776p PS=3.105u PD=4.57u rfmode=0
M$47650 VDD \$4745 \$4676 VDD sg13_lv_pmos L=0.13u W=0.42u AS=0.1428p
+ AD=0.0798p PS=1.52u PD=0.8u rfmode=0
M$47651 VDD VDD \$4676 VDD sg13_lv_pmos L=0.13u W=0.42u AS=0.3623875p
+ AD=0.0798p PS=2.605u PD=0.8u rfmode=0
M$47652 VDD \$4801 \$4657 VDD sg13_lv_pmos L=0.13u W=1u AS=0.3623875p AD=0.34p
+ PS=2.605u PD=2.68u rfmode=0
M$47653 \$4747 \$4746 \$4850 VDD sg13_lv_pmos L=0.13u W=0.42u AS=0.19115p
+ AD=0.0525p PS=1.565u PD=0.67u rfmode=0
M$47654 \$4850 \$4802 VDD VDD sg13_lv_pmos L=0.13u W=0.42u AS=0.0525p
+ AD=0.25605p PS=0.67u PD=1.935u rfmode=0
M$47655 VDD VDD \$4802 VDD sg13_lv_pmos L=0.13u W=0.42u AS=0.25605p AD=0.0798p
+ PS=1.935u PD=0.8u rfmode=0
M$47656 VDD \$4747 \$4802 VDD sg13_lv_pmos L=0.13u W=0.42u AS=0.2014p
+ AD=0.0798p PS=1.53u PD=0.8u rfmode=0
M$47657 VDD \$4747 \$4680 VDD sg13_lv_pmos L=0.13u W=1u AS=0.2083p AD=0.34p
+ PS=1.5u PD=2.68u rfmode=0
M$47658 VDD \$4747 \$4679 VDD sg13_lv_pmos L=0.13u W=2.24u AS=0.4142p
+ AD=0.4211p PS=3.03u PD=3u rfmode=0
M$47660 \$4657 \$4658 \$4747 VDD sg13_lv_pmos L=0.13u W=1u AS=0.34p AD=0.19115p
+ PS=2.68u PD=1.565u rfmode=0
M$47661 \$4682 \$3193 \$4890 VDD sg13_lv_pmos L=0.13u W=0.84u AS=0.2856p
+ AD=0.1596p PS=2.36u PD=1.22u rfmode=0
M$47662 VDD \$3439 \$4890 VDD sg13_lv_pmos L=0.13u W=0.84u AS=0.2226p
+ AD=0.1596p PS=1.535u PD=1.22u rfmode=0
M$47663 VDD \$4682 \$4683 VDD sg13_lv_pmos L=0.13u W=2.24u AS=0.4746p
+ AD=0.6776p PS=3.105u PD=4.57u rfmode=0
M$47665 VDD \$4749 \$4685 VDD sg13_lv_pmos L=0.13u W=0.42u AS=0.1428p
+ AD=0.0798p PS=1.52u PD=0.8u rfmode=0
M$47666 VDD VDD \$4685 VDD sg13_lv_pmos L=0.13u W=0.42u AS=0.3623875p
+ AD=0.0798p PS=2.605u PD=0.8u rfmode=0
M$47667 VDD \$4803 \$4659 VDD sg13_lv_pmos L=0.13u W=1u AS=0.3623875p AD=0.34p
+ PS=2.605u PD=2.68u rfmode=0
M$47668 \$4751 \$4750 \$4855 VDD sg13_lv_pmos L=0.13u W=0.42u AS=0.19115p
+ AD=0.0525p PS=1.565u PD=0.67u rfmode=0
M$47669 \$4855 \$4804 VDD VDD sg13_lv_pmos L=0.13u W=0.42u AS=0.0525p
+ AD=0.25605p PS=0.67u PD=1.935u rfmode=0
M$47670 VDD VDD \$4804 VDD sg13_lv_pmos L=0.13u W=0.42u AS=0.25605p AD=0.0798p
+ PS=1.935u PD=0.8u rfmode=0
M$47671 VDD \$4751 \$4804 VDD sg13_lv_pmos L=0.13u W=0.42u AS=0.2014p
+ AD=0.0798p PS=1.53u PD=0.8u rfmode=0
M$47672 VDD \$4751 \$4689 VDD sg13_lv_pmos L=0.13u W=1u AS=0.2083p AD=0.34p
+ PS=1.5u PD=2.68u rfmode=0
M$47673 VDD \$4751 \$4688 VDD sg13_lv_pmos L=0.13u W=2.24u AS=0.4142p
+ AD=0.4211p PS=3.03u PD=3u rfmode=0
M$47675 \$4659 \$4660 \$4751 VDD sg13_lv_pmos L=0.13u W=1u AS=0.34p AD=0.19115p
+ PS=2.68u PD=1.565u rfmode=0
M$47676 \$4691 \$3194 \$4891 VDD sg13_lv_pmos L=0.13u W=0.84u AS=0.2856p
+ AD=0.1596p PS=2.36u PD=1.22u rfmode=0
M$47677 VDD \$3439 \$4891 VDD sg13_lv_pmos L=0.13u W=0.84u AS=0.2226p
+ AD=0.1596p PS=1.535u PD=1.22u rfmode=0
M$47678 VDD \$4691 \$4692 VDD sg13_lv_pmos L=0.13u W=2.24u AS=0.4746p
+ AD=0.6776p PS=3.105u PD=4.57u rfmode=0
M$47680 VDD \$4753 \$4694 VDD sg13_lv_pmos L=0.13u W=0.42u AS=0.1428p
+ AD=0.0798p PS=1.52u PD=0.8u rfmode=0
M$47681 VDD VDD \$4694 VDD sg13_lv_pmos L=0.13u W=0.42u AS=0.3623875p
+ AD=0.0798p PS=2.605u PD=0.8u rfmode=0
M$47682 VDD \$4805 \$4661 VDD sg13_lv_pmos L=0.13u W=1u AS=0.3623875p AD=0.34p
+ PS=2.605u PD=2.68u rfmode=0
M$47683 \$4755 \$4754 \$4860 VDD sg13_lv_pmos L=0.13u W=0.42u AS=0.19115p
+ AD=0.0525p PS=1.565u PD=0.67u rfmode=0
M$47684 \$4860 \$4806 VDD VDD sg13_lv_pmos L=0.13u W=0.42u AS=0.0525p
+ AD=0.25605p PS=0.67u PD=1.935u rfmode=0
M$47685 VDD VDD \$4806 VDD sg13_lv_pmos L=0.13u W=0.42u AS=0.25605p AD=0.0798p
+ PS=1.935u PD=0.8u rfmode=0
M$47686 VDD \$4755 \$4806 VDD sg13_lv_pmos L=0.13u W=0.42u AS=0.2014p
+ AD=0.0798p PS=1.53u PD=0.8u rfmode=0
M$47687 VDD \$4755 \$4698 VDD sg13_lv_pmos L=0.13u W=1u AS=0.2083p AD=0.34p
+ PS=1.5u PD=2.68u rfmode=0
M$47688 VDD \$4755 \$4697 VDD sg13_lv_pmos L=0.13u W=2.24u AS=0.4142p
+ AD=0.4211p PS=3.03u PD=3u rfmode=0
M$47690 \$4661 \$4662 \$4755 VDD sg13_lv_pmos L=0.13u W=1u AS=0.34p AD=0.19115p
+ PS=2.68u PD=1.565u rfmode=0
M$47691 \$4700 \$3195 \$4892 VDD sg13_lv_pmos L=0.13u W=0.84u AS=0.2856p
+ AD=0.1596p PS=2.36u PD=1.22u rfmode=0
M$47692 VDD \$3439 \$4892 VDD sg13_lv_pmos L=0.13u W=0.84u AS=0.2226p
+ AD=0.1596p PS=1.535u PD=1.22u rfmode=0
M$47693 VDD \$4700 \$4701 VDD sg13_lv_pmos L=0.13u W=2.24u AS=0.4746p
+ AD=0.6776p PS=3.105u PD=4.57u rfmode=0
M$47695 VDD \$4757 \$4703 VDD sg13_lv_pmos L=0.13u W=0.42u AS=0.1428p
+ AD=0.0798p PS=1.52u PD=0.8u rfmode=0
M$47696 VDD VDD \$4703 VDD sg13_lv_pmos L=0.13u W=0.42u AS=0.3623875p
+ AD=0.0798p PS=2.605u PD=0.8u rfmode=0
M$47697 VDD \$4807 \$4663 VDD sg13_lv_pmos L=0.13u W=1u AS=0.3623875p AD=0.34p
+ PS=2.605u PD=2.68u rfmode=0
M$47698 \$4759 \$4758 \$4864 VDD sg13_lv_pmos L=0.13u W=0.42u AS=0.19115p
+ AD=0.0525p PS=1.565u PD=0.67u rfmode=0
M$47699 \$4864 \$4808 VDD VDD sg13_lv_pmos L=0.13u W=0.42u AS=0.0525p
+ AD=0.25605p PS=0.67u PD=1.935u rfmode=0
M$47700 VDD VDD \$4808 VDD sg13_lv_pmos L=0.13u W=0.42u AS=0.25605p AD=0.0798p
+ PS=1.935u PD=0.8u rfmode=0
M$47701 VDD \$4759 \$4808 VDD sg13_lv_pmos L=0.13u W=0.42u AS=0.2014p
+ AD=0.0798p PS=1.53u PD=0.8u rfmode=0
M$47702 VDD \$4759 \$4707 VDD sg13_lv_pmos L=0.13u W=1u AS=0.2083p AD=0.34p
+ PS=1.5u PD=2.68u rfmode=0
M$47703 VDD \$4759 \$4706 VDD sg13_lv_pmos L=0.13u W=2.24u AS=0.4142p
+ AD=0.4211p PS=3.03u PD=3u rfmode=0
M$47705 \$4663 \$4664 \$4759 VDD sg13_lv_pmos L=0.13u W=1u AS=0.34p AD=0.19115p
+ PS=2.68u PD=1.565u rfmode=0
M$47706 \$4709 \$3196 \$4893 VDD sg13_lv_pmos L=0.13u W=0.84u AS=0.2856p
+ AD=0.1596p PS=2.36u PD=1.22u rfmode=0
M$47707 VDD \$3439 \$4893 VDD sg13_lv_pmos L=0.13u W=0.84u AS=0.2226p
+ AD=0.1596p PS=1.535u PD=1.22u rfmode=0
M$47708 VDD \$4709 \$4710 VDD sg13_lv_pmos L=0.13u W=2.24u AS=0.4746p
+ AD=0.6776p PS=3.105u PD=4.57u rfmode=0
M$47710 VDD \$4761 \$4712 VDD sg13_lv_pmos L=0.13u W=0.42u AS=0.1428p
+ AD=0.0798p PS=1.52u PD=0.8u rfmode=0
M$47711 VDD VDD \$4712 VDD sg13_lv_pmos L=0.13u W=0.42u AS=0.3623875p
+ AD=0.0798p PS=2.605u PD=0.8u rfmode=0
M$47712 VDD \$4809 \$4665 VDD sg13_lv_pmos L=0.13u W=1u AS=0.3623875p AD=0.34p
+ PS=2.605u PD=2.68u rfmode=0
M$47713 \$4763 \$4762 \$4870 VDD sg13_lv_pmos L=0.13u W=0.42u AS=0.19115p
+ AD=0.0525p PS=1.565u PD=0.67u rfmode=0
M$47714 \$4870 \$4810 VDD VDD sg13_lv_pmos L=0.13u W=0.42u AS=0.0525p
+ AD=0.25605p PS=0.67u PD=1.935u rfmode=0
M$47715 VDD VDD \$4810 VDD sg13_lv_pmos L=0.13u W=0.42u AS=0.25605p AD=0.0798p
+ PS=1.935u PD=0.8u rfmode=0
M$47716 VDD \$4763 \$4810 VDD sg13_lv_pmos L=0.13u W=0.42u AS=0.2014p
+ AD=0.0798p PS=1.53u PD=0.8u rfmode=0
M$47717 VDD \$4763 \$4716 VDD sg13_lv_pmos L=0.13u W=1u AS=0.2083p AD=0.34p
+ PS=1.5u PD=2.68u rfmode=0
M$47718 VDD \$4763 \$4715 VDD sg13_lv_pmos L=0.13u W=2.24u AS=0.4142p
+ AD=0.4211p PS=3.03u PD=3u rfmode=0
M$47720 \$4665 \$4666 \$4763 VDD sg13_lv_pmos L=0.13u W=1u AS=0.34p AD=0.19115p
+ PS=2.68u PD=1.565u rfmode=0
M$47721 \$4718 \$3197 \$4894 VDD sg13_lv_pmos L=0.13u W=0.84u AS=0.2856p
+ AD=0.1596p PS=2.36u PD=1.22u rfmode=0
M$47722 VDD \$3439 \$4894 VDD sg13_lv_pmos L=0.13u W=0.84u AS=0.2226p
+ AD=0.1596p PS=1.535u PD=1.22u rfmode=0
M$47723 VDD \$4718 \$4719 VDD sg13_lv_pmos L=0.13u W=2.24u AS=0.4746p
+ AD=0.6776p PS=3.105u PD=4.57u rfmode=0
M$47725 VDD \$4765 \$4721 VDD sg13_lv_pmos L=0.13u W=0.42u AS=0.1428p
+ AD=0.0798p PS=1.52u PD=0.8u rfmode=0
M$47726 VDD VDD \$4721 VDD sg13_lv_pmos L=0.13u W=0.42u AS=0.3623875p
+ AD=0.0798p PS=2.605u PD=0.8u rfmode=0
M$47727 VDD \$4811 \$4667 VDD sg13_lv_pmos L=0.13u W=1u AS=0.3623875p AD=0.34p
+ PS=2.605u PD=2.68u rfmode=0
M$47728 \$4767 \$4766 \$4875 VDD sg13_lv_pmos L=0.13u W=0.42u AS=0.19115p
+ AD=0.0525p PS=1.565u PD=0.67u rfmode=0
M$47729 \$4875 \$4812 VDD VDD sg13_lv_pmos L=0.13u W=0.42u AS=0.0525p
+ AD=0.25605p PS=0.67u PD=1.935u rfmode=0
M$47730 VDD VDD \$4812 VDD sg13_lv_pmos L=0.13u W=0.42u AS=0.25605p AD=0.0798p
+ PS=1.935u PD=0.8u rfmode=0
M$47731 VDD \$4767 \$4812 VDD sg13_lv_pmos L=0.13u W=0.42u AS=0.2014p
+ AD=0.0798p PS=1.53u PD=0.8u rfmode=0
M$47732 VDD \$4767 \$4725 VDD sg13_lv_pmos L=0.13u W=1u AS=0.2083p AD=0.34p
+ PS=1.5u PD=2.68u rfmode=0
M$47733 VDD \$4767 \$4724 VDD sg13_lv_pmos L=0.13u W=2.24u AS=0.4142p
+ AD=0.4211p PS=3.03u PD=3u rfmode=0
M$47735 \$4667 \$4668 \$4767 VDD sg13_lv_pmos L=0.13u W=1u AS=0.34p AD=0.19115p
+ PS=2.68u PD=1.565u rfmode=0
M$47736 \$4727 \$3198 \$4895 VDD sg13_lv_pmos L=0.13u W=0.84u AS=0.2856p
+ AD=0.1596p PS=2.36u PD=1.22u rfmode=0
M$47737 VDD \$3439 \$4895 VDD sg13_lv_pmos L=0.13u W=0.84u AS=0.2226p
+ AD=0.1596p PS=1.535u PD=1.22u rfmode=0
M$47738 VDD \$4727 \$4728 VDD sg13_lv_pmos L=0.13u W=2.24u AS=0.4746p
+ AD=0.6776p PS=3.105u PD=4.57u rfmode=0
M$47740 VDD \$4769 \$4730 VDD sg13_lv_pmos L=0.13u W=0.42u AS=0.1428p
+ AD=0.0798p PS=1.52u PD=0.8u rfmode=0
M$47741 VDD VDD \$4730 VDD sg13_lv_pmos L=0.13u W=0.42u AS=0.3623875p
+ AD=0.0798p PS=2.605u PD=0.8u rfmode=0
M$47742 VDD \$4813 \$4669 VDD sg13_lv_pmos L=0.13u W=1u AS=0.3623875p AD=0.34p
+ PS=2.605u PD=2.68u rfmode=0
M$47743 \$4771 \$4770 \$4880 VDD sg13_lv_pmos L=0.13u W=0.42u AS=0.19115p
+ AD=0.0525p PS=1.565u PD=0.67u rfmode=0
M$47744 \$4880 \$4814 VDD VDD sg13_lv_pmos L=0.13u W=0.42u AS=0.0525p
+ AD=0.25605p PS=0.67u PD=1.935u rfmode=0
M$47745 VDD VDD \$4814 VDD sg13_lv_pmos L=0.13u W=0.42u AS=0.25605p AD=0.0798p
+ PS=1.935u PD=0.8u rfmode=0
M$47746 VDD \$4771 \$4814 VDD sg13_lv_pmos L=0.13u W=0.42u AS=0.2014p
+ AD=0.0798p PS=1.53u PD=0.8u rfmode=0
M$47747 VDD \$4771 \$4734 VDD sg13_lv_pmos L=0.13u W=1u AS=0.2083p AD=0.34p
+ PS=1.5u PD=2.68u rfmode=0
M$47748 VDD \$4771 \$4733 VDD sg13_lv_pmos L=0.13u W=2.24u AS=0.4142p
+ AD=0.4211p PS=3.03u PD=3u rfmode=0
M$47750 \$4669 \$4670 \$4771 VDD sg13_lv_pmos L=0.13u W=1u AS=0.34p AD=0.19115p
+ PS=2.68u PD=1.565u rfmode=0
M$47751 \$4736 VSS|anode|cathode|vss \$4896 VDD sg13_lv_pmos L=0.13u W=0.84u
+ AS=0.2856p AD=0.1596p PS=2.36u PD=1.22u rfmode=0
M$47752 VDD \$3439 \$4896 VDD sg13_lv_pmos L=0.13u W=0.84u AS=0.2226p
+ AD=0.1596p PS=1.535u PD=1.22u rfmode=0
M$47753 VDD \$4736 \$4737 VDD sg13_lv_pmos L=0.13u W=2.24u AS=0.4746p
+ AD=0.6776p PS=3.105u PD=4.57u rfmode=0
M$47755 VDD \$4773 \$4739 VDD sg13_lv_pmos L=0.13u W=0.42u AS=0.1428p
+ AD=0.0798p PS=1.52u PD=0.8u rfmode=0
M$47756 VDD VDD \$4739 VDD sg13_lv_pmos L=0.13u W=0.42u AS=0.3623875p
+ AD=0.0798p PS=2.605u PD=0.8u rfmode=0
M$47757 VDD \$4815 \$4671 VDD sg13_lv_pmos L=0.13u W=1u AS=0.3623875p AD=0.34p
+ PS=2.605u PD=2.68u rfmode=0
M$47758 \$4775 \$4774 \$4888 VDD sg13_lv_pmos L=0.13u W=0.42u AS=0.19115p
+ AD=0.0525p PS=1.565u PD=0.67u rfmode=0
M$47759 \$4888 \$4816 VDD VDD sg13_lv_pmos L=0.13u W=0.42u AS=0.0525p
+ AD=0.25605p PS=0.67u PD=1.935u rfmode=0
M$47760 VDD VDD \$4816 VDD sg13_lv_pmos L=0.13u W=0.42u AS=0.25605p AD=0.0798p
+ PS=1.935u PD=0.8u rfmode=0
M$47761 VDD \$4775 \$4816 VDD sg13_lv_pmos L=0.13u W=0.42u AS=0.2014p
+ AD=0.0798p PS=1.53u PD=0.8u rfmode=0
M$47762 VDD \$4775 \$4743 VDD sg13_lv_pmos L=0.13u W=1u AS=0.2083p AD=0.34p
+ PS=1.5u PD=2.68u rfmode=0
M$47763 VDD \$4775 \$4742 VDD sg13_lv_pmos L=0.13u W=2.24u AS=0.4142p
+ AD=0.4211p PS=3.03u PD=3u rfmode=0
M$47765 \$4671 \$4672 \$4775 VDD sg13_lv_pmos L=0.13u W=1u AS=0.34p AD=0.19115p
+ PS=2.68u PD=1.565u rfmode=0
M$47766 VDD \$4962 \$5030 VDD sg13_lv_pmos L=0.13u W=2.24u AS=0.616p AD=0.4312p
+ PS=4.46u PD=3.01u rfmode=0
M$47768 VDD \$3439 \$5030 VDD sg13_lv_pmos L=0.13u W=2.24u AS=0.4312p
+ AD=0.6048p PS=3.01u PD=4.44u rfmode=0
M$47770 VDD \$5030 \$4964 VDD sg13_lv_pmos L=0.13u W=0.42u AS=0.1428p
+ AD=0.0798p PS=1.52u PD=0.8u rfmode=0
M$47771 VDD VDD \$4964 VDD sg13_lv_pmos L=0.13u W=0.42u AS=0.3623875p
+ AD=0.0798p PS=2.605u PD=0.8u rfmode=0
M$47772 VDD \$5078 \$4945 VDD sg13_lv_pmos L=0.13u W=1u AS=0.3623875p AD=0.34p
+ PS=2.605u PD=2.68u rfmode=0
M$47773 \$4801 VDD VDD VDD sg13_lv_pmos L=0.13u W=0.42u AS=0.147p AD=0.1563p
+ PS=1.54u PD=1.22u rfmode=0
M$47774 VDD \$4657 \$4849 VDD sg13_lv_pmos L=0.13u W=0.42u AS=0.1563p
+ AD=0.0546p PS=1.22u PD=0.68u rfmode=0
M$47775 \$4849 \$4658 \$4801 VDD sg13_lv_pmos L=0.13u W=0.42u AS=0.0546p
+ AD=0.0798p PS=0.68u PD=0.8u rfmode=0
M$47776 \$4801 \$4746 \$4676 VDD sg13_lv_pmos L=0.13u W=0.42u AS=0.0798p
+ AD=0.1428p PS=0.8u PD=1.52u rfmode=0
M$47777 \$5118 \$4946 VDD VDD sg13_lv_pmos L=0.13u W=1.12u AS=0.3864p
+ AD=0.431025p PS=2.93u PD=2.145u rfmode=0
M$47778 VDD CLK|clk|core|fclk_in|p2c|ui_p2c[6] \$4946 VDD sg13_lv_pmos L=0.13u
+ W=1.12u AS=0.431025p AD=0.3808p PS=2.145u PD=2.92u rfmode=0
M$47779 \$5031 \$5118 \$5138 VDD sg13_lv_pmos L=0.13u W=0.42u AS=0.19115p
+ AD=0.0525p PS=1.565u PD=0.67u rfmode=0
M$47780 \$5138 \$5079 VDD VDD sg13_lv_pmos L=0.13u W=0.42u AS=0.0525p
+ AD=0.25605p PS=0.67u PD=1.935u rfmode=0
M$47781 VDD VDD \$5079 VDD sg13_lv_pmos L=0.13u W=0.42u AS=0.25605p AD=0.0798p
+ PS=1.935u PD=0.8u rfmode=0
M$47782 VDD \$5031 \$5079 VDD sg13_lv_pmos L=0.13u W=0.42u AS=0.2014p
+ AD=0.0798p PS=1.53u PD=0.8u rfmode=0
M$47783 VDD \$5031 \$4968 VDD sg13_lv_pmos L=0.13u W=1u AS=0.2083p AD=0.34p
+ PS=1.5u PD=2.68u rfmode=0
M$47784 VDD \$5031 \$4967 VDD sg13_lv_pmos L=0.13u W=2.24u AS=0.4142p
+ AD=0.4211p PS=3.03u PD=3u rfmode=0
M$47786 \$4945 \$4946 \$5031 VDD sg13_lv_pmos L=0.13u W=1u AS=0.34p AD=0.19115p
+ PS=2.68u PD=1.565u rfmode=0
M$47787 VDD \$4968 \$4969 VDD sg13_lv_pmos L=0.13u W=2.24u AS=0.5964p
+ AD=0.5964p PS=4.425u PD=4.425u rfmode=0
M$47789 VDD \$4971 \$5033 VDD sg13_lv_pmos L=0.13u W=2.24u AS=0.616p AD=0.4312p
+ PS=4.46u PD=3.01u rfmode=0
M$47791 VDD \$3439 \$5033 VDD sg13_lv_pmos L=0.13u W=2.24u AS=0.4312p
+ AD=0.6048p PS=3.01u PD=4.44u rfmode=0
M$47793 VDD \$5033 \$4973 VDD sg13_lv_pmos L=0.13u W=0.42u AS=0.1428p
+ AD=0.0798p PS=1.52u PD=0.8u rfmode=0
M$47794 VDD VDD \$4973 VDD sg13_lv_pmos L=0.13u W=0.42u AS=0.3623875p
+ AD=0.0798p PS=2.605u PD=0.8u rfmode=0
M$47795 VDD \$5080 \$4947 VDD sg13_lv_pmos L=0.13u W=1u AS=0.3623875p AD=0.34p
+ PS=2.605u PD=2.68u rfmode=0
M$47796 \$4803 VDD VDD VDD sg13_lv_pmos L=0.13u W=0.42u AS=0.147p AD=0.1563p
+ PS=1.54u PD=1.22u rfmode=0
M$47797 VDD \$4659 \$4854 VDD sg13_lv_pmos L=0.13u W=0.42u AS=0.1563p
+ AD=0.0546p PS=1.22u PD=0.68u rfmode=0
M$47798 \$4854 \$4660 \$4803 VDD sg13_lv_pmos L=0.13u W=0.42u AS=0.0546p
+ AD=0.0798p PS=0.68u PD=0.8u rfmode=0
M$47799 \$4803 \$4750 \$4685 VDD sg13_lv_pmos L=0.13u W=0.42u AS=0.0798p
+ AD=0.1428p PS=0.8u PD=1.52u rfmode=0
M$47800 \$5120 \$4948 VDD VDD sg13_lv_pmos L=0.13u W=1.12u AS=0.3864p
+ AD=0.431025p PS=2.93u PD=2.145u rfmode=0
M$47801 VDD CLK|clk|core|fclk_in|p2c|ui_p2c[6] \$4948 VDD sg13_lv_pmos L=0.13u
+ W=1.12u AS=0.431025p AD=0.3808p PS=2.145u PD=2.92u rfmode=0
M$47802 \$5034 \$5120 \$5142 VDD sg13_lv_pmos L=0.13u W=0.42u AS=0.19115p
+ AD=0.0525p PS=1.565u PD=0.67u rfmode=0
M$47803 \$5142 \$5081 VDD VDD sg13_lv_pmos L=0.13u W=0.42u AS=0.0525p
+ AD=0.25605p PS=0.67u PD=1.935u rfmode=0
M$47804 VDD VDD \$5081 VDD sg13_lv_pmos L=0.13u W=0.42u AS=0.25605p AD=0.0798p
+ PS=1.935u PD=0.8u rfmode=0
M$47805 VDD \$5034 \$5081 VDD sg13_lv_pmos L=0.13u W=0.42u AS=0.2014p
+ AD=0.0798p PS=1.53u PD=0.8u rfmode=0
M$47806 VDD \$5034 \$4977 VDD sg13_lv_pmos L=0.13u W=1u AS=0.2083p AD=0.34p
+ PS=1.5u PD=2.68u rfmode=0
M$47807 VDD \$5034 \$4976 VDD sg13_lv_pmos L=0.13u W=2.24u AS=0.4142p
+ AD=0.4211p PS=3.03u PD=3u rfmode=0
M$47809 \$4947 \$4948 \$5034 VDD sg13_lv_pmos L=0.13u W=1u AS=0.34p AD=0.19115p
+ PS=2.68u PD=1.565u rfmode=0
M$47810 VDD \$4977 \$4978 VDD sg13_lv_pmos L=0.13u W=2.24u AS=0.5964p
+ AD=0.5964p PS=4.425u PD=4.425u rfmode=0
M$47812 VDD \$4980 \$5036 VDD sg13_lv_pmos L=0.13u W=2.24u AS=0.616p AD=0.4312p
+ PS=4.46u PD=3.01u rfmode=0
M$47814 VDD \$3439 \$5036 VDD sg13_lv_pmos L=0.13u W=2.24u AS=0.4312p
+ AD=0.6048p PS=3.01u PD=4.44u rfmode=0
M$47816 VDD \$5036 \$5122 VDD sg13_lv_pmos L=0.13u W=0.42u AS=0.1428p
+ AD=0.0798p PS=1.52u PD=0.8u rfmode=0
M$47817 VDD VDD \$5122 VDD sg13_lv_pmos L=0.13u W=0.42u AS=0.3623875p
+ AD=0.0798p PS=2.605u PD=0.8u rfmode=0
M$47818 VDD \$5082 \$4949 VDD sg13_lv_pmos L=0.13u W=1u AS=0.3623875p AD=0.34p
+ PS=2.605u PD=2.68u rfmode=0
M$47819 \$4805 VDD VDD VDD sg13_lv_pmos L=0.13u W=0.42u AS=0.147p AD=0.1563p
+ PS=1.54u PD=1.22u rfmode=0
M$47820 VDD \$4661 \$4859 VDD sg13_lv_pmos L=0.13u W=0.42u AS=0.1563p
+ AD=0.0546p PS=1.22u PD=0.68u rfmode=0
M$47821 \$4859 \$4662 \$4805 VDD sg13_lv_pmos L=0.13u W=0.42u AS=0.0546p
+ AD=0.0798p PS=0.68u PD=0.8u rfmode=0
M$47822 \$4805 \$4754 \$4694 VDD sg13_lv_pmos L=0.13u W=0.42u AS=0.0798p
+ AD=0.1428p PS=0.8u PD=1.52u rfmode=0
M$47823 \$5123 \$4950 VDD VDD sg13_lv_pmos L=0.13u W=1.12u AS=0.3864p
+ AD=0.431025p PS=2.93u PD=2.145u rfmode=0
M$47824 VDD CLK|clk|core|fclk_in|p2c|ui_p2c[6] \$4950 VDD sg13_lv_pmos L=0.13u
+ W=1.12u AS=0.431025p AD=0.3808p PS=2.145u PD=2.92u rfmode=0
M$47825 \$5037 \$5123 \$5147 VDD sg13_lv_pmos L=0.13u W=0.42u AS=0.19115p
+ AD=0.0525p PS=1.565u PD=0.67u rfmode=0
M$47826 \$5147 \$5083 VDD VDD sg13_lv_pmos L=0.13u W=0.42u AS=0.0525p
+ AD=0.25605p PS=0.67u PD=1.935u rfmode=0
M$47827 VDD VDD \$5083 VDD sg13_lv_pmos L=0.13u W=0.42u AS=0.25605p AD=0.0798p
+ PS=1.935u PD=0.8u rfmode=0
M$47828 VDD \$5037 \$5083 VDD sg13_lv_pmos L=0.13u W=0.42u AS=0.2014p
+ AD=0.0798p PS=1.53u PD=0.8u rfmode=0
M$47829 VDD \$5037 \$4985 VDD sg13_lv_pmos L=0.13u W=1u AS=0.2083p AD=0.34p
+ PS=1.5u PD=2.68u rfmode=0
M$47830 VDD \$5037 \$4984 VDD sg13_lv_pmos L=0.13u W=2.24u AS=0.4142p
+ AD=0.4211p PS=3.03u PD=3u rfmode=0
M$47832 \$4949 \$4950 \$5037 VDD sg13_lv_pmos L=0.13u W=1u AS=0.34p AD=0.19115p
+ PS=2.68u PD=1.565u rfmode=0
M$47833 VDD \$4985 \$4986 VDD sg13_lv_pmos L=0.13u W=2.24u AS=0.5964p
+ AD=0.5964p PS=4.425u PD=4.425u rfmode=0
M$47835 VDD \$4988 \$5039 VDD sg13_lv_pmos L=0.13u W=2.24u AS=0.616p AD=0.4312p
+ PS=4.46u PD=3.01u rfmode=0
M$47837 VDD \$3439 \$5039 VDD sg13_lv_pmos L=0.13u W=2.24u AS=0.4312p
+ AD=0.6048p PS=3.01u PD=4.44u rfmode=0
M$47839 VDD \$5039 \$4990 VDD sg13_lv_pmos L=0.13u W=0.42u AS=0.1428p
+ AD=0.0798p PS=1.52u PD=0.8u rfmode=0
M$47840 VDD VDD \$4990 VDD sg13_lv_pmos L=0.13u W=0.42u AS=0.3623875p
+ AD=0.0798p PS=2.605u PD=0.8u rfmode=0
M$47841 VDD \$5084 \$4951 VDD sg13_lv_pmos L=0.13u W=1u AS=0.3623875p AD=0.34p
+ PS=2.605u PD=2.68u rfmode=0
M$47842 \$4807 VDD VDD VDD sg13_lv_pmos L=0.13u W=0.42u AS=0.147p AD=0.1563p
+ PS=1.54u PD=1.22u rfmode=0
M$47843 VDD \$4663 \$4865 VDD sg13_lv_pmos L=0.13u W=0.42u AS=0.1563p
+ AD=0.0546p PS=1.22u PD=0.68u rfmode=0
M$47844 \$4865 \$4664 \$4807 VDD sg13_lv_pmos L=0.13u W=0.42u AS=0.0546p
+ AD=0.0798p PS=0.68u PD=0.8u rfmode=0
M$47845 \$4807 \$4758 \$4703 VDD sg13_lv_pmos L=0.13u W=0.42u AS=0.0798p
+ AD=0.1428p PS=0.8u PD=1.52u rfmode=0
M$47846 \$5125 \$4952 VDD VDD sg13_lv_pmos L=0.13u W=1.12u AS=0.3864p
+ AD=0.431025p PS=2.93u PD=2.145u rfmode=0
M$47847 VDD CLK|clk|core|fclk_in|p2c|ui_p2c[6] \$4952 VDD sg13_lv_pmos L=0.13u
+ W=1.12u AS=0.431025p AD=0.3808p PS=2.145u PD=2.92u rfmode=0
M$47848 \$5040 \$5125 \$5152 VDD sg13_lv_pmos L=0.13u W=0.42u AS=0.19115p
+ AD=0.0525p PS=1.565u PD=0.67u rfmode=0
M$47849 \$5152 \$5085 VDD VDD sg13_lv_pmos L=0.13u W=0.42u AS=0.0525p
+ AD=0.25605p PS=0.67u PD=1.935u rfmode=0
M$47850 VDD VDD \$5085 VDD sg13_lv_pmos L=0.13u W=0.42u AS=0.25605p AD=0.0798p
+ PS=1.935u PD=0.8u rfmode=0
M$47851 VDD \$5040 \$5085 VDD sg13_lv_pmos L=0.13u W=0.42u AS=0.2014p
+ AD=0.0798p PS=1.53u PD=0.8u rfmode=0
M$47852 VDD \$5040 \$4994 VDD sg13_lv_pmos L=0.13u W=1u AS=0.2083p AD=0.34p
+ PS=1.5u PD=2.68u rfmode=0
M$47853 VDD \$5040 \$4993 VDD sg13_lv_pmos L=0.13u W=2.24u AS=0.4142p
+ AD=0.4211p PS=3.03u PD=3u rfmode=0
M$47855 \$4951 \$4952 \$5040 VDD sg13_lv_pmos L=0.13u W=1u AS=0.34p AD=0.19115p
+ PS=2.68u PD=1.565u rfmode=0
M$47856 VDD \$4994 \$4995 VDD sg13_lv_pmos L=0.13u W=2.24u AS=0.5964p
+ AD=0.5964p PS=4.425u PD=4.425u rfmode=0
M$47858 VDD \$4997 \$5042 VDD sg13_lv_pmos L=0.13u W=2.24u AS=0.616p AD=0.4312p
+ PS=4.46u PD=3.01u rfmode=0
M$47860 VDD \$3439 \$5042 VDD sg13_lv_pmos L=0.13u W=2.24u AS=0.4312p
+ AD=0.6048p PS=3.01u PD=4.44u rfmode=0
M$47862 VDD \$5042 \$4999 VDD sg13_lv_pmos L=0.13u W=0.42u AS=0.1428p
+ AD=0.0798p PS=1.52u PD=0.8u rfmode=0
M$47863 VDD VDD \$4999 VDD sg13_lv_pmos L=0.13u W=0.42u AS=0.3623875p
+ AD=0.0798p PS=2.605u PD=0.8u rfmode=0
M$47864 VDD \$5086 \$4953 VDD sg13_lv_pmos L=0.13u W=1u AS=0.3623875p AD=0.34p
+ PS=2.605u PD=2.68u rfmode=0
M$47865 \$4809 VDD VDD VDD sg13_lv_pmos L=0.13u W=0.42u AS=0.147p AD=0.1563p
+ PS=1.54u PD=1.22u rfmode=0
M$47866 VDD \$4665 \$4869 VDD sg13_lv_pmos L=0.13u W=0.42u AS=0.1563p
+ AD=0.0546p PS=1.22u PD=0.68u rfmode=0
M$47867 \$4869 \$4666 \$4809 VDD sg13_lv_pmos L=0.13u W=0.42u AS=0.0546p
+ AD=0.0798p PS=0.68u PD=0.8u rfmode=0
M$47868 \$4809 \$4762 \$4712 VDD sg13_lv_pmos L=0.13u W=0.42u AS=0.0798p
+ AD=0.1428p PS=0.8u PD=1.52u rfmode=0
M$47869 \$5127 \$4954 VDD VDD sg13_lv_pmos L=0.13u W=1.12u AS=0.3864p
+ AD=0.431025p PS=2.93u PD=2.145u rfmode=0
M$47870 VDD CLK|clk|core|fclk_in|p2c|ui_p2c[6] \$4954 VDD sg13_lv_pmos L=0.13u
+ W=1.12u AS=0.431025p AD=0.3808p PS=2.145u PD=2.92u rfmode=0
M$47871 \$5043 \$5127 \$5158 VDD sg13_lv_pmos L=0.13u W=0.42u AS=0.19115p
+ AD=0.0525p PS=1.565u PD=0.67u rfmode=0
M$47872 \$5158 \$5087 VDD VDD sg13_lv_pmos L=0.13u W=0.42u AS=0.0525p
+ AD=0.25605p PS=0.67u PD=1.935u rfmode=0
M$47873 VDD VDD \$5087 VDD sg13_lv_pmos L=0.13u W=0.42u AS=0.25605p AD=0.0798p
+ PS=1.935u PD=0.8u rfmode=0
M$47874 VDD \$5043 \$5087 VDD sg13_lv_pmos L=0.13u W=0.42u AS=0.2014p
+ AD=0.0798p PS=1.53u PD=0.8u rfmode=0
M$47875 VDD \$5043 \$5003 VDD sg13_lv_pmos L=0.13u W=1u AS=0.2083p AD=0.34p
+ PS=1.5u PD=2.68u rfmode=0
M$47876 VDD \$5043 \$5002 VDD sg13_lv_pmos L=0.13u W=2.24u AS=0.4142p
+ AD=0.4211p PS=3.03u PD=3u rfmode=0
M$47878 \$4953 \$4954 \$5043 VDD sg13_lv_pmos L=0.13u W=1u AS=0.34p AD=0.19115p
+ PS=2.68u PD=1.565u rfmode=0
M$47879 VDD \$5003 \$5004 VDD sg13_lv_pmos L=0.13u W=2.24u AS=0.5964p
+ AD=0.5964p PS=4.425u PD=4.425u rfmode=0
M$47881 VDD \$5006 \$5045 VDD sg13_lv_pmos L=0.13u W=2.24u AS=0.616p AD=0.4312p
+ PS=4.46u PD=3.01u rfmode=0
M$47883 VDD \$3439 \$5045 VDD sg13_lv_pmos L=0.13u W=2.24u AS=0.4312p
+ AD=0.6048p PS=3.01u PD=4.44u rfmode=0
M$47885 VDD \$5045 \$5129 VDD sg13_lv_pmos L=0.13u W=0.42u AS=0.1428p
+ AD=0.0798p PS=1.52u PD=0.8u rfmode=0
M$47886 VDD VDD \$5129 VDD sg13_lv_pmos L=0.13u W=0.42u AS=0.3623875p
+ AD=0.0798p PS=2.605u PD=0.8u rfmode=0
M$47887 VDD \$5088 \$4955 VDD sg13_lv_pmos L=0.13u W=1u AS=0.3623875p AD=0.34p
+ PS=2.605u PD=2.68u rfmode=0
M$47888 \$4811 VDD VDD VDD sg13_lv_pmos L=0.13u W=0.42u AS=0.147p AD=0.1563p
+ PS=1.54u PD=1.22u rfmode=0
M$47889 VDD \$4667 \$4874 VDD sg13_lv_pmos L=0.13u W=0.42u AS=0.1563p
+ AD=0.0546p PS=1.22u PD=0.68u rfmode=0
M$47890 \$4874 \$4668 \$4811 VDD sg13_lv_pmos L=0.13u W=0.42u AS=0.0546p
+ AD=0.0798p PS=0.68u PD=0.8u rfmode=0
M$47891 \$4811 \$4766 \$4721 VDD sg13_lv_pmos L=0.13u W=0.42u AS=0.0798p
+ AD=0.1428p PS=0.8u PD=1.52u rfmode=0
M$47892 \$5130 \$4956 VDD VDD sg13_lv_pmos L=0.13u W=1.12u AS=0.3864p
+ AD=0.431025p PS=2.93u PD=2.145u rfmode=0
M$47893 VDD CLK|clk|core|fclk_in|p2c|ui_p2c[6] \$4956 VDD sg13_lv_pmos L=0.13u
+ W=1.12u AS=0.431025p AD=0.3808p PS=2.145u PD=2.92u rfmode=0
M$47894 \$5046 \$5130 \$5163 VDD sg13_lv_pmos L=0.13u W=0.42u AS=0.19115p
+ AD=0.0525p PS=1.565u PD=0.67u rfmode=0
M$47895 \$5163 \$5089 VDD VDD sg13_lv_pmos L=0.13u W=0.42u AS=0.0525p
+ AD=0.25605p PS=0.67u PD=1.935u rfmode=0
M$47896 VDD VDD \$5089 VDD sg13_lv_pmos L=0.13u W=0.42u AS=0.25605p AD=0.0798p
+ PS=1.935u PD=0.8u rfmode=0
M$47897 VDD \$5046 \$5089 VDD sg13_lv_pmos L=0.13u W=0.42u AS=0.2014p
+ AD=0.0798p PS=1.53u PD=0.8u rfmode=0
M$47898 VDD \$5046 \$5011 VDD sg13_lv_pmos L=0.13u W=1u AS=0.2083p AD=0.34p
+ PS=1.5u PD=2.68u rfmode=0
M$47899 VDD \$5046 \$5010 VDD sg13_lv_pmos L=0.13u W=2.24u AS=0.4142p
+ AD=0.4211p PS=3.03u PD=3u rfmode=0
M$47901 \$4955 \$4956 \$5046 VDD sg13_lv_pmos L=0.13u W=1u AS=0.34p AD=0.19115p
+ PS=2.68u PD=1.565u rfmode=0
M$47902 VDD \$5011 \$5012 VDD sg13_lv_pmos L=0.13u W=2.24u AS=0.5964p
+ AD=0.5964p PS=4.425u PD=4.425u rfmode=0
M$47904 VDD \$5014 \$5048 VDD sg13_lv_pmos L=0.13u W=2.24u AS=0.616p AD=0.4312p
+ PS=4.46u PD=3.01u rfmode=0
M$47906 VDD \$3439 \$5048 VDD sg13_lv_pmos L=0.13u W=2.24u AS=0.4312p
+ AD=0.6048p PS=3.01u PD=4.44u rfmode=0
M$47908 VDD \$5048 \$5132 VDD sg13_lv_pmos L=0.13u W=0.42u AS=0.1428p
+ AD=0.0798p PS=1.52u PD=0.8u rfmode=0
M$47909 VDD VDD \$5132 VDD sg13_lv_pmos L=0.13u W=0.42u AS=0.3623875p
+ AD=0.0798p PS=2.605u PD=0.8u rfmode=0
M$47910 VDD \$5090 \$4957 VDD sg13_lv_pmos L=0.13u W=1u AS=0.3623875p AD=0.34p
+ PS=2.605u PD=2.68u rfmode=0
M$47911 \$4813 VDD VDD VDD sg13_lv_pmos L=0.13u W=0.42u AS=0.147p AD=0.1563p
+ PS=1.54u PD=1.22u rfmode=0
M$47912 VDD \$4669 \$4879 VDD sg13_lv_pmos L=0.13u W=0.42u AS=0.1563p
+ AD=0.0546p PS=1.22u PD=0.68u rfmode=0
M$47913 \$4879 \$4670 \$4813 VDD sg13_lv_pmos L=0.13u W=0.42u AS=0.0546p
+ AD=0.0798p PS=0.68u PD=0.8u rfmode=0
M$47914 \$4813 \$4770 \$4730 VDD sg13_lv_pmos L=0.13u W=0.42u AS=0.0798p
+ AD=0.1428p PS=0.8u PD=1.52u rfmode=0
M$47915 \$5133 \$4958 VDD VDD sg13_lv_pmos L=0.13u W=1.12u AS=0.3864p
+ AD=0.431025p PS=2.93u PD=2.145u rfmode=0
M$47916 VDD CLK|clk|core|fclk_in|p2c|ui_p2c[6] \$4958 VDD sg13_lv_pmos L=0.13u
+ W=1.12u AS=0.431025p AD=0.3808p PS=2.145u PD=2.92u rfmode=0
M$47917 \$5049 \$5133 \$5168 VDD sg13_lv_pmos L=0.13u W=0.42u AS=0.19115p
+ AD=0.0525p PS=1.565u PD=0.67u rfmode=0
M$47918 \$5168 \$5091 VDD VDD sg13_lv_pmos L=0.13u W=0.42u AS=0.0525p
+ AD=0.25605p PS=0.67u PD=1.935u rfmode=0
M$47919 VDD VDD \$5091 VDD sg13_lv_pmos L=0.13u W=0.42u AS=0.25605p AD=0.0798p
+ PS=1.935u PD=0.8u rfmode=0
M$47920 VDD \$5049 \$5091 VDD sg13_lv_pmos L=0.13u W=0.42u AS=0.2014p
+ AD=0.0798p PS=1.53u PD=0.8u rfmode=0
M$47921 VDD \$5049 \$5019 VDD sg13_lv_pmos L=0.13u W=1u AS=0.2083p AD=0.34p
+ PS=1.5u PD=2.68u rfmode=0
M$47922 VDD \$5049 \$5018 VDD sg13_lv_pmos L=0.13u W=2.24u AS=0.4142p
+ AD=0.4211p PS=3.03u PD=3u rfmode=0
M$47924 \$4957 \$4958 \$5049 VDD sg13_lv_pmos L=0.13u W=1u AS=0.34p AD=0.19115p
+ PS=2.68u PD=1.565u rfmode=0
M$47925 VDD \$5019 \$5020 VDD sg13_lv_pmos L=0.13u W=2.24u AS=0.5964p
+ AD=0.5964p PS=4.425u PD=4.425u rfmode=0
M$47927 VDD \$5022 \$5051 VDD sg13_lv_pmos L=0.13u W=2.24u AS=0.616p AD=0.4312p
+ PS=4.46u PD=3.01u rfmode=0
M$47929 VDD \$3439 \$5051 VDD sg13_lv_pmos L=0.13u W=2.24u AS=0.4312p
+ AD=0.6048p PS=3.01u PD=4.44u rfmode=0
M$47931 VDD \$5051 \$5024 VDD sg13_lv_pmos L=0.13u W=0.42u AS=0.1428p
+ AD=0.0798p PS=1.52u PD=0.8u rfmode=0
M$47932 VDD VDD \$5024 VDD sg13_lv_pmos L=0.13u W=0.42u AS=0.3623875p
+ AD=0.0798p PS=2.605u PD=0.8u rfmode=0
M$47933 VDD \$5092 \$4959 VDD sg13_lv_pmos L=0.13u W=1u AS=0.3623875p AD=0.34p
+ PS=2.605u PD=2.68u rfmode=0
M$47934 \$4815 VDD VDD VDD sg13_lv_pmos L=0.13u W=0.42u AS=0.147p AD=0.1563p
+ PS=1.54u PD=1.22u rfmode=0
M$47935 VDD \$4671 \$4886 VDD sg13_lv_pmos L=0.13u W=0.42u AS=0.1563p
+ AD=0.0546p PS=1.22u PD=0.68u rfmode=0
M$47936 \$4886 \$4672 \$4815 VDD sg13_lv_pmos L=0.13u W=0.42u AS=0.0546p
+ AD=0.0798p PS=0.68u PD=0.8u rfmode=0
M$47937 \$4815 \$4774 \$4739 VDD sg13_lv_pmos L=0.13u W=0.42u AS=0.0798p
+ AD=0.1428p PS=0.8u PD=1.52u rfmode=0
M$47938 \$5135 \$4960 VDD VDD sg13_lv_pmos L=0.13u W=1.12u AS=0.3864p
+ AD=0.431025p PS=2.93u PD=2.145u rfmode=0
M$47939 VDD CLK|clk|core|fclk_in|p2c|ui_p2c[6] \$4960 VDD sg13_lv_pmos L=0.13u
+ W=1.12u AS=0.431025p AD=0.3808p PS=2.145u PD=2.92u rfmode=0
M$47940 \$5052 \$5135 \$5173 VDD sg13_lv_pmos L=0.13u W=0.42u AS=0.19115p
+ AD=0.0525p PS=1.565u PD=0.67u rfmode=0
M$47941 \$5173 \$5093 VDD VDD sg13_lv_pmos L=0.13u W=0.42u AS=0.0525p
+ AD=0.25605p PS=0.67u PD=1.935u rfmode=0
M$47942 VDD VDD \$5093 VDD sg13_lv_pmos L=0.13u W=0.42u AS=0.25605p AD=0.0798p
+ PS=1.935u PD=0.8u rfmode=0
M$47943 VDD \$5052 \$5093 VDD sg13_lv_pmos L=0.13u W=0.42u AS=0.2014p
+ AD=0.0798p PS=1.53u PD=0.8u rfmode=0
M$47944 VDD \$5052 \$5028 VDD sg13_lv_pmos L=0.13u W=1u AS=0.2083p AD=0.34p
+ PS=1.5u PD=2.68u rfmode=0
M$47945 VDD \$5052 \$5027 VDD sg13_lv_pmos L=0.13u W=2.24u AS=0.4142p
+ AD=0.4211p PS=3.03u PD=3u rfmode=0
M$47947 \$4959 \$4960 \$5052 VDD sg13_lv_pmos L=0.13u W=1u AS=0.34p AD=0.19115p
+ PS=2.68u PD=1.565u rfmode=0
M$47948 VDD \$5028 \$5029 VDD sg13_lv_pmos L=0.13u W=2.24u AS=0.5964p
+ AD=0.5964p PS=4.425u PD=4.425u rfmode=0
M$47950 \$4961 \$3192 \$5177 VDD sg13_lv_pmos L=0.13u W=0.84u AS=0.2856p
+ AD=0.1596p PS=2.36u PD=1.22u rfmode=0
M$47951 VDD \$3685 \$5177 VDD sg13_lv_pmos L=0.13u W=0.84u AS=0.2226p
+ AD=0.1596p PS=1.535u PD=1.22u rfmode=0
M$47952 VDD \$4961 \$4962 VDD sg13_lv_pmos L=0.13u W=2.24u AS=0.4746p
+ AD=0.6776p PS=3.105u PD=4.57u rfmode=0
M$47954 VDD \$5264 \$5326 VDD sg13_lv_pmos L=0.13u W=2.24u AS=0.616p AD=0.4312p
+ PS=4.46u PD=3.01u rfmode=0
M$47956 VDD \$3685 \$5326 VDD sg13_lv_pmos L=0.13u W=2.24u AS=0.4312p
+ AD=0.6048p PS=3.01u PD=4.44u rfmode=0
M$47958 \$5078 VDD VDD VDD sg13_lv_pmos L=0.13u W=0.42u AS=0.147p AD=0.1563p
+ PS=1.54u PD=1.22u rfmode=0
M$47959 VDD \$4945 \$5137 VDD sg13_lv_pmos L=0.13u W=0.42u AS=0.1563p
+ AD=0.0546p PS=1.22u PD=0.68u rfmode=0
M$47960 \$5137 \$4946 \$5078 VDD sg13_lv_pmos L=0.13u W=0.42u AS=0.0546p
+ AD=0.0798p PS=0.68u PD=0.8u rfmode=0
M$47961 \$5078 \$5118 \$4964 VDD sg13_lv_pmos L=0.13u W=0.42u AS=0.0798p
+ AD=0.1428p PS=0.8u PD=1.52u rfmode=0
M$47962 \$5327 \$5250 VDD VDD sg13_lv_pmos L=0.13u W=1.12u AS=0.3864p
+ AD=0.431025p PS=2.93u PD=2.145u rfmode=0
M$47963 VDD CLK|clk|core|fclk_in|p2c|ui_p2c[6] \$5250 VDD sg13_lv_pmos L=0.13u
+ W=1.12u AS=0.431025p AD=0.3808p PS=2.145u PD=2.92u rfmode=0
M$47964 \$5328 \$5327 \$5425 VDD sg13_lv_pmos L=0.13u W=0.42u AS=0.19115p
+ AD=0.0525p PS=1.565u PD=0.67u rfmode=0
M$47965 \$5425 \$5397 VDD VDD sg13_lv_pmos L=0.13u W=0.42u AS=0.0525p
+ AD=0.25605p PS=0.67u PD=1.935u rfmode=0
M$47966 VDD VDD \$5397 VDD sg13_lv_pmos L=0.13u W=0.42u AS=0.25605p AD=0.0798p
+ PS=1.935u PD=0.8u rfmode=0
M$47967 VDD \$5328 \$5397 VDD sg13_lv_pmos L=0.13u W=0.42u AS=0.2014p
+ AD=0.0798p PS=1.53u PD=0.8u rfmode=0
M$47968 VDD \$5328 \$5270 VDD sg13_lv_pmos L=0.13u W=1u AS=0.2083p AD=0.34p
+ PS=1.5u PD=2.68u rfmode=0
M$47969 VDD \$5328 \$5269 VDD sg13_lv_pmos L=0.13u W=2.24u AS=0.4142p
+ AD=0.4211p PS=3.03u PD=3u rfmode=0
M$47971 \$5249 \$5250 \$5328 VDD sg13_lv_pmos L=0.13u W=1u AS=0.34p AD=0.19115p
+ PS=2.68u PD=1.565u rfmode=0
M$47972 VDD \$5270 \$5271 VDD sg13_lv_pmos L=0.13u W=2.24u AS=0.5964p
+ AD=0.5964p PS=4.425u PD=4.425u rfmode=0
M$47974 \$4970 \$3193 \$5178 VDD sg13_lv_pmos L=0.13u W=0.84u AS=0.2856p
+ AD=0.1596p PS=2.36u PD=1.22u rfmode=0
M$47975 VDD \$3685 \$5178 VDD sg13_lv_pmos L=0.13u W=0.84u AS=0.2226p
+ AD=0.1596p PS=1.535u PD=1.22u rfmode=0
M$47976 VDD \$4970 \$4971 VDD sg13_lv_pmos L=0.13u W=2.24u AS=0.4746p
+ AD=0.6776p PS=3.105u PD=4.57u rfmode=0
M$47978 VDD \$5273 \$5330 VDD sg13_lv_pmos L=0.13u W=2.24u AS=0.616p AD=0.4312p
+ PS=4.46u PD=3.01u rfmode=0
M$47980 VDD \$3685 \$5330 VDD sg13_lv_pmos L=0.13u W=2.24u AS=0.4312p
+ AD=0.6048p PS=3.01u PD=4.44u rfmode=0
M$47982 \$5080 VDD VDD VDD sg13_lv_pmos L=0.13u W=0.42u AS=0.147p AD=0.1563p
+ PS=1.54u PD=1.22u rfmode=0
M$47983 VDD \$4947 \$5143 VDD sg13_lv_pmos L=0.13u W=0.42u AS=0.1563p
+ AD=0.0546p PS=1.22u PD=0.68u rfmode=0
M$47984 \$5143 \$4948 \$5080 VDD sg13_lv_pmos L=0.13u W=0.42u AS=0.0546p
+ AD=0.0798p PS=0.68u PD=0.8u rfmode=0
M$47985 \$5080 \$5120 \$4973 VDD sg13_lv_pmos L=0.13u W=0.42u AS=0.0798p
+ AD=0.1428p PS=0.8u PD=1.52u rfmode=0
M$47986 \$5331 \$5252 VDD VDD sg13_lv_pmos L=0.13u W=1.12u AS=0.3864p
+ AD=0.431025p PS=2.93u PD=2.145u rfmode=0
M$47987 VDD CLK|clk|core|fclk_in|p2c|ui_p2c[6] \$5252 VDD sg13_lv_pmos L=0.13u
+ W=1.12u AS=0.431025p AD=0.3808p PS=2.145u PD=2.92u rfmode=0
M$47988 \$5332 \$5331 \$5437 VDD sg13_lv_pmos L=0.13u W=0.42u AS=0.19115p
+ AD=0.0525p PS=1.565u PD=0.67u rfmode=0
M$47989 \$5437 \$5399 VDD VDD sg13_lv_pmos L=0.13u W=0.42u AS=0.0525p
+ AD=0.25605p PS=0.67u PD=1.935u rfmode=0
M$47990 VDD VDD \$5399 VDD sg13_lv_pmos L=0.13u W=0.42u AS=0.25605p AD=0.0798p
+ PS=1.935u PD=0.8u rfmode=0
M$47991 VDD \$5332 \$5399 VDD sg13_lv_pmos L=0.13u W=0.42u AS=0.2014p
+ AD=0.0798p PS=1.53u PD=0.8u rfmode=0
M$47992 VDD \$5332 \$5279 VDD sg13_lv_pmos L=0.13u W=1u AS=0.2083p AD=0.34p
+ PS=1.5u PD=2.68u rfmode=0
M$47993 VDD \$5332 \$5278 VDD sg13_lv_pmos L=0.13u W=2.24u AS=0.4142p
+ AD=0.4211p PS=3.03u PD=3u rfmode=0
M$47995 \$5251 \$5252 \$5332 VDD sg13_lv_pmos L=0.13u W=1u AS=0.34p AD=0.19115p
+ PS=2.68u PD=1.565u rfmode=0
M$47996 VDD \$5279 \$5280 VDD sg13_lv_pmos L=0.13u W=2.24u AS=0.5964p
+ AD=0.5964p PS=4.425u PD=4.425u rfmode=0
M$47998 \$4979 \$3194 \$5179 VDD sg13_lv_pmos L=0.13u W=0.84u AS=0.2856p
+ AD=0.1596p PS=2.36u PD=1.22u rfmode=0
M$47999 VDD \$3685 \$5179 VDD sg13_lv_pmos L=0.13u W=0.84u AS=0.2226p
+ AD=0.1596p PS=1.535u PD=1.22u rfmode=0
M$48000 VDD \$4979 \$4980 VDD sg13_lv_pmos L=0.13u W=2.24u AS=0.4746p
+ AD=0.6776p PS=3.105u PD=4.57u rfmode=0
M$48002 VDD \$5282 \$5334 VDD sg13_lv_pmos L=0.13u W=2.24u AS=0.616p AD=0.4312p
+ PS=4.46u PD=3.01u rfmode=0
M$48004 VDD \$3685 \$5334 VDD sg13_lv_pmos L=0.13u W=2.24u AS=0.4312p
+ AD=0.6048p PS=3.01u PD=4.44u rfmode=0
M$48006 \$5082 VDD VDD VDD sg13_lv_pmos L=0.13u W=0.42u AS=0.147p AD=0.1563p
+ PS=1.54u PD=1.22u rfmode=0
M$48007 VDD \$4949 \$5148 VDD sg13_lv_pmos L=0.13u W=0.42u AS=0.1563p
+ AD=0.0546p PS=1.22u PD=0.68u rfmode=0
M$48008 \$5148 \$4950 \$5082 VDD sg13_lv_pmos L=0.13u W=0.42u AS=0.0546p
+ AD=0.0798p PS=0.68u PD=0.8u rfmode=0
M$48009 \$5082 \$5123 \$5122 VDD sg13_lv_pmos L=0.13u W=0.42u AS=0.0798p
+ AD=0.1428p PS=0.8u PD=1.52u rfmode=0
M$48010 \$5335 \$5254 VDD VDD sg13_lv_pmos L=0.13u W=1.12u AS=0.3864p
+ AD=0.431025p PS=2.93u PD=2.145u rfmode=0
M$48011 VDD CLK|clk|core|fclk_in|p2c|ui_p2c[6] \$5254 VDD sg13_lv_pmos L=0.13u
+ W=1.12u AS=0.431025p AD=0.3808p PS=2.145u PD=2.92u rfmode=0
M$48012 \$5336 \$5335 \$5443 VDD sg13_lv_pmos L=0.13u W=0.42u AS=0.19115p
+ AD=0.0525p PS=1.565u PD=0.67u rfmode=0
M$48013 \$5443 \$5401 VDD VDD sg13_lv_pmos L=0.13u W=0.42u AS=0.0525p
+ AD=0.25605p PS=0.67u PD=1.935u rfmode=0
M$48014 VDD VDD \$5401 VDD sg13_lv_pmos L=0.13u W=0.42u AS=0.25605p AD=0.0798p
+ PS=1.935u PD=0.8u rfmode=0
M$48015 VDD \$5336 \$5401 VDD sg13_lv_pmos L=0.13u W=0.42u AS=0.2014p
+ AD=0.0798p PS=1.53u PD=0.8u rfmode=0
M$48016 VDD \$5336 \$5288 VDD sg13_lv_pmos L=0.13u W=1u AS=0.2083p AD=0.34p
+ PS=1.5u PD=2.68u rfmode=0
M$48017 VDD \$5336 \$5287 VDD sg13_lv_pmos L=0.13u W=2.24u AS=0.4142p
+ AD=0.4211p PS=3.03u PD=3u rfmode=0
M$48019 \$5253 \$5254 \$5336 VDD sg13_lv_pmos L=0.13u W=1u AS=0.34p AD=0.19115p
+ PS=2.68u PD=1.565u rfmode=0
M$48020 VDD \$5288 \$5289 VDD sg13_lv_pmos L=0.13u W=2.24u AS=0.5964p
+ AD=0.5964p PS=4.425u PD=4.425u rfmode=0
M$48022 \$4987 \$3195 \$5180 VDD sg13_lv_pmos L=0.13u W=0.84u AS=0.2856p
+ AD=0.1596p PS=2.36u PD=1.22u rfmode=0
M$48023 VDD \$3685 \$5180 VDD sg13_lv_pmos L=0.13u W=0.84u AS=0.2226p
+ AD=0.1596p PS=1.535u PD=1.22u rfmode=0
M$48024 VDD \$4987 \$4988 VDD sg13_lv_pmos L=0.13u W=2.24u AS=0.4746p
+ AD=0.6776p PS=3.105u PD=4.57u rfmode=0
M$48026 VDD \$5291 \$5338 VDD sg13_lv_pmos L=0.13u W=2.24u AS=0.616p AD=0.4312p
+ PS=4.46u PD=3.01u rfmode=0
M$48028 VDD \$3685 \$5338 VDD sg13_lv_pmos L=0.13u W=2.24u AS=0.4312p
+ AD=0.6048p PS=3.01u PD=4.44u rfmode=0
M$48030 \$5084 VDD VDD VDD sg13_lv_pmos L=0.13u W=0.42u AS=0.147p AD=0.1563p
+ PS=1.54u PD=1.22u rfmode=0
M$48031 VDD \$4951 \$5153 VDD sg13_lv_pmos L=0.13u W=0.42u AS=0.1563p
+ AD=0.0546p PS=1.22u PD=0.68u rfmode=0
M$48032 \$5153 \$4952 \$5084 VDD sg13_lv_pmos L=0.13u W=0.42u AS=0.0546p
+ AD=0.0798p PS=0.68u PD=0.8u rfmode=0
M$48033 \$5084 \$5125 \$4990 VDD sg13_lv_pmos L=0.13u W=0.42u AS=0.0798p
+ AD=0.1428p PS=0.8u PD=1.52u rfmode=0
M$48034 \$5339 \$5256 VDD VDD sg13_lv_pmos L=0.13u W=1.12u AS=0.3864p
+ AD=0.431025p PS=2.93u PD=2.145u rfmode=0
M$48035 VDD CLK|clk|core|fclk_in|p2c|ui_p2c[6] \$5256 VDD sg13_lv_pmos L=0.13u
+ W=1.12u AS=0.431025p AD=0.3808p PS=2.145u PD=2.92u rfmode=0
M$48036 \$5340 \$5339 \$5450 VDD sg13_lv_pmos L=0.13u W=0.42u AS=0.19115p
+ AD=0.0525p PS=1.565u PD=0.67u rfmode=0
M$48037 \$5450 \$5403 VDD VDD sg13_lv_pmos L=0.13u W=0.42u AS=0.0525p
+ AD=0.25605p PS=0.67u PD=1.935u rfmode=0
M$48038 VDD VDD \$5403 VDD sg13_lv_pmos L=0.13u W=0.42u AS=0.25605p AD=0.0798p
+ PS=1.935u PD=0.8u rfmode=0
M$48039 VDD \$5340 \$5403 VDD sg13_lv_pmos L=0.13u W=0.42u AS=0.2014p
+ AD=0.0798p PS=1.53u PD=0.8u rfmode=0
M$48040 VDD \$5340 \$5297 VDD sg13_lv_pmos L=0.13u W=1u AS=0.2083p AD=0.34p
+ PS=1.5u PD=2.68u rfmode=0
M$48041 VDD \$5340 \$5296 VDD sg13_lv_pmos L=0.13u W=2.24u AS=0.4142p
+ AD=0.4211p PS=3.03u PD=3u rfmode=0
M$48043 \$5255 \$5256 \$5340 VDD sg13_lv_pmos L=0.13u W=1u AS=0.34p AD=0.19115p
+ PS=2.68u PD=1.565u rfmode=0
M$48044 VDD \$5297 \$5298 VDD sg13_lv_pmos L=0.13u W=2.24u AS=0.5964p
+ AD=0.5964p PS=4.425u PD=4.425u rfmode=0
M$48046 \$4996 \$3196 \$5181 VDD sg13_lv_pmos L=0.13u W=0.84u AS=0.2856p
+ AD=0.1596p PS=2.36u PD=1.22u rfmode=0
M$48047 VDD \$3685 \$5181 VDD sg13_lv_pmos L=0.13u W=0.84u AS=0.2226p
+ AD=0.1596p PS=1.535u PD=1.22u rfmode=0
M$48048 VDD \$4996 \$4997 VDD sg13_lv_pmos L=0.13u W=2.24u AS=0.4746p
+ AD=0.6776p PS=3.105u PD=4.57u rfmode=0
M$48050 VDD \$5300 \$5342 VDD sg13_lv_pmos L=0.13u W=2.24u AS=0.616p AD=0.4312p
+ PS=4.46u PD=3.01u rfmode=0
M$48052 VDD \$3685 \$5342 VDD sg13_lv_pmos L=0.13u W=2.24u AS=0.4312p
+ AD=0.6048p PS=3.01u PD=4.44u rfmode=0
M$48054 \$5086 VDD VDD VDD sg13_lv_pmos L=0.13u W=0.42u AS=0.147p AD=0.1563p
+ PS=1.54u PD=1.22u rfmode=0
M$48055 VDD \$4953 \$5157 VDD sg13_lv_pmos L=0.13u W=0.42u AS=0.1563p
+ AD=0.0546p PS=1.22u PD=0.68u rfmode=0
M$48056 \$5157 \$4954 \$5086 VDD sg13_lv_pmos L=0.13u W=0.42u AS=0.0546p
+ AD=0.0798p PS=0.68u PD=0.8u rfmode=0
M$48057 \$5086 \$5127 \$4999 VDD sg13_lv_pmos L=0.13u W=0.42u AS=0.0798p
+ AD=0.1428p PS=0.8u PD=1.52u rfmode=0
M$48058 \$5343 \$5258 VDD VDD sg13_lv_pmos L=0.13u W=1.12u AS=0.3864p
+ AD=0.431025p PS=2.93u PD=2.145u rfmode=0
M$48059 VDD CLK|clk|core|fclk_in|p2c|ui_p2c[6] \$5258 VDD sg13_lv_pmos L=0.13u
+ W=1.12u AS=0.431025p AD=0.3808p PS=2.145u PD=2.92u rfmode=0
M$48060 \$5344 \$5343 \$5436 VDD sg13_lv_pmos L=0.13u W=0.42u AS=0.19115p
+ AD=0.0525p PS=1.565u PD=0.67u rfmode=0
M$48061 \$5436 \$5405 VDD VDD sg13_lv_pmos L=0.13u W=0.42u AS=0.0525p
+ AD=0.25605p PS=0.67u PD=1.935u rfmode=0
M$48062 VDD VDD \$5405 VDD sg13_lv_pmos L=0.13u W=0.42u AS=0.25605p AD=0.0798p
+ PS=1.935u PD=0.8u rfmode=0
M$48063 VDD \$5344 \$5405 VDD sg13_lv_pmos L=0.13u W=0.42u AS=0.2014p
+ AD=0.0798p PS=1.53u PD=0.8u rfmode=0
M$48064 VDD \$5344 \$5306 VDD sg13_lv_pmos L=0.13u W=1u AS=0.2083p AD=0.34p
+ PS=1.5u PD=2.68u rfmode=0
M$48065 VDD \$5344 \$5305 VDD sg13_lv_pmos L=0.13u W=2.24u AS=0.4142p
+ AD=0.4211p PS=3.03u PD=3u rfmode=0
M$48067 \$5257 \$5258 \$5344 VDD sg13_lv_pmos L=0.13u W=1u AS=0.34p AD=0.19115p
+ PS=2.68u PD=1.565u rfmode=0
M$48068 VDD \$5306 \$5307 VDD sg13_lv_pmos L=0.13u W=2.24u AS=0.5964p
+ AD=0.5964p PS=4.425u PD=4.425u rfmode=0
M$48070 \$5005 \$3197 \$5182 VDD sg13_lv_pmos L=0.13u W=0.84u AS=0.2856p
+ AD=0.1596p PS=2.36u PD=1.22u rfmode=0
M$48071 VDD \$3685 \$5182 VDD sg13_lv_pmos L=0.13u W=0.84u AS=0.2226p
+ AD=0.1596p PS=1.535u PD=1.22u rfmode=0
M$48072 VDD \$5005 \$5006 VDD sg13_lv_pmos L=0.13u W=2.24u AS=0.4746p
+ AD=0.6776p PS=3.105u PD=4.57u rfmode=0
M$48074 VDD \$5309 \$5346 VDD sg13_lv_pmos L=0.13u W=2.24u AS=0.616p AD=0.4312p
+ PS=4.46u PD=3.01u rfmode=0
M$48076 VDD \$3685 \$5346 VDD sg13_lv_pmos L=0.13u W=2.24u AS=0.4312p
+ AD=0.6048p PS=3.01u PD=4.44u rfmode=0
M$48078 \$5088 VDD VDD VDD sg13_lv_pmos L=0.13u W=0.42u AS=0.147p AD=0.1563p
+ PS=1.54u PD=1.22u rfmode=0
M$48079 VDD \$4955 \$5162 VDD sg13_lv_pmos L=0.13u W=0.42u AS=0.1563p
+ AD=0.0546p PS=1.22u PD=0.68u rfmode=0
M$48080 \$5162 \$4956 \$5088 VDD sg13_lv_pmos L=0.13u W=0.42u AS=0.0546p
+ AD=0.0798p PS=0.68u PD=0.8u rfmode=0
M$48081 \$5088 \$5130 \$5129 VDD sg13_lv_pmos L=0.13u W=0.42u AS=0.0798p
+ AD=0.1428p PS=0.8u PD=1.52u rfmode=0
M$48082 \$5347 \$5260 VDD VDD sg13_lv_pmos L=0.13u W=1.12u AS=0.3864p
+ AD=0.431025p PS=2.93u PD=2.145u rfmode=0
M$48083 VDD CLK|clk|core|fclk_in|p2c|ui_p2c[6] \$5260 VDD sg13_lv_pmos L=0.13u
+ W=1.12u AS=0.431025p AD=0.3808p PS=2.145u PD=2.92u rfmode=0
M$48084 \$5348 \$5347 \$5428 VDD sg13_lv_pmos L=0.13u W=0.42u AS=0.19115p
+ AD=0.0525p PS=1.565u PD=0.67u rfmode=0
M$48085 \$5428 \$5407 VDD VDD sg13_lv_pmos L=0.13u W=0.42u AS=0.0525p
+ AD=0.25605p PS=0.67u PD=1.935u rfmode=0
M$48086 VDD VDD \$5407 VDD sg13_lv_pmos L=0.13u W=0.42u AS=0.25605p AD=0.0798p
+ PS=1.935u PD=0.8u rfmode=0
M$48087 VDD \$5348 \$5407 VDD sg13_lv_pmos L=0.13u W=0.42u AS=0.2014p
+ AD=0.0798p PS=1.53u PD=0.8u rfmode=0
M$48088 VDD \$5348 \$5315 VDD sg13_lv_pmos L=0.13u W=1u AS=0.2083p AD=0.34p
+ PS=1.5u PD=2.68u rfmode=0
M$48089 VDD \$5348 \$5314 VDD sg13_lv_pmos L=0.13u W=2.24u AS=0.4142p
+ AD=0.4211p PS=3.03u PD=3u rfmode=0
M$48091 \$5259 \$5260 \$5348 VDD sg13_lv_pmos L=0.13u W=1u AS=0.34p AD=0.19115p
+ PS=2.68u PD=1.565u rfmode=0
M$48092 VDD \$5315 \$5316 VDD sg13_lv_pmos L=0.13u W=2.24u AS=0.5964p
+ AD=0.5964p PS=4.425u PD=4.425u rfmode=0
M$48094 \$5013 \$3198 \$5183 VDD sg13_lv_pmos L=0.13u W=0.84u AS=0.2856p
+ AD=0.1596p PS=2.36u PD=1.22u rfmode=0
M$48095 VDD \$3685 \$5183 VDD sg13_lv_pmos L=0.13u W=0.84u AS=0.2226p
+ AD=0.1596p PS=1.535u PD=1.22u rfmode=0
M$48096 VDD \$5013 \$5014 VDD sg13_lv_pmos L=0.13u W=2.24u AS=0.4746p
+ AD=0.6776p PS=3.105u PD=4.57u rfmode=0
M$48098 VDD \$5318 \$5350 VDD sg13_lv_pmos L=0.13u W=2.24u AS=0.616p AD=0.4312p
+ PS=4.46u PD=3.01u rfmode=0
M$48100 VDD \$3685 \$5350 VDD sg13_lv_pmos L=0.13u W=2.24u AS=0.4312p
+ AD=0.6048p PS=3.01u PD=4.44u rfmode=0
M$48102 \$5090 VDD VDD VDD sg13_lv_pmos L=0.13u W=0.42u AS=0.147p AD=0.1563p
+ PS=1.54u PD=1.22u rfmode=0
M$48103 VDD \$4957 \$5167 VDD sg13_lv_pmos L=0.13u W=0.42u AS=0.1563p
+ AD=0.0546p PS=1.22u PD=0.68u rfmode=0
M$48104 \$5167 \$4958 \$5090 VDD sg13_lv_pmos L=0.13u W=0.42u AS=0.0546p
+ AD=0.0798p PS=0.68u PD=0.8u rfmode=0
M$48105 \$5090 \$5133 \$5132 VDD sg13_lv_pmos L=0.13u W=0.42u AS=0.0798p
+ AD=0.1428p PS=0.8u PD=1.52u rfmode=0
M$48106 \$5351 \$5262 VDD VDD sg13_lv_pmos L=0.13u W=1.12u AS=0.3864p
+ AD=0.431025p PS=2.93u PD=2.145u rfmode=0
M$48107 VDD CLK|clk|core|fclk_in|p2c|ui_p2c[6] \$5262 VDD sg13_lv_pmos L=0.13u
+ W=1.12u AS=0.431025p AD=0.3808p PS=2.145u PD=2.92u rfmode=0
M$48108 \$5352 \$5351 \$5422 VDD sg13_lv_pmos L=0.13u W=0.42u AS=0.19115p
+ AD=0.0525p PS=1.565u PD=0.67u rfmode=0
M$48109 \$5422 \$5409 VDD VDD sg13_lv_pmos L=0.13u W=0.42u AS=0.0525p
+ AD=0.25605p PS=0.67u PD=1.935u rfmode=0
M$48110 VDD VDD \$5409 VDD sg13_lv_pmos L=0.13u W=0.42u AS=0.25605p AD=0.0798p
+ PS=1.935u PD=0.8u rfmode=0
M$48111 VDD \$5352 \$5409 VDD sg13_lv_pmos L=0.13u W=0.42u AS=0.2014p
+ AD=0.0798p PS=1.53u PD=0.8u rfmode=0
M$48112 VDD \$5352 \$5324 VDD sg13_lv_pmos L=0.13u W=1u AS=0.2083p AD=0.34p
+ PS=1.5u PD=2.68u rfmode=0
M$48113 VDD \$5352 \$5323 VDD sg13_lv_pmos L=0.13u W=2.24u AS=0.4142p
+ AD=0.4211p PS=3.03u PD=3u rfmode=0
M$48115 \$5261 \$5262 \$5352 VDD sg13_lv_pmos L=0.13u W=1u AS=0.34p AD=0.19115p
+ PS=2.68u PD=1.565u rfmode=0
M$48116 VDD \$5324 \$5325 VDD sg13_lv_pmos L=0.13u W=2.24u AS=0.5964p
+ AD=0.5964p PS=4.425u PD=4.425u rfmode=0
M$48118 \$5021 VSS|anode|cathode|vss \$5184 VDD sg13_lv_pmos L=0.13u W=0.84u
+ AS=0.2856p AD=0.1596p PS=2.36u PD=1.22u rfmode=0
M$48119 VDD \$3685 \$5184 VDD sg13_lv_pmos L=0.13u W=0.84u AS=0.2226p
+ AD=0.1596p PS=1.535u PD=1.22u rfmode=0
M$48120 VDD \$5021 \$5022 VDD sg13_lv_pmos L=0.13u W=2.24u AS=0.4746p
+ AD=0.6776p PS=3.105u PD=4.57u rfmode=0
M$48122 \$5092 VDD VDD VDD sg13_lv_pmos L=0.13u W=0.42u AS=0.147p AD=0.1563p
+ PS=1.54u PD=1.22u rfmode=0
M$48123 VDD \$4959 \$5172 VDD sg13_lv_pmos L=0.13u W=0.42u AS=0.1563p
+ AD=0.0546p PS=1.22u PD=0.68u rfmode=0
M$48124 \$5172 \$4960 \$5092 VDD sg13_lv_pmos L=0.13u W=0.42u AS=0.0546p
+ AD=0.0798p PS=0.68u PD=0.8u rfmode=0
M$48125 \$5092 \$5135 \$5024 VDD sg13_lv_pmos L=0.13u W=0.42u AS=0.0798p
+ AD=0.1428p PS=0.8u PD=1.52u rfmode=0
M$48126 \$5263 \$3192 \$5452 VDD sg13_lv_pmos L=0.13u W=0.84u AS=0.2856p
+ AD=0.1596p PS=2.36u PD=1.22u rfmode=0
M$48127 VDD VSS|anode|cathode|vss \$5452 VDD sg13_lv_pmos L=0.13u W=0.84u
+ AS=0.2226p AD=0.1596p PS=1.535u PD=1.22u rfmode=0
M$48128 VDD \$5263 \$5264 VDD sg13_lv_pmos L=0.13u W=2.24u AS=0.4746p
+ AD=0.6776p PS=3.105u PD=4.57u rfmode=0
M$48130 VDD \$5578 \$3194 VDD sg13_lv_pmos L=0.13u W=2.24u AS=0.6776p
+ AD=0.4746p PS=4.57u PD=3.105u rfmode=0
M$48132 VDD \$5574 \$5584 VDD sg13_lv_pmos L=0.13u W=0.84u AS=0.2226p
+ AD=0.1596p PS=1.535u PD=1.22u rfmode=0
M$48133 \$5584 X7|dout[8] \$5578 VDD sg13_lv_pmos L=0.13u W=0.84u AS=0.1596p
+ AD=0.2856p PS=1.22u PD=2.36u rfmode=0
M$48134 VDD \$5326 \$5266 VDD sg13_lv_pmos L=0.13u W=0.42u AS=0.1428p
+ AD=0.0798p PS=1.52u PD=0.8u rfmode=0
M$48135 VDD VDD \$5266 VDD sg13_lv_pmos L=0.13u W=0.42u AS=0.3623875p
+ AD=0.0798p PS=2.605u PD=0.8u rfmode=0
M$48136 VDD \$5396 \$5249 VDD sg13_lv_pmos L=0.13u W=1u AS=0.3623875p AD=0.34p
+ PS=2.605u PD=2.68u rfmode=0
M$48137 VDD \$5563 \$3196 VDD sg13_lv_pmos L=0.13u W=2.24u AS=0.6384p
+ AD=0.4046p PS=4.5u PD=3u rfmode=0
M$48139 VDD \$5576 \$5563 VDD sg13_lv_pmos L=0.13u W=0.84u AS=0.1918p
+ AD=0.1596p PS=1.5u PD=1.22u rfmode=0
M$48140 \$5563 X7|dout[8] VDD VDD sg13_lv_pmos L=0.13u W=0.84u AS=0.1596p
+ AD=0.2856p PS=1.22u PD=2.36u rfmode=0
M$48141 \$5396 VDD VDD VDD sg13_lv_pmos L=0.13u W=0.42u AS=0.147p AD=0.1563p
+ PS=1.54u PD=1.22u rfmode=0
M$48142 VDD \$5249 \$5421 VDD sg13_lv_pmos L=0.13u W=0.42u AS=0.1563p
+ AD=0.0546p PS=1.22u PD=0.68u rfmode=0
M$48143 \$5421 \$5250 \$5396 VDD sg13_lv_pmos L=0.13u W=0.42u AS=0.0546p
+ AD=0.0798p PS=0.68u PD=0.8u rfmode=0
M$48144 \$5396 \$5327 \$5266 VDD sg13_lv_pmos L=0.13u W=0.42u AS=0.0798p
+ AD=0.1428p PS=0.8u PD=1.52u rfmode=0
M$48145 VDD \$5564 \$3192 VDD sg13_lv_pmos L=0.13u W=2.24u AS=0.6776p
+ AD=0.4746p PS=4.57u PD=3.105u rfmode=0
M$48147 VDD \$3193 \$5586 VDD sg13_lv_pmos L=0.13u W=0.84u AS=0.2226p
+ AD=0.1596p PS=1.535u PD=1.22u rfmode=0
M$48148 \$5586 X5|dout[6] \$5564 VDD sg13_lv_pmos L=0.13u W=0.84u AS=0.1596p
+ AD=0.2856p PS=1.22u PD=2.36u rfmode=0
M$48149 VDD \$5565 \$3198 VDD sg13_lv_pmos L=0.13u W=2.24u AS=0.6384p
+ AD=0.4046p PS=4.5u PD=3u rfmode=0
M$48151 VDD \$5577 \$5565 VDD sg13_lv_pmos L=0.13u W=0.84u AS=0.1918p
+ AD=0.1596p PS=1.5u PD=1.22u rfmode=0
M$48152 \$5565 X7|dout[8] VDD VDD sg13_lv_pmos L=0.13u W=0.84u AS=0.1596p
+ AD=0.2856p PS=1.22u PD=2.36u rfmode=0
M$48153 \$5272 \$3193 \$5453 VDD sg13_lv_pmos L=0.13u W=0.84u AS=0.2856p
+ AD=0.1596p PS=2.36u PD=1.22u rfmode=0
M$48154 VDD VSS|anode|cathode|vss \$5453 VDD sg13_lv_pmos L=0.13u W=0.84u
+ AS=0.2226p AD=0.1596p PS=1.535u PD=1.22u rfmode=0
M$48155 VDD \$5272 \$5273 VDD sg13_lv_pmos L=0.13u W=2.24u AS=0.4746p
+ AD=0.6776p PS=3.105u PD=4.57u rfmode=0
M$48157 VDD \$5330 \$5275 VDD sg13_lv_pmos L=0.13u W=0.42u AS=0.1428p
+ AD=0.0798p PS=1.52u PD=0.8u rfmode=0
M$48158 VDD VDD \$5275 VDD sg13_lv_pmos L=0.13u W=0.42u AS=0.3623875p
+ AD=0.0798p PS=2.605u PD=0.8u rfmode=0
M$48159 VDD \$5398 \$5251 VDD sg13_lv_pmos L=0.13u W=1u AS=0.3623875p AD=0.34p
+ PS=2.605u PD=2.68u rfmode=0
M$48160 \$5398 VDD VDD VDD sg13_lv_pmos L=0.13u W=0.42u AS=0.147p AD=0.1563p
+ PS=1.54u PD=1.22u rfmode=0
M$48161 VDD \$5251 \$5433 VDD sg13_lv_pmos L=0.13u W=0.42u AS=0.1563p
+ AD=0.0546p PS=1.22u PD=0.68u rfmode=0
M$48162 \$5433 \$5252 \$5398 VDD sg13_lv_pmos L=0.13u W=0.42u AS=0.0546p
+ AD=0.0798p PS=0.68u PD=0.8u rfmode=0
M$48163 \$5398 \$5331 \$5275 VDD sg13_lv_pmos L=0.13u W=0.42u AS=0.0798p
+ AD=0.1428p PS=0.8u PD=1.52u rfmode=0
M$48164 \$5281 \$3194 \$5454 VDD sg13_lv_pmos L=0.13u W=0.84u AS=0.2856p
+ AD=0.1596p PS=2.36u PD=1.22u rfmode=0
M$48165 VDD VSS|anode|cathode|vss \$5454 VDD sg13_lv_pmos L=0.13u W=0.84u
+ AS=0.2226p AD=0.1596p PS=1.535u PD=1.22u rfmode=0
M$48166 VDD \$5281 \$5282 VDD sg13_lv_pmos L=0.13u W=2.24u AS=0.4746p
+ AD=0.6776p PS=3.105u PD=4.57u rfmode=0
M$48168 VDD \$5334 \$5284 VDD sg13_lv_pmos L=0.13u W=0.42u AS=0.1428p
+ AD=0.0798p PS=1.52u PD=0.8u rfmode=0
M$48169 VDD VDD \$5284 VDD sg13_lv_pmos L=0.13u W=0.42u AS=0.3623875p
+ AD=0.0798p PS=2.605u PD=0.8u rfmode=0
M$48170 VDD \$5400 \$5253 VDD sg13_lv_pmos L=0.13u W=1u AS=0.3623875p AD=0.34p
+ PS=2.605u PD=2.68u rfmode=0
M$48171 \$5400 VDD VDD VDD sg13_lv_pmos L=0.13u W=0.42u AS=0.147p AD=0.1563p
+ PS=1.54u PD=1.22u rfmode=0
M$48172 VDD \$5253 \$5446 VDD sg13_lv_pmos L=0.13u W=0.42u AS=0.1563p
+ AD=0.0546p PS=1.22u PD=0.68u rfmode=0
M$48173 \$5446 \$5254 \$5400 VDD sg13_lv_pmos L=0.13u W=0.42u AS=0.0546p
+ AD=0.0798p PS=0.68u PD=0.8u rfmode=0
M$48174 \$5400 \$5335 \$5284 VDD sg13_lv_pmos L=0.13u W=0.42u AS=0.0798p
+ AD=0.1428p PS=0.8u PD=1.52u rfmode=0
M$48175 \$5290 \$3195 \$5455 VDD sg13_lv_pmos L=0.13u W=0.84u AS=0.2856p
+ AD=0.1596p PS=2.36u PD=1.22u rfmode=0
M$48176 VDD VSS|anode|cathode|vss \$5455 VDD sg13_lv_pmos L=0.13u W=0.84u
+ AS=0.2226p AD=0.1596p PS=1.535u PD=1.22u rfmode=0
M$48177 VDD \$5290 \$5291 VDD sg13_lv_pmos L=0.13u W=2.24u AS=0.4746p
+ AD=0.6776p PS=3.105u PD=4.57u rfmode=0
M$48179 VDD \$5338 \$5293 VDD sg13_lv_pmos L=0.13u W=0.42u AS=0.1428p
+ AD=0.0798p PS=1.52u PD=0.8u rfmode=0
M$48180 VDD VDD \$5293 VDD sg13_lv_pmos L=0.13u W=0.42u AS=0.3623875p
+ AD=0.0798p PS=2.605u PD=0.8u rfmode=0
M$48181 VDD \$5402 \$5255 VDD sg13_lv_pmos L=0.13u W=1u AS=0.3623875p AD=0.34p
+ PS=2.605u PD=2.68u rfmode=0
M$48182 \$5402 VDD VDD VDD sg13_lv_pmos L=0.13u W=0.42u AS=0.147p AD=0.1563p
+ PS=1.54u PD=1.22u rfmode=0
M$48183 VDD \$5255 \$5447 VDD sg13_lv_pmos L=0.13u W=0.42u AS=0.1563p
+ AD=0.0546p PS=1.22u PD=0.68u rfmode=0
M$48184 \$5447 \$5256 \$5402 VDD sg13_lv_pmos L=0.13u W=0.42u AS=0.0546p
+ AD=0.0798p PS=0.68u PD=0.8u rfmode=0
M$48185 \$5402 \$5339 \$5293 VDD sg13_lv_pmos L=0.13u W=0.42u AS=0.0798p
+ AD=0.1428p PS=0.8u PD=1.52u rfmode=0
M$48186 \$5299 \$3196 \$5456 VDD sg13_lv_pmos L=0.13u W=0.84u AS=0.2856p
+ AD=0.1596p PS=2.36u PD=1.22u rfmode=0
M$48187 VDD VSS|anode|cathode|vss \$5456 VDD sg13_lv_pmos L=0.13u W=0.84u
+ AS=0.2226p AD=0.1596p PS=1.535u PD=1.22u rfmode=0
M$48188 VDD \$5299 \$5300 VDD sg13_lv_pmos L=0.13u W=2.24u AS=0.4746p
+ AD=0.6776p PS=3.105u PD=4.57u rfmode=0
M$48190 VDD \$5342 \$5302 VDD sg13_lv_pmos L=0.13u W=0.42u AS=0.1428p
+ AD=0.0798p PS=1.52u PD=0.8u rfmode=0
M$48191 VDD VDD \$5302 VDD sg13_lv_pmos L=0.13u W=0.42u AS=0.3623875p
+ AD=0.0798p PS=2.605u PD=0.8u rfmode=0
M$48192 VDD \$5404 \$5257 VDD sg13_lv_pmos L=0.13u W=1u AS=0.3623875p AD=0.34p
+ PS=2.605u PD=2.68u rfmode=0
M$48193 \$5404 VDD VDD VDD sg13_lv_pmos L=0.13u W=0.42u AS=0.147p AD=0.1563p
+ PS=1.54u PD=1.22u rfmode=0
M$48194 VDD \$5257 \$5441 VDD sg13_lv_pmos L=0.13u W=0.42u AS=0.1563p
+ AD=0.0546p PS=1.22u PD=0.68u rfmode=0
M$48195 \$5441 \$5258 \$5404 VDD sg13_lv_pmos L=0.13u W=0.42u AS=0.0546p
+ AD=0.0798p PS=0.68u PD=0.8u rfmode=0
M$48196 \$5404 \$5343 \$5302 VDD sg13_lv_pmos L=0.13u W=0.42u AS=0.0798p
+ AD=0.1428p PS=0.8u PD=1.52u rfmode=0
M$48197 \$5308 \$3197 \$5457 VDD sg13_lv_pmos L=0.13u W=0.84u AS=0.2856p
+ AD=0.1596p PS=2.36u PD=1.22u rfmode=0
M$48198 VDD VSS|anode|cathode|vss \$5457 VDD sg13_lv_pmos L=0.13u W=0.84u
+ AS=0.2226p AD=0.1596p PS=1.535u PD=1.22u rfmode=0
M$48199 VDD \$5308 \$5309 VDD sg13_lv_pmos L=0.13u W=2.24u AS=0.4746p
+ AD=0.6776p PS=3.105u PD=4.57u rfmode=0
M$48201 VDD \$5346 \$5311 VDD sg13_lv_pmos L=0.13u W=0.42u AS=0.1428p
+ AD=0.0798p PS=1.52u PD=0.8u rfmode=0
M$48202 VDD VDD \$5311 VDD sg13_lv_pmos L=0.13u W=0.42u AS=0.3623875p
+ AD=0.0798p PS=2.605u PD=0.8u rfmode=0
M$48203 VDD \$5406 \$5259 VDD sg13_lv_pmos L=0.13u W=1u AS=0.3623875p AD=0.34p
+ PS=2.605u PD=2.68u rfmode=0
M$48204 \$5406 VDD VDD VDD sg13_lv_pmos L=0.13u W=0.42u AS=0.147p AD=0.1563p
+ PS=1.54u PD=1.22u rfmode=0
M$48205 VDD \$5259 \$5430 VDD sg13_lv_pmos L=0.13u W=0.42u AS=0.1563p
+ AD=0.0546p PS=1.22u PD=0.68u rfmode=0
M$48206 \$5430 \$5260 \$5406 VDD sg13_lv_pmos L=0.13u W=0.42u AS=0.0546p
+ AD=0.0798p PS=0.68u PD=0.8u rfmode=0
M$48207 \$5406 \$5347 \$5311 VDD sg13_lv_pmos L=0.13u W=0.42u AS=0.0798p
+ AD=0.1428p PS=0.8u PD=1.52u rfmode=0
M$48208 \$5317 \$3198 \$5458 VDD sg13_lv_pmos L=0.13u W=0.84u AS=0.2856p
+ AD=0.1596p PS=2.36u PD=1.22u rfmode=0
M$48209 VDD VSS|anode|cathode|vss \$5458 VDD sg13_lv_pmos L=0.13u W=0.84u
+ AS=0.2226p AD=0.1596p PS=1.535u PD=1.22u rfmode=0
M$48210 VDD \$5317 \$5318 VDD sg13_lv_pmos L=0.13u W=2.24u AS=0.4746p
+ AD=0.6776p PS=3.105u PD=4.57u rfmode=0
M$48212 VDD \$5350 \$5320 VDD sg13_lv_pmos L=0.13u W=0.42u AS=0.1428p
+ AD=0.0798p PS=1.52u PD=0.8u rfmode=0
M$48213 VDD VDD \$5320 VDD sg13_lv_pmos L=0.13u W=0.42u AS=0.3623875p
+ AD=0.0798p PS=2.605u PD=0.8u rfmode=0
M$48214 VDD \$5408 \$5261 VDD sg13_lv_pmos L=0.13u W=1u AS=0.3623875p AD=0.34p
+ PS=2.605u PD=2.68u rfmode=0
M$48215 \$5408 VDD VDD VDD sg13_lv_pmos L=0.13u W=0.42u AS=0.147p AD=0.1563p
+ PS=1.54u PD=1.22u rfmode=0
M$48216 VDD \$5261 \$5420 VDD sg13_lv_pmos L=0.13u W=0.42u AS=0.1563p
+ AD=0.0546p PS=1.22u PD=0.68u rfmode=0
M$48217 \$5420 \$5262 \$5408 VDD sg13_lv_pmos L=0.13u W=0.42u AS=0.0546p
+ AD=0.0798p PS=0.68u PD=0.8u rfmode=0
M$48218 \$5408 \$5351 \$5320 VDD sg13_lv_pmos L=0.13u W=0.42u AS=0.0798p
+ AD=0.1428p PS=0.8u PD=1.52u rfmode=0
M$48219 VDD X4|dout[5] \$5527 VDD sg13_lv_pmos L=0.13u W=0.42u AS=0.1428p
+ AD=0.0798p PS=1.52u PD=0.8u rfmode=0
M$48220 VDD VDD \$5527 VDD sg13_lv_pmos L=0.13u W=0.42u AS=0.3623875p
+ AD=0.0798p PS=2.605u PD=0.8u rfmode=0
M$48221 VDD \$5532 \$5531 VDD sg13_lv_pmos L=0.13u W=1u AS=0.3623875p AD=0.34p
+ PS=2.605u PD=2.68u rfmode=0
M$48222 VDD VDD \$5532 VDD sg13_lv_pmos L=0.13u W=0.42u AS=0.1563p AD=0.147p
+ PS=1.22u PD=1.54u rfmode=0
M$48223 VDD \$5531 \$5538 VDD sg13_lv_pmos L=0.13u W=0.42u AS=0.1563p
+ AD=0.0546p PS=1.22u PD=0.68u rfmode=0
M$48224 \$5538 \$5542 \$5532 VDD sg13_lv_pmos L=0.13u W=0.42u AS=0.0546p
+ AD=0.0798p PS=0.68u PD=0.8u rfmode=0
M$48225 \$5532 \$5535 \$5527 VDD sg13_lv_pmos L=0.13u W=0.42u AS=0.0798p
+ AD=0.1428p PS=0.8u PD=1.52u rfmode=0
M$48226 VDD \$5542 \$5535 VDD sg13_lv_pmos L=0.13u W=1.12u AS=0.431025p
+ AD=0.3864p PS=2.145u PD=2.93u rfmode=0
M$48227 VDD CLK|clk|core|fclk_in|p2c|ui_p2c[6] \$5542 VDD sg13_lv_pmos L=0.13u
+ W=1.12u AS=0.431025p AD=0.3808p PS=2.145u PD=2.92u rfmode=0
M$48228 \$5531 \$5542 \$5536 VDD sg13_lv_pmos L=0.13u W=1u AS=0.34p AD=0.19115p
+ PS=2.68u PD=1.565u rfmode=0
M$48229 \$5536 \$5535 \$5543 VDD sg13_lv_pmos L=0.13u W=0.42u AS=0.19115p
+ AD=0.0525p PS=1.565u PD=0.67u rfmode=0
M$48230 VDD \$5537 \$5543 VDD sg13_lv_pmos L=0.13u W=0.42u AS=0.25605p
+ AD=0.0525p PS=1.935u PD=0.67u rfmode=0
M$48231 VDD VDD \$5537 VDD sg13_lv_pmos L=0.13u W=0.42u AS=0.25605p AD=0.0798p
+ PS=1.935u PD=0.8u rfmode=0
M$48232 VDD \$5536 \$5537 VDD sg13_lv_pmos L=0.13u W=0.42u AS=0.2014p
+ AD=0.0798p PS=1.53u PD=0.8u rfmode=0
M$48233 VDD \$5536 \$5501 VDD sg13_lv_pmos L=0.13u W=2.24u AS=0.4142p
+ AD=0.4211p PS=3.03u PD=3u rfmode=0
M$48235 VDD \$5536 \$5533 VDD sg13_lv_pmos L=0.13u W=1u AS=0.2083p AD=0.34p
+ PS=1.5u PD=2.68u rfmode=0
M$48236 VDD \$5533 \$5528 VDD sg13_lv_pmos L=0.13u W=2.24u AS=0.5964p
+ AD=0.5964p PS=4.425u PD=4.425u rfmode=0
M$48238 \$5580 \$5558 VDD VDD sg13_lv_pmos L=0.13u W=1.12u AS=0.3864p
+ AD=0.431025p PS=2.93u PD=2.145u rfmode=0
M$48239 VDD CLK|clk|core|fclk_in|p2c|ui_p2c[6] \$5558 VDD sg13_lv_pmos L=0.13u
+ W=1.12u AS=0.431025p AD=0.3808p PS=2.145u PD=2.92u rfmode=0
M$48240 VDD \$5561 \$5562 VDD sg13_lv_pmos L=0.13u W=2.24u AS=0.5964p
+ AD=0.5964p PS=4.425u PD=4.425u rfmode=0
M$48242 VDD X3|dout[4] \$5556 VDD sg13_lv_pmos L=0.13u W=0.42u AS=0.1428p
+ AD=0.0798p PS=1.52u PD=0.8u rfmode=0
M$48243 VDD VDD \$5556 VDD sg13_lv_pmos L=0.13u W=0.42u AS=0.3623875p
+ AD=0.0798p PS=2.605u PD=0.8u rfmode=0
M$48244 VDD \$5579 \$5557 VDD sg13_lv_pmos L=0.13u W=1u AS=0.3623875p AD=0.34p
+ PS=2.605u PD=2.68u rfmode=0
M$48245 \$5579 VDD VDD VDD sg13_lv_pmos L=0.13u W=0.42u AS=0.147p AD=0.1563p
+ PS=1.54u PD=1.22u rfmode=0
M$48246 VDD \$5557 \$5590 VDD sg13_lv_pmos L=0.13u W=0.42u AS=0.1563p
+ AD=0.0546p PS=1.22u PD=0.68u rfmode=0
M$48247 \$5590 \$5558 \$5579 VDD sg13_lv_pmos L=0.13u W=0.42u AS=0.0546p
+ AD=0.0798p PS=0.68u PD=0.8u rfmode=0
M$48248 \$5579 \$5580 \$5556 VDD sg13_lv_pmos L=0.13u W=0.42u AS=0.0798p
+ AD=0.1428p PS=0.8u PD=1.52u rfmode=0
M$48249 \$5575 \$5580 \$5591 VDD sg13_lv_pmos L=0.13u W=0.42u AS=0.19115p
+ AD=0.0525p PS=1.565u PD=0.67u rfmode=0
M$48250 \$5591 \$5581 VDD VDD sg13_lv_pmos L=0.13u W=0.42u AS=0.0525p
+ AD=0.25605p PS=0.67u PD=1.935u rfmode=0
M$48251 VDD VDD \$5581 VDD sg13_lv_pmos L=0.13u W=0.42u AS=0.25605p AD=0.0798p
+ PS=1.935u PD=0.8u rfmode=0
M$48252 VDD \$5575 \$5581 VDD sg13_lv_pmos L=0.13u W=0.42u AS=0.2014p
+ AD=0.0798p PS=1.53u PD=0.8u rfmode=0
M$48253 VDD \$5575 \$5561 VDD sg13_lv_pmos L=0.13u W=1u AS=0.2083p AD=0.34p
+ PS=1.5u PD=2.68u rfmode=0
M$48254 VDD \$5575 \$5560 VDD sg13_lv_pmos L=0.13u W=2.24u AS=0.4142p
+ AD=0.4211p PS=3.03u PD=3u rfmode=0
M$48256 \$5557 \$5558 \$5575 VDD sg13_lv_pmos L=0.13u W=1u AS=0.34p AD=0.19115p
+ PS=2.68u PD=1.565u rfmode=0
M$48257 VDD \$5592 \$3195 VDD sg13_lv_pmos L=0.13u W=2.24u AS=0.9464p
+ AD=0.4214p PS=5.05u PD=3u rfmode=0
M$48259 VDD X7|dout[8] \$5592 VDD sg13_lv_pmos L=0.13u W=1u AS=0.2086p AD=0.34p
+ PS=1.5u PD=2.68u rfmode=0
M$48260 VDD \$5593 \$5574 VDD sg13_lv_pmos L=0.13u W=2.24u AS=0.6384p
+ AD=0.4046p PS=4.5u PD=3u rfmode=0
M$48262 VDD X6|dout[7] \$5593 VDD sg13_lv_pmos L=0.13u W=0.84u AS=0.1918p
+ AD=0.1596p PS=1.5u PD=1.22u rfmode=0
M$48263 \$5593 X5|dout[6] VDD VDD sg13_lv_pmos L=0.13u W=0.84u AS=0.1596p
+ AD=0.2856p PS=1.22u PD=2.36u rfmode=0
M$48264 VDD \$5594 \$5576 VDD sg13_lv_pmos L=0.13u W=2.24u AS=0.6776p
+ AD=0.4746p PS=4.57u PD=3.105u rfmode=0
M$48266 VDD X5|dout[6] \$5610 VDD sg13_lv_pmos L=0.13u W=0.84u AS=0.2226p
+ AD=0.1596p PS=1.535u PD=1.22u rfmode=0
M$48267 \$5610 X6|dout[7] \$5594 VDD sg13_lv_pmos L=0.13u W=0.84u AS=0.1596p
+ AD=0.2856p PS=1.22u PD=2.36u rfmode=0
M$48268 VDD \$5595 \$3193 VDD sg13_lv_pmos L=0.13u W=2.24u AS=0.6776p
+ AD=0.4746p PS=4.57u PD=3.105u rfmode=0
M$48270 VDD X7|dout[8] \$5609 VDD sg13_lv_pmos L=0.13u W=0.84u AS=0.2226p
+ AD=0.1596p PS=1.535u PD=1.22u rfmode=0
M$48271 \$5609 X6|dout[7] \$5595 VDD sg13_lv_pmos L=0.13u W=0.84u AS=0.1596p
+ AD=0.2856p PS=1.22u PD=2.36u rfmode=0
M$48272 VDD \$5601 \$3197 VDD sg13_lv_pmos L=0.13u W=2.24u AS=0.6384p
+ AD=0.4046p PS=4.5u PD=3u rfmode=0
M$48274 VDD X7|dout[8] \$5601 VDD sg13_lv_pmos L=0.13u W=0.84u AS=0.1918p
+ AD=0.1596p PS=1.5u PD=1.22u rfmode=0
M$48275 \$5601 X6|dout[7] VDD VDD sg13_lv_pmos L=0.13u W=0.84u AS=0.1596p
+ AD=0.2856p PS=1.22u PD=2.36u rfmode=0
M$48276 VDD \$5596 \$5577 VDD sg13_lv_pmos L=0.13u W=2.24u AS=0.6384p
+ AD=0.4046p PS=4.5u PD=3u rfmode=0
M$48278 VDD X6|dout[7] \$5596 VDD sg13_lv_pmos L=0.13u W=0.84u AS=0.1918p
+ AD=0.1596p PS=1.5u PD=1.22u rfmode=0
M$48279 \$5596 X5|dout[6] VDD VDD sg13_lv_pmos L=0.13u W=0.84u AS=0.1596p
+ AD=0.2856p PS=1.22u PD=2.36u rfmode=0
M$48280 VDD \$5630 \$5626 VDD sg13_lv_pmos L=0.13u W=2.24u AS=0.5964p
+ AD=0.5964p PS=4.425u PD=4.425u rfmode=0
M$48282 VDD X2|dout[3] \$5625 VDD sg13_lv_pmos L=0.13u W=0.42u AS=0.1428p
+ AD=0.0798p PS=1.52u PD=0.8u rfmode=0
M$48283 VDD VDD \$5625 VDD sg13_lv_pmos L=0.13u W=0.42u AS=0.3623875p
+ AD=0.0798p PS=2.605u PD=0.8u rfmode=0
M$48284 VDD \$5629 \$5628 VDD sg13_lv_pmos L=0.13u W=1u AS=0.3623875p AD=0.34p
+ PS=2.605u PD=2.68u rfmode=0
M$48285 VDD \$5633 \$5632 VDD sg13_lv_pmos L=0.13u W=1.12u AS=0.431025p
+ AD=0.3864p PS=2.145u PD=2.93u rfmode=0
M$48286 VDD CLK|clk|core|fclk_in|p2c|ui_p2c[6] \$5633 VDD sg13_lv_pmos L=0.13u
+ W=1.12u AS=0.431025p AD=0.3808p PS=2.145u PD=2.92u rfmode=0
M$48287 \$5628 \$5633 \$5634 VDD sg13_lv_pmos L=0.13u W=1u AS=0.34p AD=0.19115p
+ PS=2.68u PD=1.565u rfmode=0
M$48288 \$5634 \$5632 \$5643 VDD sg13_lv_pmos L=0.13u W=0.42u AS=0.19115p
+ AD=0.0525p PS=1.565u PD=0.67u rfmode=0
M$48289 VDD \$5635 \$5643 VDD sg13_lv_pmos L=0.13u W=0.42u AS=0.25605p
+ AD=0.0525p PS=1.935u PD=0.67u rfmode=0
M$48290 VDD VDD \$5635 VDD sg13_lv_pmos L=0.13u W=0.42u AS=0.25605p AD=0.0798p
+ PS=1.935u PD=0.8u rfmode=0
M$48291 VDD \$5634 \$5635 VDD sg13_lv_pmos L=0.13u W=0.42u AS=0.2014p
+ AD=0.0798p PS=1.53u PD=0.8u rfmode=0
M$48292 VDD \$5634 \$5617 VDD sg13_lv_pmos L=0.13u W=2.24u AS=0.4142p
+ AD=0.4211p PS=3.03u PD=3u rfmode=0
M$48294 VDD \$5634 \$5630 VDD sg13_lv_pmos L=0.13u W=1u AS=0.2083p AD=0.34p
+ PS=1.5u PD=2.68u rfmode=0
M$48295 VDD VDD \$5629 VDD sg13_lv_pmos L=0.13u W=0.42u AS=0.1563p AD=0.147p
+ PS=1.22u PD=1.54u rfmode=0
M$48296 VDD \$5628 \$5638 VDD sg13_lv_pmos L=0.13u W=0.42u AS=0.1563p
+ AD=0.0546p PS=1.22u PD=0.68u rfmode=0
M$48297 \$5638 \$5633 \$5629 VDD sg13_lv_pmos L=0.13u W=0.42u AS=0.0546p
+ AD=0.0798p PS=0.68u PD=0.8u rfmode=0
M$48298 \$5629 \$5632 \$5625 VDD sg13_lv_pmos L=0.13u W=0.42u AS=0.0798p
+ AD=0.1428p PS=0.8u PD=1.52u rfmode=0
M$48299 VDD X1|dout[2] \$5652 VDD sg13_lv_pmos L=0.13u W=0.42u AS=0.1428p
+ AD=0.0798p PS=1.52u PD=0.8u rfmode=0
M$48300 VDD VDD \$5652 VDD sg13_lv_pmos L=0.13u W=0.42u AS=0.3623875p
+ AD=0.0798p PS=2.605u PD=0.8u rfmode=0
M$48301 VDD \$5668 \$5653 VDD sg13_lv_pmos L=0.13u W=1u AS=0.3623875p AD=0.34p
+ PS=2.605u PD=2.68u rfmode=0
M$48302 \$5674 \$5655 VDD VDD sg13_lv_pmos L=0.13u W=1.12u AS=0.3864p
+ AD=0.431025p PS=2.93u PD=2.145u rfmode=0
M$48303 VDD CLK|clk|core|fclk_in|p2c|ui_p2c[6] \$5655 VDD sg13_lv_pmos L=0.13u
+ W=1.12u AS=0.431025p AD=0.3808p PS=2.145u PD=2.92u rfmode=0
M$48304 \$5660 \$5674 \$5675 VDD sg13_lv_pmos L=0.13u W=0.42u AS=0.19115p
+ AD=0.0525p PS=1.565u PD=0.67u rfmode=0
M$48305 \$5675 \$5669 VDD VDD sg13_lv_pmos L=0.13u W=0.42u AS=0.0525p
+ AD=0.25605p PS=0.67u PD=1.935u rfmode=0
M$48306 VDD VDD \$5669 VDD sg13_lv_pmos L=0.13u W=0.42u AS=0.25605p AD=0.0798p
+ PS=1.935u PD=0.8u rfmode=0
M$48307 VDD \$5660 \$5669 VDD sg13_lv_pmos L=0.13u W=0.42u AS=0.2014p
+ AD=0.0798p PS=1.53u PD=0.8u rfmode=0
M$48308 VDD \$5660 \$5658 VDD sg13_lv_pmos L=0.13u W=1u AS=0.2083p AD=0.34p
+ PS=1.5u PD=2.68u rfmode=0
M$48309 VDD \$5660 \$5657 VDD sg13_lv_pmos L=0.13u W=2.24u AS=0.4142p
+ AD=0.4211p PS=3.03u PD=3u rfmode=0
M$48311 \$5653 \$5655 \$5660 VDD sg13_lv_pmos L=0.13u W=1u AS=0.34p AD=0.19115p
+ PS=2.68u PD=1.565u rfmode=0
M$48312 VDD \$5658 \$5659 VDD sg13_lv_pmos L=0.13u W=2.24u AS=0.5964p
+ AD=0.5964p PS=4.425u PD=4.425u rfmode=0
M$48314 \$5690 D2|c2p|core|i|uo_c2p[6] VDD|in|pad|pin1|pin2|supply|vdd
+ VDD|in|pad|pin1|pin2|supply|vdd sg13_lv_pmos L=0.13u W=4.75u AS=1.615p
+ AD=1.615p PS=10.18u PD=10.18u rfmode=0
M$48315 \$5668 VDD VDD VDD sg13_lv_pmos L=0.13u W=0.42u AS=0.147p AD=0.1563p
+ PS=1.54u PD=1.22u rfmode=0
M$48316 VDD \$5653 \$5676 VDD sg13_lv_pmos L=0.13u W=0.42u AS=0.1563p
+ AD=0.0546p PS=1.22u PD=0.68u rfmode=0
M$48317 \$5676 \$5655 \$5668 VDD sg13_lv_pmos L=0.13u W=0.42u AS=0.0546p
+ AD=0.0798p PS=0.68u PD=0.8u rfmode=0
M$48318 \$5668 \$5674 \$5652 VDD sg13_lv_pmos L=0.13u W=0.42u AS=0.0798p
+ AD=0.1428p PS=0.8u PD=1.52u rfmode=0
M$48319 core|data_in|p2c|ui_p2c[2] \$5695 VDD|in|pad|pin1|pin2|supply|vdd
+ VDD|in|pad|pin1|pin2|supply|vdd sg13_lv_pmos L=0.13u W=4.75u AS=1.615p
+ AD=1.615p PS=10.18u PD=10.18u rfmode=0
M$48320 \$5701 D2|c2p|core|i|uo_c2p[6] VDD|in|pad|pin1|pin2|supply|vdd
+ VDD|in|pad|pin1|pin2|supply|vdd sg13_lv_pmos L=0.13u W=4.75u AS=1.615p
+ AD=1.615p PS=10.18u PD=10.18u rfmode=0
M$48321 \$5787 D1|c2p|core|i|uo_c2p[7] VDD|in|pad|pin1|pin2|supply|vdd
+ VDD|in|pad|pin1|pin2|supply|vdd sg13_lv_pmos L=0.13u W=4.75u AS=1.615p
+ AD=1.615p PS=10.18u PD=10.18u rfmode=0
M$48322 \$5791 D1|c2p|core|i|uo_c2p[7] VDD|in|pad|pin1|pin2|supply|vdd
+ VDD|in|pad|pin1|pin2|supply|vdd sg13_lv_pmos L=0.13u W=4.75u AS=1.615p
+ AD=1.615p PS=10.18u PD=10.18u rfmode=0
M$48323 \$5879 D0|c2p|core|i|uo_c2p[8] VDD|in|pad|pin1|pin2|supply|vdd
+ VDD|in|pad|pin1|pin2|supply|vdd sg13_lv_pmos L=0.13u W=4.75u AS=1.615p
+ AD=1.615p PS=10.18u PD=10.18u rfmode=0
M$48324 \$5887 D0|c2p|core|i|uo_c2p[8] VDD|in|pad|pin1|pin2|supply|vdd
+ VDD|in|pad|pin1|pin2|supply|vdd sg13_lv_pmos L=0.13u W=4.75u AS=1.615p
+ AD=1.615p PS=10.18u PD=10.18u rfmode=0
M$48325 Vs|core|p2c|ui_p2c[1] \$6055 VDD|in|pad|pin1|pin2|supply|vdd
+ VDD|in|pad|pin1|pin2|supply|vdd sg13_lv_pmos L=0.13u W=4.75u AS=1.615p
+ AD=1.615p PS=10.18u PD=10.18u rfmode=0
M$48326 \$6208 Vs|core|p2c|ui_p2c[1] VDDLS|analog_io_padres[12]|core|padres
+ VDDLS|analog_io_padres[12]|core|padres sg13_lv_pmos L=0.13u W=2.24u
+ AS=1.0528p AD=1.0528p PS=5.24u PD=5.24u rfmode=0
M$48328 B|IN|Y IN|Y$2 VDD$1 VDD$1 sg13_lv_pmos L=0.13u W=1.12u AS=0.3808p
+ AD=0.3808p PS=2.92u PD=2.92u rfmode=0
M$48329 IN|Y$2 B|IN|Y$1 VDD$1 VDD$1 sg13_lv_pmos L=0.13u W=1.12u AS=0.3808p
+ AD=0.3808p PS=2.92u PD=2.92u rfmode=0
M$48330 IN|Y B|IN|Y$1 VDD$1 VDD$1 sg13_lv_pmos L=0.13u W=1.12u AS=0.3808p
+ AD=0.3808p PS=2.92u PD=2.92u rfmode=0
M$48331 VFE|X|vfe \$6232 VDD$1 VDD$1 sg13_lv_pmos L=0.13u W=1.12u AS=0.3808p
+ AD=0.1918p PS=2.92u PD=1.5u rfmode=0
M$48332 VDD$1 B|IN|Y \$6232 VDD$1 sg13_lv_pmos L=0.13u W=0.84u AS=0.1918p
+ AD=0.1596p PS=1.5u PD=1.22u rfmode=0
M$48333 \$6232 IN|Y VDD$1 VDD$1 sg13_lv_pmos L=0.13u W=0.84u AS=0.1596p
+ AD=0.2856p PS=1.22u PD=2.36u rfmode=0
M$48334 IN|Y$1 B|IN|Y VDD$1 VDD$1 sg13_lv_pmos L=0.13u W=1.12u AS=0.3808p
+ AD=0.3808p PS=2.92u PD=2.92u rfmode=0
M$48335 B|IN|Y$1 IN|Y$3 VDD$1 VDD$1 sg13_lv_pmos L=0.13u W=1.12u AS=0.3808p
+ AD=0.3808p PS=2.92u PD=2.92u rfmode=0
M$48336 IN|Y$3 IN|core|p2c|ui_p2c[0] VDD$1 VDD$1 sg13_lv_pmos L=0.13u W=1.12u
+ AS=0.3808p AD=0.3808p PS=2.92u PD=2.92u rfmode=0
M$48337 VRE|X|vre \$6234 VDD$1 VDD$1 sg13_lv_pmos L=0.13u W=1.12u AS=0.3808p
+ AD=0.1918p PS=2.92u PD=1.5u rfmode=0
M$48338 VDD$1 B|IN|Y$1 \$6234 VDD$1 sg13_lv_pmos L=0.13u W=0.84u AS=0.1918p
+ AD=0.1596p PS=1.5u PD=1.22u rfmode=0
M$48339 \$6234 IN|Y$1 VDD$1 VDD$1 sg13_lv_pmos L=0.13u W=0.84u AS=0.1596p
+ AD=0.2856p PS=1.22u PD=2.36u rfmode=0
M$48340 IN|core|p2c|ui_p2c[0] \$6598 VDD|in|pad|pin1|pin2|supply|vdd
+ VDD|in|pad|pin1|pin2|supply|vdd sg13_lv_pmos L=0.13u W=4.75u AS=1.615p
+ AD=1.615p PS=10.18u PD=10.18u rfmode=0
M$48341 IOVDD|cathode|guard|in|iovdd|pad|pin1|pin2|plus|supply \$244
+ analog_io[19]|anode|cathode|pad
+ IOVDD|cathode|guard|in|iovdd|pad|pin1|pin2|plus|supply sg13_hv_pmos L=0.6u
+ W=266.4u AS=123.21p AD=123.21p PS=316.72u PD=316.72u rfmode=0
M$48361 IOVDD|cathode|guard|in|iovdd|pad|pin1|pin2|plus|supply \$245
+ analog_io[18]|anode|cathode|pad
+ IOVDD|cathode|guard|in|iovdd|pad|pin1|pin2|plus|supply sg13_hv_pmos L=0.6u
+ W=266.4u AS=123.21p AD=123.21p PS=316.72u PD=316.72u rfmode=0
M$48381 IOVDD|cathode|guard|in|iovdd|pad|pin1|pin2|plus|supply \$246
+ analog_io[17]|anode|cathode|pad
+ IOVDD|cathode|guard|in|iovdd|pad|pin1|pin2|plus|supply sg13_hv_pmos L=0.6u
+ W=266.4u AS=123.21p AD=123.21p PS=316.72u PD=316.72u rfmode=0
M$48401 IOVDD|cathode|guard|in|iovdd|pad|pin1|pin2|plus|supply gate|o|pgate
+ anode|cathode|pad|uo_PAD[3]
+ IOVDD|cathode|guard|in|iovdd|pad|pin1|pin2|plus|supply sg13_hv_pmos L=0.6u
+ W=199.8u AS=91.1088p AD=94.7052p PS=240.48u PD=241.56u rfmode=0
M$48416 IOVDD|cathode|guard|in|iovdd|pad|pin1|pin2|plus|supply gate|o|pgate$1
+ anode|cathode|pad|uo_PAD[2]
+ IOVDD|cathode|guard|in|iovdd|pad|pin1|pin2|plus|supply sg13_hv_pmos L=0.6u
+ W=199.8u AS=91.1088p AD=94.7052p PS=240.48u PD=241.56u rfmode=0
M$48431 IOVDD|cathode|guard|in|iovdd|pad|pin1|pin2|plus|supply gate|o|pgate$2
+ anode|cathode|pad|uo_PAD[1]
+ IOVDD|cathode|guard|in|iovdd|pad|pin1|pin2|plus|supply sg13_hv_pmos L=0.6u
+ W=199.8u AS=91.1088p AD=94.7052p PS=240.48u PD=241.56u rfmode=0
M$48446 IOVDD|cathode|guard|in|iovdd|pad|pin1|pin2|plus|supply gate|o|pgate$3
+ anode|cathode|pad|uo_PAD[0]
+ IOVDD|cathode|guard|in|iovdd|pad|pin1|pin2|plus|supply sg13_hv_pmos L=0.6u
+ W=199.8u AS=91.1088p AD=94.7052p PS=240.48u PD=241.56u rfmode=0
M$48581 IOVDD|cathode|guard|in|iovdd|pad|pin1|pin2|plus|supply
+ IOVDD|cathode|guard|in|iovdd|pad|pin1|pin2|plus|supply gate|out
+ IOVDD|cathode|guard|in|iovdd|pad|pin1|pin2|plus|supply sg13_hv_pmos L=0.5u
+ W=350u AS=67.55p AD=67.55p PS=376.3u PD=376.3u rfmode=0
M$48631 \$488 \$489 IOVDD|cathode|guard|in|iovdd|pad|pin1|pin2|plus|supply
+ IOVDD|cathode|guard|in|iovdd|pad|pin1|pin2|plus|supply sg13_hv_pmos L=0.45u
+ W=0.3u AS=0.102p AD=0.057p PS=1.28u PD=0.68u rfmode=0
M$48632 IOVDD|cathode|guard|in|iovdd|pad|pin1|pin2|plus|supply \$488 \$489
+ IOVDD|cathode|guard|in|iovdd|pad|pin1|pin2|plus|supply sg13_hv_pmos L=0.45u
+ W=0.3u AS=0.057p AD=0.102p PS=0.68u PD=1.28u rfmode=0
M$48633 IOVDD|cathode|guard|in|iovdd|pad|pin1|pin2|plus|supply \$489
+ gate|ngate|o IOVDD|cathode|guard|in|iovdd|pad|pin1|pin2|plus|supply
+ sg13_hv_pmos L=0.45u W=3.9u AS=1.326p AD=1.326p PS=8.48u PD=8.48u rfmode=0
M$48634 \$490 \$491 IOVDD|cathode|guard|in|iovdd|pad|pin1|pin2|plus|supply
+ IOVDD|cathode|guard|in|iovdd|pad|pin1|pin2|plus|supply sg13_hv_pmos L=0.45u
+ W=0.3u AS=0.102p AD=0.057p PS=1.28u PD=0.68u rfmode=0
M$48635 IOVDD|cathode|guard|in|iovdd|pad|pin1|pin2|plus|supply \$490 \$491
+ IOVDD|cathode|guard|in|iovdd|pad|pin1|pin2|plus|supply sg13_hv_pmos L=0.45u
+ W=0.3u AS=0.057p AD=0.102p PS=0.68u PD=1.28u rfmode=0
M$48636 IOVDD|cathode|guard|in|iovdd|pad|pin1|pin2|plus|supply \$491
+ gate|o|pgate IOVDD|cathode|guard|in|iovdd|pad|pin1|pin2|plus|supply
+ sg13_hv_pmos L=0.45u W=3.9u AS=1.326p AD=1.326p PS=8.48u PD=8.48u rfmode=0
M$48637 \$492 \$493 IOVDD|cathode|guard|in|iovdd|pad|pin1|pin2|plus|supply
+ IOVDD|cathode|guard|in|iovdd|pad|pin1|pin2|plus|supply sg13_hv_pmos L=0.45u
+ W=0.3u AS=0.102p AD=0.057p PS=1.28u PD=0.68u rfmode=0
M$48638 IOVDD|cathode|guard|in|iovdd|pad|pin1|pin2|plus|supply \$492 \$493
+ IOVDD|cathode|guard|in|iovdd|pad|pin1|pin2|plus|supply sg13_hv_pmos L=0.45u
+ W=0.3u AS=0.057p AD=0.102p PS=0.68u PD=1.28u rfmode=0
M$48639 IOVDD|cathode|guard|in|iovdd|pad|pin1|pin2|plus|supply \$493
+ gate|ngate|o$1 IOVDD|cathode|guard|in|iovdd|pad|pin1|pin2|plus|supply
+ sg13_hv_pmos L=0.45u W=3.9u AS=1.326p AD=1.326p PS=8.48u PD=8.48u rfmode=0
M$48640 \$494 \$495 IOVDD|cathode|guard|in|iovdd|pad|pin1|pin2|plus|supply
+ IOVDD|cathode|guard|in|iovdd|pad|pin1|pin2|plus|supply sg13_hv_pmos L=0.45u
+ W=0.3u AS=0.102p AD=0.057p PS=1.28u PD=0.68u rfmode=0
M$48641 IOVDD|cathode|guard|in|iovdd|pad|pin1|pin2|plus|supply \$494 \$495
+ IOVDD|cathode|guard|in|iovdd|pad|pin1|pin2|plus|supply sg13_hv_pmos L=0.45u
+ W=0.3u AS=0.057p AD=0.102p PS=0.68u PD=1.28u rfmode=0
M$48642 IOVDD|cathode|guard|in|iovdd|pad|pin1|pin2|plus|supply \$495
+ gate|o|pgate$1 IOVDD|cathode|guard|in|iovdd|pad|pin1|pin2|plus|supply
+ sg13_hv_pmos L=0.45u W=3.9u AS=1.326p AD=1.326p PS=8.48u PD=8.48u rfmode=0
M$48643 \$496 \$497 IOVDD|cathode|guard|in|iovdd|pad|pin1|pin2|plus|supply
+ IOVDD|cathode|guard|in|iovdd|pad|pin1|pin2|plus|supply sg13_hv_pmos L=0.45u
+ W=0.3u AS=0.102p AD=0.057p PS=1.28u PD=0.68u rfmode=0
M$48644 IOVDD|cathode|guard|in|iovdd|pad|pin1|pin2|plus|supply \$496 \$497
+ IOVDD|cathode|guard|in|iovdd|pad|pin1|pin2|plus|supply sg13_hv_pmos L=0.45u
+ W=0.3u AS=0.057p AD=0.102p PS=0.68u PD=1.28u rfmode=0
M$48645 IOVDD|cathode|guard|in|iovdd|pad|pin1|pin2|plus|supply \$497
+ gate|ngate|o$2 IOVDD|cathode|guard|in|iovdd|pad|pin1|pin2|plus|supply
+ sg13_hv_pmos L=0.45u W=3.9u AS=1.326p AD=1.326p PS=8.48u PD=8.48u rfmode=0
M$48646 \$498 \$499 IOVDD|cathode|guard|in|iovdd|pad|pin1|pin2|plus|supply
+ IOVDD|cathode|guard|in|iovdd|pad|pin1|pin2|plus|supply sg13_hv_pmos L=0.45u
+ W=0.3u AS=0.102p AD=0.057p PS=1.28u PD=0.68u rfmode=0
M$48647 IOVDD|cathode|guard|in|iovdd|pad|pin1|pin2|plus|supply \$498 \$499
+ IOVDD|cathode|guard|in|iovdd|pad|pin1|pin2|plus|supply sg13_hv_pmos L=0.45u
+ W=0.3u AS=0.057p AD=0.102p PS=0.68u PD=1.28u rfmode=0
M$48648 IOVDD|cathode|guard|in|iovdd|pad|pin1|pin2|plus|supply \$499
+ gate|o|pgate$2 IOVDD|cathode|guard|in|iovdd|pad|pin1|pin2|plus|supply
+ sg13_hv_pmos L=0.45u W=3.9u AS=1.326p AD=1.326p PS=8.48u PD=8.48u rfmode=0
M$48649 \$500 \$501 IOVDD|cathode|guard|in|iovdd|pad|pin1|pin2|plus|supply
+ IOVDD|cathode|guard|in|iovdd|pad|pin1|pin2|plus|supply sg13_hv_pmos L=0.45u
+ W=0.3u AS=0.102p AD=0.057p PS=1.28u PD=0.68u rfmode=0
M$48650 IOVDD|cathode|guard|in|iovdd|pad|pin1|pin2|plus|supply \$500 \$501
+ IOVDD|cathode|guard|in|iovdd|pad|pin1|pin2|plus|supply sg13_hv_pmos L=0.45u
+ W=0.3u AS=0.057p AD=0.102p PS=0.68u PD=1.28u rfmode=0
M$48651 IOVDD|cathode|guard|in|iovdd|pad|pin1|pin2|plus|supply \$501
+ gate|ngate|o$3 IOVDD|cathode|guard|in|iovdd|pad|pin1|pin2|plus|supply
+ sg13_hv_pmos L=0.45u W=3.9u AS=1.326p AD=1.326p PS=8.48u PD=8.48u rfmode=0
M$48652 \$502 \$503 IOVDD|cathode|guard|in|iovdd|pad|pin1|pin2|plus|supply
+ IOVDD|cathode|guard|in|iovdd|pad|pin1|pin2|plus|supply sg13_hv_pmos L=0.45u
+ W=0.3u AS=0.102p AD=0.057p PS=1.28u PD=0.68u rfmode=0
M$48653 IOVDD|cathode|guard|in|iovdd|pad|pin1|pin2|plus|supply \$502 \$503
+ IOVDD|cathode|guard|in|iovdd|pad|pin1|pin2|plus|supply sg13_hv_pmos L=0.45u
+ W=0.3u AS=0.057p AD=0.102p PS=0.68u PD=1.28u rfmode=0
M$48654 IOVDD|cathode|guard|in|iovdd|pad|pin1|pin2|plus|supply \$503
+ gate|o|pgate$3 IOVDD|cathode|guard|in|iovdd|pad|pin1|pin2|plus|supply
+ sg13_hv_pmos L=0.45u W=3.9u AS=1.326p AD=1.326p PS=8.48u PD=8.48u rfmode=0
M$48655 IOVDD|cathode|guard|in|iovdd|pad|pin1|pin2|plus|supply core \$461
+ IOVDD|cathode|guard|in|iovdd|pad|pin1|pin2|plus|supply sg13_hv_pmos L=0.45u
+ W=4.6u AS=1.219p AD=0.874p PS=7.96u PD=5.36u rfmode=0
M$48657 IOVDD|cathode|guard|in|iovdd|pad|pin1|pin2|plus|supply \$461 \$462
+ IOVDD|cathode|guard|in|iovdd|pad|pin1|pin2|plus|supply sg13_hv_pmos L=0.45u
+ W=4.6u AS=0.874p AD=1.219p PS=5.36u PD=7.96u rfmode=0
M$48659 IOVDD|cathode|guard|in|iovdd|pad|pin1|pin2|plus|supply core$1 \$463
+ IOVDD|cathode|guard|in|iovdd|pad|pin1|pin2|plus|supply sg13_hv_pmos L=0.45u
+ W=4.6u AS=1.219p AD=0.874p PS=7.96u PD=5.36u rfmode=0
M$48661 IOVDD|cathode|guard|in|iovdd|pad|pin1|pin2|plus|supply \$463 \$464
+ IOVDD|cathode|guard|in|iovdd|pad|pin1|pin2|plus|supply sg13_hv_pmos L=0.45u
+ W=4.6u AS=0.874p AD=1.219p PS=5.36u PD=7.96u rfmode=0
M$48663 VDD|in|pad|pin1|pin2|supply|vdd VDD|in|pad|pin1|pin2|supply|vdd
+ gate|out$1 VDD|in|pad|pin1|pin2|supply|vdd sg13_hv_pmos L=0.5u W=350u
+ AS=67.55p AD=67.55p PS=376.3u PD=376.3u rfmode=0
M$48713 VDD|in|pad|pin1|pin2|supply|vdd VDD|in|pad|pin1|pin2|supply|vdd
+ gate|out$2 VDD|in|pad|pin1|pin2|supply|vdd sg13_hv_pmos L=0.5u W=350u
+ AS=67.55p AD=67.55p PS=376.3u PD=376.3u rfmode=0
M$48763 VDD|in|pad|pin1|pin2|supply|vdd VDD|in|pad|pin1|pin2|supply|vdd
+ VDD|in|pad|pin1|pin2|supply|vdd VDD|in|pad|pin1|pin2|supply|vdd sg13_hv_pmos
+ L=0.45u W=32.55u AS=11.067p AD=11.067p PS=69.86u PD=69.86u rfmode=0
M$48765 IOVDD|cathode|guard|in|iovdd|pad|pin1|pin2|plus|supply
+ IOVDD|cathode|guard|in|iovdd|pad|pin1|pin2|plus|supply gate|out$3
+ IOVDD|cathode|guard|in|iovdd|pad|pin1|pin2|plus|supply sg13_hv_pmos L=0.5u
+ W=350u AS=67.55p AD=67.55p PS=376.3u PD=376.3u rfmode=0
M$48815 IOVDD|cathode|guard|in|iovdd|pad|pin1|pin2|plus|supply gate|o|pgate$4
+ anode|cathode|pad|uo_PAD[4]
+ IOVDD|cathode|guard|in|iovdd|pad|pin1|pin2|plus|supply sg13_hv_pmos L=0.6u
+ W=199.8u AS=91.1088p AD=94.7052p PS=240.48u PD=241.56u rfmode=0
M$48845 IOVDD|cathode|guard|in|iovdd|pad|pin1|pin2|plus|supply \$2059
+ gate|o|pgate$4 IOVDD|cathode|guard|in|iovdd|pad|pin1|pin2|plus|supply
+ sg13_hv_pmos L=0.45u W=3.9u AS=1.326p AD=1.326p PS=8.48u PD=8.48u rfmode=0
M$48846 IOVDD|cathode|guard|in|iovdd|pad|pin1|pin2|plus|supply \$2047
+ gate|ngate|o$4 IOVDD|cathode|guard|in|iovdd|pad|pin1|pin2|plus|supply
+ sg13_hv_pmos L=0.45u W=3.9u AS=1.326p AD=1.326p PS=8.48u PD=8.48u rfmode=0
M$48847 \$2045 \$2047 IOVDD|cathode|guard|in|iovdd|pad|pin1|pin2|plus|supply
+ IOVDD|cathode|guard|in|iovdd|pad|pin1|pin2|plus|supply sg13_hv_pmos L=0.45u
+ W=0.3u AS=0.102p AD=0.057p PS=1.28u PD=0.68u rfmode=0
M$48848 IOVDD|cathode|guard|in|iovdd|pad|pin1|pin2|plus|supply \$2045 \$2047
+ IOVDD|cathode|guard|in|iovdd|pad|pin1|pin2|plus|supply sg13_hv_pmos L=0.45u
+ W=0.3u AS=0.057p AD=0.102p PS=0.68u PD=1.28u rfmode=0
M$48849 \$2056 \$2059 IOVDD|cathode|guard|in|iovdd|pad|pin1|pin2|plus|supply
+ IOVDD|cathode|guard|in|iovdd|pad|pin1|pin2|plus|supply sg13_hv_pmos L=0.45u
+ W=0.3u AS=0.102p AD=0.057p PS=1.28u PD=0.68u rfmode=0
M$48850 IOVDD|cathode|guard|in|iovdd|pad|pin1|pin2|plus|supply \$2056 \$2059
+ IOVDD|cathode|guard|in|iovdd|pad|pin1|pin2|plus|supply sg13_hv_pmos L=0.45u
+ W=0.3u AS=0.057p AD=0.102p PS=0.68u PD=1.28u rfmode=0
M$48852 IOVDD|cathode|guard|in|iovdd|pad|pin1|pin2|plus|supply core$2 \$2062
+ IOVDD|cathode|guard|in|iovdd|pad|pin1|pin2|plus|supply sg13_hv_pmos L=0.45u
+ W=4.6u AS=1.219p AD=0.874p PS=7.96u PD=5.36u rfmode=0
M$48854 IOVDD|cathode|guard|in|iovdd|pad|pin1|pin2|plus|supply \$2062 \$2061
+ IOVDD|cathode|guard|in|iovdd|pad|pin1|pin2|plus|supply sg13_hv_pmos L=0.45u
+ W=4.6u AS=0.874p AD=1.219p PS=5.36u PD=7.96u rfmode=0
M$48856 IOVDD|cathode|guard|in|iovdd|pad|pin1|pin2|plus|supply gate|o|pgate$5
+ anode|cathode|pad|uo_PAD[5]
+ IOVDD|cathode|guard|in|iovdd|pad|pin1|pin2|plus|supply sg13_hv_pmos L=0.6u
+ W=199.8u AS=91.1088p AD=94.7052p PS=240.48u PD=241.56u rfmode=0
M$48886 IOVDD|cathode|guard|in|iovdd|pad|pin1|pin2|plus|supply \$4349
+ gate|o|pgate$5 IOVDD|cathode|guard|in|iovdd|pad|pin1|pin2|plus|supply
+ sg13_hv_pmos L=0.45u W=3.9u AS=1.326p AD=1.326p PS=8.48u PD=8.48u rfmode=0
M$48887 IOVDD|cathode|guard|in|iovdd|pad|pin1|pin2|plus|supply \$4337
+ gate|ngate|o$5 IOVDD|cathode|guard|in|iovdd|pad|pin1|pin2|plus|supply
+ sg13_hv_pmos L=0.45u W=3.9u AS=1.326p AD=1.326p PS=8.48u PD=8.48u rfmode=0
M$48888 \$4335 \$4337 IOVDD|cathode|guard|in|iovdd|pad|pin1|pin2|plus|supply
+ IOVDD|cathode|guard|in|iovdd|pad|pin1|pin2|plus|supply sg13_hv_pmos L=0.45u
+ W=0.3u AS=0.102p AD=0.057p PS=1.28u PD=0.68u rfmode=0
M$48889 IOVDD|cathode|guard|in|iovdd|pad|pin1|pin2|plus|supply \$4335 \$4337
+ IOVDD|cathode|guard|in|iovdd|pad|pin1|pin2|plus|supply sg13_hv_pmos L=0.45u
+ W=0.3u AS=0.057p AD=0.102p PS=0.68u PD=1.28u rfmode=0
M$48890 \$4346 \$4349 IOVDD|cathode|guard|in|iovdd|pad|pin1|pin2|plus|supply
+ IOVDD|cathode|guard|in|iovdd|pad|pin1|pin2|plus|supply sg13_hv_pmos L=0.45u
+ W=0.3u AS=0.102p AD=0.057p PS=1.28u PD=0.68u rfmode=0
M$48891 IOVDD|cathode|guard|in|iovdd|pad|pin1|pin2|plus|supply \$4346 \$4349
+ IOVDD|cathode|guard|in|iovdd|pad|pin1|pin2|plus|supply sg13_hv_pmos L=0.45u
+ W=0.3u AS=0.057p AD=0.102p PS=0.68u PD=1.28u rfmode=0
M$48893 IOVDD|cathode|guard|in|iovdd|pad|pin1|pin2|plus|supply core$3 \$4352
+ IOVDD|cathode|guard|in|iovdd|pad|pin1|pin2|plus|supply sg13_hv_pmos L=0.45u
+ W=4.6u AS=1.219p AD=0.874p PS=7.96u PD=5.36u rfmode=0
M$48895 IOVDD|cathode|guard|in|iovdd|pad|pin1|pin2|plus|supply \$4352 \$4351
+ IOVDD|cathode|guard|in|iovdd|pad|pin1|pin2|plus|supply sg13_hv_pmos L=0.45u
+ W=4.6u AS=0.874p AD=1.219p PS=5.36u PD=7.96u rfmode=0
M$48897 IOVDD|cathode|guard|in|iovdd|pad|pin1|pin2|plus|supply gate|o|pgate$6
+ anode|cathode|pad|uo_PAD[6]
+ IOVDD|cathode|guard|in|iovdd|pad|pin1|pin2|plus|supply sg13_hv_pmos L=0.6u
+ W=199.8u AS=91.1088p AD=94.7052p PS=240.48u PD=241.56u rfmode=0
M$48927 \$5689 \$5691 IOVDD|cathode|guard|in|iovdd|pad|pin1|pin2|plus|supply
+ IOVDD|cathode|guard|in|iovdd|pad|pin1|pin2|plus|supply sg13_hv_pmos L=0.45u
+ W=0.3u AS=0.102p AD=0.057p PS=1.28u PD=0.68u rfmode=0
M$48928 IOVDD|cathode|guard|in|iovdd|pad|pin1|pin2|plus|supply \$5689 \$5691
+ IOVDD|cathode|guard|in|iovdd|pad|pin1|pin2|plus|supply sg13_hv_pmos L=0.45u
+ W=0.3u AS=0.057p AD=0.102p PS=0.68u PD=1.28u rfmode=0
M$48929 IOVDD|cathode|guard|in|iovdd|pad|pin1|pin2|plus|supply \$5691
+ gate|ngate|o$6 IOVDD|cathode|guard|in|iovdd|pad|pin1|pin2|plus|supply
+ sg13_hv_pmos L=0.45u W=3.9u AS=1.326p AD=1.326p PS=8.48u PD=8.48u rfmode=0
M$48930 \$5700 \$5703 IOVDD|cathode|guard|in|iovdd|pad|pin1|pin2|plus|supply
+ IOVDD|cathode|guard|in|iovdd|pad|pin1|pin2|plus|supply sg13_hv_pmos L=0.45u
+ W=0.3u AS=0.102p AD=0.057p PS=1.28u PD=0.68u rfmode=0
M$48931 IOVDD|cathode|guard|in|iovdd|pad|pin1|pin2|plus|supply \$5700 \$5703
+ IOVDD|cathode|guard|in|iovdd|pad|pin1|pin2|plus|supply sg13_hv_pmos L=0.45u
+ W=0.3u AS=0.057p AD=0.102p PS=0.68u PD=1.28u rfmode=0
M$48933 IOVDD|cathode|guard|in|iovdd|pad|pin1|pin2|plus|supply \$5703
+ gate|o|pgate$6 IOVDD|cathode|guard|in|iovdd|pad|pin1|pin2|plus|supply
+ sg13_hv_pmos L=0.45u W=3.9u AS=1.326p AD=1.326p PS=8.48u PD=8.48u rfmode=0
M$48934 IOVDD|cathode|guard|in|iovdd|pad|pin1|pin2|plus|supply core$4 \$5706
+ IOVDD|cathode|guard|in|iovdd|pad|pin1|pin2|plus|supply sg13_hv_pmos L=0.45u
+ W=4.6u AS=1.219p AD=0.874p PS=7.96u PD=5.36u rfmode=0
M$48936 IOVDD|cathode|guard|in|iovdd|pad|pin1|pin2|plus|supply \$5706 \$5704
+ IOVDD|cathode|guard|in|iovdd|pad|pin1|pin2|plus|supply sg13_hv_pmos L=0.45u
+ W=4.6u AS=0.874p AD=1.219p PS=5.36u PD=7.96u rfmode=0
M$48938 IOVDD|cathode|guard|in|iovdd|pad|pin1|pin2|plus|supply \$5780
+ analog_io[16]|anode|cathode|pad
+ IOVDD|cathode|guard|in|iovdd|pad|pin1|pin2|plus|supply sg13_hv_pmos L=0.6u
+ W=266.4u AS=123.21p AD=123.21p PS=316.72u PD=316.72u rfmode=0
M$48978 IOVDD|cathode|guard|in|iovdd|pad|pin1|pin2|plus|supply gate|o|pgate$7
+ anode|cathode|pad|uo_PAD[7]
+ IOVDD|cathode|guard|in|iovdd|pad|pin1|pin2|plus|supply sg13_hv_pmos L=0.6u
+ W=199.8u AS=91.1088p AD=94.7052p PS=240.48u PD=241.56u rfmode=0
M$49008 \$5786 \$5788 IOVDD|cathode|guard|in|iovdd|pad|pin1|pin2|plus|supply
+ IOVDD|cathode|guard|in|iovdd|pad|pin1|pin2|plus|supply sg13_hv_pmos L=0.45u
+ W=0.3u AS=0.102p AD=0.057p PS=1.28u PD=0.68u rfmode=0
M$49009 IOVDD|cathode|guard|in|iovdd|pad|pin1|pin2|plus|supply \$5786 \$5788
+ IOVDD|cathode|guard|in|iovdd|pad|pin1|pin2|plus|supply sg13_hv_pmos L=0.45u
+ W=0.3u AS=0.057p AD=0.102p PS=0.68u PD=1.28u rfmode=0
M$49010 IOVDD|cathode|guard|in|iovdd|pad|pin1|pin2|plus|supply \$5788
+ gate|ngate|o$7 IOVDD|cathode|guard|in|iovdd|pad|pin1|pin2|plus|supply
+ sg13_hv_pmos L=0.45u W=3.9u AS=1.326p AD=1.326p PS=8.48u PD=8.48u rfmode=0
M$49011 \$5790 \$5798 IOVDD|cathode|guard|in|iovdd|pad|pin1|pin2|plus|supply
+ IOVDD|cathode|guard|in|iovdd|pad|pin1|pin2|plus|supply sg13_hv_pmos L=0.45u
+ W=0.3u AS=0.102p AD=0.057p PS=1.28u PD=0.68u rfmode=0
M$49012 IOVDD|cathode|guard|in|iovdd|pad|pin1|pin2|plus|supply \$5790 \$5798
+ IOVDD|cathode|guard|in|iovdd|pad|pin1|pin2|plus|supply sg13_hv_pmos L=0.45u
+ W=0.3u AS=0.057p AD=0.102p PS=0.68u PD=1.28u rfmode=0
M$49013 IOVDD|cathode|guard|in|iovdd|pad|pin1|pin2|plus|supply \$5798
+ gate|o|pgate$7 IOVDD|cathode|guard|in|iovdd|pad|pin1|pin2|plus|supply
+ sg13_hv_pmos L=0.45u W=3.9u AS=1.326p AD=1.326p PS=8.48u PD=8.48u rfmode=0
M$49014 IOVDD|cathode|guard|in|iovdd|pad|pin1|pin2|plus|supply \$5870
+ analog_io[15]|anode|cathode|pad
+ IOVDD|cathode|guard|in|iovdd|pad|pin1|pin2|plus|supply sg13_hv_pmos L=0.6u
+ W=266.4u AS=123.21p AD=123.21p PS=316.72u PD=316.72u rfmode=0
M$49054 IOVDD|cathode|guard|in|iovdd|pad|pin1|pin2|plus|supply gate|o|pgate$8
+ anode|cathode|pad|uo_PAD[8]
+ IOVDD|cathode|guard|in|iovdd|pad|pin1|pin2|plus|supply sg13_hv_pmos L=0.6u
+ W=199.8u AS=91.1088p AD=94.7052p PS=240.48u PD=241.56u rfmode=0
M$49084 \$5876 \$5877 IOVDD|cathode|guard|in|iovdd|pad|pin1|pin2|plus|supply
+ IOVDD|cathode|guard|in|iovdd|pad|pin1|pin2|plus|supply sg13_hv_pmos L=0.45u
+ W=0.3u AS=0.102p AD=0.057p PS=1.28u PD=0.68u rfmode=0
M$49085 IOVDD|cathode|guard|in|iovdd|pad|pin1|pin2|plus|supply \$5876 \$5877
+ IOVDD|cathode|guard|in|iovdd|pad|pin1|pin2|plus|supply sg13_hv_pmos L=0.45u
+ W=0.3u AS=0.057p AD=0.102p PS=0.68u PD=1.28u rfmode=0
M$49086 IOVDD|cathode|guard|in|iovdd|pad|pin1|pin2|plus|supply \$5877
+ gate|ngate|o$8 IOVDD|cathode|guard|in|iovdd|pad|pin1|pin2|plus|supply
+ sg13_hv_pmos L=0.45u W=3.9u AS=1.326p AD=1.326p PS=8.48u PD=8.48u rfmode=0
M$49087 \$5886 \$5888 IOVDD|cathode|guard|in|iovdd|pad|pin1|pin2|plus|supply
+ IOVDD|cathode|guard|in|iovdd|pad|pin1|pin2|plus|supply sg13_hv_pmos L=0.45u
+ W=0.3u AS=0.102p AD=0.057p PS=1.28u PD=0.68u rfmode=0
M$49088 IOVDD|cathode|guard|in|iovdd|pad|pin1|pin2|plus|supply \$5886 \$5888
+ IOVDD|cathode|guard|in|iovdd|pad|pin1|pin2|plus|supply sg13_hv_pmos L=0.45u
+ W=0.3u AS=0.057p AD=0.102p PS=0.68u PD=1.28u rfmode=0
M$49089 IOVDD|cathode|guard|in|iovdd|pad|pin1|pin2|plus|supply \$5888
+ gate|o|pgate$8 IOVDD|cathode|guard|in|iovdd|pad|pin1|pin2|plus|supply
+ sg13_hv_pmos L=0.45u W=3.9u AS=1.326p AD=1.326p PS=8.48u PD=8.48u rfmode=0
M$49090 IOVDD|cathode|guard|in|iovdd|pad|pin1|pin2|plus|supply \$5959
+ analog_io[0]|anode|cathode|pad
+ IOVDD|cathode|guard|in|iovdd|pad|pin1|pin2|plus|supply sg13_hv_pmos L=0.6u
+ W=266.4u AS=123.21p AD=123.21p PS=316.72u PD=316.72u rfmode=0
M$49130 IOVDD|cathode|guard|in|iovdd|pad|pin1|pin2|plus|supply \$5960
+ analog_io[14]|anode|cathode|pad
+ IOVDD|cathode|guard|in|iovdd|pad|pin1|pin2|plus|supply sg13_hv_pmos L=0.6u
+ W=266.4u AS=123.21p AD=123.21p PS=316.72u PD=316.72u rfmode=0
M$49170 IOVDD|cathode|guard|in|iovdd|pad|pin1|pin2|plus|supply \$6048
+ analog_io[1]|anode|cathode|pad
+ IOVDD|cathode|guard|in|iovdd|pad|pin1|pin2|plus|supply sg13_hv_pmos L=0.6u
+ W=266.4u AS=123.21p AD=123.21p PS=316.72u PD=316.72u rfmode=0
M$49211 IOVDD|cathode|guard|in|iovdd|pad|pin1|pin2|plus|supply core$5 \$6059
+ IOVDD|cathode|guard|in|iovdd|pad|pin1|pin2|plus|supply sg13_hv_pmos L=0.45u
+ W=4.6u AS=1.219p AD=0.874p PS=7.96u PD=5.36u rfmode=0
M$49213 IOVDD|cathode|guard|in|iovdd|pad|pin1|pin2|plus|supply \$6059 \$6058
+ IOVDD|cathode|guard|in|iovdd|pad|pin1|pin2|plus|supply sg13_hv_pmos L=0.45u
+ W=4.6u AS=0.874p AD=1.219p PS=5.36u PD=7.96u rfmode=0
M$49215 G1|TRIG|Trig \$6101 Vboot|vboot Vboot|vboot sg13_hv_pmos L=0.5u W=195u
+ AS=37.5p AD=37.5p PS=223u PD=223u rfmode=0
M$49280 IOVDD|cathode|guard|in|iovdd|pad|pin1|pin2|plus|supply \$6170
+ analog_io[2]|anode|cathode|pad
+ IOVDD|cathode|guard|in|iovdd|pad|pin1|pin2|plus|supply sg13_hv_pmos L=0.6u
+ W=266.4u AS=123.21p AD=123.21p PS=316.72u PD=316.72u rfmode=0
M$49320 Qn|set Qn|set \$6177 \$6177 sg13_hv_pmos L=0.5u W=1u AS=0.34p AD=0.34p
+ PS=2.68u PD=2.68u rfmode=0
M$49321 RESET|Reset|reset RESET|Reset|reset \$6192 \$6192 sg13_hv_pmos L=0.5u
+ W=1u AS=0.34p AD=0.34p PS=2.68u PD=2.68u rfmode=0
M$49322 \$6192 Qn|set Vboot|vboot Vboot|vboot sg13_hv_pmos L=0.5u W=1u AS=0.34p
+ AD=0.34p PS=2.68u PD=2.68u rfmode=0
M$49323 \$6177 RESET|Reset|reset Vboot|vboot Vboot|vboot sg13_hv_pmos L=0.5u
+ W=1u AS=0.34p AD=0.34p PS=2.68u PD=2.68u rfmode=0
M$49324 Qn|set RESET|Reset|reset Vboot|vboot Vboot|vboot sg13_hv_pmos L=1u W=5u
+ AS=1.7p AD=1.7p PS=10.68u PD=10.68u rfmode=0
M$49325 Vboot|vboot Qn|set RESET|Reset|reset Vboot|vboot sg13_hv_pmos L=1u W=5u
+ AS=1.7p AD=1.7p PS=10.68u PD=10.68u rfmode=0
M$49326 Vboot|vboot Qn|set Qn|set Vboot|vboot sg13_hv_pmos L=1u W=0.5u AS=0.17p
+ AD=0.17p PS=1.68u PD=1.68u rfmode=0
M$49327 Vboot|vboot Vboot|vboot VBAT|analog_io_padres[8]|core|padres
+ Vboot|vboot sg13_hv_pmos L=0.5u W=6u AS=2.04p AD=2.04p PS=12.68u PD=12.68u
+ rfmode=0
M$49328 \$6101 \$6107 Vboot|vboot Vboot|vboot sg13_hv_pmos L=0.5u W=3u AS=1.02p
+ AD=1.02p PS=6.68u PD=6.68u rfmode=0
M$49329 Vboot|vboot \$6101 \$6107 Vboot|vboot sg13_hv_pmos L=0.5u W=1u AS=0.34p
+ AD=0.34p PS=2.68u PD=2.68u rfmode=0
M$49330 Vboot|vboot Qn|set Q|Qn Vboot|vboot sg13_hv_pmos L=3u W=5u AS=1.025p
+ AD=1.025p PS=9.6u PD=9.6u rfmode=0
M$49340 Vboot|vboot Q|Qn Q|Reset Vboot|vboot sg13_hv_pmos L=3u W=5u AS=1.025p
+ AD=1.025p PS=9.6u PD=9.6u rfmode=0
M$49350 Vboot|vboot Q|Reset Q|Qn Vboot|vboot sg13_hv_pmos L=3u W=5u AS=1.025p
+ AD=1.025p PS=9.6u PD=9.6u rfmode=0
M$49360 IOVDD|cathode|guard|in|iovdd|pad|pin1|pin2|plus|supply \$6172
+ analog_io[13]|anode|cathode|pad
+ IOVDD|cathode|guard|in|iovdd|pad|pin1|pin2|plus|supply sg13_hv_pmos L=0.6u
+ W=266.4u AS=123.21p AD=123.21p PS=316.72u PD=316.72u rfmode=0
M$49400 RESET|Reset|reset RESET|Reset|reset Vboot|vboot Vboot|vboot
+ sg13_hv_pmos L=1u W=0.5u AS=0.17p AD=0.17p PS=1.68u PD=1.68u rfmode=0
M$49401 Vboot|vboot RESET|Reset|reset Q|Reset Vboot|vboot sg13_hv_pmos L=3u
+ W=5u AS=1.025p AD=1.025p PS=9.6u PD=9.6u rfmode=0
M$49411 G2|vg vgmd78 VHLS|analog_io_padres[13]|core|padres
+ VHLS|analog_io_padres[13]|core|padres sg13_hv_pmos L=0.4u W=2500u AS=638p
+ AD=638p PS=2677.6u PD=2677.6u rfmode=0
M$49461 vgmd78 vgmd5 VHLS|analog_io_padres[13]|core|padres
+ VHLS|analog_io_padres[13]|core|padres sg13_hv_pmos L=0.4u W=300u AS=81.1p
+ AD=81.6p PS=326.22u PD=326.32u rfmode=0
M$49491 vgmd5 vgmd1 VHLS|analog_io_padres[13]|core|padres
+ VHLS|analog_io_padres[13]|core|padres sg13_hv_pmos L=0.4u W=10u AS=5.6p
+ AD=6.1p PS=21.12u PD=21.22u rfmode=0
M$49492 vgmd1 vgmd5 VHLS|analog_io_padres[13]|core|padres
+ VHLS|analog_io_padres[13]|core|padres sg13_hv_pmos L=0.4u W=10u AS=6.75p
+ AD=7p PS=21.35u PD=21.4u rfmode=0
M$49693 IOVDD|cathode|guard|in|iovdd|pad|pin1|pin2|plus|supply \$6313
+ analog_io[3]|anode|cathode|pad
+ IOVDD|cathode|guard|in|iovdd|pad|pin1|pin2|plus|supply sg13_hv_pmos L=0.6u
+ W=266.4u AS=123.21p AD=123.21p PS=316.72u PD=316.72u rfmode=0
M$49733 IOVDD|cathode|guard|in|iovdd|pad|pin1|pin2|plus|supply
+ IOVDD|cathode|guard|in|iovdd|pad|pin1|pin2|plus|supply gate|out$4
+ IOVDD|cathode|guard|in|iovdd|pad|pin1|pin2|plus|supply sg13_hv_pmos L=0.5u
+ W=350u AS=67.55p AD=67.55p PS=376.3u PD=376.3u rfmode=0
M$49783 VDD|in|pad|pin1|pin2|supply|vdd VDD|in|pad|pin1|pin2|supply|vdd
+ gate|out$5 VDD|in|pad|pin1|pin2|supply|vdd sg13_hv_pmos L=0.5u W=350u
+ AS=67.55p AD=67.55p PS=376.3u PD=376.3u rfmode=0
M$49833 IOVDD|cathode|guard|in|iovdd|pad|pin1|pin2|plus|supply \$6314
+ analog_io[12]|anode|cathode|pad
+ IOVDD|cathode|guard|in|iovdd|pad|pin1|pin2|plus|supply sg13_hv_pmos L=0.6u
+ W=266.4u AS=123.21p AD=123.21p PS=316.72u PD=316.72u rfmode=0
M$49874 IOVDD|cathode|guard|in|iovdd|pad|pin1|pin2|plus|supply core$6 \$6600
+ IOVDD|cathode|guard|in|iovdd|pad|pin1|pin2|plus|supply sg13_hv_pmos L=0.45u
+ W=4.6u AS=1.219p AD=0.874p PS=7.96u PD=5.36u rfmode=0
M$49876 IOVDD|cathode|guard|in|iovdd|pad|pin1|pin2|plus|supply \$6600 \$6599
+ IOVDD|cathode|guard|in|iovdd|pad|pin1|pin2|plus|supply sg13_hv_pmos L=0.45u
+ W=4.6u AS=0.874p AD=1.219p PS=5.36u PD=7.96u rfmode=0
M$49878 IOVDD|cathode|guard|in|iovdd|pad|pin1|pin2|plus|supply
+ IOVDD|cathode|guard|in|iovdd|pad|pin1|pin2|plus|supply gate|out$6
+ IOVDD|cathode|guard|in|iovdd|pad|pin1|pin2|plus|supply sg13_hv_pmos L=0.5u
+ W=350u AS=67.55p AD=67.55p PS=376.3u PD=376.3u rfmode=0
M$49928 IOVDD|cathode|guard|in|iovdd|pad|pin1|pin2|plus|supply
+ IOVDD|cathode|guard|in|iovdd|pad|pin1|pin2|plus|supply gate|out$7
+ IOVDD|cathode|guard|in|iovdd|pad|pin1|pin2|plus|supply sg13_hv_pmos L=0.5u
+ W=350u AS=67.55p AD=67.55p PS=376.3u PD=376.3u rfmode=0
M$49978 IOVDD|cathode|guard|in|iovdd|pad|pin1|pin2|plus|supply \$6940
+ analog_io[4]|anode|cathode|pad
+ IOVDD|cathode|guard|in|iovdd|pad|pin1|pin2|plus|supply sg13_hv_pmos L=0.6u
+ W=266.4u AS=123.21p AD=123.21p PS=316.72u PD=316.72u rfmode=0
M$49998 IOVDD|cathode|guard|in|iovdd|pad|pin1|pin2|plus|supply \$6941
+ analog_io[5]|anode|cathode|pad
+ IOVDD|cathode|guard|in|iovdd|pad|pin1|pin2|plus|supply sg13_hv_pmos L=0.6u
+ W=266.4u AS=123.21p AD=123.21p PS=316.72u PD=316.72u rfmode=0
M$50018 IOVDD|cathode|guard|in|iovdd|pad|pin1|pin2|plus|supply \$6942
+ analog_io[6]|anode|cathode|pad
+ IOVDD|cathode|guard|in|iovdd|pad|pin1|pin2|plus|supply sg13_hv_pmos L=0.6u
+ W=266.4u AS=123.21p AD=123.21p PS=316.72u PD=316.72u rfmode=0
M$50038 IOVDD|cathode|guard|in|iovdd|pad|pin1|pin2|plus|supply \$6943
+ analog_io[7]|anode|cathode|pad
+ IOVDD|cathode|guard|in|iovdd|pad|pin1|pin2|plus|supply sg13_hv_pmos L=0.6u
+ W=266.4u AS=123.21p AD=123.21p PS=316.72u PD=316.72u rfmode=0
M$50058 IOVDD|cathode|guard|in|iovdd|pad|pin1|pin2|plus|supply \$6944
+ analog_io[8]|anode|cathode|pad
+ IOVDD|cathode|guard|in|iovdd|pad|pin1|pin2|plus|supply sg13_hv_pmos L=0.6u
+ W=266.4u AS=123.21p AD=123.21p PS=316.72u PD=316.72u rfmode=0
M$50078 IOVDD|cathode|guard|in|iovdd|pad|pin1|pin2|plus|supply \$6945
+ analog_io[9]|anode|cathode|pad
+ IOVDD|cathode|guard|in|iovdd|pad|pin1|pin2|plus|supply sg13_hv_pmos L=0.6u
+ W=266.4u AS=123.21p AD=123.21p PS=316.72u PD=316.72u rfmode=0
M$50098 IOVDD|cathode|guard|in|iovdd|pad|pin1|pin2|plus|supply \$6946
+ analog_io[10]|anode|cathode|pad
+ IOVDD|cathode|guard|in|iovdd|pad|pin1|pin2|plus|supply sg13_hv_pmos L=0.6u
+ W=266.4u AS=123.21p AD=123.21p PS=316.72u PD=316.72u rfmode=0
M$50118 IOVDD|cathode|guard|in|iovdd|pad|pin1|pin2|plus|supply \$6947
+ analog_io[11]|anode|cathode|pad
+ IOVDD|cathode|guard|in|iovdd|pad|pin1|pin2|plus|supply sg13_hv_pmos L=0.6u
+ W=266.4u AS=123.21p AD=123.21p PS=316.72u PD=316.72u rfmode=0
D$50298 VSS|anode|cathode|vss IOVSS|anode|cathode|guard|iovss|minus dantenna
+ A=35.0028p P=58.08u m=10
D$50300 VSS|anode|cathode|vss anode|cathode|pad|ui_PAD[6] dantenna A=35.0028p
+ P=58.08u m=2
D$50302 VSS|anode|cathode|vss anode|cathode|pad|ui_PAD[5] dantenna A=35.0028p
+ P=58.08u m=2
D$50304 VSS|anode|cathode|vss VSS|anode|cathode|vss dantenna A=35.0028p
+ P=58.08u m=6
D$50306 VSS|anode|cathode|vss analog_io[19]|anode|cathode|pad dantenna
+ A=35.0028p P=58.08u m=2
D$50307 VSS|anode|cathode|vss analog_io[18]|anode|cathode|pad dantenna
+ A=35.0028p P=58.08u m=2
D$50308 VSS|anode|cathode|vss analog_io[17]|anode|cathode|pad dantenna
+ A=35.0028p P=58.08u m=2
D$50309 VSS|anode|cathode|vss gate|ngate|o dantenna A=0.6084p P=3.12u m=1
D$50310 VSS|anode|cathode|vss anode|cathode|pad|uo_PAD[3] dantenna A=35.0028p
+ P=58.08u m=2
D$50311 VSS|anode|cathode|vss gate|ngate|o$1 dantenna A=0.6084p P=3.12u m=1
D$50312 VSS|anode|cathode|vss anode|cathode|pad|uo_PAD[2] dantenna A=35.0028p
+ P=58.08u m=2
D$50313 VSS|anode|cathode|vss gate|ngate|o$2 dantenna A=0.6084p P=3.12u m=1
D$50314 VSS|anode|cathode|vss anode|cathode|pad|uo_PAD[1] dantenna A=35.0028p
+ P=58.08u m=2
D$50315 VSS|anode|cathode|vss gate|ngate|o$3 dantenna A=0.6084p P=3.12u m=1
D$50316 VSS|anode|cathode|vss anode|cathode|pad|uo_PAD[0] dantenna A=35.0028p
+ P=58.08u m=2
D$50317 VSS|anode|cathode|vss gate|out dantenna A=0.2304p P=1.92u m=1
D$50319 VSS|anode|cathode|vss analog_io_padres[19]|core|padres|vin_neg dantenna
+ A=1.984p P=7.48u m=1
D$50321 VSS|anode|cathode|vss analog_io_padres[18]|core|padres dantenna
+ A=1.984p P=7.48u m=1
D$50323 VSS|anode|cathode|vss analog_io_padres[17]|core|padres|vin_pos dantenna
+ A=1.984p P=7.48u m=1
D$50328 VSS|anode|cathode|vss core dantenna A=1.984p P=7.48u m=1
D$50329 VSS|anode|cathode|vss core$1 dantenna A=1.984p P=7.48u m=1
D$50330 VSS|anode|cathode|vss gate|out$1 dantenna A=0.2304p P=1.92u m=1
D$50331 VSS|anode|cathode|vss gate|out$2 dantenna A=0.2304p P=1.92u m=1
D$50332 VSS|anode|cathode|vss gate|out$3 dantenna A=0.2304p P=1.92u m=1
D$50337 VSS|anode|cathode|vss anode|cathode|pad|ui_PAD[4] dantenna A=35.0028p
+ P=58.08u m=2
D$50339 VSS|anode|cathode|vss gate|ngate|o$4 dantenna A=0.6084p P=3.12u m=1
D$50340 VSS|anode|cathode|vss anode|cathode|pad|uo_PAD[4] dantenna A=35.0028p
+ P=58.08u m=2
D$50342 VSS|anode|cathode|vss core$2 dantenna A=1.984p P=7.48u m=1
D$50343 VSS|anode|cathode|vss anode|cathode|pad|ui_PAD[3] dantenna A=35.0028p
+ P=58.08u m=2
D$50345 VSS|anode|cathode|vss gate|ngate|o$5 dantenna A=0.6084p P=3.12u m=1
D$50346 VSS|anode|cathode|vss anode|cathode|pad|uo_PAD[5] dantenna A=35.0028p
+ P=58.08u m=2
D$50348 VSS|anode|cathode|vss core$3 dantenna A=1.984p P=7.48u m=1
D$50349 VSS|anode|cathode|vss anode|cathode|pad|ui_PAD[2] dantenna A=35.0028p
+ P=58.08u m=2
D$50351 VSS|anode|cathode|vss gate|ngate|o$6 dantenna A=0.6084p P=3.12u m=1
D$50352 VSS|anode|cathode|vss anode|cathode|pad|uo_PAD[6] dantenna A=35.0028p
+ P=58.08u m=2
D$50354 VSS|anode|cathode|vss gate|ngate|o$7 dantenna A=0.6084p P=3.12u m=1
D$50355 VSS|anode|cathode|vss core$4 dantenna A=1.984p P=7.48u m=1
D$50356 VSS|anode|cathode|vss anode|cathode|pad|uo_PAD[7] dantenna A=35.0028p
+ P=58.08u m=2
D$50358 VSS|anode|cathode|vss analog_io[16]|anode|cathode|pad dantenna
+ A=35.0028p P=58.08u m=2
D$50360 VSS|anode|cathode|vss gate|ngate|o$8 dantenna A=0.6084p P=3.12u m=1
D$50361 VSS|anode|cathode|vss OUTP|analog_io_padres[16]|core|padres dantenna
+ A=1.984p P=7.48u m=1
D$50362 VSS|anode|cathode|vss anode|cathode|pad|uo_PAD[8] dantenna A=35.0028p
+ P=58.08u m=2
D$50364 VSS|anode|cathode|vss analog_io[15]|anode|cathode|pad dantenna
+ A=35.0028p P=58.08u m=2
D$50366 VSS|anode|cathode|vss analog_io[0]|anode|cathode|pad dantenna
+ A=35.0028p P=58.08u m=2
D$50368 VSS|anode|cathode|vss OUTN|analog_io_padres[15]|core|padres dantenna
+ A=1.984p P=7.48u m=1
D$50369 VSS|anode|cathode|vss analog_io[14]|anode|cathode|pad dantenna
+ A=35.0028p P=58.08u m=2
D$50371 VSS|anode|cathode|vss analog_io_padres[0]|core|padres dantenna A=1.984p
+ P=7.48u m=1
D$50372 VSS|anode|cathode|vss VBIAS|analog_io_padres[14]|core|padres dantenna
+ A=1.984p P=7.48u m=1
D$50373 VSS|anode|cathode|vss anode|cathode|pad|ui_PAD[1] dantenna A=35.0028p
+ P=58.08u m=2
D$50375 VSS|anode|cathode|vss analog_io[1]|anode|cathode|pad dantenna
+ A=35.0028p P=58.08u m=2
D$50377 VSS|anode|cathode|vss analog_io_padres[1]|core|padres dantenna A=1.984p
+ P=7.48u m=1
D$50378 VSS|anode|cathode|vss core$5 dantenna A=1.984p P=7.48u m=1
D$50379 VSS|anode|cathode|vss analog_io[2]|anode|cathode|pad dantenna
+ A=35.0028p P=58.08u m=2
D$50381 VSS|anode|cathode|vss analog_io[13]|anode|cathode|pad dantenna
+ A=35.0028p P=58.08u m=2
D$50383 VSS|anode|cathode|vss analog_io_padres[2]|core|padres dantenna A=1.984p
+ P=7.48u m=1
D$50384 VSS|anode|cathode|vss VHLS|analog_io_padres[13]|core|padres dantenna
+ A=1.984p P=7.48u m=1
D$50385 VSS|anode|cathode|vss analog_io[3]|anode|cathode|pad dantenna
+ A=35.0028p P=58.08u m=2
D$50387 VSS|anode|cathode|vss analog_io[12]|anode|cathode|pad dantenna
+ A=35.0028p P=58.08u m=2
D$50389 VSS|anode|cathode|vss gate|out$4 dantenna A=0.2304p P=1.92u m=1
D$50390 VSS|anode|cathode|vss analog_io_padres[3]|core|padres dantenna A=1.984p
+ P=7.48u m=1
D$50391 VSS|anode|cathode|vss VDDLS|analog_io_padres[12]|core|padres dantenna
+ A=1.984p P=7.48u m=1
D$50392 VSS|anode|cathode|vss gate|out$5 dantenna A=0.2304p P=1.92u m=1
D$50397 VSS|anode|cathode|vss analog_io_padres[4]|core|padres dantenna A=1.984p
+ P=7.48u m=1
D$50398 VSS|anode|cathode|vss analog_io_padres[5]|core|padres dantenna A=1.984p
+ P=7.48u m=1
D$50399 VSS|anode|cathode|vss analog_io_padres[6]|core|padres dantenna A=1.984p
+ P=7.48u m=1
D$50400 VSS|anode|cathode|vss analog_io_padres[7]|core|padres dantenna A=1.984p
+ P=7.48u m=1
D$50401 VSS|anode|cathode|vss VBAT|analog_io_padres[8]|core|padres dantenna
+ A=1.984p P=7.48u m=1
D$50402 VSS|anode|cathode|vss VBAT2|analog_io_padres[9]|core|padres dantenna
+ A=1.984p P=7.48u m=1
D$50403 VSS|anode|cathode|vss core$6 dantenna A=1.984p P=7.48u m=1
D$50404 VSS|anode|cathode|vss VH|analog_io_padres[10]|core|padres dantenna
+ A=1.984p P=7.48u m=1
D$50405 VSS|anode|cathode|vss VOUT|analog_io_padres[11]|core|padres dantenna
+ A=1.984p P=7.48u m=1
D$50406 VSS|anode|cathode|vss gate|out$6 dantenna A=0.2304p P=1.92u m=1
D$50409 VSS|anode|cathode|vss anode|cathode|pad|ui_PAD[0] dantenna A=35.0028p
+ P=58.08u m=2
D$50411 VSS|anode|cathode|vss gate|out$7 dantenna A=0.2304p P=1.92u m=1
D$50414 VSS|anode|cathode|vss analog_io[4]|anode|cathode|pad dantenna
+ A=35.0028p P=58.08u m=2
D$50416 VSS|anode|cathode|vss analog_io[5]|anode|cathode|pad dantenna
+ A=35.0028p P=58.08u m=2
D$50418 VSS|anode|cathode|vss analog_io[6]|anode|cathode|pad dantenna
+ A=35.0028p P=58.08u m=2
D$50420 VSS|anode|cathode|vss analog_io[7]|anode|cathode|pad dantenna
+ A=35.0028p P=58.08u m=2
D$50422 VSS|anode|cathode|vss analog_io[8]|anode|cathode|pad dantenna
+ A=35.0028p P=58.08u m=2
D$50424 VSS|anode|cathode|vss analog_io[9]|anode|cathode|pad dantenna
+ A=35.0028p P=58.08u m=2
D$50426 VSS|anode|cathode|vss analog_io[10]|anode|cathode|pad dantenna
+ A=35.0028p P=58.08u m=2
D$50428 VSS|anode|cathode|vss analog_io[11]|anode|cathode|pad dantenna
+ A=35.0028p P=58.08u m=2
D$50430 analog_io[19]|anode|cathode|pad
+ IOVDD|cathode|guard|in|iovdd|pad|pin1|pin2|plus|supply dpantenna A=35.0028p
+ P=58.08u m=2
D$50431 analog_io[18]|anode|cathode|pad
+ IOVDD|cathode|guard|in|iovdd|pad|pin1|pin2|plus|supply dpantenna A=35.0028p
+ P=58.08u m=2
D$50432 analog_io[17]|anode|cathode|pad
+ IOVDD|cathode|guard|in|iovdd|pad|pin1|pin2|plus|supply dpantenna A=35.0028p
+ P=58.08u m=2
D$50433 anode|cathode|pad|uo_PAD[3]
+ IOVDD|cathode|guard|in|iovdd|pad|pin1|pin2|plus|supply dpantenna A=35.0028p
+ P=58.08u m=2
D$50434 anode|cathode|pad|uo_PAD[2]
+ IOVDD|cathode|guard|in|iovdd|pad|pin1|pin2|plus|supply dpantenna A=35.0028p
+ P=58.08u m=2
D$50435 anode|cathode|pad|uo_PAD[1]
+ IOVDD|cathode|guard|in|iovdd|pad|pin1|pin2|plus|supply dpantenna A=35.0028p
+ P=58.08u m=2
D$50436 anode|cathode|pad|uo_PAD[0]
+ IOVDD|cathode|guard|in|iovdd|pad|pin1|pin2|plus|supply dpantenna A=35.0028p
+ P=58.08u m=2
D$50444 IOVSS|anode|cathode|guard|iovss|minus
+ IOVDD|cathode|guard|in|iovdd|pad|pin1|pin2|plus|supply dpantenna A=35.0028p
+ P=58.08u m=10
D$50446 anode|cathode|pad|ui_PAD[6]
+ IOVDD|cathode|guard|in|iovdd|pad|pin1|pin2|plus|supply dpantenna A=35.0028p
+ P=58.08u m=2
D$50448 anode|cathode|pad|ui_PAD[5]
+ IOVDD|cathode|guard|in|iovdd|pad|pin1|pin2|plus|supply dpantenna A=35.0028p
+ P=58.08u m=2
D$50450 VSS|anode|cathode|vss
+ IOVDD|cathode|guard|in|iovdd|pad|pin1|pin2|plus|supply dpantenna A=35.0028p
+ P=58.08u m=6
D$50452 analog_io_padres[19]|core|padres|vin_neg
+ IOVDD|cathode|guard|in|iovdd|pad|pin1|pin2|plus|supply dpantenna A=3.1872p
+ P=11.24u m=1
D$50453 analog_io_padres[18]|core|padres
+ IOVDD|cathode|guard|in|iovdd|pad|pin1|pin2|plus|supply dpantenna A=3.1872p
+ P=11.24u m=1
D$50454 analog_io_padres[17]|core|padres|vin_pos
+ IOVDD|cathode|guard|in|iovdd|pad|pin1|pin2|plus|supply dpantenna A=3.1872p
+ P=11.24u m=1
D$50455 gate|o|pgate IOVDD|cathode|guard|in|iovdd|pad|pin1|pin2|plus|supply
+ dpantenna A=0.6084p P=3.12u m=1
D$50456 gate|o|pgate$1 IOVDD|cathode|guard|in|iovdd|pad|pin1|pin2|plus|supply
+ dpantenna A=0.6084p P=3.12u m=1
D$50457 gate|o|pgate$2 IOVDD|cathode|guard|in|iovdd|pad|pin1|pin2|plus|supply
+ dpantenna A=0.6084p P=3.12u m=1
D$50458 gate|o|pgate$3 IOVDD|cathode|guard|in|iovdd|pad|pin1|pin2|plus|supply
+ dpantenna A=0.6084p P=3.12u m=1
D$50459 core IOVDD|cathode|guard|in|iovdd|pad|pin1|pin2|plus|supply dpantenna
+ A=3.1872p P=11.24u m=1
D$50460 core$1 IOVDD|cathode|guard|in|iovdd|pad|pin1|pin2|plus|supply dpantenna
+ A=3.1872p P=11.24u m=1
D$50463 anode|cathode|pad|ui_PAD[4]
+ IOVDD|cathode|guard|in|iovdd|pad|pin1|pin2|plus|supply dpantenna A=35.0028p
+ P=58.08u m=2
D$50467 gate|o|pgate$4 IOVDD|cathode|guard|in|iovdd|pad|pin1|pin2|plus|supply
+ dpantenna A=0.6084p P=3.12u m=1
D$50468 anode|cathode|pad|uo_PAD[4]
+ IOVDD|cathode|guard|in|iovdd|pad|pin1|pin2|plus|supply dpantenna A=35.0028p
+ P=58.08u m=2
D$50470 core$2 IOVDD|cathode|guard|in|iovdd|pad|pin1|pin2|plus|supply dpantenna
+ A=3.1872p P=11.24u m=1
D$50471 anode|cathode|pad|ui_PAD[3]
+ IOVDD|cathode|guard|in|iovdd|pad|pin1|pin2|plus|supply dpantenna A=35.0028p
+ P=58.08u m=2
D$50473 gate|o|pgate$5 IOVDD|cathode|guard|in|iovdd|pad|pin1|pin2|plus|supply
+ dpantenna A=0.6084p P=3.12u m=1
D$50474 anode|cathode|pad|uo_PAD[5]
+ IOVDD|cathode|guard|in|iovdd|pad|pin1|pin2|plus|supply dpantenna A=35.0028p
+ P=58.08u m=2
D$50476 core$3 IOVDD|cathode|guard|in|iovdd|pad|pin1|pin2|plus|supply dpantenna
+ A=3.1872p P=11.24u m=1
D$50477 anode|cathode|pad|ui_PAD[2]
+ IOVDD|cathode|guard|in|iovdd|pad|pin1|pin2|plus|supply dpantenna A=35.0028p
+ P=58.08u m=2
D$50479 gate|o|pgate$6 IOVDD|cathode|guard|in|iovdd|pad|pin1|pin2|plus|supply
+ dpantenna A=0.6084p P=3.12u m=1
D$50480 anode|cathode|pad|uo_PAD[6]
+ IOVDD|cathode|guard|in|iovdd|pad|pin1|pin2|plus|supply dpantenna A=35.0028p
+ P=58.08u m=2
D$50482 gate|o|pgate$7 IOVDD|cathode|guard|in|iovdd|pad|pin1|pin2|plus|supply
+ dpantenna A=0.6084p P=3.12u m=1
D$50483 core$4 IOVDD|cathode|guard|in|iovdd|pad|pin1|pin2|plus|supply dpantenna
+ A=3.1872p P=11.24u m=1
D$50484 anode|cathode|pad|uo_PAD[7]
+ IOVDD|cathode|guard|in|iovdd|pad|pin1|pin2|plus|supply dpantenna A=35.0028p
+ P=58.08u m=2
D$50486 analog_io[16]|anode|cathode|pad
+ IOVDD|cathode|guard|in|iovdd|pad|pin1|pin2|plus|supply dpantenna A=35.0028p
+ P=58.08u m=2
D$50488 anode|cathode|pad|uo_PAD[8]
+ IOVDD|cathode|guard|in|iovdd|pad|pin1|pin2|plus|supply dpantenna A=35.0028p
+ P=58.08u m=2
D$50490 gate|o|pgate$8 IOVDD|cathode|guard|in|iovdd|pad|pin1|pin2|plus|supply
+ dpantenna A=0.6084p P=3.12u m=1
D$50491 OUTP|analog_io_padres[16]|core|padres
+ IOVDD|cathode|guard|in|iovdd|pad|pin1|pin2|plus|supply dpantenna A=3.1872p
+ P=11.24u m=1
D$50492 analog_io[15]|anode|cathode|pad
+ IOVDD|cathode|guard|in|iovdd|pad|pin1|pin2|plus|supply dpantenna A=35.0028p
+ P=58.08u m=2
D$50494 analog_io[0]|anode|cathode|pad
+ IOVDD|cathode|guard|in|iovdd|pad|pin1|pin2|plus|supply dpantenna A=35.0028p
+ P=58.08u m=2
D$50496 OUTN|analog_io_padres[15]|core|padres
+ IOVDD|cathode|guard|in|iovdd|pad|pin1|pin2|plus|supply dpantenna A=3.1872p
+ P=11.24u m=1
D$50497 analog_io[14]|anode|cathode|pad
+ IOVDD|cathode|guard|in|iovdd|pad|pin1|pin2|plus|supply dpantenna A=35.0028p
+ P=58.08u m=2
D$50499 analog_io_padres[0]|core|padres
+ IOVDD|cathode|guard|in|iovdd|pad|pin1|pin2|plus|supply dpantenna A=3.1872p
+ P=11.24u m=1
D$50500 VBIAS|analog_io_padres[14]|core|padres
+ IOVDD|cathode|guard|in|iovdd|pad|pin1|pin2|plus|supply dpantenna A=3.1872p
+ P=11.24u m=1
D$50501 anode|cathode|pad|ui_PAD[1]
+ IOVDD|cathode|guard|in|iovdd|pad|pin1|pin2|plus|supply dpantenna A=35.0028p
+ P=58.08u m=2
D$50503 analog_io[1]|anode|cathode|pad
+ IOVDD|cathode|guard|in|iovdd|pad|pin1|pin2|plus|supply dpantenna A=35.0028p
+ P=58.08u m=2
D$50505 analog_io_padres[1]|core|padres
+ IOVDD|cathode|guard|in|iovdd|pad|pin1|pin2|plus|supply dpantenna A=3.1872p
+ P=11.24u m=1
D$50506 core$5 IOVDD|cathode|guard|in|iovdd|pad|pin1|pin2|plus|supply dpantenna
+ A=3.1872p P=11.24u m=1
D$50507 analog_io[2]|anode|cathode|pad
+ IOVDD|cathode|guard|in|iovdd|pad|pin1|pin2|plus|supply dpantenna A=35.0028p
+ P=58.08u m=2
D$50509 analog_io[13]|anode|cathode|pad
+ IOVDD|cathode|guard|in|iovdd|pad|pin1|pin2|plus|supply dpantenna A=35.0028p
+ P=58.08u m=2
D$50511 analog_io[3]|anode|cathode|pad
+ IOVDD|cathode|guard|in|iovdd|pad|pin1|pin2|plus|supply dpantenna A=35.0028p
+ P=58.08u m=2
D$50513 analog_io_padres[2]|core|padres
+ IOVDD|cathode|guard|in|iovdd|pad|pin1|pin2|plus|supply dpantenna A=3.1872p
+ P=11.24u m=1
D$50514 VHLS|analog_io_padres[13]|core|padres
+ IOVDD|cathode|guard|in|iovdd|pad|pin1|pin2|plus|supply dpantenna A=3.1872p
+ P=11.24u m=1
D$50515 analog_io[12]|anode|cathode|pad
+ IOVDD|cathode|guard|in|iovdd|pad|pin1|pin2|plus|supply dpantenna A=35.0028p
+ P=58.08u m=2
D$50518 analog_io_padres[3]|core|padres
+ IOVDD|cathode|guard|in|iovdd|pad|pin1|pin2|plus|supply dpantenna A=3.1872p
+ P=11.24u m=1
D$50519 VDDLS|analog_io_padres[12]|core|padres
+ IOVDD|cathode|guard|in|iovdd|pad|pin1|pin2|plus|supply dpantenna A=3.1872p
+ P=11.24u m=1
D$50523 analog_io_padres[4]|core|padres
+ IOVDD|cathode|guard|in|iovdd|pad|pin1|pin2|plus|supply dpantenna A=3.1872p
+ P=11.24u m=1
D$50524 analog_io_padres[5]|core|padres
+ IOVDD|cathode|guard|in|iovdd|pad|pin1|pin2|plus|supply dpantenna A=3.1872p
+ P=11.24u m=1
D$50525 analog_io_padres[6]|core|padres
+ IOVDD|cathode|guard|in|iovdd|pad|pin1|pin2|plus|supply dpantenna A=3.1872p
+ P=11.24u m=1
D$50526 analog_io_padres[7]|core|padres
+ IOVDD|cathode|guard|in|iovdd|pad|pin1|pin2|plus|supply dpantenna A=3.1872p
+ P=11.24u m=1
D$50527 VBAT|analog_io_padres[8]|core|padres
+ IOVDD|cathode|guard|in|iovdd|pad|pin1|pin2|plus|supply dpantenna A=3.1872p
+ P=11.24u m=1
D$50528 VBAT2|analog_io_padres[9]|core|padres
+ IOVDD|cathode|guard|in|iovdd|pad|pin1|pin2|plus|supply dpantenna A=3.1872p
+ P=11.24u m=1
D$50529 core$6 IOVDD|cathode|guard|in|iovdd|pad|pin1|pin2|plus|supply dpantenna
+ A=3.1872p P=11.24u m=1
D$50530 VH|analog_io_padres[10]|core|padres
+ IOVDD|cathode|guard|in|iovdd|pad|pin1|pin2|plus|supply dpantenna A=3.1872p
+ P=11.24u m=1
D$50531 VOUT|analog_io_padres[11]|core|padres
+ IOVDD|cathode|guard|in|iovdd|pad|pin1|pin2|plus|supply dpantenna A=3.1872p
+ P=11.24u m=1
D$50534 analog_io[4]|anode|cathode|pad
+ IOVDD|cathode|guard|in|iovdd|pad|pin1|pin2|plus|supply dpantenna A=35.0028p
+ P=58.08u m=2
D$50535 analog_io[5]|anode|cathode|pad
+ IOVDD|cathode|guard|in|iovdd|pad|pin1|pin2|plus|supply dpantenna A=35.0028p
+ P=58.08u m=2
D$50536 analog_io[6]|anode|cathode|pad
+ IOVDD|cathode|guard|in|iovdd|pad|pin1|pin2|plus|supply dpantenna A=35.0028p
+ P=58.08u m=2
D$50537 analog_io[7]|anode|cathode|pad
+ IOVDD|cathode|guard|in|iovdd|pad|pin1|pin2|plus|supply dpantenna A=35.0028p
+ P=58.08u m=2
D$50538 analog_io[8]|anode|cathode|pad
+ IOVDD|cathode|guard|in|iovdd|pad|pin1|pin2|plus|supply dpantenna A=35.0028p
+ P=58.08u m=2
D$50539 analog_io[9]|anode|cathode|pad
+ IOVDD|cathode|guard|in|iovdd|pad|pin1|pin2|plus|supply dpantenna A=35.0028p
+ P=58.08u m=2
D$50540 anode|cathode|pad|ui_PAD[0]
+ IOVDD|cathode|guard|in|iovdd|pad|pin1|pin2|plus|supply dpantenna A=35.0028p
+ P=58.08u m=2
D$50542 analog_io[10]|anode|cathode|pad
+ IOVDD|cathode|guard|in|iovdd|pad|pin1|pin2|plus|supply dpantenna A=35.0028p
+ P=58.08u m=2
D$50543 analog_io[11]|anode|cathode|pad
+ IOVDD|cathode|guard|in|iovdd|pad|pin1|pin2|plus|supply dpantenna A=35.0028p
+ P=58.08u m=2
R$50554 IOVSS|anode|cathode|guard|iovss|minus \$35 VSS|anode|cathode|vss rppd
+ w=0.5u l=3.54u ps=0u b=0 m=1
R$50555 IOVSS|anode|cathode|guard|iovss|minus \$36 VSS|anode|cathode|vss rppd
+ w=0.5u l=3.54u ps=0u b=0 m=1
R$50556 IOVSS|anode|cathode|guard|iovss|minus \$37 VSS|anode|cathode|vss rppd
+ w=0.5u l=3.54u ps=0u b=0 m=1
R$50557 IOVDD|cathode|guard|in|iovdd|pad|pin1|pin2|plus|supply \$244
+ IOVDD|cathode|guard|in|iovdd|pad|pin1|pin2|plus|supply rppd w=0.5u l=12.9u
+ ps=0u b=0 m=1
R$50558 IOVDD|cathode|guard|in|iovdd|pad|pin1|pin2|plus|supply \$245
+ IOVDD|cathode|guard|in|iovdd|pad|pin1|pin2|plus|supply rppd w=0.5u l=12.9u
+ ps=0u b=0 m=1
R$50559 IOVDD|cathode|guard|in|iovdd|pad|pin1|pin2|plus|supply \$246
+ IOVDD|cathode|guard|in|iovdd|pad|pin1|pin2|plus|supply rppd w=0.5u l=12.9u
+ ps=0u b=0 m=1
R$50560 analog_io[19]|anode|cathode|pad
+ analog_io_padres[19]|core|padres|vin_neg VSS|anode|cathode|vss rppd w=1u l=2u
+ ps=0u b=0 m=1
R$50561 analog_io[18]|anode|cathode|pad analog_io_padres[18]|core|padres
+ VSS|anode|cathode|vss rppd w=1u l=2u ps=0u b=0 m=1
R$50562 analog_io[17]|anode|cathode|pad
+ analog_io_padres[17]|core|padres|vin_pos VSS|anode|cathode|vss rppd w=1u l=2u
+ ps=0u b=0 m=1
R$50563 anode|cathode|pad|ui_PAD[6] core VSS|anode|cathode|vss rppd w=1u l=2u
+ ps=0u b=0 m=1
R$50564 anode|cathode|pad|ui_PAD[5] core$1 VSS|anode|cathode|vss rppd w=1u l=2u
+ ps=0u b=0 m=1
R$50565 core$4 anode|cathode|pad|ui_PAD[2] VSS|anode|cathode|vss rppd w=1u l=2u
+ ps=0u b=0 m=1
R$50566 OUTP|analog_io_padres[16]|core|padres analog_io[16]|anode|cathode|pad
+ VSS|anode|cathode|vss rppd w=1u l=2u ps=0u b=0 m=1
R$50567 core$2 anode|cathode|pad|ui_PAD[4] VSS|anode|cathode|vss rppd w=1u l=2u
+ ps=0u b=0 m=1
R$50568 core$3 anode|cathode|pad|ui_PAD[3] VSS|anode|cathode|vss rppd w=1u l=2u
+ ps=0u b=0 m=1
R$50569 \$5780 IOVDD|cathode|guard|in|iovdd|pad|pin1|pin2|plus|supply
+ IOVDD|cathode|guard|in|iovdd|pad|pin1|pin2|plus|supply rppd w=0.5u l=12.9u
+ ps=0u b=0 m=1
R$50570 \$5781 IOVSS|anode|cathode|guard|iovss|minus VSS|anode|cathode|vss rppd
+ w=0.5u l=3.54u ps=0u b=0 m=1
R$50571 OUTN|analog_io_padres[15]|core|padres analog_io[15]|anode|cathode|pad
+ VSS|anode|cathode|vss rppd w=1u l=2u ps=0u b=0 m=1
R$50572 \$5870 IOVDD|cathode|guard|in|iovdd|pad|pin1|pin2|plus|supply
+ IOVDD|cathode|guard|in|iovdd|pad|pin1|pin2|plus|supply rppd w=0.5u l=12.9u
+ ps=0u b=0 m=1
R$50573 \$5871 IOVSS|anode|cathode|guard|iovss|minus VSS|anode|cathode|vss rppd
+ w=0.5u l=3.54u ps=0u b=0 m=1
R$50574 analog_io[0]|anode|cathode|pad analog_io_padres[0]|core|padres
+ VSS|anode|cathode|vss rppd w=1u l=2u ps=0u b=0 m=1
R$50575 VBIAS|analog_io_padres[14]|core|padres analog_io[14]|anode|cathode|pad
+ VSS|anode|cathode|vss rppd w=1u l=2u ps=0u b=0 m=1
R$50576 IOVSS|anode|cathode|guard|iovss|minus \$5958 VSS|anode|cathode|vss rppd
+ w=0.5u l=3.54u ps=0u b=0 m=1
R$50577 IOVDD|cathode|guard|in|iovdd|pad|pin1|pin2|plus|supply \$5959
+ IOVDD|cathode|guard|in|iovdd|pad|pin1|pin2|plus|supply rppd w=0.5u l=12.9u
+ ps=0u b=0 m=1
R$50578 \$5960 IOVDD|cathode|guard|in|iovdd|pad|pin1|pin2|plus|supply
+ IOVDD|cathode|guard|in|iovdd|pad|pin1|pin2|plus|supply rppd w=0.5u l=12.9u
+ ps=0u b=0 m=1
R$50579 \$5961 IOVSS|anode|cathode|guard|iovss|minus VSS|anode|cathode|vss rppd
+ w=0.5u l=3.54u ps=0u b=0 m=1
R$50580 IOVSS|anode|cathode|guard|iovss|minus \$6047 VSS|anode|cathode|vss rppd
+ w=0.5u l=3.54u ps=0u b=0 m=1
R$50581 IOVDD|cathode|guard|in|iovdd|pad|pin1|pin2|plus|supply \$6048
+ IOVDD|cathode|guard|in|iovdd|pad|pin1|pin2|plus|supply rppd w=0.5u l=12.9u
+ ps=0u b=0 m=1
R$50582 analog_io[1]|anode|cathode|pad analog_io_padres[1]|core|padres
+ VSS|anode|cathode|vss rppd w=1u l=2u ps=0u b=0 m=1
R$50583 core$5 anode|cathode|pad|ui_PAD[1] VSS|anode|cathode|vss rppd w=1u l=2u
+ ps=0u b=0 m=1
R$50584 analog_io[2]|anode|cathode|pad analog_io_padres[2]|core|padres
+ VSS|anode|cathode|vss rppd w=1u l=2u ps=0u b=0 m=1
R$50585 VHLS|analog_io_padres[13]|core|padres analog_io[13]|anode|cathode|pad
+ VSS|anode|cathode|vss rppd w=1u l=2u ps=0u b=0 m=1
R$50586 IOVSS|anode|cathode|guard|iovss|minus \$6169 VSS|anode|cathode|vss rppd
+ w=0.5u l=3.54u ps=0u b=0 m=1
R$50587 IOVDD|cathode|guard|in|iovdd|pad|pin1|pin2|plus|supply \$6170
+ IOVDD|cathode|guard|in|iovdd|pad|pin1|pin2|plus|supply rppd w=0.5u l=12.9u
+ ps=0u b=0 m=1
R$50588 \$6172 IOVDD|cathode|guard|in|iovdd|pad|pin1|pin2|plus|supply
+ IOVDD|cathode|guard|in|iovdd|pad|pin1|pin2|plus|supply rppd w=0.5u l=12.9u
+ ps=0u b=0 m=1
R$50589 \$6173 IOVSS|anode|cathode|guard|iovss|minus VSS|anode|cathode|vss rppd
+ w=0.5u l=3.54u ps=0u b=0 m=1
R$50590 IOVSS|anode|cathode|guard|iovss|minus \$6312 VSS|anode|cathode|vss rppd
+ w=0.5u l=3.54u ps=0u b=0 m=1
R$50591 IOVDD|cathode|guard|in|iovdd|pad|pin1|pin2|plus|supply \$6313
+ IOVDD|cathode|guard|in|iovdd|pad|pin1|pin2|plus|supply rppd w=0.5u l=12.9u
+ ps=0u b=0 m=1
R$50592 analog_io[3]|anode|cathode|pad analog_io_padres[3]|core|padres
+ VSS|anode|cathode|vss rppd w=1u l=2u ps=0u b=0 m=1
R$50593 VDDLS|analog_io_padres[12]|core|padres analog_io[12]|anode|cathode|pad
+ VSS|anode|cathode|vss rppd w=1u l=2u ps=0u b=0 m=1
R$50594 \$6314 IOVDD|cathode|guard|in|iovdd|pad|pin1|pin2|plus|supply
+ IOVDD|cathode|guard|in|iovdd|pad|pin1|pin2|plus|supply rppd w=0.5u l=12.9u
+ ps=0u b=0 m=1
R$50595 \$6315 IOVSS|anode|cathode|guard|iovss|minus VSS|anode|cathode|vss rppd
+ w=0.5u l=3.54u ps=0u b=0 m=1
R$50596 analog_io_padres[4]|core|padres analog_io[4]|anode|cathode|pad
+ VSS|anode|cathode|vss rppd w=1u l=2u ps=0u b=0 m=1
R$50597 analog_io_padres[5]|core|padres analog_io[5]|anode|cathode|pad
+ VSS|anode|cathode|vss rppd w=1u l=2u ps=0u b=0 m=1
R$50598 analog_io_padres[6]|core|padres analog_io[6]|anode|cathode|pad
+ VSS|anode|cathode|vss rppd w=1u l=2u ps=0u b=0 m=1
R$50599 analog_io_padres[7]|core|padres analog_io[7]|anode|cathode|pad
+ VSS|anode|cathode|vss rppd w=1u l=2u ps=0u b=0 m=1
R$50600 VBAT|analog_io_padres[8]|core|padres analog_io[8]|anode|cathode|pad
+ VSS|anode|cathode|vss rppd w=1u l=2u ps=0u b=0 m=1
R$50601 VBAT2|analog_io_padres[9]|core|padres analog_io[9]|anode|cathode|pad
+ VSS|anode|cathode|vss rppd w=1u l=2u ps=0u b=0 m=1
R$50602 core$6 anode|cathode|pad|ui_PAD[0] VSS|anode|cathode|vss rppd w=1u l=2u
+ ps=0u b=0 m=1
R$50603 VH|analog_io_padres[10]|core|padres analog_io[10]|anode|cathode|pad
+ VSS|anode|cathode|vss rppd w=1u l=2u ps=0u b=0 m=1
R$50604 VOUT|analog_io_padres[11]|core|padres analog_io[11]|anode|cathode|pad
+ VSS|anode|cathode|vss rppd w=1u l=2u ps=0u b=0 m=1
R$50605 \$6940 IOVDD|cathode|guard|in|iovdd|pad|pin1|pin2|plus|supply
+ IOVDD|cathode|guard|in|iovdd|pad|pin1|pin2|plus|supply rppd w=0.5u l=12.9u
+ ps=0u b=0 m=1
R$50606 \$6941 IOVDD|cathode|guard|in|iovdd|pad|pin1|pin2|plus|supply
+ IOVDD|cathode|guard|in|iovdd|pad|pin1|pin2|plus|supply rppd w=0.5u l=12.9u
+ ps=0u b=0 m=1
R$50607 \$6942 IOVDD|cathode|guard|in|iovdd|pad|pin1|pin2|plus|supply
+ IOVDD|cathode|guard|in|iovdd|pad|pin1|pin2|plus|supply rppd w=0.5u l=12.9u
+ ps=0u b=0 m=1
R$50608 \$6943 IOVDD|cathode|guard|in|iovdd|pad|pin1|pin2|plus|supply
+ IOVDD|cathode|guard|in|iovdd|pad|pin1|pin2|plus|supply rppd w=0.5u l=12.9u
+ ps=0u b=0 m=1
R$50609 \$6944 IOVDD|cathode|guard|in|iovdd|pad|pin1|pin2|plus|supply
+ IOVDD|cathode|guard|in|iovdd|pad|pin1|pin2|plus|supply rppd w=0.5u l=12.9u
+ ps=0u b=0 m=1
R$50610 \$6945 IOVDD|cathode|guard|in|iovdd|pad|pin1|pin2|plus|supply
+ IOVDD|cathode|guard|in|iovdd|pad|pin1|pin2|plus|supply rppd w=0.5u l=12.9u
+ ps=0u b=0 m=1
R$50611 \$6946 IOVDD|cathode|guard|in|iovdd|pad|pin1|pin2|plus|supply
+ IOVDD|cathode|guard|in|iovdd|pad|pin1|pin2|plus|supply rppd w=0.5u l=12.9u
+ ps=0u b=0 m=1
R$50612 \$6947 IOVDD|cathode|guard|in|iovdd|pad|pin1|pin2|plus|supply
+ IOVDD|cathode|guard|in|iovdd|pad|pin1|pin2|plus|supply rppd w=0.5u l=12.9u
+ ps=0u b=0 m=1
R$50613 \$7145 IOVSS|anode|cathode|guard|iovss|minus VSS|anode|cathode|vss rppd
+ w=0.5u l=3.54u ps=0u b=0 m=1
R$50614 \$7146 IOVSS|anode|cathode|guard|iovss|minus VSS|anode|cathode|vss rppd
+ w=0.5u l=3.54u ps=0u b=0 m=1
R$50615 \$7147 IOVSS|anode|cathode|guard|iovss|minus VSS|anode|cathode|vss rppd
+ w=0.5u l=3.54u ps=0u b=0 m=1
R$50616 \$7148 IOVSS|anode|cathode|guard|iovss|minus VSS|anode|cathode|vss rppd
+ w=0.5u l=3.54u ps=0u b=0 m=1
R$50617 \$7149 IOVSS|anode|cathode|guard|iovss|minus VSS|anode|cathode|vss rppd
+ w=0.5u l=3.54u ps=0u b=0 m=1
R$50618 \$7150 IOVSS|anode|cathode|guard|iovss|minus VSS|anode|cathode|vss rppd
+ w=0.5u l=3.54u ps=0u b=0 m=1
R$50619 \$7151 IOVSS|anode|cathode|guard|iovss|minus VSS|anode|cathode|vss rppd
+ w=0.5u l=3.54u ps=0u b=0 m=1
R$50620 \$7152 IOVSS|anode|cathode|guard|iovss|minus VSS|anode|cathode|vss rppd
+ w=0.5u l=3.54u ps=0u b=0 m=1
C$50621 \$749 \$745 cap_cmim w=5.71u l=5.71u A=32.6041p P=22.84u m=40
C$50633 \$750 \$746 cap_cmim w=5.71u l=5.71u A=32.6041p P=22.84u m=40
C$50646 \$764 \$758 cap_cmim w=5.71u l=5.71u A=32.6041p P=22.84u m=64
C$50659 \$765 \$759 cap_cmim w=5.71u l=5.71u A=32.6041p P=22.84u m=64
C$50681 \$770 \$764 cap_cmim w=1.49u l=1.49u A=2.2201p P=5.96u m=1
C$50682 \$741 \$765 cap_cmim w=1.49u l=1.49u A=2.2201p P=5.96u m=1
C$50699 \$764 \$784 cap_cmim w=5.71u l=5.71u A=32.6041p P=22.84u m=32
C$50707 \$765 \$785 cap_cmim w=5.71u l=5.71u A=32.6041p P=22.84u m=32
C$50726 \$764 \$788 cap_cmim w=5.71u l=5.71u A=32.6041p P=22.84u m=16
C$50730 \$764 VDD|in|pad|pin1|pin2|supply|vdd cap_cmim w=5.71u l=5.71u
+ A=32.6041p P=22.84u m=1
C$50731 \$765 VDD|in|pad|pin1|pin2|supply|vdd cap_cmim w=5.71u l=5.71u
+ A=32.6041p P=22.84u m=1
C$50732 \$765 \$789 cap_cmim w=5.71u l=5.71u A=32.6041p P=22.84u m=16
C$50751 \$764 \$812 cap_cmim w=5.71u l=5.71u A=32.6041p P=22.84u m=8
C$50754 \$764 \$813 cap_cmim w=5.71u l=5.71u A=32.6041p P=22.84u m=1
C$50755 \$765 \$820 cap_cmim w=5.71u l=5.71u A=32.6041p P=22.84u m=1
C$50757 \$765 \$814 cap_cmim w=5.71u l=5.71u A=32.6041p P=22.84u m=8
C$50776 \$764 \$822 cap_cmim w=5.71u l=5.71u A=32.6041p P=22.84u m=4
C$50777 \$764 \$825 cap_cmim w=5.71u l=5.71u A=32.6041p P=22.84u m=2
C$50779 \$765 \$823 cap_cmim w=5.71u l=5.71u A=32.6041p P=22.84u m=2
C$50781 \$765 \$824 cap_cmim w=5.71u l=5.71u A=32.6041p P=22.84u m=4
C$50959 \$1968 \$1870 cap_cmim w=9.39u l=6.99u A=65.6361p P=32.76u m=1
C$50960 \$2012 \$1838 cap_cmim w=4.665u l=6.99u A=32.60835p P=23.31u m=1
C$50961 \$2013 \$1839 cap_cmim w=4.665u l=6.99u A=32.60835p P=23.31u m=1
C$50962 \$2035 VSS|anode|cathode|vss cap_cmim w=3.59u l=3.59u A=12.8881p
+ P=14.36u m=1
C$50963 \$2014 \$1840 cap_cmim w=4.665u l=6.99u A=32.60835p P=23.31u m=1
C$50964 \$2015 \$1873 cap_cmim w=4.665u l=6.99u A=32.60835p P=23.31u m=1
C$50965 \$1969 \$1874 cap_cmim w=9.39u l=6.99u A=65.6361p P=32.76u m=1
C$50966 Vboot|vboot Vsource cap_cmim w=42u l=100u A=4200p P=284u m=56
C$51022 B|IN|Y VSS|anode|cathode|vss cap_cmim w=40u l=80u A=3200p P=240u m=3
R$51025 VDD|in|pad|pin1|pin2|supply|vdd \$1288 ntap1 A=15.376p P=99.2u
R$51026 IOVSS|anode|cathode|guard|iovss|minus VSS|anode|cathode|vss ptap1
+ A=363266.84045p P=100905.578u
R$51164 VSS|anode|cathode|vss VSS|anode|cathode|vss ptap1 A=1679.3736p
+ P=11290.816u
.ENDS MSPHY6034
