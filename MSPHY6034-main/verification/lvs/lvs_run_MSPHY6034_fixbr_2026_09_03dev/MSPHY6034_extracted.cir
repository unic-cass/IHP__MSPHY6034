* Extracted by KLayout with SG13G2 LVS runset on : 26/09/2026 14:16

.SUBCKT MSPHY6034 VSS IOVDD IOVSS analog_io[19] analog_io[18] analog_io[17]
+ uo_PAD[3] uo_PAD[2] uo_PAD[1] uo_PAD[0] ui_PAD[6] ui_PAD[5] VDD an19 an18
+ an17 uo0 ui6 ui5 uo1 uo2 uo3 ui4 ui3 ui2 dout[0] c1 c2 c4 c10 en c3 c5 c6
+ uo_PAD[4] c7 c8 c9 ui_PAD[4] uo_PAD[5] ui_PAD[3] uo8 uo7 uo6 uo5 uo4 an16
+ an15 uo_PAD[6] ui_PAD[2] an14 uo_PAD[7] analog_io[16] uo_PAD[8] analog_io[15]
+ analog_io[0] analog_io[14] analog_io[1] ui1 ui_PAD[1] an8 an9 analog_io[2]
+ an12 an13 analog_io[13] an10 ui0 analog_io[3] analog_io[12] an11 analog_io[4]
+ analog_io[5] analog_io[6] analog_io[7] analog_io[8] analog_io[9] ui_PAD[0]
+ analog_io[10] analog_io[11]
X$1 VSS IOVDD IOVSS analog_io[19] analog_io[18] analog_io[17] uo_PAD[3]
+ uo_PAD[2] uo_PAD[1] uo_PAD[0] ui_PAD[6] ui_PAD[5] VDD VSS ui5 ui6 uo0 uo1 uo2
+ uo3 an17 an18 an19 uo_PAD[4] ui_PAD[4] ui4 uo4 uo_PAD[5] ui_PAD[3] uo5 ui3
+ uo_PAD[6] ui_PAD[2] ui2 uo6 uo_PAD[7] analog_io[16] uo7 an16 uo_PAD[8]
+ analog_io[15] uo8 analog_io[0] analog_io[14] an14 an15 analog_io[1] ui_PAD[1]
+ ui1 analog_io[2] analog_io[13] an13 analog_io[3] analog_io[12] an12 an11 an8
+ an10 ui0 an9 analog_io[4] analog_io[5] analog_io[6] analog_io[7] analog_io[8]
+ analog_io[9] ui_PAD[0] analog_io[10] analog_io[11] user_project_wrapper
X$2 VDD VSS an14 c10 ui6 c8 c9 an16 an15 c4 c3 c5 c6 c7 c2 c1 CS_DAC_10b
X$4 VSS VDD an18 an19 an17 en ui5 ui6 uo0 uo8 uo7 uo6 uo5 uo4 uo3 uo2 uo1
+ SAR_ADC
X$5 \$83 an8 an9 VSS ui1 an12 an13 VDD ui0 an11 an10 Full_Layout
X$6 ui6 ui5 VSS VDD ui4 ui3 ui2 c4 c5 c7 dout[0] en c1 c2 c3 c6 c8 c9 c10
+ serial2parallel
.ENDS MSPHY6034

.SUBCKT serial2parallel clk reset VSS VDD done_in shift_in data_in dout[5]
+ dout[6] dout[8] dout[0] dout[1] dout[2] dout[3] dout[4] dout[7] dout[9]
+ dout[10] dout[11]
M$1 VSS reset \$5 VSS sg13_lv_nmos L=0.13u W=0.55u AS=0.14875p AD=0.187p
+ PS=1.16u PD=1.78u rfmode=0
M$2 VSS \$5 \$6 VSS sg13_lv_nmos L=0.13u W=0.74u AS=0.14875p AD=0.2886p
+ PS=1.16u PD=2.26u rfmode=0
M$3 VSS VDD VSS VSS sg13_lv_nmos L=1u W=5614.56u AS=1488.8664p AD=1488.8664p
+ PS=15518.4u PD=15518.4u rfmode=0
M$1884 VSS done_in \$14 VSS sg13_lv_nmos L=0.13u W=0.55u AS=0.14875p AD=0.187p
+ PS=1.16u PD=1.78u rfmode=0
M$1885 \$13 \$14 VSS VSS sg13_lv_nmos L=0.13u W=0.74u AS=0.2886p AD=0.14875p
+ PS=2.26u PD=1.16u rfmode=0
M$7224 \$32 \$33 VSS VSS sg13_lv_nmos L=0.13u W=0.74u AS=0.2886p AD=0.14875p
+ PS=2.26u PD=1.16u rfmode=0
M$7225 VSS shift_in \$33 VSS sg13_lv_nmos L=0.13u W=0.55u AS=0.14875p AD=0.187p
+ PS=1.16u PD=1.78u rfmode=0
M$12342 VSS \$58 \$52 VSS sg13_lv_nmos L=0.13u W=0.74u AS=0.2516p AD=0.2516p
+ PS=2.16u PD=2.16u rfmode=0
M$12372 VSS \$322 \$53 VSS sg13_lv_nmos L=0.13u W=0.55u AS=0.14875p AD=0.187p
+ PS=1.16u PD=1.78u rfmode=0
M$12373 \$58 \$53 VSS VSS sg13_lv_nmos L=0.13u W=0.74u AS=0.2886p AD=0.14875p
+ PS=2.26u PD=1.16u rfmode=0
M$12392 VSS \$322 \$54 VSS sg13_lv_nmos L=0.13u W=0.74u AS=0.2516p AD=0.2516p
+ PS=2.16u PD=2.16u rfmode=0
M$12501 VSS \$32 \$55 VSS sg13_lv_nmos L=0.13u W=0.55u AS=0.17255p AD=0.187p
+ PS=1.25u PD=1.78u rfmode=0
M$12502 VSS \$71 \$764 VSS sg13_lv_nmos L=0.13u W=0.74u AS=0.2516p AD=0.1406p
+ PS=2.16u PD=1.12u rfmode=0
M$12503 \$764 \$55 VSS VSS sg13_lv_nmos L=0.13u W=0.74u AS=0.1406p AD=0.17255p
+ PS=1.12u PD=1.25u rfmode=0
M$12504 VSS \$13 \$56 VSS sg13_lv_nmos L=0.13u W=0.55u AS=0.14875p AD=0.187p
+ PS=1.16u PD=1.78u rfmode=0
M$12505 \$71 \$56 VSS VSS sg13_lv_nmos L=0.13u W=0.74u AS=0.2886p AD=0.14875p
+ PS=2.26u PD=1.16u rfmode=0
M$12649 \$66 \$58 VSS VSS sg13_lv_nmos L=0.13u W=0.74u AS=0.2516p AD=0.2516p
+ PS=2.16u PD=2.16u rfmode=0
M$12651 \$67 \$68 VSS VSS sg13_lv_nmos L=0.13u W=0.74u AS=0.4033p AD=0.148p
+ PS=2.57u PD=1.14u rfmode=0
M$12652 VSS \$72 \$132 VSS sg13_lv_nmos L=0.13u W=0.74u AS=0.148p AD=0.3367p
+ PS=1.14u PD=1.65u rfmode=0
M$12653 \$132 \$70 \$68 VSS sg13_lv_nmos L=0.13u W=0.74u AS=0.3367p AD=0.1628p
+ PS=1.65u PD=1.18u rfmode=0
M$12654 \$68 \$69 \$133 VSS sg13_lv_nmos L=0.13u W=0.74u AS=0.1628p AD=0.13135p
+ PS=1.18u PD=1.095u rfmode=0
M$12655 \$133 \$71 VSS VSS sg13_lv_nmos L=0.13u W=0.74u AS=0.13135p AD=0.18945p
+ PS=1.095u PD=1.27u rfmode=0
M$12656 VSS \$71 \$72 VSS sg13_lv_nmos L=0.13u W=0.55u AS=0.18945p AD=0.187p
+ PS=1.27u PD=1.78u rfmode=0
M$12657 VSS \$74 \$73 VSS sg13_lv_nmos L=0.13u W=0.55u AS=0.18945p AD=0.187p
+ PS=1.27u PD=1.78u rfmode=0
M$12658 VSS \$74 \$134 VSS sg13_lv_nmos L=0.13u W=0.74u AS=0.18945p AD=0.13135p
+ PS=1.27u PD=1.095u rfmode=0
M$12659 \$134 \$69 \$75 VSS sg13_lv_nmos L=0.13u W=0.74u AS=0.13135p AD=0.1628p
+ PS=1.095u PD=1.18u rfmode=0
M$12660 \$75 \$76 \$135 VSS sg13_lv_nmos L=0.13u W=0.74u AS=0.1628p AD=0.3367p
+ PS=1.18u PD=1.65u rfmode=0
M$12661 \$135 \$73 VSS VSS sg13_lv_nmos L=0.13u W=0.74u AS=0.3367p AD=0.148p
+ PS=1.65u PD=1.14u rfmode=0
M$12662 VSS \$75 \$77 VSS sg13_lv_nmos L=0.13u W=0.74u AS=0.148p AD=0.4033p
+ PS=1.14u PD=2.57u rfmode=0
M$12663 \$81 \$77 \$136 VSS sg13_lv_nmos L=0.13u W=0.42u AS=0.1428p AD=0.0609p
+ PS=1.52u PD=0.71u rfmode=0
M$12664 \$136 \$52 VSS VSS sg13_lv_nmos L=0.13u W=0.42u AS=0.0609p AD=0.1626p
+ PS=0.71u PD=1.415u rfmode=0
M$12665 VSS \$78 \$79 VSS sg13_lv_nmos L=0.13u W=0.74u AS=0.1626p AD=0.2516p
+ PS=1.415u PD=2.16u rfmode=0
M$12666 VSS \$52 \$137 VSS sg13_lv_nmos L=0.13u W=0.42u AS=0.1701p AD=0.0378p
+ PS=1.65u PD=0.6u rfmode=0
M$12667 \$137 \$79 \$80 VSS sg13_lv_nmos L=0.13u W=0.42u AS=0.0378p AD=0.1428p
+ PS=0.6u PD=1.52u rfmode=0
M$12668 \$85 \$82 \$84 VSS sg13_lv_nmos L=0.13u W=0.42u AS=0.12665p AD=0.1428p
+ PS=1.145u PD=1.52u rfmode=0
M$12669 \$79 \$83 \$85 VSS sg13_lv_nmos L=0.13u W=0.74u AS=0.3473p AD=0.12665p
+ PS=2.71u PD=1.145u rfmode=0
M$12670 \$84 \$86 VSS VSS sg13_lv_nmos L=0.13u W=0.42u AS=0.1428p AD=0.0798p
+ PS=1.52u PD=0.8u rfmode=0
M$12671 VSS \$52 \$138 VSS sg13_lv_nmos L=0.13u W=0.42u AS=0.0798p AD=0.0378p
+ PS=0.8u PD=0.6u rfmode=0
M$12672 \$138 \$85 \$86 VSS sg13_lv_nmos L=0.13u W=0.42u AS=0.0378p AD=0.1428p
+ PS=0.6u PD=1.52u rfmode=0
M$12673 \$87 \$85 VSS VSS sg13_lv_nmos L=0.13u W=0.74u AS=0.2516p AD=0.1406p
+ PS=2.16u PD=1.12u rfmode=0
M$12674 VSS \$87 \$88 VSS sg13_lv_nmos L=0.13u W=0.74u AS=0.1406p AD=0.2516p
+ PS=1.12u PD=2.16u rfmode=0
M$12675 VSS \$58 \$89 VSS sg13_lv_nmos L=0.13u W=0.74u AS=0.2516p AD=0.2516p
+ PS=2.16u PD=2.16u rfmode=0
M$12680 VSS \$74 \$90 VSS sg13_lv_nmos L=0.13u W=0.55u AS=0.18945p AD=0.187p
+ PS=1.27u PD=1.78u rfmode=0
M$12681 VSS \$74 \$139 VSS sg13_lv_nmos L=0.13u W=0.74u AS=0.18945p AD=0.13135p
+ PS=1.27u PD=1.095u rfmode=0
M$12682 \$139 \$361 \$91 VSS sg13_lv_nmos L=0.13u W=0.74u AS=0.13135p
+ AD=0.1628p PS=1.095u PD=1.18u rfmode=0
M$12683 \$91 \$369 \$140 VSS sg13_lv_nmos L=0.13u W=0.74u AS=0.1628p AD=0.3367p
+ PS=1.18u PD=1.65u rfmode=0
M$12684 \$140 \$90 VSS VSS sg13_lv_nmos L=0.13u W=0.74u AS=0.3367p AD=0.148p
+ PS=1.65u PD=1.14u rfmode=0
M$12685 VSS \$91 \$92 VSS sg13_lv_nmos L=0.13u W=0.74u AS=0.148p AD=0.4033p
+ PS=1.14u PD=2.57u rfmode=0
M$12698 \$69 \$94 VSS VSS sg13_lv_nmos L=0.13u W=0.74u AS=0.2516p AD=0.1426p
+ PS=2.16u PD=1.16u rfmode=0
M$12699 VSS \$95 \$94 VSS sg13_lv_nmos L=0.5u W=0.42u AS=0.1426p AD=0.1428p
+ PS=1.16u PD=1.52u rfmode=0
M$12700 \$95 \$96 VSS VSS sg13_lv_nmos L=0.5u W=0.42u AS=0.1428p AD=0.0798p
+ PS=1.52u PD=0.8u rfmode=0
M$12701 VSS \$97 \$96 VSS sg13_lv_nmos L=0.13u W=0.42u AS=0.0798p AD=0.1428p
+ PS=0.8u PD=1.52u rfmode=0
M$12702 \$98 \$93 VSS VSS sg13_lv_nmos L=0.13u W=0.42u AS=0.1428p AD=0.0798p
+ PS=1.52u PD=0.8u rfmode=0
M$12703 VSS \$98 \$99 VSS sg13_lv_nmos L=0.5u W=0.42u AS=0.0798p AD=0.1428p
+ PS=0.8u PD=1.52u rfmode=0
M$12704 VSS \$99 \$100 VSS sg13_lv_nmos L=0.5u W=0.42u AS=0.1426p AD=0.1428p
+ PS=1.16u PD=1.52u rfmode=0
M$12705 VSS \$100 \$101 VSS sg13_lv_nmos L=0.13u W=0.74u AS=0.1426p AD=0.2516p
+ PS=1.16u PD=2.16u rfmode=0
M$12710 \$102 \$299 VSS VSS sg13_lv_nmos L=0.13u W=0.42u AS=0.1428p AD=0.0798p
+ PS=1.52u PD=0.8u rfmode=0
M$12711 VSS \$102 \$103 VSS sg13_lv_nmos L=0.5u W=0.42u AS=0.0798p AD=0.1428p
+ PS=0.8u PD=1.52u rfmode=0
M$12712 VSS \$103 \$104 VSS sg13_lv_nmos L=0.5u W=0.42u AS=0.1426p AD=0.1428p
+ PS=1.16u PD=1.52u rfmode=0
M$12713 VSS \$104 \$105 VSS sg13_lv_nmos L=0.13u W=0.74u AS=0.1426p AD=0.2516p
+ PS=1.16u PD=2.16u rfmode=0
M$12721 VSS \$74 \$106 VSS sg13_lv_nmos L=0.13u W=0.55u AS=0.18945p AD=0.187p
+ PS=1.27u PD=1.78u rfmode=0
M$12722 VSS \$74 \$141 VSS sg13_lv_nmos L=0.13u W=0.74u AS=0.18945p AD=0.13135p
+ PS=1.27u PD=1.095u rfmode=0
M$12723 \$141 \$108 \$107 VSS sg13_lv_nmos L=0.13u W=0.74u AS=0.13135p
+ AD=0.1628p PS=1.095u PD=1.18u rfmode=0
M$12724 \$107 \$69 \$142 VSS sg13_lv_nmos L=0.13u W=0.74u AS=0.1628p AD=0.3367p
+ PS=1.18u PD=1.65u rfmode=0
M$12725 \$142 \$106 VSS VSS sg13_lv_nmos L=0.13u W=0.74u AS=0.3367p AD=0.148p
+ PS=1.65u PD=1.14u rfmode=0
M$12726 VSS \$107 \$109 VSS sg13_lv_nmos L=0.13u W=0.74u AS=0.148p AD=0.4033p
+ PS=1.14u PD=2.57u rfmode=0
M$12727 \$113 \$109 \$143 VSS sg13_lv_nmos L=0.13u W=0.42u AS=0.1428p
+ AD=0.0609p PS=1.52u PD=0.71u rfmode=0
M$12728 \$143 \$54 VSS VSS sg13_lv_nmos L=0.13u W=0.42u AS=0.0609p AD=0.1626p
+ PS=0.71u PD=1.415u rfmode=0
M$12729 VSS \$110 \$111 VSS sg13_lv_nmos L=0.13u W=0.74u AS=0.1626p AD=0.2516p
+ PS=1.415u PD=2.16u rfmode=0
M$12730 VSS \$54 \$144 VSS sg13_lv_nmos L=0.13u W=0.42u AS=0.1701p AD=0.0378p
+ PS=1.65u PD=0.6u rfmode=0
M$12731 \$144 \$111 \$112 VSS sg13_lv_nmos L=0.13u W=0.42u AS=0.0378p
+ AD=0.1428p PS=0.6u PD=1.52u rfmode=0
M$12732 \$117 \$114 \$116 VSS sg13_lv_nmos L=0.13u W=0.42u AS=0.12665p
+ AD=0.1428p PS=1.145u PD=1.52u rfmode=0
M$12733 \$111 \$115 \$117 VSS sg13_lv_nmos L=0.13u W=0.74u AS=0.3473p
+ AD=0.12665p PS=2.71u PD=1.145u rfmode=0
M$12734 \$116 \$118 VSS VSS sg13_lv_nmos L=0.13u W=0.42u AS=0.1428p AD=0.0798p
+ PS=1.52u PD=0.8u rfmode=0
M$12735 VSS \$54 \$145 VSS sg13_lv_nmos L=0.13u W=0.42u AS=0.0798p AD=0.0378p
+ PS=0.8u PD=0.6u rfmode=0
M$12736 \$145 \$117 \$118 VSS sg13_lv_nmos L=0.13u W=0.42u AS=0.0378p
+ AD=0.1428p PS=0.6u PD=1.52u rfmode=0
M$12737 \$119 \$117 VSS VSS sg13_lv_nmos L=0.13u W=0.74u AS=0.2516p AD=0.1406p
+ PS=2.16u PD=1.12u rfmode=0
M$12738 VSS \$119 \$97 VSS sg13_lv_nmos L=0.13u W=0.74u AS=0.1406p AD=0.2516p
+ PS=1.12u PD=2.16u rfmode=0
M$12765 \$121 \$122 VSS VSS sg13_lv_nmos L=0.13u W=0.74u AS=0.2516p AD=0.2516p
+ PS=2.16u PD=2.16u rfmode=0
M$12829 VSS \$120 \$123 VSS sg13_lv_nmos L=0.13u W=0.74u AS=0.2516p AD=0.2516p
+ PS=2.16u PD=2.16u rfmode=0
M$12830 VSS \$6 \$124 VSS sg13_lv_nmos L=0.13u W=0.55u AS=0.14875p AD=0.187p
+ PS=1.16u PD=1.78u rfmode=0
M$12831 VSS \$124 \$120 VSS sg13_lv_nmos L=0.13u W=0.74u AS=0.14875p AD=0.2886p
+ PS=1.16u PD=2.26u rfmode=0
M$12841 VSS \$120 \$125 VSS sg13_lv_nmos L=0.13u W=0.74u AS=0.2516p AD=0.2516p
+ PS=2.16u PD=2.16u rfmode=0
M$12848 \$126 \$127 VSS VSS sg13_lv_nmos L=0.13u W=0.74u AS=0.2516p AD=0.1426p
+ PS=2.16u PD=1.16u rfmode=0
M$12849 VSS \$128 \$127 VSS sg13_lv_nmos L=0.5u W=0.42u AS=0.1426p AD=0.1428p
+ PS=1.16u PD=1.52u rfmode=0
M$12850 \$128 \$129 VSS VSS sg13_lv_nmos L=0.5u W=0.42u AS=0.1428p AD=0.0798p
+ PS=1.52u PD=0.8u rfmode=0
M$12851 VSS \$130 \$129 VSS sg13_lv_nmos L=0.13u W=0.42u AS=0.0798p AD=0.1428p
+ PS=0.8u PD=1.52u rfmode=0
M$12904 \$108 \$131 VSS VSS sg13_lv_nmos L=0.13u W=0.74u AS=0.2886p AD=0.14875p
+ PS=2.26u PD=1.16u rfmode=0
M$12905 VSS data_in \$131 VSS sg13_lv_nmos L=0.13u W=0.55u AS=0.14875p
+ AD=0.187p PS=1.16u PD=1.78u rfmode=0
M$12988 \$166 \$170 \$167 VSS sg13_lv_nmos L=0.13u W=0.42u AS=0.1296p
+ AD=0.0798p PS=1.52u PD=0.8u rfmode=0
M$12989 \$167 \$169 \$292 VSS sg13_lv_nmos L=0.13u W=0.42u AS=0.0798p
+ AD=0.2373p PS=0.8u PD=1.97u rfmode=0
M$12990 \$169 \$170 VSS VSS sg13_lv_nmos L=0.13u W=0.74u AS=0.2516p
+ AD=0.317325p PS=2.16u PD=1.805u rfmode=0
M$12991 VSS \$204 \$170 VSS sg13_lv_nmos L=0.13u W=0.74u AS=0.317325p
+ AD=0.2516p PS=1.805u PD=2.16u rfmode=0
M$12992 \$293 \$170 \$171 VSS sg13_lv_nmos L=0.13u W=0.42u AS=0.1428p
+ AD=0.12665p PS=1.52u PD=1.145u rfmode=0
M$12993 \$171 \$169 \$168 VSS sg13_lv_nmos L=0.13u W=0.74u AS=0.12665p
+ AD=0.3473p PS=1.145u PD=2.71u rfmode=0
M$12994 \$173 \$171 VSS VSS sg13_lv_nmos L=0.13u W=0.74u AS=0.2516p AD=0.1406p
+ PS=2.16u PD=1.12u rfmode=0
M$12995 VSS \$173 \$165 VSS sg13_lv_nmos L=0.13u W=0.74u AS=0.1406p AD=0.2516p
+ PS=1.12u PD=2.16u rfmode=0
M$12996 VSS \$175 \$174 VSS sg13_lv_nmos L=0.5u W=0.42u AS=0.1426p AD=0.1428p
+ PS=1.16u PD=1.52u rfmode=0
M$12997 \$70 \$174 VSS VSS sg13_lv_nmos L=0.13u W=0.74u AS=0.2516p AD=0.1426p
+ PS=2.16u PD=1.16u rfmode=0
M$12998 VSS \$178 \$177 VSS sg13_lv_nmos L=0.5u W=0.42u AS=0.1426p AD=0.1428p
+ PS=1.16u PD=1.52u rfmode=0
M$12999 \$76 \$177 VSS VSS sg13_lv_nmos L=0.13u W=0.74u AS=0.2516p AD=0.1426p
+ PS=2.16u PD=1.16u rfmode=0
M$13000 \$81 \$82 \$78 VSS sg13_lv_nmos L=0.13u W=0.42u AS=0.1296p AD=0.0798p
+ PS=1.52u PD=0.8u rfmode=0
M$13001 \$78 \$83 \$80 VSS sg13_lv_nmos L=0.13u W=0.42u AS=0.0798p AD=0.2373p
+ PS=0.8u PD=1.97u rfmode=0
M$13002 VSS \$82 \$83 VSS sg13_lv_nmos L=0.13u W=0.74u AS=0.317325p AD=0.2516p
+ PS=1.805u PD=2.16u rfmode=0
M$13003 VSS \$204 \$82 VSS sg13_lv_nmos L=0.13u W=0.74u AS=0.317325p AD=0.2516p
+ PS=1.805u PD=2.16u rfmode=0
M$13004 \$180 \$74 VSS VSS sg13_lv_nmos L=0.13u W=0.55u AS=0.187p AD=0.18945p
+ PS=1.78u PD=1.27u rfmode=0
M$13005 VSS \$74 \$341 VSS sg13_lv_nmos L=0.13u W=0.74u AS=0.18945p AD=0.13135p
+ PS=1.27u PD=1.095u rfmode=0
M$13006 \$341 \$76 \$181 VSS sg13_lv_nmos L=0.13u W=0.74u AS=0.13135p
+ AD=0.1628p PS=1.095u PD=1.18u rfmode=0
M$13007 \$181 \$361 \$342 VSS sg13_lv_nmos L=0.13u W=0.74u AS=0.1628p
+ AD=0.3367p PS=1.18u PD=1.65u rfmode=0
M$13008 \$342 \$180 VSS VSS sg13_lv_nmos L=0.13u W=0.74u AS=0.3367p AD=0.148p
+ PS=1.65u PD=1.14u rfmode=0
M$13009 VSS \$181 \$182 VSS sg13_lv_nmos L=0.13u W=0.74u AS=0.148p AD=0.4033p
+ PS=1.14u PD=2.57u rfmode=0
M$13010 \$183 \$187 \$184 VSS sg13_lv_nmos L=0.13u W=0.42u AS=0.1296p
+ AD=0.0798p PS=1.52u PD=0.8u rfmode=0
M$13011 \$184 \$186 \$294 VSS sg13_lv_nmos L=0.13u W=0.42u AS=0.0798p
+ AD=0.2373p PS=0.8u PD=1.97u rfmode=0
M$13012 \$186 \$187 VSS VSS sg13_lv_nmos L=0.13u W=0.74u AS=0.2516p
+ AD=0.317325p PS=2.16u PD=1.805u rfmode=0
M$13013 VSS \$204 \$187 VSS sg13_lv_nmos L=0.13u W=0.74u AS=0.317325p
+ AD=0.2516p PS=1.805u PD=2.16u rfmode=0
M$13014 \$295 \$187 \$188 VSS sg13_lv_nmos L=0.13u W=0.42u AS=0.1428p
+ AD=0.12665p PS=1.52u PD=1.145u rfmode=0
M$13015 \$188 \$186 \$185 VSS sg13_lv_nmos L=0.13u W=0.74u AS=0.12665p
+ AD=0.3473p PS=1.145u PD=2.71u rfmode=0
M$13016 \$190 \$188 VSS VSS sg13_lv_nmos L=0.13u W=0.74u AS=0.2516p AD=0.1406p
+ PS=2.16u PD=1.12u rfmode=0
M$13017 VSS \$190 \$191 VSS sg13_lv_nmos L=0.13u W=0.74u AS=0.1406p AD=0.2516p
+ PS=1.12u PD=2.16u rfmode=0
M$13018 VSS \$58 \$192 VSS sg13_lv_nmos L=0.13u W=0.74u AS=0.2516p AD=0.2516p
+ PS=2.16u PD=2.16u rfmode=0
M$13019 VSS \$58 \$193 VSS sg13_lv_nmos L=0.13u W=0.74u AS=0.2516p AD=0.2516p
+ PS=2.16u PD=2.16u rfmode=0
M$13020 \$194 \$198 \$195 VSS sg13_lv_nmos L=0.13u W=0.42u AS=0.1296p
+ AD=0.0798p PS=1.52u PD=0.8u rfmode=0
M$13021 \$195 \$197 \$296 VSS sg13_lv_nmos L=0.13u W=0.42u AS=0.0798p
+ AD=0.2373p PS=0.8u PD=1.97u rfmode=0
M$13022 \$197 \$198 VSS VSS sg13_lv_nmos L=0.13u W=0.74u AS=0.2516p
+ AD=0.317325p PS=2.16u PD=1.805u rfmode=0
M$13023 VSS \$204 \$198 VSS sg13_lv_nmos L=0.13u W=0.74u AS=0.317325p
+ AD=0.2516p PS=1.805u PD=2.16u rfmode=0
M$13024 \$298 \$198 \$199 VSS sg13_lv_nmos L=0.13u W=0.42u AS=0.1428p
+ AD=0.12665p PS=1.52u PD=1.145u rfmode=0
M$13025 \$199 \$197 \$196 VSS sg13_lv_nmos L=0.13u W=0.74u AS=0.12665p
+ AD=0.3473p PS=1.145u PD=2.71u rfmode=0
M$13026 \$201 \$199 VSS VSS sg13_lv_nmos L=0.13u W=0.74u AS=0.2516p AD=0.1406p
+ PS=2.16u PD=1.12u rfmode=0
M$13027 VSS \$201 \$297 VSS sg13_lv_nmos L=0.13u W=0.74u AS=0.1406p AD=0.2516p
+ PS=1.12u PD=2.16u rfmode=0
M$13028 \$202 \$71 VSS VSS sg13_lv_nmos L=0.13u W=0.55u AS=0.187p AD=0.18945p
+ PS=1.78u PD=1.27u rfmode=0
M$13029 VSS \$71 \$346 VSS sg13_lv_nmos L=0.13u W=0.74u AS=0.18945p AD=0.13135p
+ PS=1.27u PD=1.095u rfmode=0
M$13030 \$346 \$299 \$203 VSS sg13_lv_nmos L=0.13u W=0.74u AS=0.13135p
+ AD=0.1628p PS=1.095u PD=1.18u rfmode=0
M$13031 \$203 \$300 \$345 VSS sg13_lv_nmos L=0.13u W=0.74u AS=0.1628p
+ AD=0.3367p PS=1.18u PD=1.65u rfmode=0
M$13032 \$345 \$202 VSS VSS sg13_lv_nmos L=0.13u W=0.74u AS=0.3367p AD=0.148p
+ PS=1.65u PD=1.14u rfmode=0
M$13033 VSS \$203 \$93 VSS sg13_lv_nmos L=0.13u W=0.74u AS=0.148p AD=0.4033p
+ PS=1.14u PD=2.57u rfmode=0
M$13034 VSS \$205 \$204 VSS sg13_lv_nmos L=0.13u W=11.84u AS=2.3606p AD=2.2496p
+ PS=18.96u PD=17.92u rfmode=0
M$13050 VSS \$226 \$205 VSS sg13_lv_nmos L=0.13u W=4.44u AS=0.8436p AD=0.9546p
+ PS=6.72u PD=7.76u rfmode=0
M$13056 \$206 \$74 VSS VSS sg13_lv_nmos L=0.13u W=0.55u AS=0.187p AD=0.18945p
+ PS=1.78u PD=1.27u rfmode=0
M$13057 VSS \$74 \$340 VSS sg13_lv_nmos L=0.13u W=0.74u AS=0.18945p AD=0.13135p
+ PS=1.27u PD=1.095u rfmode=0
M$13058 \$340 \$105 \$207 VSS sg13_lv_nmos L=0.13u W=0.74u AS=0.13135p
+ AD=0.1628p PS=1.095u PD=1.18u rfmode=0
M$13059 \$207 \$301 \$339 VSS sg13_lv_nmos L=0.13u W=0.74u AS=0.1628p
+ AD=0.3367p PS=1.18u PD=1.65u rfmode=0
M$13060 \$339 \$206 VSS VSS sg13_lv_nmos L=0.13u W=0.74u AS=0.3367p AD=0.148p
+ PS=1.65u PD=1.14u rfmode=0
M$13061 VSS \$207 \$208 VSS sg13_lv_nmos L=0.13u W=0.74u AS=0.148p AD=0.4033p
+ PS=1.14u PD=2.57u rfmode=0
M$13062 VSS \$211 \$210 VSS sg13_lv_nmos L=0.5u W=0.42u AS=0.1426p AD=0.1428p
+ PS=1.16u PD=1.52u rfmode=0
M$13063 \$209 \$210 VSS VSS sg13_lv_nmos L=0.13u W=0.74u AS=0.2516p AD=0.1426p
+ PS=2.16u PD=1.16u rfmode=0
M$13072 VSS \$214 \$215 VSS sg13_lv_nmos L=0.13u W=0.55u AS=0.14875p AD=0.187p
+ PS=1.16u PD=1.78u rfmode=0
M$13073 dout[5] \$215 VSS VSS sg13_lv_nmos L=0.13u W=0.74u AS=0.2886p
+ AD=0.14875p PS=2.26u PD=1.16u rfmode=0
M$13074 \$113 \$114 \$110 VSS sg13_lv_nmos L=0.13u W=0.42u AS=0.1296p
+ AD=0.0798p PS=1.52u PD=0.8u rfmode=0
M$13075 \$110 \$115 \$112 VSS sg13_lv_nmos L=0.13u W=0.42u AS=0.0798p
+ AD=0.2373p PS=0.8u PD=1.97u rfmode=0
M$13078 VSS \$114 \$115 VSS sg13_lv_nmos L=0.13u W=0.74u AS=0.317325p
+ AD=0.2516p PS=1.805u PD=2.16u rfmode=0
M$13079 VSS \$204 \$114 VSS sg13_lv_nmos L=0.13u W=0.74u AS=0.317325p
+ AD=0.2516p PS=1.805u PD=2.16u rfmode=0
M$13082 VSS \$322 \$216 VSS sg13_lv_nmos L=0.13u W=0.74u AS=0.2516p AD=0.2516p
+ PS=2.16u PD=2.16u rfmode=0
M$13083 VSS \$220 \$219 VSS sg13_lv_nmos L=0.5u W=0.42u AS=0.1426p AD=0.1428p
+ PS=1.16u PD=1.52u rfmode=0
M$13084 \$218 \$219 VSS VSS sg13_lv_nmos L=0.13u W=0.74u AS=0.2516p AD=0.1426p
+ PS=2.16u PD=1.16u rfmode=0
M$13101 VSS \$223 \$224 VSS sg13_lv_nmos L=0.13u W=0.55u AS=0.14875p AD=0.187p
+ PS=1.16u PD=1.78u rfmode=0
M$13102 dout[6] \$224 VSS VSS sg13_lv_nmos L=0.13u W=0.74u AS=0.2886p
+ AD=0.14875p PS=2.26u PD=1.16u rfmode=0
M$13105 VSS clk \$225 VSS sg13_lv_nmos L=0.13u W=4.44u AS=0.9546p AD=0.8436p
+ PS=7.76u PD=6.72u rfmode=0
M$13111 VSS \$225 \$226 VSS sg13_lv_nmos L=0.13u W=11.84u AS=2.2496p AD=2.3606p
+ PS=17.92u PD=18.96u rfmode=0
M$13135 VSS \$268 \$228 VSS sg13_lv_nmos L=0.13u W=0.55u AS=0.18945p AD=0.187p
+ PS=1.27u PD=1.78u rfmode=0
M$13136 \$227 \$302 VSS VSS sg13_lv_nmos L=0.13u W=0.74u AS=0.4033p AD=0.148p
+ PS=2.57u PD=1.14u rfmode=0
M$13137 VSS \$228 \$335 VSS sg13_lv_nmos L=0.13u W=0.74u AS=0.148p AD=0.3367p
+ PS=1.14u PD=1.65u rfmode=0
M$13138 \$335 \$229 \$302 VSS sg13_lv_nmos L=0.13u W=0.74u AS=0.3367p
+ AD=0.1628p PS=1.65u PD=1.18u rfmode=0
M$13139 \$302 \$303 \$334 VSS sg13_lv_nmos L=0.13u W=0.74u AS=0.1628p
+ AD=0.13135p PS=1.18u PD=1.095u rfmode=0
M$13140 \$334 \$268 VSS VSS sg13_lv_nmos L=0.13u W=0.74u AS=0.13135p
+ AD=0.18945p PS=1.095u PD=1.27u rfmode=0
M$13143 VSS \$231 \$230 VSS sg13_lv_nmos L=0.5u W=0.42u AS=0.1426p AD=0.1428p
+ PS=1.16u PD=1.52u rfmode=0
M$13144 \$229 \$230 VSS VSS sg13_lv_nmos L=0.13u W=0.74u AS=0.2516p AD=0.1426p
+ PS=2.16u PD=1.16u rfmode=0
M$13157 VSS \$122 \$233 VSS sg13_lv_nmos L=0.13u W=0.74u AS=0.2516p AD=0.2516p
+ PS=2.16u PD=2.16u rfmode=0
M$13174 VSS \$122 \$234 VSS sg13_lv_nmos L=0.13u W=0.74u AS=0.2516p AD=0.2516p
+ PS=2.16u PD=2.16u rfmode=0
M$13175 VSS \$237 \$236 VSS sg13_lv_nmos L=0.5u W=0.42u AS=0.1426p AD=0.1428p
+ PS=1.16u PD=1.52u rfmode=0
M$13176 \$235 \$236 VSS VSS sg13_lv_nmos L=0.13u W=0.74u AS=0.2516p AD=0.1426p
+ PS=2.16u PD=1.16u rfmode=0
M$13181 \$239 \$323 VSS VSS sg13_lv_nmos L=0.13u W=0.55u AS=0.187p AD=0.18945p
+ PS=1.78u PD=1.27u rfmode=0
M$13182 VSS \$323 \$333 VSS sg13_lv_nmos L=0.13u W=0.74u AS=0.18945p
+ AD=0.13135p PS=1.27u PD=1.095u rfmode=0
M$13183 \$333 \$305 \$240 VSS sg13_lv_nmos L=0.13u W=0.74u AS=0.13135p
+ AD=0.1628p PS=1.095u PD=1.18u rfmode=0
M$13184 \$240 \$241 \$332 VSS sg13_lv_nmos L=0.13u W=0.74u AS=0.1628p
+ AD=0.3367p PS=1.18u PD=1.65u rfmode=0
M$13185 \$332 \$239 VSS VSS sg13_lv_nmos L=0.13u W=0.74u AS=0.3367p AD=0.148p
+ PS=1.65u PD=1.14u rfmode=0
M$13186 VSS \$240 \$242 VSS sg13_lv_nmos L=0.13u W=0.74u AS=0.148p AD=0.4033p
+ PS=1.14u PD=2.57u rfmode=0
M$13187 \$243 \$247 \$244 VSS sg13_lv_nmos L=0.13u W=0.42u AS=0.1296p
+ AD=0.0798p PS=1.52u PD=0.8u rfmode=0
M$13188 \$244 \$246 \$306 VSS sg13_lv_nmos L=0.13u W=0.42u AS=0.0798p
+ AD=0.2373p PS=0.8u PD=1.97u rfmode=0
M$13189 \$246 \$247 VSS VSS sg13_lv_nmos L=0.13u W=0.74u AS=0.2516p
+ AD=0.317325p PS=2.16u PD=1.805u rfmode=0
M$13190 VSS \$763 \$247 VSS sg13_lv_nmos L=0.13u W=0.74u AS=0.317325p
+ AD=0.2516p PS=1.805u PD=2.16u rfmode=0
M$13191 \$307 \$247 \$248 VSS sg13_lv_nmos L=0.13u W=0.42u AS=0.1428p
+ AD=0.12665p PS=1.52u PD=1.145u rfmode=0
M$13192 \$248 \$246 \$245 VSS sg13_lv_nmos L=0.13u W=0.74u AS=0.12665p
+ AD=0.3473p PS=1.145u PD=2.71u rfmode=0
M$13193 \$250 \$248 VSS VSS sg13_lv_nmos L=0.13u W=0.74u AS=0.2516p AD=0.1406p
+ PS=2.16u PD=1.12u rfmode=0
M$13194 VSS \$250 \$251 VSS sg13_lv_nmos L=0.13u W=0.74u AS=0.1406p AD=0.2516p
+ PS=1.12u PD=2.16u rfmode=0
M$13195 \$252 \$74 VSS VSS sg13_lv_nmos L=0.13u W=0.55u AS=0.187p AD=0.18945p
+ PS=1.78u PD=1.27u rfmode=0
M$13196 VSS \$74 \$328 VSS sg13_lv_nmos L=0.13u W=0.74u AS=0.18945p AD=0.13135p
+ PS=1.27u PD=1.095u rfmode=0
M$13197 \$328 \$241 \$253 VSS sg13_lv_nmos L=0.13u W=0.74u AS=0.13135p
+ AD=0.1628p PS=1.095u PD=1.18u rfmode=0
M$13198 \$253 \$254 \$327 VSS sg13_lv_nmos L=0.13u W=0.74u AS=0.1628p
+ AD=0.3367p PS=1.18u PD=1.65u rfmode=0
M$13199 \$327 \$252 VSS VSS sg13_lv_nmos L=0.13u W=0.74u AS=0.3367p AD=0.148p
+ PS=1.65u PD=1.14u rfmode=0
M$13200 VSS \$253 \$255 VSS sg13_lv_nmos L=0.13u W=0.74u AS=0.148p AD=0.4033p
+ PS=1.14u PD=2.57u rfmode=0
M$13201 \$256 \$260 \$257 VSS sg13_lv_nmos L=0.13u W=0.42u AS=0.1296p
+ AD=0.0798p PS=1.52u PD=0.8u rfmode=0
M$13202 \$257 \$259 \$308 VSS sg13_lv_nmos L=0.13u W=0.42u AS=0.0798p
+ AD=0.2373p PS=0.8u PD=1.97u rfmode=0
M$13203 \$259 \$260 VSS VSS sg13_lv_nmos L=0.13u W=0.74u AS=0.2516p
+ AD=0.317325p PS=2.16u PD=1.805u rfmode=0
M$13204 VSS \$763 \$260 VSS sg13_lv_nmos L=0.13u W=0.74u AS=0.317325p
+ AD=0.2516p PS=1.805u PD=2.16u rfmode=0
M$13205 \$309 \$260 \$261 VSS sg13_lv_nmos L=0.13u W=0.42u AS=0.1428p
+ AD=0.12665p PS=1.52u PD=1.145u rfmode=0
M$13206 \$261 \$259 \$258 VSS sg13_lv_nmos L=0.13u W=0.74u AS=0.12665p
+ AD=0.3473p PS=1.145u PD=2.71u rfmode=0
M$13207 \$263 \$261 VSS VSS sg13_lv_nmos L=0.13u W=0.74u AS=0.2516p AD=0.1406p
+ PS=2.16u PD=1.12u rfmode=0
M$13208 VSS \$263 \$264 VSS sg13_lv_nmos L=0.13u W=0.74u AS=0.1406p AD=0.2516p
+ PS=1.12u PD=2.16u rfmode=0
M$13209 VSS \$266 \$265 VSS sg13_lv_nmos L=0.5u W=0.42u AS=0.1426p AD=0.1428p
+ PS=1.16u PD=1.52u rfmode=0
M$13210 \$254 \$265 VSS VSS sg13_lv_nmos L=0.13u W=0.74u AS=0.2516p AD=0.1426p
+ PS=2.16u PD=1.16u rfmode=0
M$13211 VSS \$13 \$269 VSS sg13_lv_nmos L=0.13u W=0.55u AS=0.14875p AD=0.187p
+ PS=1.16u PD=1.78u rfmode=0
M$13212 \$268 \$269 VSS VSS sg13_lv_nmos L=0.13u W=0.74u AS=0.2886p AD=0.14875p
+ PS=2.26u PD=1.16u rfmode=0
M$13349 VSS \$167 \$168 VSS sg13_lv_nmos L=0.13u W=0.74u AS=0.1626p AD=0.2516p
+ PS=1.415u PD=2.16u rfmode=0
M$13350 \$166 \$67 \$336 VSS sg13_lv_nmos L=0.13u W=0.42u AS=0.1428p AD=0.0609p
+ PS=1.52u PD=0.71u rfmode=0
M$13351 VSS \$66 \$336 VSS sg13_lv_nmos L=0.13u W=0.42u AS=0.1626p AD=0.0609p
+ PS=1.415u PD=0.71u rfmode=0
M$13352 VSS \$66 \$337 VSS sg13_lv_nmos L=0.13u W=0.42u AS=0.1701p AD=0.0378p
+ PS=1.65u PD=0.6u rfmode=0
M$13353 \$337 \$168 \$292 VSS sg13_lv_nmos L=0.13u W=0.42u AS=0.0378p
+ AD=0.1428p PS=0.6u PD=1.52u rfmode=0
M$13354 \$351 \$58 VSS VSS sg13_lv_nmos L=0.13u W=0.74u AS=0.2516p AD=0.2516p
+ PS=2.16u PD=2.16u rfmode=0
M$13355 \$352 \$353 VSS VSS sg13_lv_nmos L=0.13u W=0.74u AS=0.2516p AD=0.1426p
+ PS=2.16u PD=1.16u rfmode=0
M$13356 VSS \$354 \$353 VSS sg13_lv_nmos L=0.5u W=0.42u AS=0.1426p AD=0.1428p
+ PS=1.16u PD=1.52u rfmode=0
M$13357 \$354 \$355 VSS VSS sg13_lv_nmos L=0.5u W=0.42u AS=0.1428p AD=0.0798p
+ PS=1.52u PD=0.8u rfmode=0
M$13358 VSS \$356 \$355 VSS sg13_lv_nmos L=0.13u W=0.42u AS=0.0798p AD=0.1428p
+ PS=0.8u PD=1.52u rfmode=0
M$13359 \$293 \$172 VSS VSS sg13_lv_nmos L=0.13u W=0.42u AS=0.1428p AD=0.0798p
+ PS=1.52u PD=0.8u rfmode=0
M$13360 VSS \$66 \$338 VSS sg13_lv_nmos L=0.13u W=0.42u AS=0.0798p AD=0.0378p
+ PS=0.8u PD=0.6u rfmode=0
M$13361 \$338 \$171 \$172 VSS sg13_lv_nmos L=0.13u W=0.42u AS=0.0378p
+ AD=0.1428p PS=0.6u PD=1.52u rfmode=0
M$13362 \$356 \$357 VSS VSS sg13_lv_nmos L=0.13u W=0.74u AS=0.4033p AD=0.148p
+ PS=2.57u PD=1.14u rfmode=0
M$13363 VSS \$358 \$526 VSS sg13_lv_nmos L=0.13u W=0.74u AS=0.148p AD=0.3367p
+ PS=1.14u PD=1.65u rfmode=0
M$13364 \$526 \$662 \$357 VSS sg13_lv_nmos L=0.13u W=0.74u AS=0.3367p
+ AD=0.1628p PS=1.65u PD=1.18u rfmode=0
M$13365 \$357 \$76 \$527 VSS sg13_lv_nmos L=0.13u W=0.74u AS=0.1628p
+ AD=0.13135p PS=1.18u PD=1.095u rfmode=0
M$13366 \$527 \$71 VSS VSS sg13_lv_nmos L=0.13u W=0.74u AS=0.13135p AD=0.18945p
+ PS=1.095u PD=1.27u rfmode=0
M$13367 VSS \$71 \$358 VSS sg13_lv_nmos L=0.13u W=0.55u AS=0.18945p AD=0.187p
+ PS=1.27u PD=1.78u rfmode=0
M$13370 \$175 \$176 VSS VSS sg13_lv_nmos L=0.5u W=0.42u AS=0.1428p AD=0.0798p
+ PS=1.52u PD=0.8u rfmode=0
M$13371 VSS \$165 \$176 VSS sg13_lv_nmos L=0.13u W=0.42u AS=0.0798p AD=0.1428p
+ PS=0.8u PD=1.52u rfmode=0
M$13372 \$359 \$360 VSS VSS sg13_lv_nmos L=0.13u W=0.74u AS=0.4033p AD=0.148p
+ PS=2.57u PD=1.14u rfmode=0
M$13373 VSS \$362 \$528 VSS sg13_lv_nmos L=0.13u W=0.74u AS=0.148p AD=0.3367p
+ PS=1.14u PD=1.65u rfmode=0
M$13374 \$528 \$665 \$360 VSS sg13_lv_nmos L=0.13u W=0.74u AS=0.3367p
+ AD=0.1628p PS=1.65u PD=1.18u rfmode=0
M$13375 \$360 \$361 \$529 VSS sg13_lv_nmos L=0.13u W=0.74u AS=0.1628p
+ AD=0.13135p PS=1.18u PD=1.095u rfmode=0
M$13376 \$529 \$71 VSS VSS sg13_lv_nmos L=0.13u W=0.74u AS=0.13135p AD=0.18945p
+ PS=1.095u PD=1.27u rfmode=0
M$13377 VSS \$71 \$362 VSS sg13_lv_nmos L=0.13u W=0.55u AS=0.18945p AD=0.187p
+ PS=1.27u PD=1.78u rfmode=0
M$13378 \$178 \$179 VSS VSS sg13_lv_nmos L=0.5u W=0.42u AS=0.1428p AD=0.0798p
+ PS=1.52u PD=0.8u rfmode=0
M$13379 VSS \$88 \$179 VSS sg13_lv_nmos L=0.13u W=0.42u AS=0.0798p AD=0.1428p
+ PS=0.8u PD=1.52u rfmode=0
M$13380 \$363 \$58 VSS VSS sg13_lv_nmos L=0.13u W=0.74u AS=0.2516p AD=0.2516p
+ PS=2.16u PD=2.16u rfmode=0
M$13383 VSS \$184 \$185 VSS sg13_lv_nmos L=0.13u W=0.74u AS=0.1626p AD=0.2516p
+ PS=1.415u PD=2.16u rfmode=0
M$13384 \$183 \$182 \$343 VSS sg13_lv_nmos L=0.13u W=0.42u AS=0.1428p
+ AD=0.0609p PS=1.52u PD=0.71u rfmode=0
M$13385 VSS \$89 \$343 VSS sg13_lv_nmos L=0.13u W=0.42u AS=0.1626p AD=0.0609p
+ PS=1.415u PD=0.71u rfmode=0
M$13387 VSS \$89 \$344 VSS sg13_lv_nmos L=0.13u W=0.42u AS=0.1701p AD=0.0378p
+ PS=1.65u PD=0.6u rfmode=0
M$13388 \$344 \$185 \$294 VSS sg13_lv_nmos L=0.13u W=0.42u AS=0.0378p
+ AD=0.1428p PS=0.6u PD=1.52u rfmode=0
M$13389 \$361 \$364 VSS VSS sg13_lv_nmos L=0.13u W=0.74u AS=0.2516p AD=0.1426p
+ PS=2.16u PD=1.16u rfmode=0
M$13390 VSS \$365 \$364 VSS sg13_lv_nmos L=0.5u W=0.42u AS=0.1426p AD=0.1428p
+ PS=1.16u PD=1.52u rfmode=0
M$13391 \$365 \$366 VSS VSS sg13_lv_nmos L=0.5u W=0.42u AS=0.1428p AD=0.0798p
+ PS=1.52u PD=0.8u rfmode=0
M$13392 VSS \$191 \$366 VSS sg13_lv_nmos L=0.13u W=0.42u AS=0.0798p AD=0.1428p
+ PS=0.8u PD=1.52u rfmode=0
M$13394 \$295 \$189 VSS VSS sg13_lv_nmos L=0.13u W=0.42u AS=0.1428p AD=0.0798p
+ PS=1.52u PD=0.8u rfmode=0
M$13395 VSS \$89 \$347 VSS sg13_lv_nmos L=0.13u W=0.42u AS=0.0798p AD=0.0378p
+ PS=0.8u PD=0.6u rfmode=0
M$13396 \$347 \$188 \$189 VSS sg13_lv_nmos L=0.13u W=0.42u AS=0.0378p
+ AD=0.1428p PS=0.6u PD=1.52u rfmode=0
M$13397 VSS \$71 \$367 VSS sg13_lv_nmos L=0.13u W=0.55u AS=0.18945p AD=0.187p
+ PS=1.27u PD=1.78u rfmode=0
M$13398 VSS \$71 \$530 VSS sg13_lv_nmos L=0.13u W=0.74u AS=0.18945p AD=0.13135p
+ PS=1.27u PD=1.095u rfmode=0
M$13399 \$530 \$369 \$368 VSS sg13_lv_nmos L=0.13u W=0.74u AS=0.13135p
+ AD=0.1628p PS=1.095u PD=1.18u rfmode=0
M$13400 \$368 \$676 \$532 VSS sg13_lv_nmos L=0.13u W=0.74u AS=0.1628p
+ AD=0.3367p PS=1.18u PD=1.65u rfmode=0
M$13401 \$532 \$367 VSS VSS sg13_lv_nmos L=0.13u W=0.74u AS=0.3367p AD=0.148p
+ PS=1.65u PD=1.14u rfmode=0
M$13402 VSS \$368 \$370 VSS sg13_lv_nmos L=0.13u W=0.74u AS=0.148p AD=0.4033p
+ PS=1.14u PD=2.57u rfmode=0
M$13403 \$371 \$370 VSS VSS sg13_lv_nmos L=0.13u W=0.42u AS=0.1428p AD=0.0798p
+ PS=1.52u PD=0.8u rfmode=0
M$13404 VSS \$371 \$372 VSS sg13_lv_nmos L=0.5u W=0.42u AS=0.0798p AD=0.1428p
+ PS=0.8u PD=1.52u rfmode=0
M$13405 VSS \$195 \$196 VSS sg13_lv_nmos L=0.13u W=0.74u AS=0.1626p AD=0.2516p
+ PS=1.415u PD=2.16u rfmode=0
M$13406 \$194 \$92 \$349 VSS sg13_lv_nmos L=0.13u W=0.42u AS=0.1428p AD=0.0609p
+ PS=1.52u PD=0.71u rfmode=0
M$13407 VSS \$193 \$349 VSS sg13_lv_nmos L=0.13u W=0.42u AS=0.1626p AD=0.0609p
+ PS=1.415u PD=0.71u rfmode=0
M$13408 VSS \$372 \$373 VSS sg13_lv_nmos L=0.5u W=0.42u AS=0.1426p AD=0.1428p
+ PS=1.16u PD=1.52u rfmode=0
M$13409 VSS \$373 \$374 VSS sg13_lv_nmos L=0.13u W=0.74u AS=0.1426p AD=0.2516p
+ PS=1.16u PD=2.16u rfmode=0
M$13411 VSS \$193 \$350 VSS sg13_lv_nmos L=0.13u W=0.42u AS=0.1701p AD=0.0378p
+ PS=1.65u PD=0.6u rfmode=0
M$13412 \$350 \$196 \$296 VSS sg13_lv_nmos L=0.13u W=0.42u AS=0.0378p
+ AD=0.1428p PS=0.6u PD=1.52u rfmode=0
M$13413 \$369 \$375 VSS VSS sg13_lv_nmos L=0.13u W=0.74u AS=0.2516p AD=0.1426p
+ PS=2.16u PD=1.16u rfmode=0
M$13414 VSS \$376 \$375 VSS sg13_lv_nmos L=0.5u W=0.42u AS=0.1426p AD=0.1428p
+ PS=1.16u PD=1.52u rfmode=0
M$13415 \$376 \$377 VSS VSS sg13_lv_nmos L=0.5u W=0.42u AS=0.1428p AD=0.0798p
+ PS=1.52u PD=0.8u rfmode=0
M$13416 VSS \$297 \$377 VSS sg13_lv_nmos L=0.13u W=0.42u AS=0.0798p AD=0.1428p
+ PS=0.8u PD=1.52u rfmode=0
M$13419 \$298 \$200 VSS VSS sg13_lv_nmos L=0.13u W=0.42u AS=0.1428p AD=0.0798p
+ PS=1.52u PD=0.8u rfmode=0
M$13420 VSS \$193 \$348 VSS sg13_lv_nmos L=0.13u W=0.42u AS=0.0798p AD=0.0378p
+ PS=0.8u PD=0.6u rfmode=0
M$13421 \$348 \$199 \$200 VSS sg13_lv_nmos L=0.13u W=0.42u AS=0.0378p
+ AD=0.1428p PS=0.6u PD=1.52u rfmode=0
M$13423 VSS \$74 \$378 VSS sg13_lv_nmos L=0.13u W=0.55u AS=0.18945p AD=0.187p
+ PS=1.27u PD=1.78u rfmode=0
M$13424 VSS \$74 \$534 VSS sg13_lv_nmos L=0.13u W=0.74u AS=0.18945p AD=0.13135p
+ PS=1.27u PD=1.095u rfmode=0
M$13425 \$534 \$369 \$379 VSS sg13_lv_nmos L=0.13u W=0.74u AS=0.13135p
+ AD=0.1628p PS=1.095u PD=1.18u rfmode=0
M$13426 \$379 \$105 \$535 VSS sg13_lv_nmos L=0.13u W=0.74u AS=0.1628p
+ AD=0.3367p PS=1.18u PD=1.65u rfmode=0
M$13427 \$535 \$378 VSS VSS sg13_lv_nmos L=0.13u W=0.74u AS=0.3367p AD=0.148p
+ PS=1.65u PD=1.14u rfmode=0
M$13428 VSS \$379 \$383 VSS sg13_lv_nmos L=0.13u W=0.74u AS=0.148p AD=0.4033p
+ PS=1.14u PD=2.57u rfmode=0
M$13429 \$380 \$322 VSS VSS sg13_lv_nmos L=0.13u W=0.74u AS=0.2516p AD=0.2516p
+ PS=2.16u PD=2.16u rfmode=0
M$13430 VSS \$58 \$381 VSS sg13_lv_nmos L=0.13u W=0.74u AS=0.2516p AD=0.2516p
+ PS=2.16u PD=2.16u rfmode=0
M$13431 \$382 \$383 \$537 VSS sg13_lv_nmos L=0.13u W=0.42u AS=0.1428p
+ AD=0.0609p PS=1.52u PD=0.71u rfmode=0
M$13432 \$537 \$381 VSS VSS sg13_lv_nmos L=0.13u W=0.42u AS=0.0609p AD=0.1626p
+ PS=0.71u PD=1.415u rfmode=0
M$13433 VSS \$578 \$384 VSS sg13_lv_nmos L=0.13u W=0.74u AS=0.1626p AD=0.2516p
+ PS=1.415u PD=2.16u rfmode=0
M$13434 VSS \$381 \$538 VSS sg13_lv_nmos L=0.13u W=0.42u AS=0.1701p AD=0.0378p
+ PS=1.65u PD=0.6u rfmode=0
M$13435 \$538 \$384 \$385 VSS sg13_lv_nmos L=0.13u W=0.42u AS=0.0378p
+ AD=0.1428p PS=0.6u PD=1.52u rfmode=0
M$13436 \$388 \$386 \$387 VSS sg13_lv_nmos L=0.13u W=0.42u AS=0.12665p
+ AD=0.1428p PS=1.145u PD=1.52u rfmode=0
M$13437 \$384 \$579 \$388 VSS sg13_lv_nmos L=0.13u W=0.74u AS=0.3473p
+ AD=0.12665p PS=2.71u PD=1.145u rfmode=0
M$13439 \$387 \$390 VSS VSS sg13_lv_nmos L=0.13u W=0.42u AS=0.1428p AD=0.0798p
+ PS=1.52u PD=0.8u rfmode=0
M$13440 VSS \$381 \$541 VSS sg13_lv_nmos L=0.13u W=0.42u AS=0.0798p AD=0.0378p
+ PS=0.8u PD=0.6u rfmode=0
M$13441 \$541 \$388 \$390 VSS sg13_lv_nmos L=0.13u W=0.42u AS=0.0378p
+ AD=0.1428p PS=0.6u PD=1.52u rfmode=0
M$13442 \$391 \$388 VSS VSS sg13_lv_nmos L=0.13u W=0.74u AS=0.2516p AD=0.1406p
+ PS=2.16u PD=1.12u rfmode=0
M$13443 VSS \$391 \$299 VSS sg13_lv_nmos L=0.13u W=0.74u AS=0.1406p AD=0.2516p
+ PS=1.12u PD=2.16u rfmode=0
M$13444 VSS \$322 \$392 VSS sg13_lv_nmos L=0.13u W=0.74u AS=0.2516p AD=0.2516p
+ PS=2.16u PD=2.16u rfmode=0
M$13445 \$393 \$209 \$542 VSS sg13_lv_nmos L=0.13u W=0.42u AS=0.1428p
+ AD=0.0609p PS=1.52u PD=0.71u rfmode=0
M$13446 \$542 \$392 VSS VSS sg13_lv_nmos L=0.13u W=0.42u AS=0.0609p AD=0.1626p
+ PS=0.71u PD=1.415u rfmode=0
M$13447 VSS \$580 \$394 VSS sg13_lv_nmos L=0.13u W=0.74u AS=0.1626p AD=0.2516p
+ PS=1.415u PD=2.16u rfmode=0
M$13448 VSS \$392 \$543 VSS sg13_lv_nmos L=0.13u W=0.42u AS=0.1701p AD=0.0378p
+ PS=1.65u PD=0.6u rfmode=0
M$13449 \$543 \$394 \$395 VSS sg13_lv_nmos L=0.13u W=0.42u AS=0.0378p
+ AD=0.1428p PS=0.6u PD=1.52u rfmode=0
M$13450 \$211 \$212 VSS VSS sg13_lv_nmos L=0.5u W=0.42u AS=0.1428p AD=0.0798p
+ PS=1.52u PD=0.8u rfmode=0
M$13451 VSS \$208 \$212 VSS sg13_lv_nmos L=0.13u W=0.42u AS=0.0798p AD=0.1428p
+ PS=0.8u PD=1.52u rfmode=0
M$13452 \$398 \$396 \$397 VSS sg13_lv_nmos L=0.13u W=0.42u AS=0.12665p
+ AD=0.1428p PS=1.145u PD=1.52u rfmode=0
M$13453 \$394 \$581 \$398 VSS sg13_lv_nmos L=0.13u W=0.74u AS=0.3473p
+ AD=0.12665p PS=2.71u PD=1.145u rfmode=0
M$13454 \$397 \$399 VSS VSS sg13_lv_nmos L=0.13u W=0.42u AS=0.1428p AD=0.0798p
+ PS=1.52u PD=0.8u rfmode=0
M$13455 VSS \$392 \$545 VSS sg13_lv_nmos L=0.13u W=0.42u AS=0.0798p AD=0.0378p
+ PS=0.8u PD=0.6u rfmode=0
M$13456 \$545 \$398 \$399 VSS sg13_lv_nmos L=0.13u W=0.42u AS=0.0378p
+ AD=0.1428p PS=0.6u PD=1.52u rfmode=0
M$13457 \$400 \$398 VSS VSS sg13_lv_nmos L=0.13u W=0.74u AS=0.2516p AD=0.1406p
+ PS=2.16u PD=1.12u rfmode=0
M$13458 VSS \$400 \$301 VSS sg13_lv_nmos L=0.13u W=0.74u AS=0.1406p AD=0.2516p
+ PS=1.12u PD=2.16u rfmode=0
M$13459 VSS \$322 \$401 VSS sg13_lv_nmos L=0.13u W=0.74u AS=0.2516p AD=0.2516p
+ PS=2.16u PD=2.16u rfmode=0
M$13460 \$402 \$403 VSS VSS sg13_lv_nmos L=0.13u W=0.74u AS=0.4033p AD=0.148p
+ PS=2.57u PD=1.14u rfmode=0
M$13461 VSS \$405 \$547 VSS sg13_lv_nmos L=0.13u W=0.74u AS=0.148p AD=0.3367p
+ PS=1.14u PD=1.65u rfmode=0
M$13462 \$547 \$404 \$403 VSS sg13_lv_nmos L=0.13u W=0.74u AS=0.3367p
+ AD=0.1628p PS=1.65u PD=1.18u rfmode=0
M$13463 \$403 \$301 \$548 VSS sg13_lv_nmos L=0.13u W=0.74u AS=0.1628p
+ AD=0.13135p PS=1.18u PD=1.095u rfmode=0
M$13464 \$548 \$71 VSS VSS sg13_lv_nmos L=0.13u W=0.74u AS=0.13135p AD=0.18945p
+ PS=1.095u PD=1.27u rfmode=0
M$13465 VSS \$71 \$405 VSS sg13_lv_nmos L=0.13u W=0.55u AS=0.18945p AD=0.187p
+ PS=1.27u PD=1.78u rfmode=0
M$13467 \$406 \$301 VSS VSS sg13_lv_nmos L=0.13u W=0.42u AS=0.1428p AD=0.0798p
+ PS=1.52u PD=0.8u rfmode=0
M$13468 VSS \$406 \$407 VSS sg13_lv_nmos L=0.5u W=0.42u AS=0.0798p AD=0.1428p
+ PS=0.8u PD=1.52u rfmode=0
M$13469 VSS \$407 \$408 VSS sg13_lv_nmos L=0.5u W=0.42u AS=0.1426p AD=0.1428p
+ PS=1.16u PD=1.52u rfmode=0
M$13470 VSS \$408 \$409 VSS sg13_lv_nmos L=0.13u W=0.74u AS=0.1426p AD=0.2516p
+ PS=1.16u PD=2.16u rfmode=0
M$13472 VSS \$74 \$410 VSS sg13_lv_nmos L=0.13u W=0.55u AS=0.18945p AD=0.187p
+ PS=1.27u PD=1.78u rfmode=0
M$13473 VSS \$74 \$549 VSS sg13_lv_nmos L=0.13u W=0.74u AS=0.18945p AD=0.13135p
+ PS=1.27u PD=1.095u rfmode=0
M$13474 \$549 \$409 \$411 VSS sg13_lv_nmos L=0.13u W=0.74u AS=0.13135p
+ AD=0.1628p PS=1.095u PD=1.18u rfmode=0
M$13475 \$411 \$412 \$550 VSS sg13_lv_nmos L=0.13u W=0.74u AS=0.1628p
+ AD=0.3367p PS=1.18u PD=1.65u rfmode=0
M$13476 \$550 \$410 VSS VSS sg13_lv_nmos L=0.13u W=0.74u AS=0.3367p AD=0.148p
+ PS=1.65u PD=1.14u rfmode=0
M$13477 VSS \$411 \$217 VSS sg13_lv_nmos L=0.13u W=0.74u AS=0.148p AD=0.4033p
+ PS=1.14u PD=2.57u rfmode=0
M$13478 \$413 \$218 \$551 VSS sg13_lv_nmos L=0.13u W=0.42u AS=0.1428p
+ AD=0.0609p PS=1.52u PD=0.71u rfmode=0
M$13479 \$551 \$216 VSS VSS sg13_lv_nmos L=0.13u W=0.42u AS=0.0609p AD=0.1626p
+ PS=0.71u PD=1.415u rfmode=0
M$13480 VSS \$582 \$414 VSS sg13_lv_nmos L=0.13u W=0.74u AS=0.1626p AD=0.2516p
+ PS=1.415u PD=2.16u rfmode=0
M$13481 VSS \$216 \$552 VSS sg13_lv_nmos L=0.13u W=0.42u AS=0.1701p AD=0.0378p
+ PS=1.65u PD=0.6u rfmode=0
M$13482 \$552 \$414 \$415 VSS sg13_lv_nmos L=0.13u W=0.42u AS=0.0378p
+ AD=0.1428p PS=0.6u PD=1.52u rfmode=0
M$13483 \$220 \$221 VSS VSS sg13_lv_nmos L=0.5u W=0.42u AS=0.1428p AD=0.0798p
+ PS=1.52u PD=0.8u rfmode=0
M$13484 VSS \$217 \$221 VSS sg13_lv_nmos L=0.13u W=0.42u AS=0.0798p AD=0.1428p
+ PS=0.8u PD=1.52u rfmode=0
M$13485 \$419 \$416 \$418 VSS sg13_lv_nmos L=0.13u W=0.42u AS=0.12665p
+ AD=0.1428p PS=1.145u PD=1.52u rfmode=0
M$13486 \$414 \$583 \$419 VSS sg13_lv_nmos L=0.13u W=0.74u AS=0.3473p
+ AD=0.12665p PS=2.71u PD=1.145u rfmode=0
M$13487 \$418 \$420 VSS VSS sg13_lv_nmos L=0.13u W=0.42u AS=0.1428p AD=0.0798p
+ PS=1.52u PD=0.8u rfmode=0
M$13488 VSS \$216 \$553 VSS sg13_lv_nmos L=0.13u W=0.42u AS=0.0798p AD=0.0378p
+ PS=0.8u PD=0.6u rfmode=0
M$13489 \$553 \$419 \$420 VSS sg13_lv_nmos L=0.13u W=0.42u AS=0.0378p
+ AD=0.1428p PS=0.6u PD=1.52u rfmode=0
M$13490 \$421 \$419 VSS VSS sg13_lv_nmos L=0.13u W=0.74u AS=0.2516p AD=0.1406p
+ PS=2.16u PD=1.12u rfmode=0
M$13491 VSS \$421 \$412 VSS sg13_lv_nmos L=0.13u W=0.74u AS=0.1406p AD=0.2516p
+ PS=1.12u PD=2.16u rfmode=0
M$13496 VSS \$322 \$422 VSS sg13_lv_nmos L=0.13u W=0.74u AS=0.2516p AD=0.2516p
+ PS=2.16u PD=2.16u rfmode=0
M$13497 \$322 \$423 VSS VSS sg13_lv_nmos L=0.13u W=0.74u AS=0.2886p AD=0.14875p
+ PS=2.26u PD=1.16u rfmode=0
M$13498 VSS \$120 \$423 VSS sg13_lv_nmos L=0.13u W=0.55u AS=0.14875p AD=0.187p
+ PS=1.16u PD=1.78u rfmode=0
M$13499 \$424 \$425 VSS VSS sg13_lv_nmos L=0.13u W=0.74u AS=0.4033p AD=0.148p
+ PS=2.57u PD=1.14u rfmode=0
M$13500 VSS \$427 \$554 VSS sg13_lv_nmos L=0.13u W=0.74u AS=0.148p AD=0.3367p
+ PS=1.14u PD=1.65u rfmode=0
M$13501 \$554 \$426 \$425 VSS sg13_lv_nmos L=0.13u W=0.74u AS=0.3367p
+ AD=0.1628p PS=1.65u PD=1.18u rfmode=0
M$13502 \$425 \$412 \$555 VSS sg13_lv_nmos L=0.13u W=0.74u AS=0.1628p
+ AD=0.13135p PS=1.18u PD=1.095u rfmode=0
M$13503 \$555 \$71 VSS VSS sg13_lv_nmos L=0.13u W=0.74u AS=0.13135p AD=0.18945p
+ PS=1.095u PD=1.27u rfmode=0
M$13504 VSS \$71 \$427 VSS sg13_lv_nmos L=0.13u W=0.55u AS=0.18945p AD=0.187p
+ PS=1.27u PD=1.78u rfmode=0
M$13505 \$428 \$412 VSS VSS sg13_lv_nmos L=0.13u W=0.42u AS=0.1428p AD=0.0798p
+ PS=1.52u PD=0.8u rfmode=0
M$13506 VSS \$428 \$429 VSS sg13_lv_nmos L=0.5u W=0.42u AS=0.0798p AD=0.1428p
+ PS=0.8u PD=1.52u rfmode=0
M$13508 VSS \$429 \$430 VSS sg13_lv_nmos L=0.5u W=0.42u AS=0.1426p AD=0.1428p
+ PS=1.16u PD=1.52u rfmode=0
M$13509 VSS \$430 \$431 VSS sg13_lv_nmos L=0.13u W=0.74u AS=0.1426p AD=0.2516p
+ PS=1.16u PD=2.16u rfmode=0
M$13510 \$426 \$432 VSS VSS sg13_lv_nmos L=0.13u W=0.74u AS=0.2516p AD=0.1426p
+ PS=2.16u PD=1.16u rfmode=0
M$13511 VSS \$433 \$432 VSS sg13_lv_nmos L=0.5u W=0.42u AS=0.1426p AD=0.1428p
+ PS=1.16u PD=1.52u rfmode=0
M$13512 \$433 \$434 VSS VSS sg13_lv_nmos L=0.5u W=0.42u AS=0.1428p AD=0.0798p
+ PS=1.52u PD=0.8u rfmode=0
M$13513 VSS \$223 \$434 VSS sg13_lv_nmos L=0.13u W=0.42u AS=0.0798p AD=0.1428p
+ PS=0.8u PD=1.52u rfmode=0
M$13514 VSS \$323 \$435 VSS sg13_lv_nmos L=0.13u W=0.55u AS=0.18945p AD=0.187p
+ PS=1.27u PD=1.78u rfmode=0
M$13515 VSS \$323 \$558 VSS sg13_lv_nmos L=0.13u W=0.74u AS=0.18945p
+ AD=0.13135p PS=1.27u PD=1.095u rfmode=0
M$13516 \$558 \$431 \$436 VSS sg13_lv_nmos L=0.13u W=0.74u AS=0.13135p
+ AD=0.1628p PS=1.095u PD=1.18u rfmode=0
M$13517 \$436 \$437 \$559 VSS sg13_lv_nmos L=0.13u W=0.74u AS=0.1628p
+ AD=0.3367p PS=1.18u PD=1.65u rfmode=0
M$13518 \$559 \$435 VSS VSS sg13_lv_nmos L=0.13u W=0.74u AS=0.3367p AD=0.148p
+ PS=1.65u PD=1.14u rfmode=0
M$13519 VSS \$436 \$438 VSS sg13_lv_nmos L=0.13u W=0.74u AS=0.148p AD=0.4033p
+ PS=1.14u PD=2.57u rfmode=0
M$13521 \$439 \$438 \$560 VSS sg13_lv_nmos L=0.13u W=0.42u AS=0.1428p
+ AD=0.0609p PS=1.52u PD=0.71u rfmode=0
M$13522 \$560 \$121 VSS VSS sg13_lv_nmos L=0.13u W=0.42u AS=0.0609p AD=0.1626p
+ PS=0.71u PD=1.415u rfmode=0
M$13523 VSS \$584 \$440 VSS sg13_lv_nmos L=0.13u W=0.74u AS=0.1626p AD=0.2516p
+ PS=1.415u PD=2.16u rfmode=0
M$13524 VSS \$121 \$561 VSS sg13_lv_nmos L=0.13u W=0.42u AS=0.1701p AD=0.0378p
+ PS=1.65u PD=0.6u rfmode=0
M$13525 \$561 \$440 \$441 VSS sg13_lv_nmos L=0.13u W=0.42u AS=0.0378p
+ AD=0.1428p PS=0.6u PD=1.52u rfmode=0
M$13526 \$444 \$442 \$443 VSS sg13_lv_nmos L=0.13u W=0.42u AS=0.12665p
+ AD=0.1428p PS=1.145u PD=1.52u rfmode=0
M$13527 \$440 \$585 \$444 VSS sg13_lv_nmos L=0.13u W=0.74u AS=0.3473p
+ AD=0.12665p PS=2.71u PD=1.145u rfmode=0
M$13528 \$443 \$445 VSS VSS sg13_lv_nmos L=0.13u W=0.42u AS=0.1428p AD=0.0798p
+ PS=1.52u PD=0.8u rfmode=0
M$13529 VSS \$121 \$562 VSS sg13_lv_nmos L=0.13u W=0.42u AS=0.0798p AD=0.0378p
+ PS=0.8u PD=0.6u rfmode=0
M$13530 \$562 \$444 \$445 VSS sg13_lv_nmos L=0.13u W=0.42u AS=0.0378p
+ AD=0.1428p PS=0.6u PD=1.52u rfmode=0
M$13531 \$446 \$444 VSS VSS sg13_lv_nmos L=0.13u W=0.74u AS=0.2516p AD=0.1406p
+ PS=2.16u PD=1.12u rfmode=0
M$13532 VSS \$446 \$303 VSS sg13_lv_nmos L=0.13u W=0.74u AS=0.1406p AD=0.2516p
+ PS=1.12u PD=2.16u rfmode=0
M$13541 VSS \$122 \$447 VSS sg13_lv_nmos L=0.13u W=0.74u AS=0.2516p AD=0.2516p
+ PS=2.16u PD=2.16u rfmode=0
M$13542 \$448 \$449 \$564 VSS sg13_lv_nmos L=0.13u W=0.42u AS=0.1428p
+ AD=0.0609p PS=1.52u PD=0.71u rfmode=0
M$13543 \$564 \$447 VSS VSS sg13_lv_nmos L=0.13u W=0.42u AS=0.0609p AD=0.1626p
+ PS=0.71u PD=1.415u rfmode=0
M$13544 VSS \$586 \$450 VSS sg13_lv_nmos L=0.13u W=0.74u AS=0.1626p AD=0.2516p
+ PS=1.415u PD=2.16u rfmode=0
M$13545 VSS \$447 \$565 VSS sg13_lv_nmos L=0.13u W=0.42u AS=0.1701p AD=0.0378p
+ PS=1.65u PD=0.6u rfmode=0
M$13546 \$565 \$450 \$451 VSS sg13_lv_nmos L=0.13u W=0.42u AS=0.0378p
+ AD=0.1428p PS=0.6u PD=1.52u rfmode=0
M$13547 \$454 \$452 \$453 VSS sg13_lv_nmos L=0.13u W=0.42u AS=0.12665p
+ AD=0.1428p PS=1.145u PD=1.52u rfmode=0
M$13548 \$450 \$587 \$454 VSS sg13_lv_nmos L=0.13u W=0.74u AS=0.3473p
+ AD=0.12665p PS=2.71u PD=1.145u rfmode=0
M$13549 \$453 \$455 VSS VSS sg13_lv_nmos L=0.13u W=0.42u AS=0.1428p AD=0.0798p
+ PS=1.52u PD=0.8u rfmode=0
M$13550 VSS \$447 \$568 VSS sg13_lv_nmos L=0.13u W=0.42u AS=0.0798p AD=0.0378p
+ PS=0.8u PD=0.6u rfmode=0
M$13551 \$568 \$454 \$455 VSS sg13_lv_nmos L=0.13u W=0.42u AS=0.0378p
+ AD=0.1428p PS=0.6u PD=1.52u rfmode=0
M$13552 \$231 \$232 VSS VSS sg13_lv_nmos L=0.5u W=0.42u AS=0.1428p AD=0.0798p
+ PS=1.52u PD=0.8u rfmode=0
M$13553 VSS \$304 \$232 VSS sg13_lv_nmos L=0.13u W=0.42u AS=0.0798p AD=0.1428p
+ PS=0.8u PD=1.52u rfmode=0
M$13554 \$456 \$454 VSS VSS sg13_lv_nmos L=0.13u W=0.74u AS=0.2516p AD=0.1406p
+ PS=2.16u PD=1.12u rfmode=0
M$13555 VSS \$456 \$304 VSS sg13_lv_nmos L=0.13u W=0.74u AS=0.1406p AD=0.2516p
+ PS=1.12u PD=2.16u rfmode=0
M$13563 VSS \$323 \$457 VSS sg13_lv_nmos L=0.13u W=0.55u AS=0.18945p AD=0.187p
+ PS=1.27u PD=1.78u rfmode=0
M$13564 VSS \$323 \$571 VSS sg13_lv_nmos L=0.13u W=0.74u AS=0.18945p
+ AD=0.13135p PS=1.27u PD=1.095u rfmode=0
M$13565 \$571 \$437 \$458 VSS sg13_lv_nmos L=0.13u W=0.74u AS=0.13135p
+ AD=0.1628p PS=1.095u PD=1.18u rfmode=0
M$13566 \$458 \$459 \$572 VSS sg13_lv_nmos L=0.13u W=0.74u AS=0.1628p
+ AD=0.3367p PS=1.18u PD=1.65u rfmode=0
M$13567 \$572 \$457 VSS VSS sg13_lv_nmos L=0.13u W=0.74u AS=0.3367p AD=0.148p
+ PS=1.65u PD=1.14u rfmode=0
M$13568 VSS \$458 \$460 VSS sg13_lv_nmos L=0.13u W=0.74u AS=0.148p AD=0.4033p
+ PS=1.14u PD=2.57u rfmode=0
M$13569 \$461 \$460 \$573 VSS sg13_lv_nmos L=0.13u W=0.42u AS=0.1428p
+ AD=0.0609p PS=1.52u PD=0.71u rfmode=0
M$13570 \$573 \$233 VSS VSS sg13_lv_nmos L=0.13u W=0.42u AS=0.0609p AD=0.1626p
+ PS=0.71u PD=1.415u rfmode=0
M$13571 VSS \$588 \$462 VSS sg13_lv_nmos L=0.13u W=0.74u AS=0.1626p AD=0.2516p
+ PS=1.415u PD=2.16u rfmode=0
M$13572 VSS \$233 \$574 VSS sg13_lv_nmos L=0.13u W=0.42u AS=0.1701p AD=0.0378p
+ PS=1.65u PD=0.6u rfmode=0
M$13573 \$574 \$462 \$463 VSS sg13_lv_nmos L=0.13u W=0.42u AS=0.0378p
+ AD=0.1428p PS=0.6u PD=1.52u rfmode=0
M$13574 \$466 \$464 \$465 VSS sg13_lv_nmos L=0.13u W=0.42u AS=0.12665p
+ AD=0.1428p PS=1.145u PD=1.52u rfmode=0
M$13575 \$462 \$589 \$466 VSS sg13_lv_nmos L=0.13u W=0.74u AS=0.3473p
+ AD=0.12665p PS=2.71u PD=1.145u rfmode=0
M$13576 \$465 \$467 VSS VSS sg13_lv_nmos L=0.13u W=0.42u AS=0.1428p AD=0.0798p
+ PS=1.52u PD=0.8u rfmode=0
M$13577 VSS \$233 \$575 VSS sg13_lv_nmos L=0.13u W=0.42u AS=0.0798p AD=0.0378p
+ PS=0.8u PD=0.6u rfmode=0
M$13578 \$575 \$466 \$467 VSS sg13_lv_nmos L=0.13u W=0.42u AS=0.0378p
+ AD=0.1428p PS=0.6u PD=1.52u rfmode=0
M$13579 \$468 \$466 VSS VSS sg13_lv_nmos L=0.13u W=0.74u AS=0.2516p AD=0.1406p
+ PS=2.16u PD=1.12u rfmode=0
M$13580 VSS \$468 \$469 VSS sg13_lv_nmos L=0.13u W=0.74u AS=0.1406p AD=0.2516p
+ PS=1.12u PD=2.16u rfmode=0
M$13581 \$470 \$471 VSS VSS sg13_lv_nmos L=0.13u W=0.74u AS=0.4033p AD=0.148p
+ PS=2.57u PD=1.14u rfmode=0
M$13582 VSS \$473 \$576 VSS sg13_lv_nmos L=0.13u W=0.74u AS=0.148p AD=0.3367p
+ PS=1.14u PD=1.65u rfmode=0
M$13583 \$576 \$472 \$471 VSS sg13_lv_nmos L=0.13u W=0.74u AS=0.3367p
+ AD=0.1628p PS=1.65u PD=1.18u rfmode=0
M$13584 \$471 \$469 \$577 VSS sg13_lv_nmos L=0.13u W=0.74u AS=0.1628p
+ AD=0.13135p PS=1.18u PD=1.095u rfmode=0
M$13585 \$577 \$268 VSS VSS sg13_lv_nmos L=0.13u W=0.74u AS=0.13135p
+ AD=0.18945p PS=1.095u PD=1.27u rfmode=0
M$13586 VSS \$268 \$473 VSS sg13_lv_nmos L=0.13u W=0.55u AS=0.18945p AD=0.187p
+ PS=1.27u PD=1.78u rfmode=0
M$13587 \$474 \$122 VSS VSS sg13_lv_nmos L=0.13u W=0.74u AS=0.2516p AD=0.2516p
+ PS=2.16u PD=2.16u rfmode=0
M$13588 VSS \$590 \$475 VSS sg13_lv_nmos L=0.13u W=0.55u AS=0.14875p AD=0.187p
+ PS=1.16u PD=1.78u rfmode=0
M$13589 VSS \$475 dout[8] VSS sg13_lv_nmos L=0.13u W=0.74u AS=0.14875p
+ AD=0.2886p PS=1.16u PD=2.26u rfmode=0
M$13590 \$477 \$469 VSS VSS sg13_lv_nmos L=0.13u W=0.42u AS=0.1428p AD=0.0798p
+ PS=1.52u PD=0.8u rfmode=0
M$13591 VSS \$477 \$478 VSS sg13_lv_nmos L=0.5u W=0.42u AS=0.0798p AD=0.1428p
+ PS=0.8u PD=1.52u rfmode=0
M$13592 VSS \$478 \$479 VSS sg13_lv_nmos L=0.5u W=0.42u AS=0.1426p AD=0.1428p
+ PS=1.16u PD=1.52u rfmode=0
M$13593 VSS \$479 \$459 VSS sg13_lv_nmos L=0.13u W=0.74u AS=0.1426p AD=0.2516p
+ PS=1.16u PD=2.16u rfmode=0
M$13595 VSS \$323 \$480 VSS sg13_lv_nmos L=0.13u W=0.55u AS=0.18945p AD=0.187p
+ PS=1.27u PD=1.78u rfmode=0
M$13596 VSS \$323 \$570 VSS sg13_lv_nmos L=0.13u W=0.74u AS=0.18945p
+ AD=0.13135p PS=1.27u PD=1.095u rfmode=0
M$13597 \$570 \$459 \$481 VSS sg13_lv_nmos L=0.13u W=0.74u AS=0.13135p
+ AD=0.1628p PS=1.095u PD=1.18u rfmode=0
M$13598 \$481 \$493 \$569 VSS sg13_lv_nmos L=0.13u W=0.74u AS=0.1628p
+ AD=0.3367p PS=1.18u PD=1.65u rfmode=0
M$13599 \$569 \$480 VSS VSS sg13_lv_nmos L=0.13u W=0.74u AS=0.3367p AD=0.148p
+ PS=1.65u PD=1.14u rfmode=0
M$13600 VSS \$481 \$482 VSS sg13_lv_nmos L=0.13u W=0.74u AS=0.148p AD=0.4033p
+ PS=1.14u PD=2.57u rfmode=0
M$13602 \$483 \$235 \$567 VSS sg13_lv_nmos L=0.13u W=0.42u AS=0.1428p
+ AD=0.0609p PS=1.52u PD=0.71u rfmode=0
M$13603 \$567 \$234 VSS VSS sg13_lv_nmos L=0.13u W=0.42u AS=0.0609p AD=0.1626p
+ PS=0.71u PD=1.415u rfmode=0
M$13604 VSS \$591 \$484 VSS sg13_lv_nmos L=0.13u W=0.74u AS=0.1626p AD=0.2516p
+ PS=1.415u PD=2.16u rfmode=0
M$13605 VSS \$234 \$566 VSS sg13_lv_nmos L=0.13u W=0.42u AS=0.1701p AD=0.0378p
+ PS=1.65u PD=0.6u rfmode=0
M$13606 \$566 \$484 \$485 VSS sg13_lv_nmos L=0.13u W=0.42u AS=0.0378p
+ AD=0.1428p PS=0.6u PD=1.52u rfmode=0
M$13607 \$237 \$238 VSS VSS sg13_lv_nmos L=0.5u W=0.42u AS=0.1428p AD=0.0798p
+ PS=1.52u PD=0.8u rfmode=0
M$13608 VSS \$482 \$238 VSS sg13_lv_nmos L=0.13u W=0.42u AS=0.0798p AD=0.1428p
+ PS=0.8u PD=1.52u rfmode=0
M$13609 \$488 \$486 \$487 VSS sg13_lv_nmos L=0.13u W=0.42u AS=0.12665p
+ AD=0.1428p PS=1.145u PD=1.52u rfmode=0
M$13610 \$484 \$592 \$488 VSS sg13_lv_nmos L=0.13u W=0.74u AS=0.3473p
+ AD=0.12665p PS=2.71u PD=1.145u rfmode=0
M$13611 \$487 \$489 VSS VSS sg13_lv_nmos L=0.13u W=0.42u AS=0.1428p AD=0.0798p
+ PS=1.52u PD=0.8u rfmode=0
M$13612 VSS \$234 \$563 VSS sg13_lv_nmos L=0.13u W=0.42u AS=0.0798p AD=0.0378p
+ PS=0.8u PD=0.6u rfmode=0
M$13613 \$563 \$488 \$489 VSS sg13_lv_nmos L=0.13u W=0.42u AS=0.0378p
+ AD=0.1428p PS=0.6u PD=1.52u rfmode=0
M$13615 \$490 \$488 VSS VSS sg13_lv_nmos L=0.13u W=0.74u AS=0.2516p AD=0.1406p
+ PS=2.16u PD=1.12u rfmode=0
M$13616 VSS \$490 \$493 VSS sg13_lv_nmos L=0.13u W=0.74u AS=0.1406p AD=0.2516p
+ PS=1.12u PD=2.16u rfmode=0
M$13617 VSS \$268 \$491 VSS sg13_lv_nmos L=0.13u W=0.55u AS=0.18945p AD=0.187p
+ PS=1.27u PD=1.78u rfmode=0
M$13618 VSS \$268 \$557 VSS sg13_lv_nmos L=0.13u W=0.74u AS=0.18945p
+ AD=0.13135p PS=1.27u PD=1.095u rfmode=0
M$13619 \$557 \$493 \$492 VSS sg13_lv_nmos L=0.13u W=0.74u AS=0.13135p
+ AD=0.1628p PS=1.095u PD=1.18u rfmode=0
M$13620 \$492 \$494 \$556 VSS sg13_lv_nmos L=0.13u W=0.74u AS=0.1628p
+ AD=0.3367p PS=1.18u PD=1.65u rfmode=0
M$13621 \$556 \$491 VSS VSS sg13_lv_nmos L=0.13u W=0.74u AS=0.3367p AD=0.148p
+ PS=1.65u PD=1.14u rfmode=0
M$13622 VSS \$492 \$499 VSS sg13_lv_nmos L=0.13u W=0.74u AS=0.148p AD=0.4033p
+ PS=1.14u PD=2.57u rfmode=0
M$13623 VSS \$244 \$245 VSS sg13_lv_nmos L=0.13u W=0.74u AS=0.1626p AD=0.2516p
+ PS=1.415u PD=2.16u rfmode=0
M$13624 \$243 \$242 \$331 VSS sg13_lv_nmos L=0.13u W=0.42u AS=0.1428p
+ AD=0.0609p PS=1.52u PD=0.71u rfmode=0
M$13625 VSS \$123 \$331 VSS sg13_lv_nmos L=0.13u W=0.42u AS=0.1626p AD=0.0609p
+ PS=1.415u PD=0.71u rfmode=0
M$13626 \$495 \$496 VSS VSS sg13_lv_nmos L=0.13u W=0.74u AS=0.2516p AD=0.1426p
+ PS=2.16u PD=1.16u rfmode=0
M$13627 VSS \$497 \$496 VSS sg13_lv_nmos L=0.5u W=0.42u AS=0.1426p AD=0.1428p
+ PS=1.16u PD=1.52u rfmode=0
M$13628 VSS \$123 \$330 VSS sg13_lv_nmos L=0.13u W=0.42u AS=0.1701p AD=0.0378p
+ PS=1.65u PD=0.6u rfmode=0
M$13629 \$330 \$245 \$306 VSS sg13_lv_nmos L=0.13u W=0.42u AS=0.0378p
+ AD=0.1428p PS=0.6u PD=1.52u rfmode=0
M$13630 \$497 \$498 VSS VSS sg13_lv_nmos L=0.5u W=0.42u AS=0.1428p AD=0.0798p
+ PS=1.52u PD=0.8u rfmode=0
M$13631 VSS \$499 \$498 VSS sg13_lv_nmos L=0.13u W=0.42u AS=0.0798p AD=0.1428p
+ PS=0.8u PD=1.52u rfmode=0
M$13632 \$494 \$500 VSS VSS sg13_lv_nmos L=0.13u W=0.74u AS=0.2516p AD=0.1426p
+ PS=2.16u PD=1.16u rfmode=0
M$13633 VSS \$501 \$500 VSS sg13_lv_nmos L=0.5u W=0.42u AS=0.1426p AD=0.1428p
+ PS=1.16u PD=1.52u rfmode=0
M$13634 \$501 \$502 VSS VSS sg13_lv_nmos L=0.5u W=0.42u AS=0.1428p AD=0.0798p
+ PS=1.52u PD=0.8u rfmode=0
M$13635 VSS \$503 \$502 VSS sg13_lv_nmos L=0.13u W=0.42u AS=0.0798p AD=0.1428p
+ PS=0.8u PD=1.52u rfmode=0
M$13636 \$307 \$249 VSS VSS sg13_lv_nmos L=0.13u W=0.42u AS=0.1428p AD=0.0798p
+ PS=1.52u PD=0.8u rfmode=0
M$13637 VSS \$123 \$329 VSS sg13_lv_nmos L=0.13u W=0.42u AS=0.0798p AD=0.0378p
+ PS=0.8u PD=0.6u rfmode=0
M$13638 \$329 \$248 \$249 VSS sg13_lv_nmos L=0.13u W=0.42u AS=0.0378p
+ AD=0.1428p PS=0.6u PD=1.52u rfmode=0
M$13639 \$122 \$504 VSS VSS sg13_lv_nmos L=0.13u W=0.74u AS=0.2886p AD=0.14875p
+ PS=2.26u PD=1.16u rfmode=0
M$13640 VSS \$120 \$504 VSS sg13_lv_nmos L=0.13u W=0.55u AS=0.14875p AD=0.187p
+ PS=1.16u PD=1.78u rfmode=0
M$13641 \$505 \$122 VSS VSS sg13_lv_nmos L=0.13u W=0.74u AS=0.2516p AD=0.2516p
+ PS=2.16u PD=2.16u rfmode=0
M$13642 \$506 \$251 VSS VSS sg13_lv_nmos L=0.13u W=0.42u AS=0.1428p AD=0.0798p
+ PS=1.52u PD=0.8u rfmode=0
M$13643 VSS \$506 \$507 VSS sg13_lv_nmos L=0.5u W=0.42u AS=0.0798p AD=0.1428p
+ PS=0.8u PD=1.52u rfmode=0
M$13644 VSS \$507 \$508 VSS sg13_lv_nmos L=0.5u W=0.42u AS=0.1426p AD=0.1428p
+ PS=1.16u PD=1.52u rfmode=0
M$13645 VSS \$508 \$241 VSS sg13_lv_nmos L=0.13u W=0.74u AS=0.1426p AD=0.2516p
+ PS=1.16u PD=2.16u rfmode=0
M$13646 VSS \$257 \$258 VSS sg13_lv_nmos L=0.13u W=0.74u AS=0.1626p AD=0.2516p
+ PS=1.415u PD=2.16u rfmode=0
M$13647 \$256 \$255 \$326 VSS sg13_lv_nmos L=0.13u W=0.42u AS=0.1428p
+ AD=0.0609p PS=1.52u PD=0.71u rfmode=0
M$13648 VSS \$125 \$326 VSS sg13_lv_nmos L=0.13u W=0.42u AS=0.1626p AD=0.0609p
+ PS=1.415u PD=0.71u rfmode=0
M$13649 VSS \$268 \$509 VSS sg13_lv_nmos L=0.13u W=0.55u AS=0.18945p AD=0.187p
+ PS=1.27u PD=1.78u rfmode=0
M$13650 VSS \$268 \$546 VSS sg13_lv_nmos L=0.13u W=0.74u AS=0.18945p
+ AD=0.13135p PS=1.27u PD=1.095u rfmode=0
M$13651 \$546 \$241 \$510 VSS sg13_lv_nmos L=0.13u W=0.74u AS=0.13135p
+ AD=0.1628p PS=1.095u PD=1.18u rfmode=0
M$13652 \$510 \$511 \$544 VSS sg13_lv_nmos L=0.13u W=0.74u AS=0.1628p
+ AD=0.3367p PS=1.18u PD=1.65u rfmode=0
M$13653 \$544 \$509 VSS VSS sg13_lv_nmos L=0.13u W=0.74u AS=0.3367p AD=0.148p
+ PS=1.65u PD=1.14u rfmode=0
M$13654 VSS \$510 \$512 VSS sg13_lv_nmos L=0.13u W=0.74u AS=0.148p AD=0.4033p
+ PS=1.14u PD=2.57u rfmode=0
M$13655 VSS \$125 \$325 VSS sg13_lv_nmos L=0.13u W=0.42u AS=0.1701p AD=0.0378p
+ PS=1.65u PD=0.6u rfmode=0
M$13656 \$325 \$258 \$308 VSS sg13_lv_nmos L=0.13u W=0.42u AS=0.0378p
+ AD=0.1428p PS=0.6u PD=1.52u rfmode=0
M$13657 VSS \$122 \$513 VSS sg13_lv_nmos L=0.13u W=0.74u AS=0.2516p AD=0.2516p
+ PS=2.16u PD=2.16u rfmode=0
M$13658 VSS \$122 \$514 VSS sg13_lv_nmos L=0.13u W=0.74u AS=0.2516p AD=0.2516p
+ PS=2.16u PD=2.16u rfmode=0
M$13659 VSS \$268 \$515 VSS sg13_lv_nmos L=0.13u W=0.55u AS=0.18945p AD=0.187p
+ PS=1.27u PD=1.78u rfmode=0
M$13660 VSS \$268 \$540 VSS sg13_lv_nmos L=0.13u W=0.74u AS=0.18945p
+ AD=0.13135p PS=1.27u PD=1.095u rfmode=0
M$13661 \$540 \$254 \$516 VSS sg13_lv_nmos L=0.13u W=0.74u AS=0.13135p
+ AD=0.1628p PS=1.095u PD=1.18u rfmode=0
M$13662 \$516 \$525 \$539 VSS sg13_lv_nmos L=0.13u W=0.74u AS=0.1628p
+ AD=0.3367p PS=1.18u PD=1.65u rfmode=0
M$13663 \$539 \$515 VSS VSS sg13_lv_nmos L=0.13u W=0.74u AS=0.3367p AD=0.148p
+ PS=1.65u PD=1.14u rfmode=0
M$13664 VSS \$516 \$130 VSS sg13_lv_nmos L=0.13u W=0.74u AS=0.148p AD=0.4033p
+ PS=1.14u PD=2.57u rfmode=0
M$13665 \$309 \$262 VSS VSS sg13_lv_nmos L=0.13u W=0.42u AS=0.1428p AD=0.0798p
+ PS=1.52u PD=0.8u rfmode=0
M$13666 VSS \$125 \$324 VSS sg13_lv_nmos L=0.13u W=0.42u AS=0.0798p AD=0.0378p
+ PS=0.8u PD=0.6u rfmode=0
M$13667 \$324 \$261 \$262 VSS sg13_lv_nmos L=0.13u W=0.42u AS=0.0378p
+ AD=0.1428p PS=0.6u PD=1.52u rfmode=0
M$13668 \$517 \$126 \$536 VSS sg13_lv_nmos L=0.13u W=0.42u AS=0.1428p
+ AD=0.0609p PS=1.52u PD=0.71u rfmode=0
M$13669 \$536 \$513 VSS VSS sg13_lv_nmos L=0.13u W=0.42u AS=0.0609p AD=0.1626p
+ PS=0.71u PD=1.415u rfmode=0
M$13670 VSS \$593 \$518 VSS sg13_lv_nmos L=0.13u W=0.74u AS=0.1626p AD=0.2516p
+ PS=1.415u PD=2.16u rfmode=0
M$13671 VSS \$513 \$533 VSS sg13_lv_nmos L=0.13u W=0.42u AS=0.1701p AD=0.0378p
+ PS=1.65u PD=0.6u rfmode=0
M$13672 \$533 \$518 \$519 VSS sg13_lv_nmos L=0.13u W=0.42u AS=0.0378p
+ AD=0.1428p PS=0.6u PD=1.52u rfmode=0
M$13673 \$266 \$267 VSS VSS sg13_lv_nmos L=0.5u W=0.42u AS=0.1428p AD=0.0798p
+ PS=1.52u PD=0.8u rfmode=0
M$13674 VSS \$264 \$267 VSS sg13_lv_nmos L=0.13u W=0.42u AS=0.0798p AD=0.1428p
+ PS=0.8u PD=1.52u rfmode=0
M$13675 \$522 \$520 \$521 VSS sg13_lv_nmos L=0.13u W=0.42u AS=0.12665p
+ AD=0.1428p PS=1.145u PD=1.52u rfmode=0
M$13676 \$518 \$594 \$522 VSS sg13_lv_nmos L=0.13u W=0.74u AS=0.3473p
+ AD=0.12665p PS=2.71u PD=1.145u rfmode=0
M$13677 \$521 \$523 VSS VSS sg13_lv_nmos L=0.13u W=0.42u AS=0.1428p AD=0.0798p
+ PS=1.52u PD=0.8u rfmode=0
M$13678 VSS \$513 \$531 VSS sg13_lv_nmos L=0.13u W=0.42u AS=0.0798p AD=0.0378p
+ PS=0.8u PD=0.6u rfmode=0
M$13679 \$531 \$522 \$523 VSS sg13_lv_nmos L=0.13u W=0.42u AS=0.0378p
+ AD=0.1428p PS=0.6u PD=1.52u rfmode=0
M$13680 \$524 \$522 VSS VSS sg13_lv_nmos L=0.13u W=0.74u AS=0.2516p AD=0.1406p
+ PS=2.16u PD=1.12u rfmode=0
M$13681 VSS \$524 \$525 VSS sg13_lv_nmos L=0.13u W=0.74u AS=0.1406p AD=0.2516p
+ PS=1.12u PD=2.16u rfmode=0
M$13742 VSS \$165 \$660 VSS sg13_lv_nmos L=0.13u W=0.55u AS=0.14875p AD=0.187p
+ PS=1.16u PD=1.78u rfmode=0
M$13743 dout[0] \$660 VSS VSS sg13_lv_nmos L=0.13u W=0.74u AS=0.2886p
+ AD=0.14875p PS=2.26u PD=1.16u rfmode=0
M$13768 VSS \$662 \$663 VSS sg13_lv_nmos L=0.13u W=0.55u AS=0.14875p AD=0.187p
+ PS=1.16u PD=1.78u rfmode=0
M$13769 dout[1] \$663 VSS VSS sg13_lv_nmos L=0.13u W=0.74u AS=0.2886p
+ AD=0.14875p PS=2.26u PD=1.16u rfmode=0
M$13794 VSS \$665 \$666 VSS sg13_lv_nmos L=0.13u W=0.55u AS=0.14875p AD=0.187p
+ PS=1.16u PD=1.78u rfmode=0
M$13795 dout[2] \$666 VSS VSS sg13_lv_nmos L=0.13u W=0.74u AS=0.2886p
+ AD=0.14875p PS=2.26u PD=1.16u rfmode=0
M$13812 \$667 \$671 \$668 VSS sg13_lv_nmos L=0.13u W=0.42u AS=0.1296p
+ AD=0.0798p PS=1.52u PD=0.8u rfmode=0
M$13813 \$668 \$670 \$814 VSS sg13_lv_nmos L=0.13u W=0.42u AS=0.0798p
+ AD=0.2373p PS=0.8u PD=1.97u rfmode=0
M$13814 \$670 \$671 VSS VSS sg13_lv_nmos L=0.13u W=0.74u AS=0.2516p
+ AD=0.317325p PS=2.16u PD=1.805u rfmode=0
M$13815 VSS \$389 \$671 VSS sg13_lv_nmos L=0.13u W=0.74u AS=0.317325p
+ AD=0.2516p PS=1.805u PD=2.16u rfmode=0
M$13816 \$815 \$671 \$672 VSS sg13_lv_nmos L=0.13u W=0.42u AS=0.1428p
+ AD=0.12665p PS=1.52u PD=1.145u rfmode=0
M$13817 \$672 \$670 \$669 VSS sg13_lv_nmos L=0.13u W=0.74u AS=0.12665p
+ AD=0.3473p PS=1.145u PD=2.71u rfmode=0
M$13818 \$674 \$672 VSS VSS sg13_lv_nmos L=0.13u W=0.74u AS=0.2516p AD=0.1406p
+ PS=2.16u PD=1.12u rfmode=0
M$13819 VSS \$674 \$662 VSS sg13_lv_nmos L=0.13u W=0.74u AS=0.1406p AD=0.2516p
+ PS=1.12u PD=2.16u rfmode=0
M$13820 VSS \$676 \$677 VSS sg13_lv_nmos L=0.13u W=0.55u AS=0.14875p AD=0.187p
+ PS=1.16u PD=1.78u rfmode=0
M$13821 dout[3] \$677 VSS VSS sg13_lv_nmos L=0.13u W=0.74u AS=0.2886p
+ AD=0.14875p PS=2.26u PD=1.16u rfmode=0
M$13822 \$680 \$679 VSS VSS sg13_lv_nmos L=0.5u W=0.42u AS=0.1428p AD=0.1426p
+ PS=1.52u PD=1.16u rfmode=0
M$13823 VSS \$680 \$681 VSS sg13_lv_nmos L=0.13u W=0.74u AS=0.1426p AD=0.2516p
+ PS=1.16u PD=2.16u rfmode=0
M$13824 \$682 \$686 \$683 VSS sg13_lv_nmos L=0.13u W=0.42u AS=0.1296p
+ AD=0.0798p PS=1.52u PD=0.8u rfmode=0
M$13825 \$683 \$685 \$816 VSS sg13_lv_nmos L=0.13u W=0.42u AS=0.0798p
+ AD=0.2373p PS=0.8u PD=1.97u rfmode=0
M$13826 \$685 \$686 VSS VSS sg13_lv_nmos L=0.13u W=0.74u AS=0.2516p
+ AD=0.317325p PS=2.16u PD=1.805u rfmode=0
M$13827 VSS \$389 \$686 VSS sg13_lv_nmos L=0.13u W=0.74u AS=0.317325p
+ AD=0.2516p PS=1.805u PD=2.16u rfmode=0
M$13828 \$817 \$686 \$687 VSS sg13_lv_nmos L=0.13u W=0.42u AS=0.1428p
+ AD=0.12665p PS=1.52u PD=1.145u rfmode=0
M$13829 \$687 \$685 \$684 VSS sg13_lv_nmos L=0.13u W=0.74u AS=0.12665p
+ AD=0.3473p PS=1.145u PD=2.71u rfmode=0
M$13830 \$689 \$687 VSS VSS sg13_lv_nmos L=0.13u W=0.74u AS=0.2516p AD=0.1406p
+ PS=2.16u PD=1.12u rfmode=0
M$13831 VSS \$689 \$665 VSS sg13_lv_nmos L=0.13u W=0.74u AS=0.1406p AD=0.2516p
+ PS=1.12u PD=2.16u rfmode=0
M$13836 \$676 \$690 VSS VSS sg13_lv_nmos L=0.13u W=0.74u AS=0.2516p AD=0.1406p
+ PS=2.16u PD=1.12u rfmode=0
M$13837 VSS \$818 \$690 VSS sg13_lv_nmos L=0.13u W=0.74u AS=0.1406p AD=0.2516p
+ PS=1.12u PD=2.16u rfmode=0
M$13838 \$818 \$693 \$819 VSS sg13_lv_nmos L=0.13u W=0.42u AS=0.12665p
+ AD=0.1428p PS=1.145u PD=1.52u rfmode=0
M$13839 \$696 \$692 \$818 VSS sg13_lv_nmos L=0.13u W=0.74u AS=0.3473p
+ AD=0.12665p PS=2.71u PD=1.145u rfmode=0
M$13840 \$693 \$389 VSS VSS sg13_lv_nmos L=0.13u W=0.74u AS=0.2516p
+ AD=0.317325p PS=2.16u PD=1.805u rfmode=0
M$13841 VSS \$693 \$692 VSS sg13_lv_nmos L=0.13u W=0.74u AS=0.317325p
+ AD=0.2516p PS=1.805u PD=2.16u rfmode=0
M$13842 \$820 \$692 \$695 VSS sg13_lv_nmos L=0.13u W=0.42u AS=0.2373p
+ AD=0.0798p PS=1.97u PD=0.8u rfmode=0
M$13843 \$695 \$693 \$694 VSS sg13_lv_nmos L=0.13u W=0.42u AS=0.0798p
+ AD=0.1296p PS=0.8u PD=1.52u rfmode=0
M$13844 \$696 \$695 VSS VSS sg13_lv_nmos L=0.13u W=0.74u AS=0.2516p AD=0.1626p
+ PS=2.16u PD=1.415u rfmode=0
M$13845 VSS \$192 \$864 VSS sg13_lv_nmos L=0.13u W=0.42u AS=0.1626p AD=0.0609p
+ PS=1.415u PD=0.71u rfmode=0
M$13846 \$864 \$374 \$694 VSS sg13_lv_nmos L=0.13u W=0.42u AS=0.0609p
+ AD=0.1428p PS=0.71u PD=1.52u rfmode=0
M$13847 \$697 \$698 VSS VSS sg13_lv_nmos L=0.13u W=0.55u AS=0.187p AD=0.14875p
+ PS=1.78u PD=1.16u rfmode=0
M$13848 VSS \$697 dout[4] VSS sg13_lv_nmos L=0.13u W=0.74u AS=0.14875p
+ AD=0.2886p PS=1.16u PD=2.26u rfmode=0
M$13849 \$702 \$701 VSS VSS sg13_lv_nmos L=0.5u W=0.42u AS=0.1428p AD=0.1426p
+ PS=1.52u PD=1.16u rfmode=0
M$13850 VSS \$702 \$300 VSS sg13_lv_nmos L=0.13u W=0.74u AS=0.1426p AD=0.2516p
+ PS=1.16u PD=2.16u rfmode=0
M$13851 \$698 \$703 VSS VSS sg13_lv_nmos L=0.13u W=0.74u AS=0.2516p AD=0.1406p
+ PS=2.16u PD=1.12u rfmode=0
M$13852 VSS \$821 \$703 VSS sg13_lv_nmos L=0.13u W=0.74u AS=0.1406p AD=0.2516p
+ PS=1.12u PD=2.16u rfmode=0
M$13853 \$821 \$706 \$822 VSS sg13_lv_nmos L=0.13u W=0.42u AS=0.12665p
+ AD=0.1428p PS=1.145u PD=1.52u rfmode=0
M$13854 \$709 \$705 \$821 VSS sg13_lv_nmos L=0.13u W=0.74u AS=0.3473p
+ AD=0.12665p PS=2.71u PD=1.145u rfmode=0
M$13855 \$706 \$389 VSS VSS sg13_lv_nmos L=0.13u W=0.74u AS=0.2516p
+ AD=0.317325p PS=2.16u PD=1.805u rfmode=0
M$13856 VSS \$706 \$705 VSS sg13_lv_nmos L=0.13u W=0.74u AS=0.317325p
+ AD=0.2516p PS=1.805u PD=2.16u rfmode=0
M$13857 \$823 \$705 \$708 VSS sg13_lv_nmos L=0.13u W=0.42u AS=0.2373p
+ AD=0.0798p PS=1.97u PD=0.8u rfmode=0
M$13858 \$708 \$706 \$707 VSS sg13_lv_nmos L=0.13u W=0.42u AS=0.0798p
+ AD=0.1296p PS=0.8u PD=1.52u rfmode=0
M$13859 \$382 \$386 \$578 VSS sg13_lv_nmos L=0.13u W=0.42u AS=0.1296p
+ AD=0.0798p PS=1.52u PD=0.8u rfmode=0
M$13860 \$578 \$579 \$385 VSS sg13_lv_nmos L=0.13u W=0.42u AS=0.0798p
+ AD=0.2373p PS=0.8u PD=1.97u rfmode=0
M$13861 \$709 \$708 VSS VSS sg13_lv_nmos L=0.13u W=0.74u AS=0.2516p AD=0.1626p
+ PS=2.16u PD=1.415u rfmode=0
M$13862 VSS \$380 \$867 VSS sg13_lv_nmos L=0.13u W=0.42u AS=0.1626p AD=0.0609p
+ PS=1.415u PD=0.71u rfmode=0
M$13863 \$867 \$101 \$707 VSS sg13_lv_nmos L=0.13u W=0.42u AS=0.0609p
+ AD=0.1428p PS=0.71u PD=1.52u rfmode=0
M$13864 VSS \$386 \$579 VSS sg13_lv_nmos L=0.13u W=0.74u AS=0.317325p
+ AD=0.2516p PS=1.805u PD=2.16u rfmode=0
M$13865 VSS \$204 \$386 VSS sg13_lv_nmos L=0.13u W=0.74u AS=0.317325p
+ AD=0.2516p PS=1.805u PD=2.16u rfmode=0
M$13866 VSS \$710 \$389 VSS sg13_lv_nmos L=0.13u W=11.84u AS=2.3606p AD=2.2496p
+ PS=18.96u PD=17.92u rfmode=0
M$13882 VSS \$226 \$710 VSS sg13_lv_nmos L=0.13u W=4.44u AS=0.8436p AD=0.9546p
+ PS=6.72u PD=7.76u rfmode=0
M$13890 \$393 \$396 \$580 VSS sg13_lv_nmos L=0.13u W=0.42u AS=0.1296p
+ AD=0.0798p PS=1.52u PD=0.8u rfmode=0
M$13891 \$580 \$581 \$395 VSS sg13_lv_nmos L=0.13u W=0.42u AS=0.0798p
+ AD=0.2373p PS=0.8u PD=1.97u rfmode=0
M$13892 VSS \$396 \$581 VSS sg13_lv_nmos L=0.13u W=0.74u AS=0.317325p
+ AD=0.2516p PS=1.805u PD=2.16u rfmode=0
M$13893 VSS \$389 \$396 VSS sg13_lv_nmos L=0.13u W=0.74u AS=0.317325p
+ AD=0.2516p PS=1.805u PD=2.16u rfmode=0
M$13896 \$713 \$712 VSS VSS sg13_lv_nmos L=0.5u W=0.42u AS=0.1428p AD=0.1426p
+ PS=1.52u PD=1.16u rfmode=0
M$13897 VSS \$713 \$714 VSS sg13_lv_nmos L=0.13u W=0.74u AS=0.1426p AD=0.2516p
+ PS=1.16u PD=2.16u rfmode=0
M$13898 \$715 \$719 \$716 VSS sg13_lv_nmos L=0.13u W=0.42u AS=0.1296p
+ AD=0.0798p PS=1.52u PD=0.8u rfmode=0
M$13899 \$716 \$718 \$824 VSS sg13_lv_nmos L=0.13u W=0.42u AS=0.0798p
+ AD=0.2373p PS=0.8u PD=1.97u rfmode=0
M$13900 \$718 \$719 VSS VSS sg13_lv_nmos L=0.13u W=0.74u AS=0.2516p
+ AD=0.317325p PS=2.16u PD=1.805u rfmode=0
M$13901 VSS \$389 \$719 VSS sg13_lv_nmos L=0.13u W=0.74u AS=0.317325p
+ AD=0.2516p PS=1.805u PD=2.16u rfmode=0
M$13902 \$825 \$719 \$720 VSS sg13_lv_nmos L=0.13u W=0.42u AS=0.1428p
+ AD=0.12665p PS=1.52u PD=1.145u rfmode=0
M$13903 \$720 \$718 \$717 VSS sg13_lv_nmos L=0.13u W=0.74u AS=0.12665p
+ AD=0.3473p PS=1.145u PD=2.71u rfmode=0
M$13904 \$722 \$720 VSS VSS sg13_lv_nmos L=0.13u W=0.74u AS=0.2516p AD=0.1406p
+ PS=2.16u PD=1.12u rfmode=0
M$13905 VSS \$722 \$214 VSS sg13_lv_nmos L=0.13u W=0.74u AS=0.1406p AD=0.2516p
+ PS=1.12u PD=2.16u rfmode=0
M$13906 VSS \$724 \$723 VSS sg13_lv_nmos L=0.5u W=0.42u AS=0.1426p AD=0.1428p
+ PS=1.16u PD=1.52u rfmode=0
M$13907 \$404 \$723 VSS VSS sg13_lv_nmos L=0.13u W=0.74u AS=0.2516p AD=0.1426p
+ PS=2.16u PD=1.16u rfmode=0
M$13910 \$413 \$416 \$582 VSS sg13_lv_nmos L=0.13u W=0.42u AS=0.1296p
+ AD=0.0798p PS=1.52u PD=0.8u rfmode=0
M$13911 \$582 \$583 \$415 VSS sg13_lv_nmos L=0.13u W=0.42u AS=0.0798p
+ AD=0.2373p PS=0.8u PD=1.97u rfmode=0
M$13914 VSS \$416 \$583 VSS sg13_lv_nmos L=0.13u W=0.74u AS=0.317325p
+ AD=0.2516p PS=1.805u PD=2.16u rfmode=0
M$13915 VSS \$417 \$416 VSS sg13_lv_nmos L=0.13u W=0.74u AS=0.317325p
+ AD=0.2516p PS=1.805u PD=2.16u rfmode=0
M$13922 \$728 \$727 VSS VSS sg13_lv_nmos L=0.5u W=0.42u AS=0.1428p AD=0.1426p
+ PS=1.52u PD=1.16u rfmode=0
M$13923 VSS \$728 \$729 VSS sg13_lv_nmos L=0.13u W=0.74u AS=0.1426p AD=0.2516p
+ PS=1.16u PD=2.16u rfmode=0
M$13924 \$730 \$734 \$731 VSS sg13_lv_nmos L=0.13u W=0.42u AS=0.1296p
+ AD=0.0798p PS=1.52u PD=0.8u rfmode=0
M$13925 \$731 \$733 \$826 VSS sg13_lv_nmos L=0.13u W=0.42u AS=0.0798p
+ AD=0.2373p PS=0.8u PD=1.97u rfmode=0
M$13926 \$733 \$734 VSS VSS sg13_lv_nmos L=0.13u W=0.74u AS=0.2516p
+ AD=0.317325p PS=2.16u PD=1.805u rfmode=0
M$13927 VSS \$417 \$734 VSS sg13_lv_nmos L=0.13u W=0.74u AS=0.317325p
+ AD=0.2516p PS=1.805u PD=2.16u rfmode=0
M$13928 \$827 \$734 \$735 VSS sg13_lv_nmos L=0.13u W=0.42u AS=0.1428p
+ AD=0.12665p PS=1.52u PD=1.145u rfmode=0
M$13929 \$735 \$733 \$732 VSS sg13_lv_nmos L=0.13u W=0.74u AS=0.12665p
+ AD=0.3473p PS=1.145u PD=2.71u rfmode=0
M$13930 \$737 \$735 VSS VSS sg13_lv_nmos L=0.13u W=0.74u AS=0.2516p AD=0.1406p
+ PS=2.16u PD=1.12u rfmode=0
M$13931 VSS \$737 \$223 VSS sg13_lv_nmos L=0.13u W=0.74u AS=0.1406p AD=0.2516p
+ PS=1.12u PD=2.16u rfmode=0
M$13938 \$439 \$442 \$584 VSS sg13_lv_nmos L=0.13u W=0.42u AS=0.1296p
+ AD=0.0798p PS=1.52u PD=0.8u rfmode=0
M$13939 \$584 \$585 \$441 VSS sg13_lv_nmos L=0.13u W=0.42u AS=0.0798p
+ AD=0.2373p PS=0.8u PD=1.97u rfmode=0
M$13942 VSS \$442 \$585 VSS sg13_lv_nmos L=0.13u W=0.74u AS=0.317325p
+ AD=0.2516p PS=1.805u PD=2.16u rfmode=0
M$13943 VSS \$417 \$442 VSS sg13_lv_nmos L=0.13u W=0.74u AS=0.317325p
+ AD=0.2516p PS=1.805u PD=2.16u rfmode=0
M$13954 VSS \$739 \$738 VSS sg13_lv_nmos L=0.5u W=0.42u AS=0.1426p AD=0.1428p
+ PS=1.16u PD=1.52u rfmode=0
M$13955 \$449 \$738 VSS VSS sg13_lv_nmos L=0.13u W=0.74u AS=0.2516p AD=0.1426p
+ PS=2.16u PD=1.16u rfmode=0
M$13956 \$448 \$452 \$586 VSS sg13_lv_nmos L=0.13u W=0.42u AS=0.1296p
+ AD=0.0798p PS=1.52u PD=0.8u rfmode=0
M$13957 \$586 \$587 \$451 VSS sg13_lv_nmos L=0.13u W=0.42u AS=0.0798p
+ AD=0.2373p PS=0.8u PD=1.97u rfmode=0
M$13958 VSS \$452 \$587 VSS sg13_lv_nmos L=0.13u W=0.74u AS=0.317325p
+ AD=0.2516p PS=1.805u PD=2.16u rfmode=0
M$13959 VSS \$417 \$452 VSS sg13_lv_nmos L=0.13u W=0.74u AS=0.317325p
+ AD=0.2516p PS=1.805u PD=2.16u rfmode=0
M$13960 \$743 \$742 VSS VSS sg13_lv_nmos L=0.5u W=0.42u AS=0.1428p AD=0.1426p
+ PS=1.52u PD=1.16u rfmode=0
M$13961 VSS \$743 \$437 VSS sg13_lv_nmos L=0.13u W=0.74u AS=0.1426p AD=0.2516p
+ PS=1.16u PD=2.16u rfmode=0
M$13962 VSS \$304 \$745 VSS sg13_lv_nmos L=0.13u W=0.55u AS=0.14875p AD=0.187p
+ PS=1.16u PD=1.78u rfmode=0
M$13963 dout[7] \$745 VSS VSS sg13_lv_nmos L=0.13u W=0.74u AS=0.2886p
+ AD=0.14875p PS=2.26u PD=1.16u rfmode=0
M$13972 VSS \$226 \$746 VSS sg13_lv_nmos L=0.13u W=4.44u AS=0.9546p AD=0.8436p
+ PS=7.76u PD=6.72u rfmode=0
M$13978 VSS \$746 \$417 VSS sg13_lv_nmos L=0.13u W=11.84u AS=2.2496p AD=2.3606p
+ PS=17.92u PD=18.96u rfmode=0
M$13994 \$461 \$464 \$588 VSS sg13_lv_nmos L=0.13u W=0.42u AS=0.1296p
+ AD=0.0798p PS=1.52u PD=0.8u rfmode=0
M$13995 \$588 \$589 \$463 VSS sg13_lv_nmos L=0.13u W=0.42u AS=0.0798p
+ AD=0.2373p PS=0.8u PD=1.97u rfmode=0
M$13996 VSS \$464 \$589 VSS sg13_lv_nmos L=0.13u W=0.74u AS=0.317325p
+ AD=0.2516p PS=1.805u PD=2.16u rfmode=0
M$13997 VSS \$417 \$464 VSS sg13_lv_nmos L=0.13u W=0.74u AS=0.317325p
+ AD=0.2516p PS=1.805u PD=2.16u rfmode=0
M$13998 \$749 \$748 VSS VSS sg13_lv_nmos L=0.5u W=0.42u AS=0.1428p AD=0.1426p
+ PS=1.52u PD=1.16u rfmode=0
M$13999 VSS \$749 \$750 VSS sg13_lv_nmos L=0.13u W=0.74u AS=0.1426p AD=0.2516p
+ PS=1.16u PD=2.16u rfmode=0
M$14000 \$751 \$755 \$752 VSS sg13_lv_nmos L=0.13u W=0.42u AS=0.1296p
+ AD=0.0798p PS=1.52u PD=0.8u rfmode=0
M$14001 \$752 \$754 \$828 VSS sg13_lv_nmos L=0.13u W=0.42u AS=0.0798p
+ AD=0.2373p PS=0.8u PD=1.97u rfmode=0
M$14002 \$754 \$755 VSS VSS sg13_lv_nmos L=0.13u W=0.74u AS=0.2516p
+ AD=0.317325p PS=2.16u PD=1.805u rfmode=0
M$14003 VSS \$417 \$755 VSS sg13_lv_nmos L=0.13u W=0.74u AS=0.317325p
+ AD=0.2516p PS=1.805u PD=2.16u rfmode=0
M$14004 \$829 \$755 \$756 VSS sg13_lv_nmos L=0.13u W=0.42u AS=0.1428p
+ AD=0.12665p PS=1.52u PD=1.145u rfmode=0
M$14005 \$756 \$754 \$753 VSS sg13_lv_nmos L=0.13u W=0.74u AS=0.12665p
+ AD=0.3473p PS=1.145u PD=2.71u rfmode=0
M$14006 \$758 \$756 VSS VSS sg13_lv_nmos L=0.13u W=0.74u AS=0.2516p AD=0.1406p
+ PS=2.16u PD=1.12u rfmode=0
M$14007 VSS \$758 \$590 VSS sg13_lv_nmos L=0.13u W=0.74u AS=0.1406p AD=0.2516p
+ PS=1.12u PD=2.16u rfmode=0
M$14008 VSS \$760 \$759 VSS sg13_lv_nmos L=0.5u W=0.42u AS=0.1426p AD=0.1428p
+ PS=1.16u PD=1.52u rfmode=0
M$14009 \$472 \$759 VSS VSS sg13_lv_nmos L=0.13u W=0.74u AS=0.2516p AD=0.1426p
+ PS=2.16u PD=1.16u rfmode=0
M$14010 VSS \$226 \$762 VSS sg13_lv_nmos L=0.13u W=4.44u AS=0.9546p AD=0.8436p
+ PS=7.76u PD=6.72u rfmode=0
M$14016 VSS \$762 \$763 VSS sg13_lv_nmos L=0.13u W=11.84u AS=2.2496p AD=2.3606p
+ PS=17.92u PD=18.96u rfmode=0
M$14032 \$483 \$486 \$591 VSS sg13_lv_nmos L=0.13u W=0.42u AS=0.1296p
+ AD=0.0798p PS=1.52u PD=0.8u rfmode=0
M$14033 \$591 \$592 \$485 VSS sg13_lv_nmos L=0.13u W=0.42u AS=0.0798p
+ AD=0.2373p PS=0.8u PD=1.97u rfmode=0
M$14034 VSS \$486 \$592 VSS sg13_lv_nmos L=0.13u W=0.74u AS=0.317325p
+ AD=0.2516p PS=1.805u PD=2.16u rfmode=0
M$14035 VSS \$763 \$486 VSS sg13_lv_nmos L=0.13u W=0.74u AS=0.317325p
+ AD=0.2516p PS=1.805u PD=2.16u rfmode=0
M$14036 VSS \$764 \$765 VSS sg13_lv_nmos L=0.13u W=0.55u AS=0.14875p AD=0.187p
+ PS=1.16u PD=1.78u rfmode=0
M$14037 \$323 \$765 VSS VSS sg13_lv_nmos L=0.13u W=0.74u AS=0.2886p AD=0.14875p
+ PS=2.26u PD=1.16u rfmode=0
M$14038 \$768 \$767 VSS VSS sg13_lv_nmos L=0.5u W=0.42u AS=0.1428p AD=0.1426p
+ PS=1.52u PD=1.16u rfmode=0
M$14039 VSS \$768 \$305 VSS sg13_lv_nmos L=0.13u W=0.74u AS=0.1426p AD=0.2516p
+ PS=1.16u PD=2.16u rfmode=0
M$14040 \$769 \$773 \$770 VSS sg13_lv_nmos L=0.13u W=0.42u AS=0.1296p
+ AD=0.0798p PS=1.52u PD=0.8u rfmode=0
M$14041 \$770 \$772 \$830 VSS sg13_lv_nmos L=0.13u W=0.42u AS=0.0798p
+ AD=0.2373p PS=0.8u PD=1.97u rfmode=0
M$14042 \$772 \$773 VSS VSS sg13_lv_nmos L=0.13u W=0.74u AS=0.2516p
+ AD=0.317325p PS=2.16u PD=1.805u rfmode=0
M$14043 VSS \$763 \$773 VSS sg13_lv_nmos L=0.13u W=0.74u AS=0.317325p
+ AD=0.2516p PS=1.805u PD=2.16u rfmode=0
M$14044 \$831 \$773 \$774 VSS sg13_lv_nmos L=0.13u W=0.42u AS=0.1428p
+ AD=0.12665p PS=1.52u PD=1.145u rfmode=0
M$14045 \$774 \$772 \$771 VSS sg13_lv_nmos L=0.13u W=0.74u AS=0.12665p
+ AD=0.3473p PS=1.145u PD=2.71u rfmode=0
M$14046 \$776 \$774 VSS VSS sg13_lv_nmos L=0.13u W=0.74u AS=0.2516p AD=0.1406p
+ PS=2.16u PD=1.12u rfmode=0
M$14047 VSS \$776 \$503 VSS sg13_lv_nmos L=0.13u W=0.74u AS=0.1406p AD=0.2516p
+ PS=1.12u PD=2.16u rfmode=0
M$14048 VSS \$503 \$778 VSS sg13_lv_nmos L=0.13u W=0.55u AS=0.14875p AD=0.187p
+ PS=1.16u PD=1.78u rfmode=0
M$14049 dout[9] \$778 VSS VSS sg13_lv_nmos L=0.13u W=0.74u AS=0.2886p
+ AD=0.14875p PS=2.26u PD=1.16u rfmode=0
M$14050 VSS \$764 \$779 VSS sg13_lv_nmos L=0.13u W=0.55u AS=0.14875p AD=0.187p
+ PS=1.16u PD=1.78u rfmode=0
M$14051 \$74 \$779 VSS VSS sg13_lv_nmos L=0.13u W=0.74u AS=0.2886p AD=0.14875p
+ PS=2.26u PD=1.16u rfmode=0
M$14052 VSS \$781 \$780 VSS sg13_lv_nmos L=0.5u W=0.42u AS=0.1426p AD=0.1428p
+ PS=1.16u PD=1.52u rfmode=0
M$14053 \$511 \$780 VSS VSS sg13_lv_nmos L=0.13u W=0.74u AS=0.2516p AD=0.1426p
+ PS=2.16u PD=1.16u rfmode=0
M$14054 \$783 \$787 \$784 VSS sg13_lv_nmos L=0.13u W=0.42u AS=0.1296p
+ AD=0.0798p PS=1.52u PD=0.8u rfmode=0
M$14055 \$784 \$786 \$832 VSS sg13_lv_nmos L=0.13u W=0.42u AS=0.0798p
+ AD=0.2373p PS=0.8u PD=1.97u rfmode=0
M$14056 \$786 \$787 VSS VSS sg13_lv_nmos L=0.13u W=0.74u AS=0.2516p
+ AD=0.317325p PS=2.16u PD=1.805u rfmode=0
M$14057 VSS \$763 \$787 VSS sg13_lv_nmos L=0.13u W=0.74u AS=0.317325p
+ AD=0.2516p PS=1.805u PD=2.16u rfmode=0
M$14058 \$833 \$787 \$788 VSS sg13_lv_nmos L=0.13u W=0.42u AS=0.1428p
+ AD=0.12665p PS=1.52u PD=1.145u rfmode=0
M$14059 \$788 \$786 \$785 VSS sg13_lv_nmos L=0.13u W=0.74u AS=0.12665p
+ AD=0.3473p PS=1.145u PD=2.71u rfmode=0
M$14060 \$517 \$520 \$593 VSS sg13_lv_nmos L=0.13u W=0.42u AS=0.1296p
+ AD=0.0798p PS=1.52u PD=0.8u rfmode=0
M$14061 \$593 \$594 \$519 VSS sg13_lv_nmos L=0.13u W=0.42u AS=0.0798p
+ AD=0.2373p PS=0.8u PD=1.97u rfmode=0
M$14062 \$790 \$788 VSS VSS sg13_lv_nmos L=0.13u W=0.74u AS=0.2516p AD=0.1406p
+ PS=2.16u PD=1.12u rfmode=0
M$14063 VSS \$790 \$791 VSS sg13_lv_nmos L=0.13u W=0.74u AS=0.1406p AD=0.2516p
+ PS=1.12u PD=2.16u rfmode=0
M$14064 VSS \$520 \$594 VSS sg13_lv_nmos L=0.13u W=0.74u AS=0.317325p
+ AD=0.2516p PS=1.805u PD=2.16u rfmode=0
M$14065 VSS \$763 \$520 VSS sg13_lv_nmos L=0.13u W=0.74u AS=0.317325p
+ AD=0.2516p PS=1.805u PD=2.16u rfmode=0
M$14078 VSS \$791 \$793 VSS sg13_lv_nmos L=0.13u W=0.55u AS=0.14875p AD=0.187p
+ PS=1.16u PD=1.78u rfmode=0
M$14079 dout[10] \$793 VSS VSS sg13_lv_nmos L=0.13u W=0.74u AS=0.2886p
+ AD=0.14875p PS=2.26u PD=1.16u rfmode=0
M$14104 VSS \$525 \$795 VSS sg13_lv_nmos L=0.13u W=0.55u AS=0.14875p AD=0.187p
+ PS=1.16u PD=1.78u rfmode=0
M$14105 dout[11] \$795 VSS VSS sg13_lv_nmos L=0.13u W=0.74u AS=0.2886p
+ AD=0.14875p PS=2.26u PD=1.16u rfmode=0
M$14121 VSS \$668 \$669 VSS sg13_lv_nmos L=0.13u W=0.74u AS=0.1626p AD=0.2516p
+ PS=1.415u PD=2.16u rfmode=0
M$14122 \$667 \$352 \$853 VSS sg13_lv_nmos L=0.13u W=0.42u AS=0.1428p
+ AD=0.0609p PS=1.52u PD=0.71u rfmode=0
M$14123 VSS \$351 \$853 VSS sg13_lv_nmos L=0.13u W=0.42u AS=0.1626p AD=0.0609p
+ PS=1.415u PD=0.71u rfmode=0
M$14124 VSS \$351 \$854 VSS sg13_lv_nmos L=0.13u W=0.42u AS=0.1701p AD=0.0378p
+ PS=1.65u PD=0.6u rfmode=0
M$14125 \$854 \$669 \$814 VSS sg13_lv_nmos L=0.13u W=0.42u AS=0.0378p
+ AD=0.1428p PS=0.6u PD=1.52u rfmode=0
M$14126 \$815 \$673 VSS VSS sg13_lv_nmos L=0.13u W=0.42u AS=0.1428p AD=0.0798p
+ PS=1.52u PD=0.8u rfmode=0
M$14127 VSS \$351 \$855 VSS sg13_lv_nmos L=0.13u W=0.42u AS=0.0798p AD=0.0378p
+ PS=0.8u PD=0.6u rfmode=0
M$14128 \$855 \$672 \$673 VSS sg13_lv_nmos L=0.13u W=0.42u AS=0.0378p
+ AD=0.1428p PS=0.6u PD=1.52u rfmode=0
M$14129 \$678 \$359 VSS VSS sg13_lv_nmos L=0.13u W=0.42u AS=0.1428p AD=0.0798p
+ PS=1.52u PD=0.8u rfmode=0
M$14130 VSS \$678 \$679 VSS sg13_lv_nmos L=0.5u W=0.42u AS=0.0798p AD=0.1428p
+ PS=0.8u PD=1.52u rfmode=0
M$14131 VSS \$683 \$684 VSS sg13_lv_nmos L=0.13u W=0.74u AS=0.1626p AD=0.2516p
+ PS=1.415u PD=2.16u rfmode=0
M$14132 \$682 \$681 \$856 VSS sg13_lv_nmos L=0.13u W=0.42u AS=0.1428p
+ AD=0.0609p PS=1.52u PD=0.71u rfmode=0
M$14133 VSS \$363 \$856 VSS sg13_lv_nmos L=0.13u W=0.42u AS=0.1626p AD=0.0609p
+ PS=1.415u PD=0.71u rfmode=0
M$14134 VSS \$363 \$857 VSS sg13_lv_nmos L=0.13u W=0.42u AS=0.1701p AD=0.0378p
+ PS=1.65u PD=0.6u rfmode=0
M$14135 \$857 \$684 \$816 VSS sg13_lv_nmos L=0.13u W=0.42u AS=0.0378p
+ AD=0.1428p PS=0.6u PD=1.52u rfmode=0
M$14136 \$817 \$688 VSS VSS sg13_lv_nmos L=0.13u W=0.42u AS=0.1428p AD=0.0798p
+ PS=1.52u PD=0.8u rfmode=0
M$14137 VSS \$363 \$858 VSS sg13_lv_nmos L=0.13u W=0.42u AS=0.0798p AD=0.0378p
+ PS=0.8u PD=0.6u rfmode=0
M$14138 \$858 \$687 \$688 VSS sg13_lv_nmos L=0.13u W=0.42u AS=0.0378p
+ AD=0.1428p PS=0.6u PD=1.52u rfmode=0
M$14139 \$691 \$818 \$862 VSS sg13_lv_nmos L=0.13u W=0.42u AS=0.1428p
+ AD=0.0378p PS=1.52u PD=0.6u rfmode=0
M$14140 \$862 \$192 VSS VSS sg13_lv_nmos L=0.13u W=0.42u AS=0.0378p AD=0.0798p
+ PS=0.6u PD=0.8u rfmode=0
M$14141 VSS \$691 \$819 VSS sg13_lv_nmos L=0.13u W=0.42u AS=0.0798p AD=0.1428p
+ PS=0.8u PD=1.52u rfmode=0
M$14142 \$820 \$696 \$863 VSS sg13_lv_nmos L=0.13u W=0.42u AS=0.1428p
+ AD=0.0378p PS=1.52u PD=0.6u rfmode=0
M$14143 \$863 \$192 VSS VSS sg13_lv_nmos L=0.13u W=0.42u AS=0.0378p AD=0.1701p
+ PS=0.6u PD=1.65u rfmode=0
M$14144 \$700 \$698 VSS VSS sg13_lv_nmos L=0.13u W=0.42u AS=0.1428p AD=0.0798p
+ PS=1.52u PD=0.8u rfmode=0
M$14145 VSS \$700 \$701 VSS sg13_lv_nmos L=0.5u W=0.42u AS=0.0798p AD=0.1428p
+ PS=0.8u PD=1.52u rfmode=0
M$14146 \$704 \$821 \$865 VSS sg13_lv_nmos L=0.13u W=0.42u AS=0.1428p
+ AD=0.0378p PS=1.52u PD=0.6u rfmode=0
M$14147 \$865 \$380 VSS VSS sg13_lv_nmos L=0.13u W=0.42u AS=0.0378p AD=0.0798p
+ PS=0.6u PD=0.8u rfmode=0
M$14148 VSS \$704 \$822 VSS sg13_lv_nmos L=0.13u W=0.42u AS=0.0798p AD=0.1428p
+ PS=0.8u PD=1.52u rfmode=0
M$14149 \$823 \$709 \$866 VSS sg13_lv_nmos L=0.13u W=0.42u AS=0.1428p
+ AD=0.0378p PS=1.52u PD=0.6u rfmode=0
M$14150 \$866 \$380 VSS VSS sg13_lv_nmos L=0.13u W=0.42u AS=0.0378p AD=0.1701p
+ PS=0.6u PD=1.65u rfmode=0
M$14151 \$711 \$402 VSS VSS sg13_lv_nmos L=0.13u W=0.42u AS=0.1428p AD=0.0798p
+ PS=1.52u PD=0.8u rfmode=0
M$14152 VSS \$711 \$712 VSS sg13_lv_nmos L=0.5u W=0.42u AS=0.0798p AD=0.1428p
+ PS=0.8u PD=1.52u rfmode=0
M$14153 VSS \$716 \$717 VSS sg13_lv_nmos L=0.13u W=0.74u AS=0.1626p AD=0.2516p
+ PS=1.415u PD=2.16u rfmode=0
M$14154 \$715 \$714 \$868 VSS sg13_lv_nmos L=0.13u W=0.42u AS=0.1428p
+ AD=0.0609p PS=1.52u PD=0.71u rfmode=0
M$14155 VSS \$401 \$868 VSS sg13_lv_nmos L=0.13u W=0.42u AS=0.1626p AD=0.0609p
+ PS=1.415u PD=0.71u rfmode=0
M$14156 VSS \$401 \$869 VSS sg13_lv_nmos L=0.13u W=0.42u AS=0.1701p AD=0.0378p
+ PS=1.65u PD=0.6u rfmode=0
M$14157 \$869 \$717 \$824 VSS sg13_lv_nmos L=0.13u W=0.42u AS=0.0378p
+ AD=0.1428p PS=0.6u PD=1.52u rfmode=0
M$14158 \$825 \$721 VSS VSS sg13_lv_nmos L=0.13u W=0.42u AS=0.1428p AD=0.0798p
+ PS=1.52u PD=0.8u rfmode=0
M$14159 VSS \$401 \$870 VSS sg13_lv_nmos L=0.13u W=0.42u AS=0.0798p AD=0.0378p
+ PS=0.8u PD=0.6u rfmode=0
M$14160 \$870 \$720 \$721 VSS sg13_lv_nmos L=0.13u W=0.42u AS=0.0378p
+ AD=0.1428p PS=0.6u PD=1.52u rfmode=0
M$14161 \$724 \$725 VSS VSS sg13_lv_nmos L=0.5u W=0.42u AS=0.1428p AD=0.0798p
+ PS=1.52u PD=0.8u rfmode=0
M$14162 VSS \$214 \$725 VSS sg13_lv_nmos L=0.13u W=0.42u AS=0.0798p AD=0.1428p
+ PS=0.8u PD=1.52u rfmode=0
M$14164 \$726 \$424 VSS VSS sg13_lv_nmos L=0.13u W=0.42u AS=0.1428p AD=0.0798p
+ PS=1.52u PD=0.8u rfmode=0
M$14165 VSS \$726 \$727 VSS sg13_lv_nmos L=0.5u W=0.42u AS=0.0798p AD=0.1428p
+ PS=0.8u PD=1.52u rfmode=0
M$14166 VSS \$731 \$732 VSS sg13_lv_nmos L=0.13u W=0.74u AS=0.1626p AD=0.2516p
+ PS=1.415u PD=2.16u rfmode=0
M$14167 \$730 \$729 \$873 VSS sg13_lv_nmos L=0.13u W=0.42u AS=0.1428p
+ AD=0.0609p PS=1.52u PD=0.71u rfmode=0
M$14168 VSS \$422 \$873 VSS sg13_lv_nmos L=0.13u W=0.42u AS=0.1626p AD=0.0609p
+ PS=1.415u PD=0.71u rfmode=0
M$14169 VSS \$422 \$872 VSS sg13_lv_nmos L=0.13u W=0.42u AS=0.1701p AD=0.0378p
+ PS=1.65u PD=0.6u rfmode=0
M$14170 \$872 \$732 \$826 VSS sg13_lv_nmos L=0.13u W=0.42u AS=0.0378p
+ AD=0.1428p PS=0.6u PD=1.52u rfmode=0
M$14171 \$827 \$736 VSS VSS sg13_lv_nmos L=0.13u W=0.42u AS=0.1428p AD=0.0798p
+ PS=1.52u PD=0.8u rfmode=0
M$14172 VSS \$422 \$871 VSS sg13_lv_nmos L=0.13u W=0.42u AS=0.0798p AD=0.0378p
+ PS=0.8u PD=0.6u rfmode=0
M$14173 \$871 \$735 \$736 VSS sg13_lv_nmos L=0.13u W=0.42u AS=0.0378p
+ AD=0.1428p PS=0.6u PD=1.52u rfmode=0
M$14174 \$739 \$740 VSS VSS sg13_lv_nmos L=0.5u W=0.42u AS=0.1428p AD=0.0798p
+ PS=1.52u PD=0.8u rfmode=0
M$14175 VSS \$227 \$740 VSS sg13_lv_nmos L=0.13u W=0.42u AS=0.0798p AD=0.1428p
+ PS=0.8u PD=1.52u rfmode=0
M$14177 \$741 \$303 VSS VSS sg13_lv_nmos L=0.13u W=0.42u AS=0.1428p AD=0.0798p
+ PS=1.52u PD=0.8u rfmode=0
M$14178 VSS \$741 \$742 VSS sg13_lv_nmos L=0.5u W=0.42u AS=0.0798p AD=0.1428p
+ PS=0.8u PD=1.52u rfmode=0
M$14180 \$747 \$470 VSS VSS sg13_lv_nmos L=0.13u W=0.42u AS=0.1428p AD=0.0798p
+ PS=1.52u PD=0.8u rfmode=0
M$14181 VSS \$747 \$748 VSS sg13_lv_nmos L=0.5u W=0.42u AS=0.0798p AD=0.1428p
+ PS=0.8u PD=1.52u rfmode=0
M$14182 VSS \$752 \$753 VSS sg13_lv_nmos L=0.13u W=0.74u AS=0.1626p AD=0.2516p
+ PS=1.415u PD=2.16u rfmode=0
M$14183 \$751 \$750 \$861 VSS sg13_lv_nmos L=0.13u W=0.42u AS=0.1428p
+ AD=0.0609p PS=1.52u PD=0.71u rfmode=0
M$14184 VSS \$474 \$861 VSS sg13_lv_nmos L=0.13u W=0.42u AS=0.1626p AD=0.0609p
+ PS=1.415u PD=0.71u rfmode=0
M$14185 VSS \$474 \$860 VSS sg13_lv_nmos L=0.13u W=0.42u AS=0.1701p AD=0.0378p
+ PS=1.65u PD=0.6u rfmode=0
M$14186 \$860 \$753 \$828 VSS sg13_lv_nmos L=0.13u W=0.42u AS=0.0378p
+ AD=0.1428p PS=0.6u PD=1.52u rfmode=0
M$14187 \$829 \$757 VSS VSS sg13_lv_nmos L=0.13u W=0.42u AS=0.1428p AD=0.0798p
+ PS=1.52u PD=0.8u rfmode=0
M$14188 VSS \$474 \$859 VSS sg13_lv_nmos L=0.13u W=0.42u AS=0.0798p AD=0.0378p
+ PS=0.8u PD=0.6u rfmode=0
M$14189 \$859 \$756 \$757 VSS sg13_lv_nmos L=0.13u W=0.42u AS=0.0378p
+ AD=0.1428p PS=0.6u PD=1.52u rfmode=0
M$14190 \$760 \$761 VSS VSS sg13_lv_nmos L=0.5u W=0.42u AS=0.1428p AD=0.0798p
+ PS=1.52u PD=0.8u rfmode=0
M$14191 VSS \$590 \$761 VSS sg13_lv_nmos L=0.13u W=0.42u AS=0.0798p AD=0.1428p
+ PS=0.8u PD=1.52u rfmode=0
M$14192 \$766 \$493 VSS VSS sg13_lv_nmos L=0.13u W=0.42u AS=0.1428p AD=0.0798p
+ PS=1.52u PD=0.8u rfmode=0
M$14193 VSS \$766 \$767 VSS sg13_lv_nmos L=0.5u W=0.42u AS=0.0798p AD=0.1428p
+ PS=0.8u PD=1.52u rfmode=0
M$14194 VSS \$770 \$771 VSS sg13_lv_nmos L=0.13u W=0.74u AS=0.1626p AD=0.2516p
+ PS=1.415u PD=2.16u rfmode=0
M$14195 \$769 \$495 \$852 VSS sg13_lv_nmos L=0.13u W=0.42u AS=0.1428p
+ AD=0.0609p PS=1.52u PD=0.71u rfmode=0
M$14196 VSS \$505 \$852 VSS sg13_lv_nmos L=0.13u W=0.42u AS=0.1626p AD=0.0609p
+ PS=1.415u PD=0.71u rfmode=0
M$14197 VSS \$505 \$851 VSS sg13_lv_nmos L=0.13u W=0.42u AS=0.1701p AD=0.0378p
+ PS=1.65u PD=0.6u rfmode=0
M$14198 \$851 \$771 \$830 VSS sg13_lv_nmos L=0.13u W=0.42u AS=0.0378p
+ AD=0.1428p PS=0.6u PD=1.52u rfmode=0
M$14199 \$831 \$775 VSS VSS sg13_lv_nmos L=0.13u W=0.42u AS=0.1428p AD=0.0798p
+ PS=1.52u PD=0.8u rfmode=0
M$14200 VSS \$505 \$850 VSS sg13_lv_nmos L=0.13u W=0.42u AS=0.0798p AD=0.0378p
+ PS=0.8u PD=0.6u rfmode=0
M$14201 \$850 \$774 \$775 VSS sg13_lv_nmos L=0.13u W=0.42u AS=0.0378p
+ AD=0.1428p PS=0.6u PD=1.52u rfmode=0
M$14203 \$781 \$782 VSS VSS sg13_lv_nmos L=0.5u W=0.42u AS=0.1428p AD=0.0798p
+ PS=1.52u PD=0.8u rfmode=0
M$14204 VSS \$791 \$782 VSS sg13_lv_nmos L=0.13u W=0.42u AS=0.0798p AD=0.1428p
+ PS=0.8u PD=1.52u rfmode=0
M$14205 VSS \$784 \$785 VSS sg13_lv_nmos L=0.13u W=0.74u AS=0.1626p AD=0.2516p
+ PS=1.415u PD=2.16u rfmode=0
M$14206 \$783 \$512 \$849 VSS sg13_lv_nmos L=0.13u W=0.42u AS=0.1428p
+ AD=0.0609p PS=1.52u PD=0.71u rfmode=0
M$14207 VSS \$514 \$849 VSS sg13_lv_nmos L=0.13u W=0.42u AS=0.1626p AD=0.0609p
+ PS=1.415u PD=0.71u rfmode=0
M$14208 VSS \$514 \$848 VSS sg13_lv_nmos L=0.13u W=0.42u AS=0.1701p AD=0.0378p
+ PS=1.65u PD=0.6u rfmode=0
M$14209 \$848 \$785 \$832 VSS sg13_lv_nmos L=0.13u W=0.42u AS=0.0378p
+ AD=0.1428p PS=0.6u PD=1.52u rfmode=0
M$14210 \$833 \$789 VSS VSS sg13_lv_nmos L=0.13u W=0.42u AS=0.1428p AD=0.0798p
+ PS=1.52u PD=0.8u rfmode=0
M$14211 VSS \$514 \$847 VSS sg13_lv_nmos L=0.13u W=0.42u AS=0.0798p AD=0.0378p
+ PS=0.8u PD=0.6u rfmode=0
M$14212 \$847 \$788 \$789 VSS sg13_lv_nmos L=0.13u W=0.42u AS=0.0378p
+ AD=0.1428p PS=0.6u PD=1.52u rfmode=0
M$14214 VDD reset \$5 VDD sg13_lv_pmos L=0.13u W=0.84u AS=0.2114p AD=0.2856p
+ PS=1.54u PD=2.36u rfmode=0
M$14215 VDD \$5 \$6 VDD sg13_lv_pmos L=0.13u W=1.12u AS=0.2114p AD=0.42p
+ PS=1.54u PD=2.99u rfmode=0
M$14216 VDD VSS VDD VDD sg13_lv_pmos L=1u W=13368u AS=3544.92p AD=3544.92p
+ PS=27157.84u PD=27157.84u rfmode=0
M$16098 VDD done_in \$14 VDD sg13_lv_pmos L=0.13u W=0.84u AS=0.2114p AD=0.2856p
+ PS=1.54u PD=2.36u rfmode=0
M$16099 \$13 \$14 VDD VDD sg13_lv_pmos L=0.13u W=1.12u AS=0.42p AD=0.2114p
+ PS=2.99u PD=1.54u rfmode=0
M$21437 \$32 \$33 VDD VDD sg13_lv_pmos L=0.13u W=1.12u AS=0.42p AD=0.2114p
+ PS=2.99u PD=1.54u rfmode=0
M$21438 VDD shift_in \$33 VDD sg13_lv_pmos L=0.13u W=0.84u AS=0.2114p
+ AD=0.2856p PS=1.54u PD=2.36u rfmode=0
M$26555 VDD \$58 \$52 VDD sg13_lv_pmos L=0.13u W=1.12u AS=0.3808p AD=0.3808p
+ PS=2.92u PD=2.92u rfmode=0
M$26585 VDD \$322 \$53 VDD sg13_lv_pmos L=0.13u W=0.84u AS=0.2114p AD=0.2856p
+ PS=1.54u PD=2.36u rfmode=0
M$26586 \$58 \$53 VDD VDD sg13_lv_pmos L=0.13u W=1.12u AS=0.42p AD=0.2114p
+ PS=2.99u PD=1.54u rfmode=0
M$26605 VDD \$322 \$54 VDD sg13_lv_pmos L=0.13u W=1.12u AS=0.3808p AD=0.3808p
+ PS=2.92u PD=2.92u rfmode=0
M$26714 \$764 \$71 \$57 VDD sg13_lv_pmos L=0.13u W=1.12u AS=0.3808p AD=0.1176p
+ PS=2.92u PD=1.33u rfmode=0
M$26715 \$57 \$55 VDD VDD sg13_lv_pmos L=0.13u W=1.12u AS=0.1176p AD=0.2618p
+ PS=1.33u PD=1.63u rfmode=0
M$26716 VDD \$32 \$55 VDD sg13_lv_pmos L=0.13u W=0.84u AS=0.2618p AD=0.2856p
+ PS=1.63u PD=2.36u rfmode=0
M$26717 VDD \$13 \$56 VDD sg13_lv_pmos L=0.13u W=0.84u AS=0.2114p AD=0.2856p
+ PS=1.54u PD=2.36u rfmode=0
M$26718 \$71 \$56 VDD VDD sg13_lv_pmos L=0.13u W=1.12u AS=0.42p AD=0.2114p
+ PS=2.99u PD=1.54u rfmode=0
M$26862 \$66 \$58 VDD VDD sg13_lv_pmos L=0.13u W=1.12u AS=0.3808p AD=0.3808p
+ PS=2.92u PD=2.92u rfmode=0
M$26864 VDD \$71 \$72 VDD sg13_lv_pmos L=0.13u W=0.84u AS=0.253p AD=0.2856p
+ PS=1.53u PD=2.36u rfmode=0
M$26865 VDD \$72 \$159 VDD sg13_lv_pmos L=0.13u W=1u AS=0.2198p AD=0.2975p
+ PS=1.52u PD=1.595u rfmode=0
M$26866 \$159 \$69 \$68 VDD sg13_lv_pmos L=0.13u W=1u AS=0.2975p AD=0.2225p
+ PS=1.595u PD=1.445u rfmode=0
M$26867 \$68 \$70 \$160 VDD sg13_lv_pmos L=0.13u W=1u AS=0.2225p AD=0.3325p
+ PS=1.445u PD=1.665u rfmode=0
M$26868 \$160 \$71 VDD VDD sg13_lv_pmos L=0.13u W=1u AS=0.3325p AD=0.253p
+ PS=1.665u PD=1.53u rfmode=0
M$26869 \$67 \$68 VDD VDD sg13_lv_pmos L=0.13u W=1.12u AS=0.6048p AD=0.2198p
+ PS=3.32u PD=1.52u rfmode=0
M$26870 \$73 \$74 VDD VDD sg13_lv_pmos L=0.13u W=0.84u AS=0.2856p AD=0.253p
+ PS=2.36u PD=1.53u rfmode=0
M$26871 VDD \$74 \$162 VDD sg13_lv_pmos L=0.13u W=1u AS=0.253p AD=0.3325p
+ PS=1.53u PD=1.665u rfmode=0
M$26872 \$162 \$76 \$75 VDD sg13_lv_pmos L=0.13u W=1u AS=0.3325p AD=0.2225p
+ PS=1.665u PD=1.445u rfmode=0
M$26873 \$75 \$69 \$164 VDD sg13_lv_pmos L=0.13u W=1u AS=0.2225p AD=0.2975p
+ PS=1.445u PD=1.595u rfmode=0
M$26874 \$164 \$73 VDD VDD sg13_lv_pmos L=0.13u W=1u AS=0.2975p AD=0.2198p
+ PS=1.595u PD=1.52u rfmode=0
M$26875 VDD \$75 \$77 VDD sg13_lv_pmos L=0.13u W=1.12u AS=0.2198p AD=0.6048p
+ PS=1.52u PD=3.32u rfmode=0
M$26876 VDD \$77 \$81 VDD sg13_lv_pmos L=0.13u W=0.42u AS=0.1428p AD=0.0798p
+ PS=1.52u PD=0.8u rfmode=0
M$26877 VDD \$52 \$81 VDD sg13_lv_pmos L=0.13u W=0.42u AS=0.3623875p AD=0.0798p
+ PS=2.605u PD=0.8u rfmode=0
M$26878 VDD \$78 \$79 VDD sg13_lv_pmos L=0.13u W=1u AS=0.3623875p AD=0.34p
+ PS=2.605u PD=2.68u rfmode=0
M$26879 \$83 \$82 VDD VDD sg13_lv_pmos L=0.13u W=1.12u AS=0.3864p AD=0.41165p
+ PS=2.93u PD=2.12u rfmode=0
M$26880 VDD \$204 \$82 VDD sg13_lv_pmos L=0.13u W=1.12u AS=0.41165p AD=0.4088p
+ PS=2.12u PD=2.97u rfmode=0
M$26881 \$85 \$83 \$151 VDD sg13_lv_pmos L=0.13u W=0.42u AS=0.2048p AD=0.09345p
+ PS=1.63u PD=0.865u rfmode=0
M$26882 \$151 \$86 VDD VDD sg13_lv_pmos L=0.13u W=0.42u AS=0.09345p AD=0.204p
+ PS=0.865u PD=1.835u rfmode=0
M$26883 VDD \$52 \$86 VDD sg13_lv_pmos L=0.13u W=0.42u AS=0.204p AD=0.0798p
+ PS=1.835u PD=0.8u rfmode=0
M$26884 \$86 \$85 VDD VDD sg13_lv_pmos L=0.13u W=0.42u AS=0.0798p AD=0.4659p
+ PS=0.8u PD=3.65u rfmode=0
M$26885 \$79 \$82 \$85 VDD sg13_lv_pmos L=0.13u W=1u AS=0.34p AD=0.2048p
+ PS=2.68u PD=1.63u rfmode=0
M$26886 \$87 \$85 VDD VDD sg13_lv_pmos L=0.13u W=1.12u AS=0.3864p AD=0.2128p
+ PS=2.93u PD=1.5u rfmode=0
M$26887 VDD \$87 \$88 VDD sg13_lv_pmos L=0.13u W=1.12u AS=0.2128p AD=0.3808p
+ PS=1.5u PD=2.92u rfmode=0
M$26888 VDD \$58 \$89 VDD sg13_lv_pmos L=0.13u W=1.12u AS=0.3808p AD=0.3808p
+ PS=2.92u PD=2.92u rfmode=0
M$26893 \$90 \$74 VDD VDD sg13_lv_pmos L=0.13u W=0.84u AS=0.2856p AD=0.253p
+ PS=2.36u PD=1.53u rfmode=0
M$26894 VDD \$74 \$163 VDD sg13_lv_pmos L=0.13u W=1u AS=0.253p AD=0.3325p
+ PS=1.53u PD=1.665u rfmode=0
M$26895 \$163 \$369 \$91 VDD sg13_lv_pmos L=0.13u W=1u AS=0.3325p AD=0.2225p
+ PS=1.665u PD=1.445u rfmode=0
M$26896 \$91 \$361 \$161 VDD sg13_lv_pmos L=0.13u W=1u AS=0.2225p AD=0.2975p
+ PS=1.445u PD=1.595u rfmode=0
M$26897 \$161 \$90 VDD VDD sg13_lv_pmos L=0.13u W=1u AS=0.2975p AD=0.2198p
+ PS=1.595u PD=1.52u rfmode=0
M$26898 VDD \$91 \$92 VDD sg13_lv_pmos L=0.13u W=1.12u AS=0.2198p AD=0.6048p
+ PS=1.52u PD=3.32u rfmode=0
M$26911 VDD \$95 \$94 VDD sg13_lv_pmos L=0.5u W=1u AS=0.2254p AD=0.34p PS=1.53u
+ PD=2.68u rfmode=0
M$26912 \$69 \$94 VDD VDD sg13_lv_pmos L=0.13u W=1.12u AS=0.4256p AD=0.2254p
+ PS=3u PD=1.53u rfmode=0
M$26913 VDD \$97 \$96 VDD sg13_lv_pmos L=0.13u W=0.42u AS=0.1523p AD=0.1428p
+ PS=1.38u PD=1.52u rfmode=0
M$26914 \$95 \$96 VDD VDD sg13_lv_pmos L=0.5u W=1u AS=0.34p AD=0.1523p PS=2.68u
+ PD=1.38u rfmode=0
M$26915 VDD \$93 \$98 VDD sg13_lv_pmos L=0.13u W=0.42u AS=0.1523p AD=0.1428p
+ PS=1.38u PD=1.52u rfmode=0
M$26916 VDD \$98 \$99 VDD sg13_lv_pmos L=0.5u W=1u AS=0.1523p AD=0.34p PS=1.38u
+ PD=2.68u rfmode=0
M$26917 \$100 \$99 VDD VDD sg13_lv_pmos L=0.5u W=1u AS=0.34p AD=0.2254p
+ PS=2.68u PD=1.53u rfmode=0
M$26918 VDD \$100 \$101 VDD sg13_lv_pmos L=0.13u W=1.12u AS=0.2254p AD=0.4256p
+ PS=1.53u PD=3u rfmode=0
M$26923 VDD \$299 \$102 VDD sg13_lv_pmos L=0.13u W=0.42u AS=0.1523p AD=0.1428p
+ PS=1.38u PD=1.52u rfmode=0
M$26924 VDD \$102 \$103 VDD sg13_lv_pmos L=0.5u W=1u AS=0.1523p AD=0.34p
+ PS=1.38u PD=2.68u rfmode=0
M$26925 \$104 \$103 VDD VDD sg13_lv_pmos L=0.5u W=1u AS=0.34p AD=0.2254p
+ PS=2.68u PD=1.53u rfmode=0
M$26926 VDD \$104 \$105 VDD sg13_lv_pmos L=0.13u W=1.12u AS=0.2254p AD=0.4256p
+ PS=1.53u PD=3u rfmode=0
M$26934 \$106 \$74 VDD VDD sg13_lv_pmos L=0.13u W=0.84u AS=0.2856p AD=0.253p
+ PS=2.36u PD=1.53u rfmode=0
M$26935 VDD \$74 \$158 VDD sg13_lv_pmos L=0.13u W=1u AS=0.253p AD=0.3325p
+ PS=1.53u PD=1.665u rfmode=0
M$26936 \$158 \$69 \$107 VDD sg13_lv_pmos L=0.13u W=1u AS=0.3325p AD=0.2225p
+ PS=1.665u PD=1.445u rfmode=0
M$26937 \$107 \$108 \$157 VDD sg13_lv_pmos L=0.13u W=1u AS=0.2225p AD=0.2975p
+ PS=1.445u PD=1.595u rfmode=0
M$26938 \$157 \$106 VDD VDD sg13_lv_pmos L=0.13u W=1u AS=0.2975p AD=0.2198p
+ PS=1.595u PD=1.52u rfmode=0
M$26939 VDD \$107 \$109 VDD sg13_lv_pmos L=0.13u W=1.12u AS=0.2198p AD=0.6048p
+ PS=1.52u PD=3.32u rfmode=0
M$26940 VDD \$109 \$113 VDD sg13_lv_pmos L=0.13u W=0.42u AS=0.1428p AD=0.0798p
+ PS=1.52u PD=0.8u rfmode=0
M$26941 VDD \$54 \$113 VDD sg13_lv_pmos L=0.13u W=0.42u AS=0.3623875p
+ AD=0.0798p PS=2.605u PD=0.8u rfmode=0
M$26942 VDD \$110 \$111 VDD sg13_lv_pmos L=0.13u W=1u AS=0.3623875p AD=0.34p
+ PS=2.605u PD=2.68u rfmode=0
M$26943 \$115 \$114 VDD VDD sg13_lv_pmos L=0.13u W=1.12u AS=0.3864p AD=0.41165p
+ PS=2.93u PD=2.12u rfmode=0
M$26944 VDD \$204 \$114 VDD sg13_lv_pmos L=0.13u W=1.12u AS=0.41165p AD=0.4088p
+ PS=2.12u PD=2.97u rfmode=0
M$26945 \$117 \$115 \$150 VDD sg13_lv_pmos L=0.13u W=0.42u AS=0.2048p
+ AD=0.09345p PS=1.63u PD=0.865u rfmode=0
M$26946 \$150 \$118 VDD VDD sg13_lv_pmos L=0.13u W=0.42u AS=0.09345p AD=0.204p
+ PS=0.865u PD=1.835u rfmode=0
M$26947 VDD \$54 \$118 VDD sg13_lv_pmos L=0.13u W=0.42u AS=0.204p AD=0.0798p
+ PS=1.835u PD=0.8u rfmode=0
M$26948 \$118 \$117 VDD VDD sg13_lv_pmos L=0.13u W=0.42u AS=0.0798p AD=0.4659p
+ PS=0.8u PD=3.65u rfmode=0
M$26949 \$111 \$114 \$117 VDD sg13_lv_pmos L=0.13u W=1u AS=0.34p AD=0.2048p
+ PS=2.68u PD=1.63u rfmode=0
M$26950 \$119 \$117 VDD VDD sg13_lv_pmos L=0.13u W=1.12u AS=0.3864p AD=0.2128p
+ PS=2.93u PD=1.5u rfmode=0
M$26951 VDD \$119 \$97 VDD sg13_lv_pmos L=0.13u W=1.12u AS=0.2128p AD=0.3808p
+ PS=1.5u PD=2.92u rfmode=0
M$26978 \$121 \$122 VDD VDD sg13_lv_pmos L=0.13u W=1.12u AS=0.3808p AD=0.3808p
+ PS=2.92u PD=2.92u rfmode=0
M$27042 VDD \$120 \$123 VDD sg13_lv_pmos L=0.13u W=1.12u AS=0.3808p AD=0.3808p
+ PS=2.92u PD=2.92u rfmode=0
M$27043 VDD \$6 \$124 VDD sg13_lv_pmos L=0.13u W=0.84u AS=0.2114p AD=0.2856p
+ PS=1.54u PD=2.36u rfmode=0
M$27044 VDD \$124 \$120 VDD sg13_lv_pmos L=0.13u W=1.12u AS=0.2114p AD=0.42p
+ PS=1.54u PD=2.99u rfmode=0
M$27054 VDD \$120 \$125 VDD sg13_lv_pmos L=0.13u W=1.12u AS=0.3808p AD=0.3808p
+ PS=2.92u PD=2.92u rfmode=0
M$27061 VDD \$128 \$127 VDD sg13_lv_pmos L=0.5u W=1u AS=0.2254p AD=0.34p
+ PS=1.53u PD=2.68u rfmode=0
M$27062 \$126 \$127 VDD VDD sg13_lv_pmos L=0.13u W=1.12u AS=0.4256p AD=0.2254p
+ PS=3u PD=1.53u rfmode=0
M$27063 VDD \$130 \$129 VDD sg13_lv_pmos L=0.13u W=0.42u AS=0.1523p AD=0.1428p
+ PS=1.38u PD=1.52u rfmode=0
M$27064 \$128 \$129 VDD VDD sg13_lv_pmos L=0.5u W=1u AS=0.34p AD=0.1523p
+ PS=2.68u PD=1.38u rfmode=0
M$27117 \$108 \$131 VDD VDD sg13_lv_pmos L=0.13u W=1.12u AS=0.42p AD=0.2114p
+ PS=2.99u PD=1.54u rfmode=0
M$27118 VDD data_in \$131 VDD sg13_lv_pmos L=0.13u W=0.84u AS=0.2114p
+ AD=0.2856p PS=1.54u PD=2.36u rfmode=0
M$27201 VDD \$67 \$166 VDD sg13_lv_pmos L=0.13u W=0.42u AS=0.1428p AD=0.0798p
+ PS=1.52u PD=0.8u rfmode=0
M$27202 VDD \$66 \$166 VDD sg13_lv_pmos L=0.13u W=0.42u AS=0.3623875p
+ AD=0.0798p PS=2.605u PD=0.8u rfmode=0
M$27203 VDD \$167 \$168 VDD sg13_lv_pmos L=0.13u W=1u AS=0.3623875p AD=0.34p
+ PS=2.605u PD=2.68u rfmode=0
M$27204 VDD \$170 \$169 VDD sg13_lv_pmos L=0.13u W=1.12u AS=0.41165p AD=0.3864p
+ PS=2.12u PD=2.93u rfmode=0
M$27205 VDD \$204 \$170 VDD sg13_lv_pmos L=0.13u W=1.12u AS=0.41165p AD=0.4088p
+ PS=2.12u PD=2.97u rfmode=0
M$27206 \$168 \$170 \$171 VDD sg13_lv_pmos L=0.13u W=1u AS=0.34p AD=0.2048p
+ PS=2.68u PD=1.63u rfmode=0
M$27207 \$171 \$169 \$271 VDD sg13_lv_pmos L=0.13u W=0.42u AS=0.2048p
+ AD=0.09345p PS=1.63u PD=0.865u rfmode=0
M$27208 VDD \$172 \$271 VDD sg13_lv_pmos L=0.13u W=0.42u AS=0.204p AD=0.09345p
+ PS=1.835u PD=0.865u rfmode=0
M$27209 VDD \$66 \$172 VDD sg13_lv_pmos L=0.13u W=0.42u AS=0.204p AD=0.0798p
+ PS=1.835u PD=0.8u rfmode=0
M$27210 VDD \$171 \$172 VDD sg13_lv_pmos L=0.13u W=0.42u AS=0.4659p AD=0.0798p
+ PS=3.65u PD=0.8u rfmode=0
M$27211 \$173 \$171 VDD VDD sg13_lv_pmos L=0.13u W=1.12u AS=0.3864p AD=0.2128p
+ PS=2.93u PD=1.5u rfmode=0
M$27212 VDD \$173 \$165 VDD sg13_lv_pmos L=0.13u W=1.12u AS=0.2128p AD=0.3808p
+ PS=1.5u PD=2.92u rfmode=0
M$27213 \$70 \$174 VDD VDD sg13_lv_pmos L=0.13u W=1.12u AS=0.4256p AD=0.2254p
+ PS=3u PD=1.53u rfmode=0
M$27214 VDD \$175 \$174 VDD sg13_lv_pmos L=0.5u W=1u AS=0.2254p AD=0.34p
+ PS=1.53u PD=2.68u rfmode=0
M$27215 VDD \$165 \$176 VDD sg13_lv_pmos L=0.13u W=0.42u AS=0.1523p AD=0.1428p
+ PS=1.38u PD=1.52u rfmode=0
M$27216 \$175 \$176 VDD VDD sg13_lv_pmos L=0.5u W=1u AS=0.34p AD=0.1523p
+ PS=2.68u PD=1.38u rfmode=0
M$27217 \$78 \$52 VDD VDD sg13_lv_pmos L=0.13u W=0.42u AS=0.147p AD=0.1563p
+ PS=1.54u PD=1.22u rfmode=0
M$27218 VDD \$79 \$149 VDD sg13_lv_pmos L=0.13u W=0.42u AS=0.1563p AD=0.063p
+ PS=1.22u PD=0.72u rfmode=0
M$27219 \$149 \$82 \$78 VDD sg13_lv_pmos L=0.13u W=0.42u AS=0.063p AD=0.0798p
+ PS=0.72u PD=0.8u rfmode=0
M$27220 \$78 \$83 \$81 VDD sg13_lv_pmos L=0.13u W=0.42u AS=0.0798p AD=0.1428p
+ PS=0.8u PD=1.52u rfmode=0
M$27221 \$76 \$177 VDD VDD sg13_lv_pmos L=0.13u W=1.12u AS=0.4256p AD=0.2254p
+ PS=3u PD=1.53u rfmode=0
M$27222 VDD \$178 \$177 VDD sg13_lv_pmos L=0.5u W=1u AS=0.2254p AD=0.34p
+ PS=1.53u PD=2.68u rfmode=0
M$27223 VDD \$88 \$179 VDD sg13_lv_pmos L=0.13u W=0.42u AS=0.1523p AD=0.1428p
+ PS=1.38u PD=1.52u rfmode=0
M$27224 \$178 \$179 VDD VDD sg13_lv_pmos L=0.5u W=1u AS=0.34p AD=0.1523p
+ PS=2.68u PD=1.38u rfmode=0
M$27225 VDD \$182 \$183 VDD sg13_lv_pmos L=0.13u W=0.42u AS=0.1428p AD=0.0798p
+ PS=1.52u PD=0.8u rfmode=0
M$27226 VDD \$89 \$183 VDD sg13_lv_pmos L=0.13u W=0.42u AS=0.3623875p
+ AD=0.0798p PS=2.605u PD=0.8u rfmode=0
M$27227 VDD \$184 \$185 VDD sg13_lv_pmos L=0.13u W=1u AS=0.3623875p AD=0.34p
+ PS=2.605u PD=2.68u rfmode=0
M$27228 VDD \$187 \$186 VDD sg13_lv_pmos L=0.13u W=1.12u AS=0.41165p AD=0.3864p
+ PS=2.12u PD=2.93u rfmode=0
M$27229 VDD \$204 \$187 VDD sg13_lv_pmos L=0.13u W=1.12u AS=0.41165p AD=0.4088p
+ PS=2.12u PD=2.97u rfmode=0
M$27230 \$185 \$187 \$188 VDD sg13_lv_pmos L=0.13u W=1u AS=0.34p AD=0.2048p
+ PS=2.68u PD=1.63u rfmode=0
M$27231 \$188 \$186 \$275 VDD sg13_lv_pmos L=0.13u W=0.42u AS=0.2048p
+ AD=0.09345p PS=1.63u PD=0.865u rfmode=0
M$27232 VDD \$189 \$275 VDD sg13_lv_pmos L=0.13u W=0.42u AS=0.204p AD=0.09345p
+ PS=1.835u PD=0.865u rfmode=0
M$27233 VDD \$89 \$189 VDD sg13_lv_pmos L=0.13u W=0.42u AS=0.204p AD=0.0798p
+ PS=1.835u PD=0.8u rfmode=0
M$27234 VDD \$188 \$189 VDD sg13_lv_pmos L=0.13u W=0.42u AS=0.4659p AD=0.0798p
+ PS=3.65u PD=0.8u rfmode=0
M$27235 \$190 \$188 VDD VDD sg13_lv_pmos L=0.13u W=1.12u AS=0.3864p AD=0.2128p
+ PS=2.93u PD=1.5u rfmode=0
M$27236 VDD \$190 \$191 VDD sg13_lv_pmos L=0.13u W=1.12u AS=0.2128p AD=0.3808p
+ PS=1.5u PD=2.92u rfmode=0
M$27237 VDD \$58 \$192 VDD sg13_lv_pmos L=0.13u W=1.12u AS=0.3808p AD=0.3808p
+ PS=2.92u PD=2.92u rfmode=0
M$27238 VDD \$58 \$193 VDD sg13_lv_pmos L=0.13u W=1.12u AS=0.3808p AD=0.3808p
+ PS=2.92u PD=2.92u rfmode=0
M$27239 VDD \$92 \$194 VDD sg13_lv_pmos L=0.13u W=0.42u AS=0.1428p AD=0.0798p
+ PS=1.52u PD=0.8u rfmode=0
M$27240 VDD \$193 \$194 VDD sg13_lv_pmos L=0.13u W=0.42u AS=0.3623875p
+ AD=0.0798p PS=2.605u PD=0.8u rfmode=0
M$27241 VDD \$195 \$196 VDD sg13_lv_pmos L=0.13u W=1u AS=0.3623875p AD=0.34p
+ PS=2.605u PD=2.68u rfmode=0
M$27242 VDD \$198 \$197 VDD sg13_lv_pmos L=0.13u W=1.12u AS=0.41165p AD=0.3864p
+ PS=2.12u PD=2.93u rfmode=0
M$27243 VDD \$204 \$198 VDD sg13_lv_pmos L=0.13u W=1.12u AS=0.41165p AD=0.4088p
+ PS=2.12u PD=2.97u rfmode=0
M$27244 \$196 \$198 \$199 VDD sg13_lv_pmos L=0.13u W=1u AS=0.34p AD=0.2048p
+ PS=2.68u PD=1.63u rfmode=0
M$27245 \$199 \$197 \$277 VDD sg13_lv_pmos L=0.13u W=0.42u AS=0.2048p
+ AD=0.09345p PS=1.63u PD=0.865u rfmode=0
M$27246 VDD \$200 \$277 VDD sg13_lv_pmos L=0.13u W=0.42u AS=0.204p AD=0.09345p
+ PS=1.835u PD=0.865u rfmode=0
M$27247 VDD \$193 \$200 VDD sg13_lv_pmos L=0.13u W=0.42u AS=0.204p AD=0.0798p
+ PS=1.835u PD=0.8u rfmode=0
M$27248 VDD \$199 \$200 VDD sg13_lv_pmos L=0.13u W=0.42u AS=0.4659p AD=0.0798p
+ PS=3.65u PD=0.8u rfmode=0
M$27249 \$201 \$199 VDD VDD sg13_lv_pmos L=0.13u W=1.12u AS=0.3864p AD=0.2128p
+ PS=2.93u PD=1.5u rfmode=0
M$27250 VDD \$201 \$297 VDD sg13_lv_pmos L=0.13u W=1.12u AS=0.2128p AD=0.3808p
+ PS=1.5u PD=2.92u rfmode=0
M$27251 VDD \$205 \$204 VDD sg13_lv_pmos L=0.13u W=17.92u AS=3.5896p AD=3.4048p
+ PS=25.45u PD=24u rfmode=0
M$27267 VDD \$226 \$205 VDD sg13_lv_pmos L=0.13u W=6.72u AS=1.2768p AD=1.4448p
+ PS=9u PD=10.42u rfmode=0
M$27274 \$209 \$210 VDD VDD sg13_lv_pmos L=0.13u W=1.12u AS=0.4256p AD=0.2254p
+ PS=3u PD=1.53u rfmode=0
M$27275 VDD \$211 \$210 VDD sg13_lv_pmos L=0.5u W=1u AS=0.2254p AD=0.34p
+ PS=1.53u PD=2.68u rfmode=0
M$27276 VDD \$208 \$212 VDD sg13_lv_pmos L=0.13u W=0.42u AS=0.1523p AD=0.1428p
+ PS=1.38u PD=1.52u rfmode=0
M$27277 \$211 \$212 VDD VDD sg13_lv_pmos L=0.5u W=1u AS=0.34p AD=0.1523p
+ PS=2.68u PD=1.38u rfmode=0
M$27287 \$110 \$54 VDD VDD sg13_lv_pmos L=0.13u W=0.42u AS=0.147p AD=0.1563p
+ PS=1.54u PD=1.22u rfmode=0
M$27288 VDD \$111 \$152 VDD sg13_lv_pmos L=0.13u W=0.42u AS=0.1563p AD=0.063p
+ PS=1.22u PD=0.72u rfmode=0
M$27289 \$152 \$114 \$110 VDD sg13_lv_pmos L=0.13u W=0.42u AS=0.063p AD=0.0798p
+ PS=0.72u PD=0.8u rfmode=0
M$27290 \$110 \$115 \$113 VDD sg13_lv_pmos L=0.13u W=0.42u AS=0.0798p
+ AD=0.1428p PS=0.8u PD=1.52u rfmode=0
M$27291 VDD \$214 \$215 VDD sg13_lv_pmos L=0.13u W=0.84u AS=0.2114p AD=0.2856p
+ PS=1.54u PD=2.36u rfmode=0
M$27292 dout[5] \$215 VDD VDD sg13_lv_pmos L=0.13u W=1.12u AS=0.42p AD=0.2114p
+ PS=2.99u PD=1.54u rfmode=0
M$27297 VDD \$322 \$216 VDD sg13_lv_pmos L=0.13u W=1.12u AS=0.3808p AD=0.3808p
+ PS=2.92u PD=2.92u rfmode=0
M$27298 \$218 \$219 VDD VDD sg13_lv_pmos L=0.13u W=1.12u AS=0.4256p AD=0.2254p
+ PS=3u PD=1.53u rfmode=0
M$27299 VDD \$220 \$219 VDD sg13_lv_pmos L=0.5u W=1u AS=0.2254p AD=0.34p
+ PS=1.53u PD=2.68u rfmode=0
M$27300 VDD \$217 \$221 VDD sg13_lv_pmos L=0.13u W=0.42u AS=0.1523p AD=0.1428p
+ PS=1.38u PD=1.52u rfmode=0
M$27301 \$220 \$221 VDD VDD sg13_lv_pmos L=0.5u W=1u AS=0.34p AD=0.1523p
+ PS=2.68u PD=1.38u rfmode=0
M$27319 VDD \$223 \$224 VDD sg13_lv_pmos L=0.13u W=0.84u AS=0.2114p AD=0.2856p
+ PS=1.54u PD=2.36u rfmode=0
M$27320 dout[6] \$224 VDD VDD sg13_lv_pmos L=0.13u W=1.12u AS=0.42p AD=0.2114p
+ PS=2.99u PD=1.54u rfmode=0
M$27324 VDD clk \$225 VDD sg13_lv_pmos L=0.13u W=6.72u AS=1.4448p AD=1.2768p
+ PS=10.42u PD=9u rfmode=0
M$27330 VDD \$225 \$226 VDD sg13_lv_pmos L=0.13u W=17.92u AS=3.4048p AD=3.5896p
+ PS=24u PD=25.45u rfmode=0
M$27355 \$227 \$302 VDD VDD sg13_lv_pmos L=0.13u W=1.12u AS=0.6048p AD=0.2198p
+ PS=3.32u PD=1.52u rfmode=0
M$27356 VDD \$228 \$282 VDD sg13_lv_pmos L=0.13u W=1u AS=0.2198p AD=0.2975p
+ PS=1.52u PD=1.595u rfmode=0
M$27357 \$282 \$303 \$302 VDD sg13_lv_pmos L=0.13u W=1u AS=0.2975p AD=0.2225p
+ PS=1.595u PD=1.445u rfmode=0
M$27358 \$302 \$229 \$284 VDD sg13_lv_pmos L=0.13u W=1u AS=0.2225p AD=0.3325p
+ PS=1.445u PD=1.665u rfmode=0
M$27359 \$284 \$268 VDD VDD sg13_lv_pmos L=0.13u W=1u AS=0.3325p AD=0.253p
+ PS=1.665u PD=1.53u rfmode=0
M$27360 VDD \$268 \$228 VDD sg13_lv_pmos L=0.13u W=0.84u AS=0.253p AD=0.2856p
+ PS=1.53u PD=2.36u rfmode=0
M$27363 \$229 \$230 VDD VDD sg13_lv_pmos L=0.13u W=1.12u AS=0.4256p AD=0.2254p
+ PS=3u PD=1.53u rfmode=0
M$27364 VDD \$231 \$230 VDD sg13_lv_pmos L=0.5u W=1u AS=0.2254p AD=0.34p
+ PS=1.53u PD=2.68u rfmode=0
M$27365 VDD \$304 \$232 VDD sg13_lv_pmos L=0.13u W=0.42u AS=0.1523p AD=0.1428p
+ PS=1.38u PD=1.52u rfmode=0
M$27366 \$231 \$232 VDD VDD sg13_lv_pmos L=0.5u W=1u AS=0.34p AD=0.1523p
+ PS=2.68u PD=1.38u rfmode=0
M$27379 VDD \$122 \$233 VDD sg13_lv_pmos L=0.13u W=1.12u AS=0.3808p AD=0.3808p
+ PS=2.92u PD=2.92u rfmode=0
M$27397 VDD \$122 \$234 VDD sg13_lv_pmos L=0.13u W=1.12u AS=0.3808p AD=0.3808p
+ PS=2.92u PD=2.92u rfmode=0
M$27398 \$235 \$236 VDD VDD sg13_lv_pmos L=0.13u W=1.12u AS=0.4256p AD=0.2254p
+ PS=3u PD=1.53u rfmode=0
M$27399 VDD \$237 \$236 VDD sg13_lv_pmos L=0.5u W=1u AS=0.2254p AD=0.34p
+ PS=1.53u PD=2.68u rfmode=0
M$27400 VDD \$482 \$238 VDD sg13_lv_pmos L=0.13u W=0.42u AS=0.1523p AD=0.1428p
+ PS=1.38u PD=1.52u rfmode=0
M$27401 \$237 \$238 VDD VDD sg13_lv_pmos L=0.5u W=1u AS=0.34p AD=0.1523p
+ PS=2.68u PD=1.38u rfmode=0
M$27407 VDD \$242 \$243 VDD sg13_lv_pmos L=0.13u W=0.42u AS=0.1428p AD=0.0798p
+ PS=1.52u PD=0.8u rfmode=0
M$27408 VDD \$123 \$243 VDD sg13_lv_pmos L=0.13u W=0.42u AS=0.3623875p
+ AD=0.0798p PS=2.605u PD=0.8u rfmode=0
M$27409 VDD \$244 \$245 VDD sg13_lv_pmos L=0.13u W=1u AS=0.3623875p AD=0.34p
+ PS=2.605u PD=2.68u rfmode=0
M$27410 VDD \$247 \$246 VDD sg13_lv_pmos L=0.13u W=1.12u AS=0.41165p AD=0.3864p
+ PS=2.12u PD=2.93u rfmode=0
M$27411 VDD \$763 \$247 VDD sg13_lv_pmos L=0.13u W=1.12u AS=0.41165p AD=0.4088p
+ PS=2.12u PD=2.97u rfmode=0
M$27412 \$245 \$247 \$248 VDD sg13_lv_pmos L=0.13u W=1u AS=0.34p AD=0.2048p
+ PS=2.68u PD=1.63u rfmode=0
M$27413 \$248 \$246 \$288 VDD sg13_lv_pmos L=0.13u W=0.42u AS=0.2048p
+ AD=0.09345p PS=1.63u PD=0.865u rfmode=0
M$27414 VDD \$249 \$288 VDD sg13_lv_pmos L=0.13u W=0.42u AS=0.204p AD=0.09345p
+ PS=1.835u PD=0.865u rfmode=0
M$27415 VDD \$123 \$249 VDD sg13_lv_pmos L=0.13u W=0.42u AS=0.204p AD=0.0798p
+ PS=1.835u PD=0.8u rfmode=0
M$27416 VDD \$248 \$249 VDD sg13_lv_pmos L=0.13u W=0.42u AS=0.4659p AD=0.0798p
+ PS=3.65u PD=0.8u rfmode=0
M$27417 \$250 \$248 VDD VDD sg13_lv_pmos L=0.13u W=1.12u AS=0.3864p AD=0.2128p
+ PS=2.93u PD=1.5u rfmode=0
M$27418 VDD \$250 \$251 VDD sg13_lv_pmos L=0.13u W=1.12u AS=0.2128p AD=0.3808p
+ PS=1.5u PD=2.92u rfmode=0
M$27419 VDD \$255 \$256 VDD sg13_lv_pmos L=0.13u W=0.42u AS=0.1428p AD=0.0798p
+ PS=1.52u PD=0.8u rfmode=0
M$27420 VDD \$125 \$256 VDD sg13_lv_pmos L=0.13u W=0.42u AS=0.3623875p
+ AD=0.0798p PS=2.605u PD=0.8u rfmode=0
M$27421 VDD \$257 \$258 VDD sg13_lv_pmos L=0.13u W=1u AS=0.3623875p AD=0.34p
+ PS=2.605u PD=2.68u rfmode=0
M$27422 VDD \$260 \$259 VDD sg13_lv_pmos L=0.13u W=1.12u AS=0.41165p AD=0.3864p
+ PS=2.12u PD=2.93u rfmode=0
M$27423 VDD \$763 \$260 VDD sg13_lv_pmos L=0.13u W=1.12u AS=0.41165p AD=0.4088p
+ PS=2.12u PD=2.97u rfmode=0
M$27424 \$258 \$260 \$261 VDD sg13_lv_pmos L=0.13u W=1u AS=0.34p AD=0.2048p
+ PS=2.68u PD=1.63u rfmode=0
M$27425 \$261 \$259 \$283 VDD sg13_lv_pmos L=0.13u W=0.42u AS=0.2048p
+ AD=0.09345p PS=1.63u PD=0.865u rfmode=0
M$27426 VDD \$262 \$283 VDD sg13_lv_pmos L=0.13u W=0.42u AS=0.204p AD=0.09345p
+ PS=1.835u PD=0.865u rfmode=0
M$27427 VDD \$125 \$262 VDD sg13_lv_pmos L=0.13u W=0.42u AS=0.204p AD=0.0798p
+ PS=1.835u PD=0.8u rfmode=0
M$27428 VDD \$261 \$262 VDD sg13_lv_pmos L=0.13u W=0.42u AS=0.4659p AD=0.0798p
+ PS=3.65u PD=0.8u rfmode=0
M$27429 \$263 \$261 VDD VDD sg13_lv_pmos L=0.13u W=1.12u AS=0.3864p AD=0.2128p
+ PS=2.93u PD=1.5u rfmode=0
M$27430 VDD \$263 \$264 VDD sg13_lv_pmos L=0.13u W=1.12u AS=0.2128p AD=0.3808p
+ PS=1.5u PD=2.92u rfmode=0
M$27431 \$254 \$265 VDD VDD sg13_lv_pmos L=0.13u W=1.12u AS=0.4256p AD=0.2254p
+ PS=3u PD=1.53u rfmode=0
M$27432 VDD \$266 \$265 VDD sg13_lv_pmos L=0.5u W=1u AS=0.2254p AD=0.34p
+ PS=1.53u PD=2.68u rfmode=0
M$27433 VDD \$264 \$267 VDD sg13_lv_pmos L=0.13u W=0.42u AS=0.1523p AD=0.1428p
+ PS=1.38u PD=1.52u rfmode=0
M$27434 \$266 \$267 VDD VDD sg13_lv_pmos L=0.5u W=1u AS=0.34p AD=0.1523p
+ PS=2.68u PD=1.38u rfmode=0
M$27435 VDD \$13 \$269 VDD sg13_lv_pmos L=0.13u W=0.84u AS=0.2114p AD=0.2856p
+ PS=1.54u PD=2.36u rfmode=0
M$27436 \$268 \$269 VDD VDD sg13_lv_pmos L=0.13u W=1.12u AS=0.42p AD=0.2114p
+ PS=2.99u PD=1.54u rfmode=0
M$27573 VDD \$66 \$167 VDD sg13_lv_pmos L=0.13u W=0.42u AS=0.1563p AD=0.147p
+ PS=1.22u PD=1.54u rfmode=0
M$27574 VDD \$168 \$270 VDD sg13_lv_pmos L=0.13u W=0.42u AS=0.1563p AD=0.063p
+ PS=1.22u PD=0.72u rfmode=0
M$27575 \$270 \$170 \$167 VDD sg13_lv_pmos L=0.13u W=0.42u AS=0.063p AD=0.0798p
+ PS=0.72u PD=0.8u rfmode=0
M$27576 \$167 \$169 \$166 VDD sg13_lv_pmos L=0.13u W=0.42u AS=0.0798p
+ AD=0.1428p PS=0.8u PD=1.52u rfmode=0
M$27577 \$351 \$58 VDD VDD sg13_lv_pmos L=0.13u W=1.12u AS=0.3808p AD=0.3808p
+ PS=2.92u PD=2.92u rfmode=0
M$27578 VDD \$354 \$353 VDD sg13_lv_pmos L=0.5u W=1u AS=0.2254p AD=0.34p
+ PS=1.53u PD=2.68u rfmode=0
M$27579 \$352 \$353 VDD VDD sg13_lv_pmos L=0.13u W=1.12u AS=0.4256p AD=0.2254p
+ PS=3u PD=1.53u rfmode=0
M$27580 VDD \$356 \$355 VDD sg13_lv_pmos L=0.13u W=0.42u AS=0.1523p AD=0.1428p
+ PS=1.38u PD=1.52u rfmode=0
M$27581 \$354 \$355 VDD VDD sg13_lv_pmos L=0.5u W=1u AS=0.34p AD=0.1523p
+ PS=2.68u PD=1.38u rfmode=0
M$27582 VDD \$71 \$358 VDD sg13_lv_pmos L=0.13u W=0.84u AS=0.253p AD=0.2856p
+ PS=1.53u PD=2.36u rfmode=0
M$27583 VDD \$358 \$627 VDD sg13_lv_pmos L=0.13u W=1u AS=0.2198p AD=0.2975p
+ PS=1.52u PD=1.595u rfmode=0
M$27584 \$627 \$76 \$357 VDD sg13_lv_pmos L=0.13u W=1u AS=0.2975p AD=0.2225p
+ PS=1.595u PD=1.445u rfmode=0
M$27585 \$357 \$662 \$628 VDD sg13_lv_pmos L=0.13u W=1u AS=0.2225p AD=0.3325p
+ PS=1.445u PD=1.665u rfmode=0
M$27586 \$628 \$71 VDD VDD sg13_lv_pmos L=0.13u W=1u AS=0.3325p AD=0.253p
+ PS=1.665u PD=1.53u rfmode=0
M$27587 \$356 \$357 VDD VDD sg13_lv_pmos L=0.13u W=1.12u AS=0.6048p AD=0.2198p
+ PS=3.32u PD=1.52u rfmode=0
M$27590 VDD \$71 \$362 VDD sg13_lv_pmos L=0.13u W=0.84u AS=0.253p AD=0.2856p
+ PS=1.53u PD=2.36u rfmode=0
M$27591 VDD \$362 \$632 VDD sg13_lv_pmos L=0.13u W=1u AS=0.2198p AD=0.2975p
+ PS=1.52u PD=1.595u rfmode=0
M$27592 \$632 \$361 \$360 VDD sg13_lv_pmos L=0.13u W=1u AS=0.2975p AD=0.2225p
+ PS=1.595u PD=1.445u rfmode=0
M$27593 \$360 \$665 \$634 VDD sg13_lv_pmos L=0.13u W=1u AS=0.2225p AD=0.3325p
+ PS=1.445u PD=1.665u rfmode=0
M$27594 \$634 \$71 VDD VDD sg13_lv_pmos L=0.13u W=1u AS=0.3325p AD=0.253p
+ PS=1.665u PD=1.53u rfmode=0
M$27595 \$359 \$360 VDD VDD sg13_lv_pmos L=0.13u W=1.12u AS=0.6048p AD=0.2198p
+ PS=3.32u PD=1.52u rfmode=0
M$27596 VDD \$74 \$180 VDD sg13_lv_pmos L=0.13u W=0.84u AS=0.253p AD=0.2856p
+ PS=1.53u PD=2.36u rfmode=0
M$27597 VDD \$74 \$272 VDD sg13_lv_pmos L=0.13u W=1u AS=0.253p AD=0.3325p
+ PS=1.53u PD=1.665u rfmode=0
M$27598 \$272 \$361 \$181 VDD sg13_lv_pmos L=0.13u W=1u AS=0.3325p AD=0.2225p
+ PS=1.665u PD=1.445u rfmode=0
M$27599 \$181 \$76 \$273 VDD sg13_lv_pmos L=0.13u W=1u AS=0.2225p AD=0.2975p
+ PS=1.445u PD=1.595u rfmode=0
M$27600 VDD \$180 \$273 VDD sg13_lv_pmos L=0.13u W=1u AS=0.2198p AD=0.2975p
+ PS=1.52u PD=1.595u rfmode=0
M$27601 VDD \$181 \$182 VDD sg13_lv_pmos L=0.13u W=1.12u AS=0.2198p AD=0.6048p
+ PS=1.52u PD=3.32u rfmode=0
M$27602 \$363 \$58 VDD VDD sg13_lv_pmos L=0.13u W=1.12u AS=0.3808p AD=0.3808p
+ PS=2.92u PD=2.92u rfmode=0
M$27606 VDD \$89 \$184 VDD sg13_lv_pmos L=0.13u W=0.42u AS=0.1563p AD=0.147p
+ PS=1.22u PD=1.54u rfmode=0
M$27607 VDD \$185 \$274 VDD sg13_lv_pmos L=0.13u W=0.42u AS=0.1563p AD=0.063p
+ PS=1.22u PD=0.72u rfmode=0
M$27608 \$274 \$187 \$184 VDD sg13_lv_pmos L=0.13u W=0.42u AS=0.063p AD=0.0798p
+ PS=0.72u PD=0.8u rfmode=0
M$27609 \$184 \$186 \$183 VDD sg13_lv_pmos L=0.13u W=0.42u AS=0.0798p
+ AD=0.1428p PS=0.8u PD=1.52u rfmode=0
M$27610 VDD \$365 \$364 VDD sg13_lv_pmos L=0.5u W=1u AS=0.2254p AD=0.34p
+ PS=1.53u PD=2.68u rfmode=0
M$27611 \$361 \$364 VDD VDD sg13_lv_pmos L=0.13u W=1.12u AS=0.4256p AD=0.2254p
+ PS=3u PD=1.53u rfmode=0
M$27612 VDD \$191 \$366 VDD sg13_lv_pmos L=0.13u W=0.42u AS=0.1523p AD=0.1428p
+ PS=1.38u PD=1.52u rfmode=0
M$27613 \$365 \$366 VDD VDD sg13_lv_pmos L=0.5u W=1u AS=0.34p AD=0.1523p
+ PS=2.68u PD=1.38u rfmode=0
M$27615 \$367 \$71 VDD VDD sg13_lv_pmos L=0.13u W=0.84u AS=0.2856p AD=0.253p
+ PS=2.36u PD=1.53u rfmode=0
M$27616 VDD \$71 \$640 VDD sg13_lv_pmos L=0.13u W=1u AS=0.253p AD=0.3325p
+ PS=1.53u PD=1.665u rfmode=0
M$27617 \$640 \$676 \$368 VDD sg13_lv_pmos L=0.13u W=1u AS=0.3325p AD=0.2225p
+ PS=1.665u PD=1.445u rfmode=0
M$27618 \$368 \$369 \$641 VDD sg13_lv_pmos L=0.13u W=1u AS=0.2225p AD=0.2975p
+ PS=1.445u PD=1.595u rfmode=0
M$27619 \$641 \$367 VDD VDD sg13_lv_pmos L=0.13u W=1u AS=0.2975p AD=0.2198p
+ PS=1.595u PD=1.52u rfmode=0
M$27620 VDD \$368 \$370 VDD sg13_lv_pmos L=0.13u W=1.12u AS=0.2198p AD=0.6048p
+ PS=1.52u PD=3.32u rfmode=0
M$27621 VDD \$370 \$371 VDD sg13_lv_pmos L=0.13u W=0.42u AS=0.1523p AD=0.1428p
+ PS=1.38u PD=1.52u rfmode=0
M$27622 VDD \$371 \$372 VDD sg13_lv_pmos L=0.5u W=1u AS=0.1523p AD=0.34p
+ PS=1.38u PD=2.68u rfmode=0
M$27623 \$373 \$372 VDD VDD sg13_lv_pmos L=0.5u W=1u AS=0.34p AD=0.2254p
+ PS=2.68u PD=1.53u rfmode=0
M$27624 VDD \$373 \$374 VDD sg13_lv_pmos L=0.13u W=1.12u AS=0.2254p AD=0.4256p
+ PS=1.53u PD=3u rfmode=0
M$27626 VDD \$193 \$195 VDD sg13_lv_pmos L=0.13u W=0.42u AS=0.1563p AD=0.147p
+ PS=1.22u PD=1.54u rfmode=0
M$27627 VDD \$196 \$276 VDD sg13_lv_pmos L=0.13u W=0.42u AS=0.1563p AD=0.063p
+ PS=1.22u PD=0.72u rfmode=0
M$27628 \$276 \$198 \$195 VDD sg13_lv_pmos L=0.13u W=0.42u AS=0.063p AD=0.0798p
+ PS=0.72u PD=0.8u rfmode=0
M$27629 \$195 \$197 \$194 VDD sg13_lv_pmos L=0.13u W=0.42u AS=0.0798p
+ AD=0.1428p PS=0.8u PD=1.52u rfmode=0
M$27630 VDD \$376 \$375 VDD sg13_lv_pmos L=0.5u W=1u AS=0.2254p AD=0.34p
+ PS=1.53u PD=2.68u rfmode=0
M$27631 \$369 \$375 VDD VDD sg13_lv_pmos L=0.13u W=1.12u AS=0.4256p AD=0.2254p
+ PS=3u PD=1.53u rfmode=0
M$27632 VDD \$297 \$377 VDD sg13_lv_pmos L=0.13u W=0.42u AS=0.1523p AD=0.1428p
+ PS=1.38u PD=1.52u rfmode=0
M$27633 \$376 \$377 VDD VDD sg13_lv_pmos L=0.5u W=1u AS=0.34p AD=0.1523p
+ PS=2.68u PD=1.38u rfmode=0
M$27637 VDD \$71 \$202 VDD sg13_lv_pmos L=0.13u W=0.84u AS=0.253p AD=0.2856p
+ PS=1.53u PD=2.36u rfmode=0
M$27638 VDD \$71 \$278 VDD sg13_lv_pmos L=0.13u W=1u AS=0.253p AD=0.3325p
+ PS=1.53u PD=1.665u rfmode=0
M$27639 \$278 \$300 \$203 VDD sg13_lv_pmos L=0.13u W=1u AS=0.3325p AD=0.2225p
+ PS=1.665u PD=1.445u rfmode=0
M$27640 \$203 \$299 \$279 VDD sg13_lv_pmos L=0.13u W=1u AS=0.2225p AD=0.2975p
+ PS=1.445u PD=1.595u rfmode=0
M$27641 VDD \$202 \$279 VDD sg13_lv_pmos L=0.13u W=1u AS=0.2198p AD=0.2975p
+ PS=1.52u PD=1.595u rfmode=0
M$27642 VDD \$203 \$93 VDD sg13_lv_pmos L=0.13u W=1.12u AS=0.2198p AD=0.6048p
+ PS=1.52u PD=3.32u rfmode=0
M$27643 \$378 \$74 VDD VDD sg13_lv_pmos L=0.13u W=0.84u AS=0.2856p AD=0.253p
+ PS=2.36u PD=1.53u rfmode=0
M$27644 VDD \$74 \$646 VDD sg13_lv_pmos L=0.13u W=1u AS=0.253p AD=0.3325p
+ PS=1.53u PD=1.665u rfmode=0
M$27645 \$646 \$105 \$379 VDD sg13_lv_pmos L=0.13u W=1u AS=0.3325p AD=0.2225p
+ PS=1.665u PD=1.445u rfmode=0
M$27646 \$379 \$369 \$647 VDD sg13_lv_pmos L=0.13u W=1u AS=0.2225p AD=0.2975p
+ PS=1.445u PD=1.595u rfmode=0
M$27647 \$647 \$378 VDD VDD sg13_lv_pmos L=0.13u W=1u AS=0.2975p AD=0.2198p
+ PS=1.595u PD=1.52u rfmode=0
M$27648 VDD \$379 \$383 VDD sg13_lv_pmos L=0.13u W=1.12u AS=0.2198p AD=0.6048p
+ PS=1.52u PD=3.32u rfmode=0
M$27649 \$380 \$322 VDD VDD sg13_lv_pmos L=0.13u W=1.12u AS=0.3808p AD=0.3808p
+ PS=2.92u PD=2.92u rfmode=0
M$27650 VDD \$58 \$381 VDD sg13_lv_pmos L=0.13u W=1.12u AS=0.3808p AD=0.3808p
+ PS=2.92u PD=2.92u rfmode=0
M$27651 VDD \$383 \$382 VDD sg13_lv_pmos L=0.13u W=0.42u AS=0.1428p AD=0.0798p
+ PS=1.52u PD=0.8u rfmode=0
M$27652 VDD \$381 \$382 VDD sg13_lv_pmos L=0.13u W=0.42u AS=0.3623875p
+ AD=0.0798p PS=2.605u PD=0.8u rfmode=0
M$27653 VDD \$578 \$384 VDD sg13_lv_pmos L=0.13u W=1u AS=0.3623875p AD=0.34p
+ PS=2.605u PD=2.68u rfmode=0
M$27654 \$579 \$386 VDD VDD sg13_lv_pmos L=0.13u W=1.12u AS=0.3864p AD=0.41165p
+ PS=2.93u PD=2.12u rfmode=0
M$27655 VDD \$204 \$386 VDD sg13_lv_pmos L=0.13u W=1.12u AS=0.41165p AD=0.4088p
+ PS=2.12u PD=2.97u rfmode=0
M$27656 \$388 \$579 \$598 VDD sg13_lv_pmos L=0.13u W=0.42u AS=0.2048p
+ AD=0.09345p PS=1.63u PD=0.865u rfmode=0
M$27657 \$598 \$390 VDD VDD sg13_lv_pmos L=0.13u W=0.42u AS=0.09345p AD=0.204p
+ PS=0.865u PD=1.835u rfmode=0
M$27658 VDD \$381 \$390 VDD sg13_lv_pmos L=0.13u W=0.42u AS=0.204p AD=0.0798p
+ PS=1.835u PD=0.8u rfmode=0
M$27659 \$390 \$388 VDD VDD sg13_lv_pmos L=0.13u W=0.42u AS=0.0798p AD=0.4659p
+ PS=0.8u PD=3.65u rfmode=0
M$27660 \$384 \$386 \$388 VDD sg13_lv_pmos L=0.13u W=1u AS=0.34p AD=0.2048p
+ PS=2.68u PD=1.63u rfmode=0
M$27661 \$391 \$388 VDD VDD sg13_lv_pmos L=0.13u W=1.12u AS=0.3864p AD=0.2128p
+ PS=2.93u PD=1.5u rfmode=0
M$27662 VDD \$391 \$299 VDD sg13_lv_pmos L=0.13u W=1.12u AS=0.2128p AD=0.3808p
+ PS=1.5u PD=2.92u rfmode=0
M$27663 VDD \$74 \$206 VDD sg13_lv_pmos L=0.13u W=0.84u AS=0.253p AD=0.2856p
+ PS=1.53u PD=2.36u rfmode=0
M$27664 VDD \$74 \$280 VDD sg13_lv_pmos L=0.13u W=1u AS=0.253p AD=0.3325p
+ PS=1.53u PD=1.665u rfmode=0
M$27665 \$280 \$301 \$207 VDD sg13_lv_pmos L=0.13u W=1u AS=0.3325p AD=0.2225p
+ PS=1.665u PD=1.445u rfmode=0
M$27666 \$207 \$105 \$281 VDD sg13_lv_pmos L=0.13u W=1u AS=0.2225p AD=0.2975p
+ PS=1.445u PD=1.595u rfmode=0
M$27667 VDD \$206 \$281 VDD sg13_lv_pmos L=0.13u W=1u AS=0.2198p AD=0.2975p
+ PS=1.52u PD=1.595u rfmode=0
M$27668 VDD \$207 \$208 VDD sg13_lv_pmos L=0.13u W=1.12u AS=0.2198p AD=0.6048p
+ PS=1.52u PD=3.32u rfmode=0
M$27669 VDD \$322 \$392 VDD sg13_lv_pmos L=0.13u W=1.12u AS=0.3808p AD=0.3808p
+ PS=2.92u PD=2.92u rfmode=0
M$27670 VDD \$209 \$393 VDD sg13_lv_pmos L=0.13u W=0.42u AS=0.1428p AD=0.0798p
+ PS=1.52u PD=0.8u rfmode=0
M$27671 VDD \$392 \$393 VDD sg13_lv_pmos L=0.13u W=0.42u AS=0.3623875p
+ AD=0.0798p PS=2.605u PD=0.8u rfmode=0
M$27672 VDD \$580 \$394 VDD sg13_lv_pmos L=0.13u W=1u AS=0.3623875p AD=0.34p
+ PS=2.605u PD=2.68u rfmode=0
M$27673 \$581 \$396 VDD VDD sg13_lv_pmos L=0.13u W=1.12u AS=0.3864p AD=0.41165p
+ PS=2.93u PD=2.12u rfmode=0
M$27674 VDD \$389 \$396 VDD sg13_lv_pmos L=0.13u W=1.12u AS=0.41165p AD=0.4088p
+ PS=2.12u PD=2.97u rfmode=0
M$27675 \$398 \$581 \$599 VDD sg13_lv_pmos L=0.13u W=0.42u AS=0.2048p
+ AD=0.09345p PS=1.63u PD=0.865u rfmode=0
M$27676 \$599 \$399 VDD VDD sg13_lv_pmos L=0.13u W=0.42u AS=0.09345p AD=0.204p
+ PS=0.865u PD=1.835u rfmode=0
M$27677 VDD \$392 \$399 VDD sg13_lv_pmos L=0.13u W=0.42u AS=0.204p AD=0.0798p
+ PS=1.835u PD=0.8u rfmode=0
M$27678 \$399 \$398 VDD VDD sg13_lv_pmos L=0.13u W=0.42u AS=0.0798p AD=0.4659p
+ PS=0.8u PD=3.65u rfmode=0
M$27679 \$394 \$396 \$398 VDD sg13_lv_pmos L=0.13u W=1u AS=0.34p AD=0.2048p
+ PS=2.68u PD=1.63u rfmode=0
M$27680 \$400 \$398 VDD VDD sg13_lv_pmos L=0.13u W=1.12u AS=0.3864p AD=0.2128p
+ PS=2.93u PD=1.5u rfmode=0
M$27681 VDD \$400 \$301 VDD sg13_lv_pmos L=0.13u W=1.12u AS=0.2128p AD=0.3808p
+ PS=1.5u PD=2.92u rfmode=0
M$27682 VDD \$322 \$401 VDD sg13_lv_pmos L=0.13u W=1.12u AS=0.3808p AD=0.3808p
+ PS=2.92u PD=2.92u rfmode=0
M$27683 VDD \$71 \$405 VDD sg13_lv_pmos L=0.13u W=0.84u AS=0.253p AD=0.2856p
+ PS=1.53u PD=2.36u rfmode=0
M$27684 VDD \$405 \$655 VDD sg13_lv_pmos L=0.13u W=1u AS=0.2198p AD=0.2975p
+ PS=1.52u PD=1.595u rfmode=0
M$27685 \$655 \$301 \$403 VDD sg13_lv_pmos L=0.13u W=1u AS=0.2975p AD=0.2225p
+ PS=1.595u PD=1.445u rfmode=0
M$27686 \$403 \$404 \$654 VDD sg13_lv_pmos L=0.13u W=1u AS=0.2225p AD=0.3325p
+ PS=1.445u PD=1.665u rfmode=0
M$27687 \$654 \$71 VDD VDD sg13_lv_pmos L=0.13u W=1u AS=0.3325p AD=0.253p
+ PS=1.665u PD=1.53u rfmode=0
M$27688 \$402 \$403 VDD VDD sg13_lv_pmos L=0.13u W=1.12u AS=0.6048p AD=0.2198p
+ PS=3.32u PD=1.52u rfmode=0
M$27689 VDD \$301 \$406 VDD sg13_lv_pmos L=0.13u W=0.42u AS=0.1523p AD=0.1428p
+ PS=1.38u PD=1.52u rfmode=0
M$27690 VDD \$406 \$407 VDD sg13_lv_pmos L=0.5u W=1u AS=0.1523p AD=0.34p
+ PS=1.38u PD=2.68u rfmode=0
M$27691 \$408 \$407 VDD VDD sg13_lv_pmos L=0.5u W=1u AS=0.34p AD=0.2254p
+ PS=2.68u PD=1.53u rfmode=0
M$27692 VDD \$408 \$409 VDD sg13_lv_pmos L=0.13u W=1.12u AS=0.2254p AD=0.4256p
+ PS=1.53u PD=3u rfmode=0
M$27694 \$410 \$74 VDD VDD sg13_lv_pmos L=0.13u W=0.84u AS=0.2856p AD=0.253p
+ PS=2.36u PD=1.53u rfmode=0
M$27695 VDD \$74 \$650 VDD sg13_lv_pmos L=0.13u W=1u AS=0.253p AD=0.3325p
+ PS=1.53u PD=1.665u rfmode=0
M$27696 \$650 \$412 \$411 VDD sg13_lv_pmos L=0.13u W=1u AS=0.3325p AD=0.2225p
+ PS=1.665u PD=1.445u rfmode=0
M$27697 \$411 \$409 \$649 VDD sg13_lv_pmos L=0.13u W=1u AS=0.2225p AD=0.2975p
+ PS=1.445u PD=1.595u rfmode=0
M$27698 \$649 \$410 VDD VDD sg13_lv_pmos L=0.13u W=1u AS=0.2975p AD=0.2198p
+ PS=1.595u PD=1.52u rfmode=0
M$27699 VDD \$411 \$217 VDD sg13_lv_pmos L=0.13u W=1.12u AS=0.2198p AD=0.6048p
+ PS=1.52u PD=3.32u rfmode=0
M$27700 VDD \$218 \$413 VDD sg13_lv_pmos L=0.13u W=0.42u AS=0.1428p AD=0.0798p
+ PS=1.52u PD=0.8u rfmode=0
M$27701 VDD \$216 \$413 VDD sg13_lv_pmos L=0.13u W=0.42u AS=0.3623875p
+ AD=0.0798p PS=2.605u PD=0.8u rfmode=0
M$27702 VDD \$582 \$414 VDD sg13_lv_pmos L=0.13u W=1u AS=0.3623875p AD=0.34p
+ PS=2.605u PD=2.68u rfmode=0
M$27703 \$583 \$416 VDD VDD sg13_lv_pmos L=0.13u W=1.12u AS=0.3864p AD=0.41165p
+ PS=2.93u PD=2.12u rfmode=0
M$27704 VDD \$417 \$416 VDD sg13_lv_pmos L=0.13u W=1.12u AS=0.41165p AD=0.4088p
+ PS=2.12u PD=2.97u rfmode=0
M$27705 \$419 \$583 \$601 VDD sg13_lv_pmos L=0.13u W=0.42u AS=0.2048p
+ AD=0.09345p PS=1.63u PD=0.865u rfmode=0
M$27706 \$601 \$420 VDD VDD sg13_lv_pmos L=0.13u W=0.42u AS=0.09345p AD=0.204p
+ PS=0.865u PD=1.835u rfmode=0
M$27707 VDD \$216 \$420 VDD sg13_lv_pmos L=0.13u W=0.42u AS=0.204p AD=0.0798p
+ PS=1.835u PD=0.8u rfmode=0
M$27708 \$420 \$419 VDD VDD sg13_lv_pmos L=0.13u W=0.42u AS=0.0798p AD=0.4659p
+ PS=0.8u PD=3.65u rfmode=0
M$27709 \$414 \$416 \$419 VDD sg13_lv_pmos L=0.13u W=1u AS=0.34p AD=0.2048p
+ PS=2.68u PD=1.63u rfmode=0
M$27710 \$421 \$419 VDD VDD sg13_lv_pmos L=0.13u W=1.12u AS=0.3864p AD=0.2128p
+ PS=2.93u PD=1.5u rfmode=0
M$27711 VDD \$421 \$412 VDD sg13_lv_pmos L=0.13u W=1.12u AS=0.2128p AD=0.3808p
+ PS=1.5u PD=2.92u rfmode=0
M$27716 VDD \$322 \$422 VDD sg13_lv_pmos L=0.13u W=1.12u AS=0.3808p AD=0.3808p
+ PS=2.92u PD=2.92u rfmode=0
M$27717 \$322 \$423 VDD VDD sg13_lv_pmos L=0.13u W=1.12u AS=0.42p AD=0.2114p
+ PS=2.99u PD=1.54u rfmode=0
M$27718 VDD \$120 \$423 VDD sg13_lv_pmos L=0.13u W=0.84u AS=0.2114p AD=0.2856p
+ PS=1.54u PD=2.36u rfmode=0
M$27719 VDD \$71 \$427 VDD sg13_lv_pmos L=0.13u W=0.84u AS=0.253p AD=0.2856p
+ PS=1.53u PD=2.36u rfmode=0
M$27720 VDD \$427 \$643 VDD sg13_lv_pmos L=0.13u W=1u AS=0.2198p AD=0.2975p
+ PS=1.52u PD=1.595u rfmode=0
M$27721 \$643 \$412 \$425 VDD sg13_lv_pmos L=0.13u W=1u AS=0.2975p AD=0.2225p
+ PS=1.595u PD=1.445u rfmode=0
M$27722 \$425 \$426 \$642 VDD sg13_lv_pmos L=0.13u W=1u AS=0.2225p AD=0.3325p
+ PS=1.445u PD=1.665u rfmode=0
M$27723 \$642 \$71 VDD VDD sg13_lv_pmos L=0.13u W=1u AS=0.3325p AD=0.253p
+ PS=1.665u PD=1.53u rfmode=0
M$27724 \$424 \$425 VDD VDD sg13_lv_pmos L=0.13u W=1.12u AS=0.6048p AD=0.2198p
+ PS=3.32u PD=1.52u rfmode=0
M$27725 VDD \$412 \$428 VDD sg13_lv_pmos L=0.13u W=0.42u AS=0.1523p AD=0.1428p
+ PS=1.38u PD=1.52u rfmode=0
M$27726 VDD \$428 \$429 VDD sg13_lv_pmos L=0.5u W=1u AS=0.1523p AD=0.34p
+ PS=1.38u PD=2.68u rfmode=0
M$27727 \$430 \$429 VDD VDD sg13_lv_pmos L=0.5u W=1u AS=0.34p AD=0.2254p
+ PS=2.68u PD=1.53u rfmode=0
M$27728 VDD \$430 \$431 VDD sg13_lv_pmos L=0.13u W=1.12u AS=0.2254p AD=0.4256p
+ PS=1.53u PD=3u rfmode=0
M$27729 VDD \$433 \$432 VDD sg13_lv_pmos L=0.5u W=1u AS=0.2254p AD=0.34p
+ PS=1.53u PD=2.68u rfmode=0
M$27730 \$426 \$432 VDD VDD sg13_lv_pmos L=0.13u W=1.12u AS=0.4256p AD=0.2254p
+ PS=3u PD=1.53u rfmode=0
M$27731 VDD \$223 \$434 VDD sg13_lv_pmos L=0.13u W=0.42u AS=0.1523p AD=0.1428p
+ PS=1.38u PD=1.52u rfmode=0
M$27732 \$433 \$434 VDD VDD sg13_lv_pmos L=0.5u W=1u AS=0.34p AD=0.1523p
+ PS=2.68u PD=1.38u rfmode=0
M$27733 \$435 \$323 VDD VDD sg13_lv_pmos L=0.13u W=0.84u AS=0.2856p AD=0.253p
+ PS=2.36u PD=1.53u rfmode=0
M$27734 VDD \$323 \$638 VDD sg13_lv_pmos L=0.13u W=1u AS=0.253p AD=0.3325p
+ PS=1.53u PD=1.665u rfmode=0
M$27735 \$638 \$437 \$436 VDD sg13_lv_pmos L=0.13u W=1u AS=0.3325p AD=0.2225p
+ PS=1.665u PD=1.445u rfmode=0
M$27736 \$436 \$431 \$637 VDD sg13_lv_pmos L=0.13u W=1u AS=0.2225p AD=0.2975p
+ PS=1.445u PD=1.595u rfmode=0
M$27737 \$637 \$435 VDD VDD sg13_lv_pmos L=0.13u W=1u AS=0.2975p AD=0.2198p
+ PS=1.595u PD=1.52u rfmode=0
M$27738 VDD \$436 \$438 VDD sg13_lv_pmos L=0.13u W=1.12u AS=0.2198p AD=0.6048p
+ PS=1.52u PD=3.32u rfmode=0
M$27739 VDD \$438 \$439 VDD sg13_lv_pmos L=0.13u W=0.42u AS=0.1428p AD=0.0798p
+ PS=1.52u PD=0.8u rfmode=0
M$27740 VDD \$121 \$439 VDD sg13_lv_pmos L=0.13u W=0.42u AS=0.3623875p
+ AD=0.0798p PS=2.605u PD=0.8u rfmode=0
M$27741 VDD \$584 \$440 VDD sg13_lv_pmos L=0.13u W=1u AS=0.3623875p AD=0.34p
+ PS=2.605u PD=2.68u rfmode=0
M$27742 \$585 \$442 VDD VDD sg13_lv_pmos L=0.13u W=1.12u AS=0.3864p AD=0.41165p
+ PS=2.93u PD=2.12u rfmode=0
M$27743 VDD \$417 \$442 VDD sg13_lv_pmos L=0.13u W=1.12u AS=0.41165p AD=0.4088p
+ PS=2.12u PD=2.97u rfmode=0
M$27744 \$444 \$585 \$602 VDD sg13_lv_pmos L=0.13u W=0.42u AS=0.2048p
+ AD=0.09345p PS=1.63u PD=0.865u rfmode=0
M$27745 \$602 \$445 VDD VDD sg13_lv_pmos L=0.13u W=0.42u AS=0.09345p AD=0.204p
+ PS=0.865u PD=1.835u rfmode=0
M$27746 VDD \$121 \$445 VDD sg13_lv_pmos L=0.13u W=0.42u AS=0.204p AD=0.0798p
+ PS=1.835u PD=0.8u rfmode=0
M$27747 \$445 \$444 VDD VDD sg13_lv_pmos L=0.13u W=0.42u AS=0.0798p AD=0.4659p
+ PS=0.8u PD=3.65u rfmode=0
M$27748 \$440 \$442 \$444 VDD sg13_lv_pmos L=0.13u W=1u AS=0.34p AD=0.2048p
+ PS=2.68u PD=1.63u rfmode=0
M$27749 \$446 \$444 VDD VDD sg13_lv_pmos L=0.13u W=1.12u AS=0.3864p AD=0.2128p
+ PS=2.93u PD=1.5u rfmode=0
M$27750 VDD \$446 \$303 VDD sg13_lv_pmos L=0.13u W=1.12u AS=0.2128p AD=0.3808p
+ PS=1.5u PD=2.92u rfmode=0
M$27758 VDD \$122 \$447 VDD sg13_lv_pmos L=0.13u W=1.12u AS=0.3808p AD=0.3808p
+ PS=2.92u PD=2.92u rfmode=0
M$27759 VDD \$449 \$448 VDD sg13_lv_pmos L=0.13u W=0.42u AS=0.1428p AD=0.0798p
+ PS=1.52u PD=0.8u rfmode=0
M$27760 VDD \$447 \$448 VDD sg13_lv_pmos L=0.13u W=0.42u AS=0.3623875p
+ AD=0.0798p PS=2.605u PD=0.8u rfmode=0
M$27761 VDD \$586 \$450 VDD sg13_lv_pmos L=0.13u W=1u AS=0.3623875p AD=0.34p
+ PS=2.605u PD=2.68u rfmode=0
M$27762 \$587 \$452 VDD VDD sg13_lv_pmos L=0.13u W=1.12u AS=0.3864p AD=0.41165p
+ PS=2.93u PD=2.12u rfmode=0
M$27763 VDD \$417 \$452 VDD sg13_lv_pmos L=0.13u W=1.12u AS=0.41165p AD=0.4088p
+ PS=2.12u PD=2.97u rfmode=0
M$27764 \$454 \$587 \$600 VDD sg13_lv_pmos L=0.13u W=0.42u AS=0.2048p
+ AD=0.09345p PS=1.63u PD=0.865u rfmode=0
M$27765 \$600 \$455 VDD VDD sg13_lv_pmos L=0.13u W=0.42u AS=0.09345p AD=0.204p
+ PS=0.865u PD=1.835u rfmode=0
M$27766 VDD \$447 \$455 VDD sg13_lv_pmos L=0.13u W=0.42u AS=0.204p AD=0.0798p
+ PS=1.835u PD=0.8u rfmode=0
M$27767 \$455 \$454 VDD VDD sg13_lv_pmos L=0.13u W=0.42u AS=0.0798p AD=0.4659p
+ PS=0.8u PD=3.65u rfmode=0
M$27768 \$450 \$452 \$454 VDD sg13_lv_pmos L=0.13u W=1u AS=0.34p AD=0.2048p
+ PS=2.68u PD=1.63u rfmode=0
M$27769 \$456 \$454 VDD VDD sg13_lv_pmos L=0.13u W=1.12u AS=0.3864p AD=0.2128p
+ PS=2.93u PD=1.5u rfmode=0
M$27770 VDD \$456 \$304 VDD sg13_lv_pmos L=0.13u W=1.12u AS=0.2128p AD=0.3808p
+ PS=1.5u PD=2.92u rfmode=0
M$27778 \$457 \$323 VDD VDD sg13_lv_pmos L=0.13u W=0.84u AS=0.2856p AD=0.253p
+ PS=2.36u PD=1.53u rfmode=0
M$27779 VDD \$323 \$625 VDD sg13_lv_pmos L=0.13u W=1u AS=0.253p AD=0.3325p
+ PS=1.53u PD=1.665u rfmode=0
M$27780 \$625 \$459 \$458 VDD sg13_lv_pmos L=0.13u W=1u AS=0.3325p AD=0.2225p
+ PS=1.665u PD=1.445u rfmode=0
M$27781 \$458 \$437 \$624 VDD sg13_lv_pmos L=0.13u W=1u AS=0.2225p AD=0.2975p
+ PS=1.445u PD=1.595u rfmode=0
M$27782 \$624 \$457 VDD VDD sg13_lv_pmos L=0.13u W=1u AS=0.2975p AD=0.2198p
+ PS=1.595u PD=1.52u rfmode=0
M$27783 VDD \$458 \$460 VDD sg13_lv_pmos L=0.13u W=1.12u AS=0.2198p AD=0.6048p
+ PS=1.52u PD=3.32u rfmode=0
M$27784 VDD \$460 \$461 VDD sg13_lv_pmos L=0.13u W=0.42u AS=0.1428p AD=0.0798p
+ PS=1.52u PD=0.8u rfmode=0
M$27785 VDD \$233 \$461 VDD sg13_lv_pmos L=0.13u W=0.42u AS=0.3623875p
+ AD=0.0798p PS=2.605u PD=0.8u rfmode=0
M$27786 VDD \$588 \$462 VDD sg13_lv_pmos L=0.13u W=1u AS=0.3623875p AD=0.34p
+ PS=2.605u PD=2.68u rfmode=0
M$27787 \$589 \$464 VDD VDD sg13_lv_pmos L=0.13u W=1.12u AS=0.3864p AD=0.41165p
+ PS=2.93u PD=2.12u rfmode=0
M$27788 VDD \$417 \$464 VDD sg13_lv_pmos L=0.13u W=1.12u AS=0.41165p AD=0.4088p
+ PS=2.12u PD=2.97u rfmode=0
M$27789 \$466 \$589 \$597 VDD sg13_lv_pmos L=0.13u W=0.42u AS=0.2048p
+ AD=0.09345p PS=1.63u PD=0.865u rfmode=0
M$27790 \$597 \$467 VDD VDD sg13_lv_pmos L=0.13u W=0.42u AS=0.09345p AD=0.204p
+ PS=0.865u PD=1.835u rfmode=0
M$27791 VDD \$233 \$467 VDD sg13_lv_pmos L=0.13u W=0.42u AS=0.204p AD=0.0798p
+ PS=1.835u PD=0.8u rfmode=0
M$27792 \$467 \$466 VDD VDD sg13_lv_pmos L=0.13u W=0.42u AS=0.0798p AD=0.4659p
+ PS=0.8u PD=3.65u rfmode=0
M$27793 \$462 \$464 \$466 VDD sg13_lv_pmos L=0.13u W=1u AS=0.34p AD=0.2048p
+ PS=2.68u PD=1.63u rfmode=0
M$27794 \$468 \$466 VDD VDD sg13_lv_pmos L=0.13u W=1.12u AS=0.3864p AD=0.2128p
+ PS=2.93u PD=1.5u rfmode=0
M$27795 VDD \$468 \$469 VDD sg13_lv_pmos L=0.13u W=1.12u AS=0.2128p AD=0.3808p
+ PS=1.5u PD=2.92u rfmode=0
M$27796 VDD \$268 \$473 VDD sg13_lv_pmos L=0.13u W=0.84u AS=0.253p AD=0.2856p
+ PS=1.53u PD=2.36u rfmode=0
M$27797 VDD \$473 \$620 VDD sg13_lv_pmos L=0.13u W=1u AS=0.2198p AD=0.2975p
+ PS=1.52u PD=1.595u rfmode=0
M$27798 \$620 \$469 \$471 VDD sg13_lv_pmos L=0.13u W=1u AS=0.2975p AD=0.2225p
+ PS=1.595u PD=1.445u rfmode=0
M$27799 \$471 \$472 \$619 VDD sg13_lv_pmos L=0.13u W=1u AS=0.2225p AD=0.3325p
+ PS=1.445u PD=1.665u rfmode=0
M$27800 \$619 \$268 VDD VDD sg13_lv_pmos L=0.13u W=1u AS=0.3325p AD=0.253p
+ PS=1.665u PD=1.53u rfmode=0
M$27801 \$470 \$471 VDD VDD sg13_lv_pmos L=0.13u W=1.12u AS=0.6048p AD=0.2198p
+ PS=3.32u PD=1.52u rfmode=0
M$27802 \$474 \$122 VDD VDD sg13_lv_pmos L=0.13u W=1.12u AS=0.3808p AD=0.3808p
+ PS=2.92u PD=2.92u rfmode=0
M$27803 VDD \$590 \$475 VDD sg13_lv_pmos L=0.13u W=0.84u AS=0.2114p AD=0.2856p
+ PS=1.54u PD=2.36u rfmode=0
M$27804 VDD \$475 dout[8] VDD sg13_lv_pmos L=0.13u W=1.12u AS=0.2114p AD=0.42p
+ PS=1.54u PD=2.99u rfmode=0
M$27805 VDD \$469 \$477 VDD sg13_lv_pmos L=0.13u W=0.42u AS=0.1523p AD=0.1428p
+ PS=1.38u PD=1.52u rfmode=0
M$27806 VDD \$477 \$478 VDD sg13_lv_pmos L=0.5u W=1u AS=0.1523p AD=0.34p
+ PS=1.38u PD=2.68u rfmode=0
M$27807 \$479 \$478 VDD VDD sg13_lv_pmos L=0.5u W=1u AS=0.34p AD=0.2254p
+ PS=2.68u PD=1.53u rfmode=0
M$27808 VDD \$479 \$459 VDD sg13_lv_pmos L=0.13u W=1.12u AS=0.2254p AD=0.4256p
+ PS=1.53u PD=3u rfmode=0
M$27810 \$480 \$323 VDD VDD sg13_lv_pmos L=0.13u W=0.84u AS=0.2856p AD=0.253p
+ PS=2.36u PD=1.53u rfmode=0
M$27811 VDD \$323 \$617 VDD sg13_lv_pmos L=0.13u W=1u AS=0.253p AD=0.3325p
+ PS=1.53u PD=1.665u rfmode=0
M$27812 \$617 \$493 \$481 VDD sg13_lv_pmos L=0.13u W=1u AS=0.3325p AD=0.2225p
+ PS=1.665u PD=1.445u rfmode=0
M$27813 \$481 \$459 \$616 VDD sg13_lv_pmos L=0.13u W=1u AS=0.2225p AD=0.2975p
+ PS=1.445u PD=1.595u rfmode=0
M$27814 \$616 \$480 VDD VDD sg13_lv_pmos L=0.13u W=1u AS=0.2975p AD=0.2198p
+ PS=1.595u PD=1.52u rfmode=0
M$27815 VDD \$481 \$482 VDD sg13_lv_pmos L=0.13u W=1.12u AS=0.2198p AD=0.6048p
+ PS=1.52u PD=3.32u rfmode=0
M$27816 VDD \$235 \$483 VDD sg13_lv_pmos L=0.13u W=0.42u AS=0.1428p AD=0.0798p
+ PS=1.52u PD=0.8u rfmode=0
M$27817 VDD \$234 \$483 VDD sg13_lv_pmos L=0.13u W=0.42u AS=0.3623875p
+ AD=0.0798p PS=2.605u PD=0.8u rfmode=0
M$27818 VDD \$591 \$484 VDD sg13_lv_pmos L=0.13u W=1u AS=0.3623875p AD=0.34p
+ PS=2.605u PD=2.68u rfmode=0
M$27819 \$592 \$486 VDD VDD sg13_lv_pmos L=0.13u W=1.12u AS=0.3864p AD=0.41165p
+ PS=2.93u PD=2.12u rfmode=0
M$27820 VDD \$763 \$486 VDD sg13_lv_pmos L=0.13u W=1.12u AS=0.41165p AD=0.4088p
+ PS=2.12u PD=2.97u rfmode=0
M$27821 \$488 \$592 \$596 VDD sg13_lv_pmos L=0.13u W=0.42u AS=0.2048p
+ AD=0.09345p PS=1.63u PD=0.865u rfmode=0
M$27822 \$596 \$489 VDD VDD sg13_lv_pmos L=0.13u W=0.42u AS=0.09345p AD=0.204p
+ PS=0.865u PD=1.835u rfmode=0
M$27823 VDD \$234 \$489 VDD sg13_lv_pmos L=0.13u W=0.42u AS=0.204p AD=0.0798p
+ PS=1.835u PD=0.8u rfmode=0
M$27824 \$489 \$488 VDD VDD sg13_lv_pmos L=0.13u W=0.42u AS=0.0798p AD=0.4659p
+ PS=0.8u PD=3.65u rfmode=0
M$27825 \$484 \$486 \$488 VDD sg13_lv_pmos L=0.13u W=1u AS=0.34p AD=0.2048p
+ PS=2.68u PD=1.63u rfmode=0
M$27826 \$490 \$488 VDD VDD sg13_lv_pmos L=0.13u W=1.12u AS=0.3864p AD=0.2128p
+ PS=2.93u PD=1.5u rfmode=0
M$27827 VDD \$490 \$493 VDD sg13_lv_pmos L=0.13u W=1.12u AS=0.2128p AD=0.3808p
+ PS=1.5u PD=2.92u rfmode=0
M$27828 VDD \$323 \$239 VDD sg13_lv_pmos L=0.13u W=0.84u AS=0.253p AD=0.2856p
+ PS=1.53u PD=2.36u rfmode=0
M$27829 VDD \$323 \$289 VDD sg13_lv_pmos L=0.13u W=1u AS=0.253p AD=0.3325p
+ PS=1.53u PD=1.665u rfmode=0
M$27830 \$289 \$241 \$240 VDD sg13_lv_pmos L=0.13u W=1u AS=0.3325p AD=0.2225p
+ PS=1.665u PD=1.445u rfmode=0
M$27831 \$240 \$305 \$290 VDD sg13_lv_pmos L=0.13u W=1u AS=0.2225p AD=0.2975p
+ PS=1.445u PD=1.595u rfmode=0
M$27832 VDD \$239 \$290 VDD sg13_lv_pmos L=0.13u W=1u AS=0.2198p AD=0.2975p
+ PS=1.52u PD=1.595u rfmode=0
M$27833 VDD \$240 \$242 VDD sg13_lv_pmos L=0.13u W=1.12u AS=0.2198p AD=0.6048p
+ PS=1.52u PD=3.32u rfmode=0
M$27834 \$491 \$268 VDD VDD sg13_lv_pmos L=0.13u W=0.84u AS=0.2856p AD=0.253p
+ PS=2.36u PD=1.53u rfmode=0
M$27835 VDD \$268 \$612 VDD sg13_lv_pmos L=0.13u W=1u AS=0.253p AD=0.3325p
+ PS=1.53u PD=1.665u rfmode=0
M$27836 \$612 \$494 \$492 VDD sg13_lv_pmos L=0.13u W=1u AS=0.3325p AD=0.2225p
+ PS=1.665u PD=1.445u rfmode=0
M$27837 \$492 \$493 \$611 VDD sg13_lv_pmos L=0.13u W=1u AS=0.2225p AD=0.2975p
+ PS=1.445u PD=1.595u rfmode=0
M$27838 \$611 \$491 VDD VDD sg13_lv_pmos L=0.13u W=1u AS=0.2975p AD=0.2198p
+ PS=1.595u PD=1.52u rfmode=0
M$27839 VDD \$492 \$499 VDD sg13_lv_pmos L=0.13u W=1.12u AS=0.2198p AD=0.6048p
+ PS=1.52u PD=3.32u rfmode=0
M$27840 VDD \$497 \$496 VDD sg13_lv_pmos L=0.5u W=1u AS=0.2254p AD=0.34p
+ PS=1.53u PD=2.68u rfmode=0
M$27841 \$495 \$496 VDD VDD sg13_lv_pmos L=0.13u W=1.12u AS=0.4256p AD=0.2254p
+ PS=3u PD=1.53u rfmode=0
M$27842 VDD \$123 \$244 VDD sg13_lv_pmos L=0.13u W=0.42u AS=0.1563p AD=0.147p
+ PS=1.22u PD=1.54u rfmode=0
M$27843 VDD \$245 \$291 VDD sg13_lv_pmos L=0.13u W=0.42u AS=0.1563p AD=0.063p
+ PS=1.22u PD=0.72u rfmode=0
M$27844 \$291 \$247 \$244 VDD sg13_lv_pmos L=0.13u W=0.42u AS=0.063p AD=0.0798p
+ PS=0.72u PD=0.8u rfmode=0
M$27845 \$244 \$246 \$243 VDD sg13_lv_pmos L=0.13u W=0.42u AS=0.0798p
+ AD=0.1428p PS=0.8u PD=1.52u rfmode=0
M$27846 VDD \$499 \$498 VDD sg13_lv_pmos L=0.13u W=0.42u AS=0.1523p AD=0.1428p
+ PS=1.38u PD=1.52u rfmode=0
M$27847 \$497 \$498 VDD VDD sg13_lv_pmos L=0.5u W=1u AS=0.34p AD=0.1523p
+ PS=2.68u PD=1.38u rfmode=0
M$27848 VDD \$501 \$500 VDD sg13_lv_pmos L=0.5u W=1u AS=0.2254p AD=0.34p
+ PS=1.53u PD=2.68u rfmode=0
M$27849 \$494 \$500 VDD VDD sg13_lv_pmos L=0.13u W=1.12u AS=0.4256p AD=0.2254p
+ PS=3u PD=1.53u rfmode=0
M$27850 VDD \$503 \$502 VDD sg13_lv_pmos L=0.13u W=0.42u AS=0.1523p AD=0.1428p
+ PS=1.38u PD=1.52u rfmode=0
M$27851 \$501 \$502 VDD VDD sg13_lv_pmos L=0.5u W=1u AS=0.34p AD=0.1523p
+ PS=2.68u PD=1.38u rfmode=0
M$27852 \$122 \$504 VDD VDD sg13_lv_pmos L=0.13u W=1.12u AS=0.42p AD=0.2114p
+ PS=2.99u PD=1.54u rfmode=0
M$27853 VDD \$120 \$504 VDD sg13_lv_pmos L=0.13u W=0.84u AS=0.2114p AD=0.2856p
+ PS=1.54u PD=2.36u rfmode=0
M$27854 \$505 \$122 VDD VDD sg13_lv_pmos L=0.13u W=1.12u AS=0.3808p AD=0.3808p
+ PS=2.92u PD=2.92u rfmode=0
M$27855 VDD \$74 \$252 VDD sg13_lv_pmos L=0.13u W=0.84u AS=0.253p AD=0.2856p
+ PS=1.53u PD=2.36u rfmode=0
M$27856 VDD \$74 \$287 VDD sg13_lv_pmos L=0.13u W=1u AS=0.253p AD=0.3325p
+ PS=1.53u PD=1.665u rfmode=0
M$27857 \$287 \$254 \$253 VDD sg13_lv_pmos L=0.13u W=1u AS=0.3325p AD=0.2225p
+ PS=1.665u PD=1.445u rfmode=0
M$27858 \$253 \$241 \$286 VDD sg13_lv_pmos L=0.13u W=1u AS=0.2225p AD=0.2975p
+ PS=1.445u PD=1.595u rfmode=0
M$27859 VDD \$252 \$286 VDD sg13_lv_pmos L=0.13u W=1u AS=0.2198p AD=0.2975p
+ PS=1.52u PD=1.595u rfmode=0
M$27860 VDD \$253 \$255 VDD sg13_lv_pmos L=0.13u W=1.12u AS=0.2198p AD=0.6048p
+ PS=1.52u PD=3.32u rfmode=0
M$27861 VDD \$251 \$506 VDD sg13_lv_pmos L=0.13u W=0.42u AS=0.1523p AD=0.1428p
+ PS=1.38u PD=1.52u rfmode=0
M$27862 VDD \$506 \$507 VDD sg13_lv_pmos L=0.5u W=1u AS=0.1523p AD=0.34p
+ PS=1.38u PD=2.68u rfmode=0
M$27863 \$508 \$507 VDD VDD sg13_lv_pmos L=0.5u W=1u AS=0.34p AD=0.2254p
+ PS=2.68u PD=1.53u rfmode=0
M$27864 VDD \$508 \$241 VDD sg13_lv_pmos L=0.13u W=1.12u AS=0.2254p AD=0.4256p
+ PS=1.53u PD=3u rfmode=0
M$27865 \$509 \$268 VDD VDD sg13_lv_pmos L=0.13u W=0.84u AS=0.2856p AD=0.253p
+ PS=2.36u PD=1.53u rfmode=0
M$27866 VDD \$268 \$608 VDD sg13_lv_pmos L=0.13u W=1u AS=0.253p AD=0.3325p
+ PS=1.53u PD=1.665u rfmode=0
M$27867 \$608 \$511 \$510 VDD sg13_lv_pmos L=0.13u W=1u AS=0.3325p AD=0.2225p
+ PS=1.665u PD=1.445u rfmode=0
M$27868 \$510 \$241 \$607 VDD sg13_lv_pmos L=0.13u W=1u AS=0.2225p AD=0.2975p
+ PS=1.445u PD=1.595u rfmode=0
M$27869 \$607 \$509 VDD VDD sg13_lv_pmos L=0.13u W=1u AS=0.2975p AD=0.2198p
+ PS=1.595u PD=1.52u rfmode=0
M$27870 VDD \$510 \$512 VDD sg13_lv_pmos L=0.13u W=1.12u AS=0.2198p AD=0.6048p
+ PS=1.52u PD=3.32u rfmode=0
M$27871 VDD \$125 \$257 VDD sg13_lv_pmos L=0.13u W=0.42u AS=0.1563p AD=0.147p
+ PS=1.22u PD=1.54u rfmode=0
M$27872 VDD \$258 \$285 VDD sg13_lv_pmos L=0.13u W=0.42u AS=0.1563p AD=0.063p
+ PS=1.22u PD=0.72u rfmode=0
M$27873 \$285 \$260 \$257 VDD sg13_lv_pmos L=0.13u W=0.42u AS=0.063p AD=0.0798p
+ PS=0.72u PD=0.8u rfmode=0
M$27874 \$257 \$259 \$256 VDD sg13_lv_pmos L=0.13u W=0.42u AS=0.0798p
+ AD=0.1428p PS=0.8u PD=1.52u rfmode=0
M$27875 VDD \$122 \$513 VDD sg13_lv_pmos L=0.13u W=1.12u AS=0.3808p AD=0.3808p
+ PS=2.92u PD=2.92u rfmode=0
M$27876 VDD \$122 \$514 VDD sg13_lv_pmos L=0.13u W=1.12u AS=0.3808p AD=0.3808p
+ PS=2.92u PD=2.92u rfmode=0
M$27877 \$515 \$268 VDD VDD sg13_lv_pmos L=0.13u W=0.84u AS=0.2856p AD=0.253p
+ PS=2.36u PD=1.53u rfmode=0
M$27878 VDD \$268 \$606 VDD sg13_lv_pmos L=0.13u W=1u AS=0.253p AD=0.3325p
+ PS=1.53u PD=1.665u rfmode=0
M$27879 \$606 \$525 \$516 VDD sg13_lv_pmos L=0.13u W=1u AS=0.3325p AD=0.2225p
+ PS=1.665u PD=1.445u rfmode=0
M$27880 \$516 \$254 \$605 VDD sg13_lv_pmos L=0.13u W=1u AS=0.2225p AD=0.2975p
+ PS=1.445u PD=1.595u rfmode=0
M$27881 \$605 \$515 VDD VDD sg13_lv_pmos L=0.13u W=1u AS=0.2975p AD=0.2198p
+ PS=1.595u PD=1.52u rfmode=0
M$27882 VDD \$516 \$130 VDD sg13_lv_pmos L=0.13u W=1.12u AS=0.2198p AD=0.6048p
+ PS=1.52u PD=3.32u rfmode=0
M$27883 VDD \$126 \$517 VDD sg13_lv_pmos L=0.13u W=0.42u AS=0.1428p AD=0.0798p
+ PS=1.52u PD=0.8u rfmode=0
M$27884 VDD \$513 \$517 VDD sg13_lv_pmos L=0.13u W=0.42u AS=0.3623875p
+ AD=0.0798p PS=2.605u PD=0.8u rfmode=0
M$27885 VDD \$593 \$518 VDD sg13_lv_pmos L=0.13u W=1u AS=0.3623875p AD=0.34p
+ PS=2.605u PD=2.68u rfmode=0
M$27886 \$594 \$520 VDD VDD sg13_lv_pmos L=0.13u W=1.12u AS=0.3864p AD=0.41165p
+ PS=2.93u PD=2.12u rfmode=0
M$27887 VDD \$763 \$520 VDD sg13_lv_pmos L=0.13u W=1.12u AS=0.41165p AD=0.4088p
+ PS=2.12u PD=2.97u rfmode=0
M$27888 \$522 \$594 \$595 VDD sg13_lv_pmos L=0.13u W=0.42u AS=0.2048p
+ AD=0.09345p PS=1.63u PD=0.865u rfmode=0
M$27889 \$595 \$523 VDD VDD sg13_lv_pmos L=0.13u W=0.42u AS=0.09345p AD=0.204p
+ PS=0.865u PD=1.835u rfmode=0
M$27890 VDD \$513 \$523 VDD sg13_lv_pmos L=0.13u W=0.42u AS=0.204p AD=0.0798p
+ PS=1.835u PD=0.8u rfmode=0
M$27891 \$523 \$522 VDD VDD sg13_lv_pmos L=0.13u W=0.42u AS=0.0798p AD=0.4659p
+ PS=0.8u PD=3.65u rfmode=0
M$27892 \$518 \$520 \$522 VDD sg13_lv_pmos L=0.13u W=1u AS=0.34p AD=0.2048p
+ PS=2.68u PD=1.63u rfmode=0
M$27893 \$524 \$522 VDD VDD sg13_lv_pmos L=0.13u W=1.12u AS=0.3864p AD=0.2128p
+ PS=2.93u PD=1.5u rfmode=0
M$27894 VDD \$524 \$525 VDD sg13_lv_pmos L=0.13u W=1.12u AS=0.2128p AD=0.3808p
+ PS=1.5u PD=2.92u rfmode=0
M$27955 VDD \$165 \$660 VDD sg13_lv_pmos L=0.13u W=0.84u AS=0.2114p AD=0.2856p
+ PS=1.54u PD=2.36u rfmode=0
M$27956 dout[0] \$660 VDD VDD sg13_lv_pmos L=0.13u W=1.12u AS=0.42p AD=0.2114p
+ PS=2.99u PD=1.54u rfmode=0
M$27982 VDD \$662 \$663 VDD sg13_lv_pmos L=0.13u W=0.84u AS=0.2114p AD=0.2856p
+ PS=1.54u PD=2.36u rfmode=0
M$27983 dout[1] \$663 VDD VDD sg13_lv_pmos L=0.13u W=1.12u AS=0.42p AD=0.2114p
+ PS=2.99u PD=1.54u rfmode=0
M$28009 VDD \$665 \$666 VDD sg13_lv_pmos L=0.13u W=0.84u AS=0.2114p AD=0.2856p
+ PS=1.54u PD=2.36u rfmode=0
M$28010 dout[2] \$666 VDD VDD sg13_lv_pmos L=0.13u W=1.12u AS=0.42p AD=0.2114p
+ PS=2.99u PD=1.54u rfmode=0
M$28028 VDD \$352 \$667 VDD sg13_lv_pmos L=0.13u W=0.42u AS=0.1428p AD=0.0798p
+ PS=1.52u PD=0.8u rfmode=0
M$28029 VDD \$351 \$667 VDD sg13_lv_pmos L=0.13u W=0.42u AS=0.3623875p
+ AD=0.0798p PS=2.605u PD=0.8u rfmode=0
M$28030 VDD \$668 \$669 VDD sg13_lv_pmos L=0.13u W=1u AS=0.3623875p AD=0.34p
+ PS=2.605u PD=2.68u rfmode=0
M$28031 VDD \$671 \$670 VDD sg13_lv_pmos L=0.13u W=1.12u AS=0.41165p AD=0.3864p
+ PS=2.12u PD=2.93u rfmode=0
M$28032 VDD \$389 \$671 VDD sg13_lv_pmos L=0.13u W=1.12u AS=0.41165p AD=0.4088p
+ PS=2.12u PD=2.97u rfmode=0
M$28033 \$669 \$671 \$672 VDD sg13_lv_pmos L=0.13u W=1u AS=0.34p AD=0.2048p
+ PS=2.68u PD=1.63u rfmode=0
M$28034 \$672 \$670 \$797 VDD sg13_lv_pmos L=0.13u W=0.42u AS=0.2048p
+ AD=0.09345p PS=1.63u PD=0.865u rfmode=0
M$28035 VDD \$673 \$797 VDD sg13_lv_pmos L=0.13u W=0.42u AS=0.204p AD=0.09345p
+ PS=1.835u PD=0.865u rfmode=0
M$28036 VDD \$351 \$673 VDD sg13_lv_pmos L=0.13u W=0.42u AS=0.204p AD=0.0798p
+ PS=1.835u PD=0.8u rfmode=0
M$28037 VDD \$672 \$673 VDD sg13_lv_pmos L=0.13u W=0.42u AS=0.4659p AD=0.0798p
+ PS=3.65u PD=0.8u rfmode=0
M$28038 \$674 \$672 VDD VDD sg13_lv_pmos L=0.13u W=1.12u AS=0.3864p AD=0.2128p
+ PS=2.93u PD=1.5u rfmode=0
M$28039 VDD \$674 \$662 VDD sg13_lv_pmos L=0.13u W=1.12u AS=0.2128p AD=0.3808p
+ PS=1.5u PD=2.92u rfmode=0
M$28040 VDD \$676 \$677 VDD sg13_lv_pmos L=0.13u W=0.84u AS=0.2114p AD=0.2856p
+ PS=1.54u PD=2.36u rfmode=0
M$28041 dout[3] \$677 VDD VDD sg13_lv_pmos L=0.13u W=1.12u AS=0.42p AD=0.2114p
+ PS=2.99u PD=1.54u rfmode=0
M$28042 VDD \$359 \$678 VDD sg13_lv_pmos L=0.13u W=0.42u AS=0.1523p AD=0.1428p
+ PS=1.38u PD=1.52u rfmode=0
M$28043 VDD \$678 \$679 VDD sg13_lv_pmos L=0.5u W=1u AS=0.1523p AD=0.34p
+ PS=1.38u PD=2.68u rfmode=0
M$28044 VDD \$679 \$680 VDD sg13_lv_pmos L=0.5u W=1u AS=0.2254p AD=0.34p
+ PS=1.53u PD=2.68u rfmode=0
M$28045 VDD \$680 \$681 VDD sg13_lv_pmos L=0.13u W=1.12u AS=0.2254p AD=0.4256p
+ PS=1.53u PD=3u rfmode=0
M$28046 VDD \$681 \$682 VDD sg13_lv_pmos L=0.13u W=0.42u AS=0.1428p AD=0.0798p
+ PS=1.52u PD=0.8u rfmode=0
M$28047 VDD \$363 \$682 VDD sg13_lv_pmos L=0.13u W=0.42u AS=0.3623875p
+ AD=0.0798p PS=2.605u PD=0.8u rfmode=0
M$28048 VDD \$683 \$684 VDD sg13_lv_pmos L=0.13u W=1u AS=0.3623875p AD=0.34p
+ PS=2.605u PD=2.68u rfmode=0
M$28049 VDD \$686 \$685 VDD sg13_lv_pmos L=0.13u W=1.12u AS=0.41165p AD=0.3864p
+ PS=2.12u PD=2.93u rfmode=0
M$28050 VDD \$389 \$686 VDD sg13_lv_pmos L=0.13u W=1.12u AS=0.41165p AD=0.4088p
+ PS=2.12u PD=2.97u rfmode=0
M$28051 \$684 \$686 \$687 VDD sg13_lv_pmos L=0.13u W=1u AS=0.34p AD=0.2048p
+ PS=2.68u PD=1.63u rfmode=0
M$28052 \$687 \$685 \$799 VDD sg13_lv_pmos L=0.13u W=0.42u AS=0.2048p
+ AD=0.09345p PS=1.63u PD=0.865u rfmode=0
M$28053 VDD \$688 \$799 VDD sg13_lv_pmos L=0.13u W=0.42u AS=0.204p AD=0.09345p
+ PS=1.835u PD=0.865u rfmode=0
M$28054 VDD \$363 \$688 VDD sg13_lv_pmos L=0.13u W=0.42u AS=0.204p AD=0.0798p
+ PS=1.835u PD=0.8u rfmode=0
M$28055 VDD \$687 \$688 VDD sg13_lv_pmos L=0.13u W=0.42u AS=0.4659p AD=0.0798p
+ PS=3.65u PD=0.8u rfmode=0
M$28056 \$689 \$687 VDD VDD sg13_lv_pmos L=0.13u W=1.12u AS=0.3864p AD=0.2128p
+ PS=2.93u PD=1.5u rfmode=0
M$28057 VDD \$689 \$665 VDD sg13_lv_pmos L=0.13u W=1.12u AS=0.2128p AD=0.3808p
+ PS=1.5u PD=2.92u rfmode=0
M$28062 \$676 \$690 VDD VDD sg13_lv_pmos L=0.13u W=1.12u AS=0.3808p AD=0.2128p
+ PS=2.92u PD=1.5u rfmode=0
M$28063 VDD \$818 \$690 VDD sg13_lv_pmos L=0.13u W=1.12u AS=0.2128p AD=0.3864p
+ PS=1.5u PD=2.93u rfmode=0
M$28064 VDD \$389 \$693 VDD sg13_lv_pmos L=0.13u W=1.12u AS=0.41165p AD=0.4088p
+ PS=2.12u PD=2.97u rfmode=0
M$28065 VDD \$693 \$692 VDD sg13_lv_pmos L=0.13u W=1.12u AS=0.41165p AD=0.3864p
+ PS=2.12u PD=2.93u rfmode=0
M$28066 VDD \$695 \$696 VDD sg13_lv_pmos L=0.13u W=1u AS=0.3623875p AD=0.34p
+ PS=2.605u PD=2.68u rfmode=0
M$28067 VDD \$192 \$694 VDD sg13_lv_pmos L=0.13u W=0.42u AS=0.3623875p
+ AD=0.0798p PS=2.605u PD=0.8u rfmode=0
M$28068 \$694 \$374 VDD VDD sg13_lv_pmos L=0.13u W=0.42u AS=0.0798p AD=0.1428p
+ PS=0.8u PD=1.52u rfmode=0
M$28069 \$697 \$698 VDD VDD sg13_lv_pmos L=0.13u W=0.84u AS=0.2856p AD=0.2114p
+ PS=2.36u PD=1.54u rfmode=0
M$28070 VDD \$697 dout[4] VDD sg13_lv_pmos L=0.13u W=1.12u AS=0.2114p AD=0.42p
+ PS=1.54u PD=2.99u rfmode=0
M$28071 VDD \$698 \$700 VDD sg13_lv_pmos L=0.13u W=0.42u AS=0.1523p AD=0.1428p
+ PS=1.38u PD=1.52u rfmode=0
M$28072 VDD \$700 \$701 VDD sg13_lv_pmos L=0.5u W=1u AS=0.1523p AD=0.34p
+ PS=1.38u PD=2.68u rfmode=0
M$28073 VDD \$701 \$702 VDD sg13_lv_pmos L=0.5u W=1u AS=0.2254p AD=0.34p
+ PS=1.53u PD=2.68u rfmode=0
M$28074 VDD \$702 \$300 VDD sg13_lv_pmos L=0.13u W=1.12u AS=0.2254p AD=0.4256p
+ PS=1.53u PD=3u rfmode=0
M$28075 \$698 \$703 VDD VDD sg13_lv_pmos L=0.13u W=1.12u AS=0.3808p AD=0.2128p
+ PS=2.92u PD=1.5u rfmode=0
M$28076 VDD \$821 \$703 VDD sg13_lv_pmos L=0.13u W=1.12u AS=0.2128p AD=0.3864p
+ PS=1.5u PD=2.93u rfmode=0
M$28077 VDD \$389 \$706 VDD sg13_lv_pmos L=0.13u W=1.12u AS=0.41165p AD=0.4088p
+ PS=2.12u PD=2.97u rfmode=0
M$28078 VDD \$706 \$705 VDD sg13_lv_pmos L=0.13u W=1.12u AS=0.41165p AD=0.3864p
+ PS=2.12u PD=2.93u rfmode=0
M$28079 \$578 \$381 VDD VDD sg13_lv_pmos L=0.13u W=0.42u AS=0.147p AD=0.1563p
+ PS=1.54u PD=1.22u rfmode=0
M$28080 VDD \$384 \$651 VDD sg13_lv_pmos L=0.13u W=0.42u AS=0.1563p AD=0.063p
+ PS=1.22u PD=0.72u rfmode=0
M$28081 \$651 \$386 \$578 VDD sg13_lv_pmos L=0.13u W=0.42u AS=0.063p AD=0.0798p
+ PS=0.72u PD=0.8u rfmode=0
M$28082 \$578 \$579 \$382 VDD sg13_lv_pmos L=0.13u W=0.42u AS=0.0798p
+ AD=0.1428p PS=0.8u PD=1.52u rfmode=0
M$28083 VDD \$708 \$709 VDD sg13_lv_pmos L=0.13u W=1u AS=0.3623875p AD=0.34p
+ PS=2.605u PD=2.68u rfmode=0
M$28084 VDD \$380 \$707 VDD sg13_lv_pmos L=0.13u W=0.42u AS=0.3623875p
+ AD=0.0798p PS=2.605u PD=0.8u rfmode=0
M$28085 \$707 \$101 VDD VDD sg13_lv_pmos L=0.13u W=0.42u AS=0.0798p AD=0.1428p
+ PS=0.8u PD=1.52u rfmode=0
M$28086 VDD \$710 \$389 VDD sg13_lv_pmos L=0.13u W=17.92u AS=3.5896p AD=3.4048p
+ PS=25.45u PD=24u rfmode=0
M$28102 VDD \$226 \$710 VDD sg13_lv_pmos L=0.13u W=6.72u AS=1.2768p AD=1.4448p
+ PS=9u PD=10.42u rfmode=0
M$28108 \$580 \$392 VDD VDD sg13_lv_pmos L=0.13u W=0.42u AS=0.147p AD=0.1563p
+ PS=1.54u PD=1.22u rfmode=0
M$28109 VDD \$394 \$658 VDD sg13_lv_pmos L=0.13u W=0.42u AS=0.1563p AD=0.063p
+ PS=1.22u PD=0.72u rfmode=0
M$28110 \$658 \$396 \$580 VDD sg13_lv_pmos L=0.13u W=0.42u AS=0.063p AD=0.0798p
+ PS=0.72u PD=0.8u rfmode=0
M$28111 \$580 \$581 \$393 VDD sg13_lv_pmos L=0.13u W=0.42u AS=0.0798p
+ AD=0.1428p PS=0.8u PD=1.52u rfmode=0
M$28116 VDD \$402 \$711 VDD sg13_lv_pmos L=0.13u W=0.42u AS=0.1523p AD=0.1428p
+ PS=1.38u PD=1.52u rfmode=0
M$28117 VDD \$711 \$712 VDD sg13_lv_pmos L=0.5u W=1u AS=0.1523p AD=0.34p
+ PS=1.38u PD=2.68u rfmode=0
M$28118 VDD \$712 \$713 VDD sg13_lv_pmos L=0.5u W=1u AS=0.2254p AD=0.34p
+ PS=1.53u PD=2.68u rfmode=0
M$28119 VDD \$713 \$714 VDD sg13_lv_pmos L=0.13u W=1.12u AS=0.2254p AD=0.4256p
+ PS=1.53u PD=3u rfmode=0
M$28120 VDD \$714 \$715 VDD sg13_lv_pmos L=0.13u W=0.42u AS=0.1428p AD=0.0798p
+ PS=1.52u PD=0.8u rfmode=0
M$28121 VDD \$401 \$715 VDD sg13_lv_pmos L=0.13u W=0.42u AS=0.3623875p
+ AD=0.0798p PS=2.605u PD=0.8u rfmode=0
M$28122 VDD \$716 \$717 VDD sg13_lv_pmos L=0.13u W=1u AS=0.3623875p AD=0.34p
+ PS=2.605u PD=2.68u rfmode=0
M$28123 VDD \$719 \$718 VDD sg13_lv_pmos L=0.13u W=1.12u AS=0.41165p AD=0.3864p
+ PS=2.12u PD=2.93u rfmode=0
M$28124 VDD \$389 \$719 VDD sg13_lv_pmos L=0.13u W=1.12u AS=0.41165p AD=0.4088p
+ PS=2.12u PD=2.97u rfmode=0
M$28125 \$717 \$719 \$720 VDD sg13_lv_pmos L=0.13u W=1u AS=0.34p AD=0.2048p
+ PS=2.68u PD=1.63u rfmode=0
M$28126 \$720 \$718 \$805 VDD sg13_lv_pmos L=0.13u W=0.42u AS=0.2048p
+ AD=0.09345p PS=1.63u PD=0.865u rfmode=0
M$28127 VDD \$721 \$805 VDD sg13_lv_pmos L=0.13u W=0.42u AS=0.204p AD=0.09345p
+ PS=1.835u PD=0.865u rfmode=0
M$28128 VDD \$401 \$721 VDD sg13_lv_pmos L=0.13u W=0.42u AS=0.204p AD=0.0798p
+ PS=1.835u PD=0.8u rfmode=0
M$28129 VDD \$720 \$721 VDD sg13_lv_pmos L=0.13u W=0.42u AS=0.4659p AD=0.0798p
+ PS=3.65u PD=0.8u rfmode=0
M$28130 \$722 \$720 VDD VDD sg13_lv_pmos L=0.13u W=1.12u AS=0.3864p AD=0.2128p
+ PS=2.93u PD=1.5u rfmode=0
M$28131 VDD \$722 \$214 VDD sg13_lv_pmos L=0.13u W=1.12u AS=0.2128p AD=0.3808p
+ PS=1.5u PD=2.92u rfmode=0
M$28132 \$404 \$723 VDD VDD sg13_lv_pmos L=0.13u W=1.12u AS=0.4256p AD=0.2254p
+ PS=3u PD=1.53u rfmode=0
M$28133 VDD \$724 \$723 VDD sg13_lv_pmos L=0.5u W=1u AS=0.2254p AD=0.34p
+ PS=1.53u PD=2.68u rfmode=0
M$28134 VDD \$214 \$725 VDD sg13_lv_pmos L=0.13u W=0.42u AS=0.1523p AD=0.1428p
+ PS=1.38u PD=1.52u rfmode=0
M$28135 \$724 \$725 VDD VDD sg13_lv_pmos L=0.5u W=1u AS=0.34p AD=0.1523p
+ PS=2.68u PD=1.38u rfmode=0
M$28138 \$582 \$216 VDD VDD sg13_lv_pmos L=0.13u W=0.42u AS=0.147p AD=0.1563p
+ PS=1.54u PD=1.22u rfmode=0
M$28139 VDD \$414 \$648 VDD sg13_lv_pmos L=0.13u W=0.42u AS=0.1563p AD=0.063p
+ PS=1.22u PD=0.72u rfmode=0
M$28140 \$648 \$416 \$582 VDD sg13_lv_pmos L=0.13u W=0.42u AS=0.063p AD=0.0798p
+ PS=0.72u PD=0.8u rfmode=0
M$28141 \$582 \$583 \$413 VDD sg13_lv_pmos L=0.13u W=0.42u AS=0.0798p
+ AD=0.1428p PS=0.8u PD=1.52u rfmode=0
M$28151 VDD \$424 \$726 VDD sg13_lv_pmos L=0.13u W=0.42u AS=0.1523p AD=0.1428p
+ PS=1.38u PD=1.52u rfmode=0
M$28152 VDD \$726 \$727 VDD sg13_lv_pmos L=0.5u W=1u AS=0.1523p AD=0.34p
+ PS=1.38u PD=2.68u rfmode=0
M$28153 VDD \$727 \$728 VDD sg13_lv_pmos L=0.5u W=1u AS=0.2254p AD=0.34p
+ PS=1.53u PD=2.68u rfmode=0
M$28154 VDD \$728 \$729 VDD sg13_lv_pmos L=0.13u W=1.12u AS=0.2254p AD=0.4256p
+ PS=1.53u PD=3u rfmode=0
M$28155 VDD \$729 \$730 VDD sg13_lv_pmos L=0.13u W=0.42u AS=0.1428p AD=0.0798p
+ PS=1.52u PD=0.8u rfmode=0
M$28156 VDD \$422 \$730 VDD sg13_lv_pmos L=0.13u W=0.42u AS=0.3623875p
+ AD=0.0798p PS=2.605u PD=0.8u rfmode=0
M$28157 VDD \$731 \$732 VDD sg13_lv_pmos L=0.13u W=1u AS=0.3623875p AD=0.34p
+ PS=2.605u PD=2.68u rfmode=0
M$28158 VDD \$734 \$733 VDD sg13_lv_pmos L=0.13u W=1.12u AS=0.41165p AD=0.3864p
+ PS=2.12u PD=2.93u rfmode=0
M$28159 VDD \$417 \$734 VDD sg13_lv_pmos L=0.13u W=1.12u AS=0.41165p AD=0.4088p
+ PS=2.12u PD=2.97u rfmode=0
M$28160 \$732 \$734 \$735 VDD sg13_lv_pmos L=0.13u W=1u AS=0.34p AD=0.2048p
+ PS=2.68u PD=1.63u rfmode=0
M$28161 \$735 \$733 \$807 VDD sg13_lv_pmos L=0.13u W=0.42u AS=0.2048p
+ AD=0.09345p PS=1.63u PD=0.865u rfmode=0
M$28162 VDD \$736 \$807 VDD sg13_lv_pmos L=0.13u W=0.42u AS=0.204p AD=0.09345p
+ PS=1.835u PD=0.865u rfmode=0
M$28163 VDD \$422 \$736 VDD sg13_lv_pmos L=0.13u W=0.42u AS=0.204p AD=0.0798p
+ PS=1.835u PD=0.8u rfmode=0
M$28164 VDD \$735 \$736 VDD sg13_lv_pmos L=0.13u W=0.42u AS=0.4659p AD=0.0798p
+ PS=3.65u PD=0.8u rfmode=0
M$28165 \$737 \$735 VDD VDD sg13_lv_pmos L=0.13u W=1.12u AS=0.3864p AD=0.2128p
+ PS=2.93u PD=1.5u rfmode=0
M$28166 VDD \$737 \$223 VDD sg13_lv_pmos L=0.13u W=1.12u AS=0.2128p AD=0.3808p
+ PS=1.5u PD=2.92u rfmode=0
M$28173 \$584 \$121 VDD VDD sg13_lv_pmos L=0.13u W=0.42u AS=0.147p AD=0.1563p
+ PS=1.54u PD=1.22u rfmode=0
M$28174 VDD \$440 \$635 VDD sg13_lv_pmos L=0.13u W=0.42u AS=0.1563p AD=0.063p
+ PS=1.22u PD=0.72u rfmode=0
M$28175 \$635 \$442 \$584 VDD sg13_lv_pmos L=0.13u W=0.42u AS=0.063p AD=0.0798p
+ PS=0.72u PD=0.8u rfmode=0
M$28176 \$584 \$585 \$439 VDD sg13_lv_pmos L=0.13u W=0.42u AS=0.0798p
+ AD=0.1428p PS=0.8u PD=1.52u rfmode=0
M$28189 \$449 \$738 VDD VDD sg13_lv_pmos L=0.13u W=1.12u AS=0.4256p AD=0.2254p
+ PS=3u PD=1.53u rfmode=0
M$28190 VDD \$739 \$738 VDD sg13_lv_pmos L=0.5u W=1u AS=0.2254p AD=0.34p
+ PS=1.53u PD=2.68u rfmode=0
M$28191 \$586 \$447 VDD VDD sg13_lv_pmos L=0.13u W=0.42u AS=0.147p AD=0.1563p
+ PS=1.54u PD=1.22u rfmode=0
M$28192 VDD \$450 \$630 VDD sg13_lv_pmos L=0.13u W=0.42u AS=0.1563p AD=0.063p
+ PS=1.22u PD=0.72u rfmode=0
M$28193 \$630 \$452 \$586 VDD sg13_lv_pmos L=0.13u W=0.42u AS=0.063p AD=0.0798p
+ PS=0.72u PD=0.8u rfmode=0
M$28194 \$586 \$587 \$448 VDD sg13_lv_pmos L=0.13u W=0.42u AS=0.0798p
+ AD=0.1428p PS=0.8u PD=1.52u rfmode=0
M$28195 VDD \$227 \$740 VDD sg13_lv_pmos L=0.13u W=0.42u AS=0.1523p AD=0.1428p
+ PS=1.38u PD=1.52u rfmode=0
M$28196 \$739 \$740 VDD VDD sg13_lv_pmos L=0.5u W=1u AS=0.34p AD=0.1523p
+ PS=2.68u PD=1.38u rfmode=0
M$28198 VDD \$303 \$741 VDD sg13_lv_pmos L=0.13u W=0.42u AS=0.1523p AD=0.1428p
+ PS=1.38u PD=1.52u rfmode=0
M$28199 VDD \$741 \$742 VDD sg13_lv_pmos L=0.5u W=1u AS=0.1523p AD=0.34p
+ PS=1.38u PD=2.68u rfmode=0
M$28200 VDD \$742 \$743 VDD sg13_lv_pmos L=0.5u W=1u AS=0.2254p AD=0.34p
+ PS=1.53u PD=2.68u rfmode=0
M$28201 VDD \$743 \$437 VDD sg13_lv_pmos L=0.13u W=1.12u AS=0.2254p AD=0.4256p
+ PS=1.53u PD=3u rfmode=0
M$28202 VDD \$304 \$745 VDD sg13_lv_pmos L=0.13u W=0.84u AS=0.2114p AD=0.2856p
+ PS=1.54u PD=2.36u rfmode=0
M$28203 dout[7] \$745 VDD VDD sg13_lv_pmos L=0.13u W=1.12u AS=0.42p AD=0.2114p
+ PS=2.99u PD=1.54u rfmode=0
M$28212 VDD \$226 \$746 VDD sg13_lv_pmos L=0.13u W=6.72u AS=1.4448p AD=1.2768p
+ PS=10.42u PD=9u rfmode=0
M$28218 VDD \$746 \$417 VDD sg13_lv_pmos L=0.13u W=17.92u AS=3.4048p AD=3.5896p
+ PS=24u PD=25.45u rfmode=0
M$28234 \$588 \$233 VDD VDD sg13_lv_pmos L=0.13u W=0.42u AS=0.147p AD=0.1563p
+ PS=1.54u PD=1.22u rfmode=0
M$28235 VDD \$462 \$622 VDD sg13_lv_pmos L=0.13u W=0.42u AS=0.1563p AD=0.063p
+ PS=1.22u PD=0.72u rfmode=0
M$28236 \$622 \$464 \$588 VDD sg13_lv_pmos L=0.13u W=0.42u AS=0.063p AD=0.0798p
+ PS=0.72u PD=0.8u rfmode=0
M$28237 \$588 \$589 \$461 VDD sg13_lv_pmos L=0.13u W=0.42u AS=0.0798p
+ AD=0.1428p PS=0.8u PD=1.52u rfmode=0
M$28239 VDD \$470 \$747 VDD sg13_lv_pmos L=0.13u W=0.42u AS=0.1523p AD=0.1428p
+ PS=1.38u PD=1.52u rfmode=0
M$28240 VDD \$747 \$748 VDD sg13_lv_pmos L=0.5u W=1u AS=0.1523p AD=0.34p
+ PS=1.38u PD=2.68u rfmode=0
M$28241 VDD \$748 \$749 VDD sg13_lv_pmos L=0.5u W=1u AS=0.2254p AD=0.34p
+ PS=1.53u PD=2.68u rfmode=0
M$28242 VDD \$749 \$750 VDD sg13_lv_pmos L=0.13u W=1.12u AS=0.2254p AD=0.4256p
+ PS=1.53u PD=3u rfmode=0
M$28243 VDD \$750 \$751 VDD sg13_lv_pmos L=0.13u W=0.42u AS=0.1428p AD=0.0798p
+ PS=1.52u PD=0.8u rfmode=0
M$28244 VDD \$474 \$751 VDD sg13_lv_pmos L=0.13u W=0.42u AS=0.3623875p
+ AD=0.0798p PS=2.605u PD=0.8u rfmode=0
M$28245 VDD \$752 \$753 VDD sg13_lv_pmos L=0.13u W=1u AS=0.3623875p AD=0.34p
+ PS=2.605u PD=2.68u rfmode=0
M$28246 VDD \$755 \$754 VDD sg13_lv_pmos L=0.13u W=1.12u AS=0.41165p AD=0.3864p
+ PS=2.12u PD=2.93u rfmode=0
M$28247 VDD \$417 \$755 VDD sg13_lv_pmos L=0.13u W=1.12u AS=0.41165p AD=0.4088p
+ PS=2.12u PD=2.97u rfmode=0
M$28248 \$753 \$755 \$756 VDD sg13_lv_pmos L=0.13u W=1u AS=0.34p AD=0.2048p
+ PS=2.68u PD=1.63u rfmode=0
M$28249 \$756 \$754 \$811 VDD sg13_lv_pmos L=0.13u W=0.42u AS=0.2048p
+ AD=0.09345p PS=1.63u PD=0.865u rfmode=0
M$28250 VDD \$757 \$811 VDD sg13_lv_pmos L=0.13u W=0.42u AS=0.204p AD=0.09345p
+ PS=1.835u PD=0.865u rfmode=0
M$28251 VDD \$474 \$757 VDD sg13_lv_pmos L=0.13u W=0.42u AS=0.204p AD=0.0798p
+ PS=1.835u PD=0.8u rfmode=0
M$28252 VDD \$756 \$757 VDD sg13_lv_pmos L=0.13u W=0.42u AS=0.4659p AD=0.0798p
+ PS=3.65u PD=0.8u rfmode=0
M$28253 \$758 \$756 VDD VDD sg13_lv_pmos L=0.13u W=1.12u AS=0.3864p AD=0.2128p
+ PS=2.93u PD=1.5u rfmode=0
M$28254 VDD \$758 \$590 VDD sg13_lv_pmos L=0.13u W=1.12u AS=0.2128p AD=0.3808p
+ PS=1.5u PD=2.92u rfmode=0
M$28255 \$472 \$759 VDD VDD sg13_lv_pmos L=0.13u W=1.12u AS=0.4256p AD=0.2254p
+ PS=3u PD=1.53u rfmode=0
M$28256 VDD \$760 \$759 VDD sg13_lv_pmos L=0.5u W=1u AS=0.2254p AD=0.34p
+ PS=1.53u PD=2.68u rfmode=0
M$28257 VDD \$590 \$761 VDD sg13_lv_pmos L=0.13u W=0.42u AS=0.1523p AD=0.1428p
+ PS=1.38u PD=1.52u rfmode=0
M$28258 \$760 \$761 VDD VDD sg13_lv_pmos L=0.5u W=1u AS=0.34p AD=0.1523p
+ PS=2.68u PD=1.38u rfmode=0
M$28259 VDD \$226 \$762 VDD sg13_lv_pmos L=0.13u W=6.72u AS=1.4448p AD=1.2768p
+ PS=10.42u PD=9u rfmode=0
M$28265 VDD \$762 \$763 VDD sg13_lv_pmos L=0.13u W=17.92u AS=3.4048p AD=3.5896p
+ PS=24u PD=25.45u rfmode=0
M$28281 \$591 \$234 VDD VDD sg13_lv_pmos L=0.13u W=0.42u AS=0.147p AD=0.1563p
+ PS=1.54u PD=1.22u rfmode=0
M$28282 VDD \$484 \$615 VDD sg13_lv_pmos L=0.13u W=0.42u AS=0.1563p AD=0.063p
+ PS=1.22u PD=0.72u rfmode=0
M$28283 \$615 \$486 \$591 VDD sg13_lv_pmos L=0.13u W=0.42u AS=0.063p AD=0.0798p
+ PS=0.72u PD=0.8u rfmode=0
M$28284 \$591 \$592 \$483 VDD sg13_lv_pmos L=0.13u W=0.42u AS=0.0798p
+ AD=0.1428p PS=0.8u PD=1.52u rfmode=0
M$28285 VDD \$764 \$765 VDD sg13_lv_pmos L=0.13u W=0.84u AS=0.2114p AD=0.2856p
+ PS=1.54u PD=2.36u rfmode=0
M$28286 \$323 \$765 VDD VDD sg13_lv_pmos L=0.13u W=1.12u AS=0.42p AD=0.2114p
+ PS=2.99u PD=1.54u rfmode=0
M$28287 VDD \$493 \$766 VDD sg13_lv_pmos L=0.13u W=0.42u AS=0.1523p AD=0.1428p
+ PS=1.38u PD=1.52u rfmode=0
M$28288 VDD \$766 \$767 VDD sg13_lv_pmos L=0.5u W=1u AS=0.1523p AD=0.34p
+ PS=1.38u PD=2.68u rfmode=0
M$28289 VDD \$767 \$768 VDD sg13_lv_pmos L=0.5u W=1u AS=0.2254p AD=0.34p
+ PS=1.53u PD=2.68u rfmode=0
M$28290 VDD \$768 \$305 VDD sg13_lv_pmos L=0.13u W=1.12u AS=0.2254p AD=0.4256p
+ PS=1.53u PD=3u rfmode=0
M$28291 VDD \$495 \$769 VDD sg13_lv_pmos L=0.13u W=0.42u AS=0.1428p AD=0.0798p
+ PS=1.52u PD=0.8u rfmode=0
M$28292 VDD \$505 \$769 VDD sg13_lv_pmos L=0.13u W=0.42u AS=0.3623875p
+ AD=0.0798p PS=2.605u PD=0.8u rfmode=0
M$28293 VDD \$770 \$771 VDD sg13_lv_pmos L=0.13u W=1u AS=0.3623875p AD=0.34p
+ PS=2.605u PD=2.68u rfmode=0
M$28294 VDD \$773 \$772 VDD sg13_lv_pmos L=0.13u W=1.12u AS=0.41165p AD=0.3864p
+ PS=2.12u PD=2.93u rfmode=0
M$28295 VDD \$763 \$773 VDD sg13_lv_pmos L=0.13u W=1.12u AS=0.41165p AD=0.4088p
+ PS=2.12u PD=2.97u rfmode=0
M$28296 \$771 \$773 \$774 VDD sg13_lv_pmos L=0.13u W=1u AS=0.34p AD=0.2048p
+ PS=2.68u PD=1.63u rfmode=0
M$28297 \$774 \$772 \$813 VDD sg13_lv_pmos L=0.13u W=0.42u AS=0.2048p
+ AD=0.09345p PS=1.63u PD=0.865u rfmode=0
M$28298 VDD \$775 \$813 VDD sg13_lv_pmos L=0.13u W=0.42u AS=0.204p AD=0.09345p
+ PS=1.835u PD=0.865u rfmode=0
M$28299 VDD \$505 \$775 VDD sg13_lv_pmos L=0.13u W=0.42u AS=0.204p AD=0.0798p
+ PS=1.835u PD=0.8u rfmode=0
M$28300 VDD \$774 \$775 VDD sg13_lv_pmos L=0.13u W=0.42u AS=0.4659p AD=0.0798p
+ PS=3.65u PD=0.8u rfmode=0
M$28301 \$776 \$774 VDD VDD sg13_lv_pmos L=0.13u W=1.12u AS=0.3864p AD=0.2128p
+ PS=2.93u PD=1.5u rfmode=0
M$28302 VDD \$776 \$503 VDD sg13_lv_pmos L=0.13u W=1.12u AS=0.2128p AD=0.3808p
+ PS=1.5u PD=2.92u rfmode=0
M$28303 VDD \$503 \$778 VDD sg13_lv_pmos L=0.13u W=0.84u AS=0.2114p AD=0.2856p
+ PS=1.54u PD=2.36u rfmode=0
M$28304 dout[9] \$778 VDD VDD sg13_lv_pmos L=0.13u W=1.12u AS=0.42p AD=0.2114p
+ PS=2.99u PD=1.54u rfmode=0
M$28305 VDD \$764 \$779 VDD sg13_lv_pmos L=0.13u W=0.84u AS=0.2114p AD=0.2856p
+ PS=1.54u PD=2.36u rfmode=0
M$28306 \$74 \$779 VDD VDD sg13_lv_pmos L=0.13u W=1.12u AS=0.42p AD=0.2114p
+ PS=2.99u PD=1.54u rfmode=0
M$28308 \$511 \$780 VDD VDD sg13_lv_pmos L=0.13u W=1.12u AS=0.4256p AD=0.2254p
+ PS=3u PD=1.53u rfmode=0
M$28309 VDD \$781 \$780 VDD sg13_lv_pmos L=0.5u W=1u AS=0.2254p AD=0.34p
+ PS=1.53u PD=2.68u rfmode=0
M$28310 VDD \$791 \$782 VDD sg13_lv_pmos L=0.13u W=0.42u AS=0.1523p AD=0.1428p
+ PS=1.38u PD=1.52u rfmode=0
M$28311 \$781 \$782 VDD VDD sg13_lv_pmos L=0.5u W=1u AS=0.34p AD=0.1523p
+ PS=2.68u PD=1.38u rfmode=0
M$28312 VDD \$512 \$783 VDD sg13_lv_pmos L=0.13u W=0.42u AS=0.1428p AD=0.0798p
+ PS=1.52u PD=0.8u rfmode=0
M$28313 VDD \$514 \$783 VDD sg13_lv_pmos L=0.13u W=0.42u AS=0.3623875p
+ AD=0.0798p PS=2.605u PD=0.8u rfmode=0
M$28314 VDD \$784 \$785 VDD sg13_lv_pmos L=0.13u W=1u AS=0.3623875p AD=0.34p
+ PS=2.605u PD=2.68u rfmode=0
M$28315 VDD \$787 \$786 VDD sg13_lv_pmos L=0.13u W=1.12u AS=0.41165p AD=0.3864p
+ PS=2.12u PD=2.93u rfmode=0
M$28316 VDD \$763 \$787 VDD sg13_lv_pmos L=0.13u W=1.12u AS=0.41165p AD=0.4088p
+ PS=2.12u PD=2.97u rfmode=0
M$28317 \$785 \$787 \$788 VDD sg13_lv_pmos L=0.13u W=1u AS=0.34p AD=0.2048p
+ PS=2.68u PD=1.63u rfmode=0
M$28318 \$788 \$786 \$808 VDD sg13_lv_pmos L=0.13u W=0.42u AS=0.2048p
+ AD=0.09345p PS=1.63u PD=0.865u rfmode=0
M$28319 VDD \$789 \$808 VDD sg13_lv_pmos L=0.13u W=0.42u AS=0.204p AD=0.09345p
+ PS=1.835u PD=0.865u rfmode=0
M$28320 VDD \$514 \$789 VDD sg13_lv_pmos L=0.13u W=0.42u AS=0.204p AD=0.0798p
+ PS=1.835u PD=0.8u rfmode=0
M$28321 VDD \$788 \$789 VDD sg13_lv_pmos L=0.13u W=0.42u AS=0.4659p AD=0.0798p
+ PS=3.65u PD=0.8u rfmode=0
M$28322 \$593 \$513 VDD VDD sg13_lv_pmos L=0.13u W=0.42u AS=0.147p AD=0.1563p
+ PS=1.54u PD=1.22u rfmode=0
M$28323 VDD \$518 \$604 VDD sg13_lv_pmos L=0.13u W=0.42u AS=0.1563p AD=0.063p
+ PS=1.22u PD=0.72u rfmode=0
M$28324 \$604 \$520 \$593 VDD sg13_lv_pmos L=0.13u W=0.42u AS=0.063p AD=0.0798p
+ PS=0.72u PD=0.8u rfmode=0
M$28325 \$593 \$594 \$517 VDD sg13_lv_pmos L=0.13u W=0.42u AS=0.0798p
+ AD=0.1428p PS=0.8u PD=1.52u rfmode=0
M$28326 \$790 \$788 VDD VDD sg13_lv_pmos L=0.13u W=1.12u AS=0.3864p AD=0.2128p
+ PS=2.93u PD=1.5u rfmode=0
M$28327 VDD \$790 \$791 VDD sg13_lv_pmos L=0.13u W=1.12u AS=0.2128p AD=0.3808p
+ PS=1.5u PD=2.92u rfmode=0
M$28340 VDD \$791 \$793 VDD sg13_lv_pmos L=0.13u W=0.84u AS=0.2114p AD=0.2856p
+ PS=1.54u PD=2.36u rfmode=0
M$28341 dout[10] \$793 VDD VDD sg13_lv_pmos L=0.13u W=1.12u AS=0.42p AD=0.2114p
+ PS=2.99u PD=1.54u rfmode=0
M$28367 VDD \$525 \$795 VDD sg13_lv_pmos L=0.13u W=0.84u AS=0.2114p AD=0.2856p
+ PS=1.54u PD=2.36u rfmode=0
M$28368 dout[11] \$795 VDD VDD sg13_lv_pmos L=0.13u W=1.12u AS=0.42p AD=0.2114p
+ PS=2.99u PD=1.54u rfmode=0
M$28381 VDD \$351 \$668 VDD sg13_lv_pmos L=0.13u W=0.42u AS=0.1563p AD=0.147p
+ PS=1.22u PD=1.54u rfmode=0
M$28382 VDD \$669 \$796 VDD sg13_lv_pmos L=0.13u W=0.42u AS=0.1563p AD=0.063p
+ PS=1.22u PD=0.72u rfmode=0
M$28383 \$796 \$671 \$668 VDD sg13_lv_pmos L=0.13u W=0.42u AS=0.063p AD=0.0798p
+ PS=0.72u PD=0.8u rfmode=0
M$28384 \$668 \$670 \$667 VDD sg13_lv_pmos L=0.13u W=0.42u AS=0.0798p
+ AD=0.1428p PS=0.8u PD=1.52u rfmode=0
M$28385 VDD \$363 \$683 VDD sg13_lv_pmos L=0.13u W=0.42u AS=0.1563p AD=0.147p
+ PS=1.22u PD=1.54u rfmode=0
M$28386 VDD \$684 \$798 VDD sg13_lv_pmos L=0.13u W=0.42u AS=0.1563p AD=0.063p
+ PS=1.22u PD=0.72u rfmode=0
M$28387 \$798 \$686 \$683 VDD sg13_lv_pmos L=0.13u W=0.42u AS=0.063p AD=0.0798p
+ PS=0.72u PD=0.8u rfmode=0
M$28388 \$683 \$685 \$682 VDD sg13_lv_pmos L=0.13u W=0.42u AS=0.0798p
+ AD=0.1428p PS=0.8u PD=1.52u rfmode=0
M$28389 VDD \$818 \$691 VDD sg13_lv_pmos L=0.13u W=0.42u AS=0.4659p AD=0.0798p
+ PS=3.65u PD=0.8u rfmode=0
M$28390 VDD \$192 \$691 VDD sg13_lv_pmos L=0.13u W=0.42u AS=0.204p AD=0.0798p
+ PS=1.835u PD=0.8u rfmode=0
M$28391 VDD \$691 \$800 VDD sg13_lv_pmos L=0.13u W=0.42u AS=0.204p AD=0.09345p
+ PS=1.835u PD=0.865u rfmode=0
M$28392 \$818 \$692 \$800 VDD sg13_lv_pmos L=0.13u W=0.42u AS=0.2048p
+ AD=0.09345p PS=1.63u PD=0.865u rfmode=0
M$28393 \$818 \$693 \$696 VDD sg13_lv_pmos L=0.13u W=1u AS=0.2048p AD=0.34p
+ PS=1.63u PD=2.68u rfmode=0
M$28394 \$694 \$692 \$695 VDD sg13_lv_pmos L=0.13u W=0.42u AS=0.1428p
+ AD=0.0798p PS=1.52u PD=0.8u rfmode=0
M$28395 \$695 \$693 \$801 VDD sg13_lv_pmos L=0.13u W=0.42u AS=0.0798p AD=0.063p
+ PS=0.8u PD=0.72u rfmode=0
M$28396 VDD \$696 \$801 VDD sg13_lv_pmos L=0.13u W=0.42u AS=0.1563p AD=0.063p
+ PS=1.22u PD=0.72u rfmode=0
M$28397 VDD \$192 \$695 VDD sg13_lv_pmos L=0.13u W=0.42u AS=0.1563p AD=0.147p
+ PS=1.22u PD=1.54u rfmode=0
M$28398 VDD \$821 \$704 VDD sg13_lv_pmos L=0.13u W=0.42u AS=0.4659p AD=0.0798p
+ PS=3.65u PD=0.8u rfmode=0
M$28399 VDD \$380 \$704 VDD sg13_lv_pmos L=0.13u W=0.42u AS=0.204p AD=0.0798p
+ PS=1.835u PD=0.8u rfmode=0
M$28400 VDD \$704 \$802 VDD sg13_lv_pmos L=0.13u W=0.42u AS=0.204p AD=0.09345p
+ PS=1.835u PD=0.865u rfmode=0
M$28401 \$821 \$705 \$802 VDD sg13_lv_pmos L=0.13u W=0.42u AS=0.2048p
+ AD=0.09345p PS=1.63u PD=0.865u rfmode=0
M$28402 \$821 \$706 \$709 VDD sg13_lv_pmos L=0.13u W=1u AS=0.2048p AD=0.34p
+ PS=1.63u PD=2.68u rfmode=0
M$28403 \$707 \$705 \$708 VDD sg13_lv_pmos L=0.13u W=0.42u AS=0.1428p
+ AD=0.0798p PS=1.52u PD=0.8u rfmode=0
M$28404 \$708 \$706 \$803 VDD sg13_lv_pmos L=0.13u W=0.42u AS=0.0798p AD=0.063p
+ PS=0.8u PD=0.72u rfmode=0
M$28405 VDD \$709 \$803 VDD sg13_lv_pmos L=0.13u W=0.42u AS=0.1563p AD=0.063p
+ PS=1.22u PD=0.72u rfmode=0
M$28406 VDD \$380 \$708 VDD sg13_lv_pmos L=0.13u W=0.42u AS=0.1563p AD=0.147p
+ PS=1.22u PD=1.54u rfmode=0
M$28407 VDD \$401 \$716 VDD sg13_lv_pmos L=0.13u W=0.42u AS=0.1563p AD=0.147p
+ PS=1.22u PD=1.54u rfmode=0
M$28408 VDD \$717 \$804 VDD sg13_lv_pmos L=0.13u W=0.42u AS=0.1563p AD=0.063p
+ PS=1.22u PD=0.72u rfmode=0
M$28409 \$804 \$719 \$716 VDD sg13_lv_pmos L=0.13u W=0.42u AS=0.063p AD=0.0798p
+ PS=0.72u PD=0.8u rfmode=0
M$28410 \$716 \$718 \$715 VDD sg13_lv_pmos L=0.13u W=0.42u AS=0.0798p
+ AD=0.1428p PS=0.8u PD=1.52u rfmode=0
M$28411 VDD \$422 \$731 VDD sg13_lv_pmos L=0.13u W=0.42u AS=0.1563p AD=0.147p
+ PS=1.22u PD=1.54u rfmode=0
M$28412 VDD \$732 \$806 VDD sg13_lv_pmos L=0.13u W=0.42u AS=0.1563p AD=0.063p
+ PS=1.22u PD=0.72u rfmode=0
M$28413 \$806 \$734 \$731 VDD sg13_lv_pmos L=0.13u W=0.42u AS=0.063p AD=0.0798p
+ PS=0.72u PD=0.8u rfmode=0
M$28414 \$731 \$733 \$730 VDD sg13_lv_pmos L=0.13u W=0.42u AS=0.0798p
+ AD=0.1428p PS=0.8u PD=1.52u rfmode=0
M$28415 VDD \$474 \$752 VDD sg13_lv_pmos L=0.13u W=0.42u AS=0.1563p AD=0.147p
+ PS=1.22u PD=1.54u rfmode=0
M$28416 VDD \$753 \$810 VDD sg13_lv_pmos L=0.13u W=0.42u AS=0.1563p AD=0.063p
+ PS=1.22u PD=0.72u rfmode=0
M$28417 \$810 \$755 \$752 VDD sg13_lv_pmos L=0.13u W=0.42u AS=0.063p AD=0.0798p
+ PS=0.72u PD=0.8u rfmode=0
M$28418 \$752 \$754 \$751 VDD sg13_lv_pmos L=0.13u W=0.42u AS=0.0798p
+ AD=0.1428p PS=0.8u PD=1.52u rfmode=0
M$28419 VDD \$505 \$770 VDD sg13_lv_pmos L=0.13u W=0.42u AS=0.1563p AD=0.147p
+ PS=1.22u PD=1.54u rfmode=0
M$28420 VDD \$771 \$812 VDD sg13_lv_pmos L=0.13u W=0.42u AS=0.1563p AD=0.063p
+ PS=1.22u PD=0.72u rfmode=0
M$28421 \$812 \$773 \$770 VDD sg13_lv_pmos L=0.13u W=0.42u AS=0.063p AD=0.0798p
+ PS=0.72u PD=0.8u rfmode=0
M$28422 \$770 \$772 \$769 VDD sg13_lv_pmos L=0.13u W=0.42u AS=0.0798p
+ AD=0.1428p PS=0.8u PD=1.52u rfmode=0
M$28423 VDD \$514 \$784 VDD sg13_lv_pmos L=0.13u W=0.42u AS=0.1563p AD=0.147p
+ PS=1.22u PD=1.54u rfmode=0
M$28424 VDD \$785 \$809 VDD sg13_lv_pmos L=0.13u W=0.42u AS=0.1563p AD=0.063p
+ PS=1.22u PD=0.72u rfmode=0
M$28425 \$809 \$787 \$784 VDD sg13_lv_pmos L=0.13u W=0.42u AS=0.063p AD=0.0798p
+ PS=0.72u PD=0.8u rfmode=0
M$28426 \$784 \$786 \$783 VDD sg13_lv_pmos L=0.13u W=0.42u AS=0.0798p
+ AD=0.1428p PS=0.8u PD=1.52u rfmode=0
.ENDS serial2parallel

.SUBCKT user_project_wrapper \$1 IOVDD IOVSS analog_io[19] analog_io[18]
+ analog_io[17] uo_PAD[3] uo_PAD[2] uo_PAD[1] uo_PAD[0] ui_PAD[6] ui_PAD[5] VDD
+ VSS ui_p2c[5] ui_p2c[6] uo_c2p[0] uo_c2p[1] uo_c2p[2] uo_c2p[3]
+ analog_io_padres[17] analog_io_padres[18] analog_io_padres[19] uo_PAD[4]
+ ui_PAD[4] ui_p2c[4] uo_c2p[4] uo_PAD[5] ui_PAD[3] uo_c2p[5] ui_p2c[3]
+ uo_PAD[6] ui_PAD[2] ui_p2c[2] uo_c2p[6] uo_PAD[7] analog_io[16] uo_c2p[7]
+ analog_io_padres[16] uo_PAD[8] analog_io[15] uo_c2p[8] analog_io[0]
+ analog_io[14] analog_io_padres[14] analog_io_padres[15] analog_io[1]
+ ui_PAD[1] ui_p2c[1] analog_io[2] analog_io[13] analog_io_padres[13]
+ analog_io[3] analog_io[12] analog_io_padres[12] analog_io_padres[11]
+ analog_io_padres[8] analog_io_padres[10] ui_p2c[0] analog_io_padres[9]
+ analog_io[4] analog_io[5] analog_io[6] analog_io[7] analog_io[8] analog_io[9]
+ ui_PAD[0] analog_io[10] analog_io[11]
X$1 \$1 IOVSS IOVSS IOVSS VSS sg13g2_Filler4000
X$3 \$1 IOVSS IOVSS IOVSS VSS sg13g2_Filler1000
X$4 \$1 IOVSS IOVSS IOVSS VSS sg13g2_Filler400
X$5 \$1 IOVSS IOVSS IOVSS VSS sg13g2_Filler200
X$6 \$1 IOVDD IOVSS IOVSS VSS sg13g2_IOPadIOVdd
X$8 \$1 IOVSS IOVSS IOVSS VSS sg13g2_Filler4000
X$9 \$1 IOVSS IOVSS IOVSS VSS sg13g2_Filler400
X$10 \$1 IOVSS IOVDD VSS sg13g2_IOPadIOVss
X$12 \$1 IOVSS IOVSS IOVSS VSS sg13g2_Filler4000
X$13 \$1 IOVSS IOVSS IOVSS VSS sg13g2_Filler400
X$14 \$1 analog_io[19] IOVSS IOVDD IOVDD VSS analog_io_padres[19]
+ sg13g2_IOPadAnalog
X$16 \$1 IOVSS IOVSS IOVSS VSS sg13g2_Filler4000
X$17 \$1 IOVSS IOVSS IOVSS VSS sg13g2_Filler400
X$18 \$1 analog_io[18] IOVSS IOVDD IOVDD VSS analog_io_padres[18]
+ sg13g2_IOPadAnalog
X$20 \$1 IOVSS IOVSS IOVSS VSS sg13g2_Filler4000
X$21 \$1 IOVSS IOVSS IOVSS VSS sg13g2_Filler400
X$22 \$1 analog_io[17] IOVSS IOVDD IOVDD VSS analog_io_padres[17]
+ sg13g2_IOPadAnalog
X$24 \$1 IOVSS IOVSS IOVSS VSS sg13g2_Filler4000
X$25 \$1 IOVSS IOVSS IOVSS VSS sg13g2_Filler400
X$26 \$1 uo_PAD[3] IOVSS IOVDD IOVDD VDD VSS uo_c2p[3] sg13g2_IOPadOut30mA
X$28 \$1 IOVSS IOVSS IOVSS VSS sg13g2_Filler4000
X$29 \$1 IOVSS IOVSS IOVSS VSS sg13g2_Filler400
X$30 \$1 uo_PAD[2] IOVSS IOVDD IOVDD VDD VSS uo_c2p[2] sg13g2_IOPadOut30mA
X$32 \$1 IOVSS IOVSS IOVSS VSS sg13g2_Filler4000
X$33 \$1 IOVSS IOVSS IOVSS VSS sg13g2_Filler400
X$34 \$1 uo_PAD[1] IOVSS IOVDD IOVDD VDD VSS uo_c2p[1] sg13g2_IOPadOut30mA
X$36 \$1 IOVSS IOVSS IOVSS VSS sg13g2_Filler4000
X$37 \$1 IOVSS IOVSS IOVSS VSS sg13g2_Filler400
X$38 \$1 uo_PAD[0] IOVSS IOVDD IOVDD VDD VSS uo_c2p[0] sg13g2_IOPadOut30mA
X$40 \$1 IOVSS IOVSS IOVSS VSS sg13g2_Filler4000
X$41 \$1 IOVSS IOVSS IOVSS VSS sg13g2_Filler400
X$42 \$1 ui_PAD[6] IOVSS IOVSS IOVDD VDD VSS ui_p2c[6] sg13g2_IOPadIn
X$44 \$1 IOVSS IOVSS IOVSS VSS sg13g2_Filler4000
X$45 \$1 IOVSS IOVSS IOVSS VSS sg13g2_Filler400
X$46 \$1 ui_PAD[5] IOVSS IOVSS IOVDD VDD VSS ui_p2c[5] sg13g2_IOPadIn
X$48 \$1 IOVSS IOVSS IOVSS VSS sg13g2_Filler4000
X$49 \$1 IOVSS IOVSS IOVSS VSS sg13g2_Filler400
X$50 \$1 VDD IOVSS IOVSS VSS sg13g2_IOPadVdd
X$52 \$1 IOVSS IOVSS IOVSS VSS sg13g2_Filler4000
X$53 \$1 IOVSS IOVSS IOVSS VSS sg13g2_Filler400
X$54 \$1 VSS IOVSS IOVSS IOVDD sg13g2_IOPadVss
X$56 \$1 IOVSS IOVSS IOVSS VSS sg13g2_Filler4000
X$57 \$1 IOVSS IOVSS IOVSS VSS sg13g2_Filler1000
X$58 \$1 IOVSS IOVSS IOVSS VSS sg13g2_Filler400
X$59 \$1 IOVSS IOVSS IOVSS VSS sg13g2_Filler200
X$61 \$1 uo_PAD[4] IOVSS IOVDD IOVDD VDD VSS uo_c2p[4] sg13g2_IOPadOut30mA
X$63 \$1 IOVSS IOVSS IOVSS VSS sg13g2_Filler400
X$64 \$1 IOVSS IOVSS IOVSS VSS sg13g2_Filler4000
X$65 \$1 VSS IOVSS IOVSS IOVDD sg13g2_IOPadVss
X$67 \$1 IOVSS IOVSS IOVSS VSS sg13g2_Filler400
X$68 \$1 IOVSS IOVSS IOVSS VSS sg13g2_Filler4000
X$69 \$1 VDD IOVSS IOVSS VSS sg13g2_IOPadVdd
X$71 \$1 IOVSS IOVSS IOVSS VSS sg13g2_Filler200
X$72 \$1 IOVSS IOVSS IOVSS VSS sg13g2_Filler400
X$73 \$1 IOVSS IOVSS IOVSS VSS sg13g2_Filler1000
X$74 \$1 IOVSS IOVSS IOVSS VSS sg13g2_Filler4000
X$75 \$1 IOVSS IOVSS IOVSS VSS sg13g2_Filler4000
X$76 \$1 IOVSS IOVSS IOVSS VSS sg13g2_Filler400
X$77 \$1 uo_PAD[5] IOVSS IOVDD IOVDD VDD VSS uo_c2p[5] sg13g2_IOPadOut30mA
X$79 \$1 IOVSS IOVSS IOVSS VSS sg13g2_Filler4000
X$80 \$1 IOVSS IOVSS IOVSS VSS sg13g2_Filler400
X$81 \$1 uo_PAD[6] IOVSS IOVDD IOVDD VDD VSS uo_c2p[6] sg13g2_IOPadOut30mA
X$83 \$1 IOVSS IOVSS IOVSS VSS sg13g2_Filler4000
X$84 \$1 IOVSS IOVSS IOVSS VSS sg13g2_Filler400
X$85 \$1 uo_PAD[7] IOVSS IOVDD IOVDD VDD VSS uo_c2p[7] sg13g2_IOPadOut30mA
X$87 \$1 IOVSS IOVSS IOVSS VSS sg13g2_Filler4000
X$88 \$1 IOVSS IOVSS IOVSS VSS sg13g2_Filler400
X$89 \$1 uo_PAD[8] IOVSS IOVDD IOVDD VDD VSS uo_c2p[8] sg13g2_IOPadOut30mA
X$91 \$1 IOVSS IOVSS IOVSS VSS sg13g2_Filler4000
X$92 \$1 IOVSS IOVSS IOVSS VSS sg13g2_Filler1000
X$93 \$1 IOVSS IOVSS IOVSS VSS sg13g2_Filler400
X$94 \$1 IOVSS IOVSS IOVSS VSS sg13g2_Filler200
X$95 \$1 IOVDD IOVSS IOVSS VSS sg13g2_IOPadIOVdd
X$96 \$1 IOVSS IOVSS IOVSS VSS sg13g2_Filler400
X$97 \$1 ui_PAD[2] IOVSS IOVSS IOVDD VDD VSS ui_p2c[2] sg13g2_IOPadIn
X$98 \$1 IOVSS IOVSS IOVSS VSS sg13g2_Filler4000
X$99 \$1 IOVSS IOVSS IOVSS VSS sg13g2_Filler400
X$100 \$1 analog_io[16] IOVSS IOVDD IOVDD VSS analog_io_padres[16]
+ sg13g2_IOPadAnalog
X$101 \$1 IOVSS IOVSS IOVSS VSS sg13g2_Filler4000
X$102 \$1 IOVSS IOVSS IOVSS VSS sg13g2_Filler400
X$103 \$1 analog_io[15] IOVSS IOVDD IOVDD VSS analog_io_padres[15]
+ sg13g2_IOPadAnalog
X$104 \$1 IOVSS IOVSS IOVSS VSS sg13g2_Filler4000
X$105 \$1 IOVSS IOVSS IOVSS VSS sg13g2_Filler400
X$106 \$1 ui_PAD[3] IOVSS IOVSS IOVDD VDD VSS ui_p2c[3] sg13g2_IOPadIn
X$107 \$1 IOVSS IOVSS IOVSS VSS sg13g2_Filler4000
X$108 \$1 ui_PAD[4] IOVSS IOVSS IOVDD VDD VSS ui_p2c[4] sg13g2_IOPadIn
X$109 \$1 IOVSS IOVSS IOVSS VSS sg13g2_Filler400
X$110 \$1 IOVSS IOVSS IOVSS VSS sg13g2_Filler4000
X$111 \$1 IOVSS IOVDD VSS sg13g2_IOPadIOVss
X$112 \$1 IOVSS IOVSS IOVSS VSS sg13g2_Filler400
X$113 \$1 IOVSS IOVSS IOVSS VSS sg13g2_Filler4000
X$121 \$1 IOVSS IOVSS IOVSS VSS sg13g2_Filler4000
X$122 \$1 IOVSS IOVSS IOVSS VSS sg13g2_Filler400
X$123 \$1 IOVSS IOVSS IOVSS VSS sg13g2_Filler4000
X$124 \$1 IOVSS IOVSS IOVSS VSS sg13g2_Filler400
X$125 \$1 analog_io[0] IOVSS IOVDD IOVDD VSS analog_io_padres[0]
+ sg13g2_IOPadAnalog
X$127 \$1 analog_io[14] IOVSS IOVDD IOVDD VSS analog_io_padres[14]
+ sg13g2_IOPadAnalog
X$129 \$1 IOVSS IOVSS IOVSS VSS sg13g2_Filler4000
X$130 \$1 IOVSS IOVSS IOVSS VSS sg13g2_Filler400
X$131 \$1 IOVSS IOVSS IOVSS VSS sg13g2_Filler4000
X$132 \$1 IOVSS IOVSS IOVSS VSS sg13g2_Filler400
X$133 \$1 analog_io[1] IOVSS IOVDD IOVDD VSS analog_io_padres[1]
+ sg13g2_IOPadAnalog
X$135 \$1 ui_PAD[1] IOVSS IOVSS IOVDD VDD VSS ui_p2c[1] sg13g2_IOPadIn
X$137 \$1 IOVSS IOVSS IOVSS VSS sg13g2_Filler4000
X$138 \$1 IOVSS IOVSS IOVSS VSS sg13g2_Filler400
X$139 \$1 IOVSS IOVSS IOVSS VSS sg13g2_Filler4000
X$140 \$1 IOVSS IOVSS IOVSS VSS sg13g2_Filler400
X$141 \$1 analog_io[2] IOVSS IOVDD IOVDD VSS analog_io_padres[2]
+ sg13g2_IOPadAnalog
X$143 \$1 analog_io[13] IOVSS IOVDD IOVDD VSS analog_io_padres[13]
+ sg13g2_IOPadAnalog
X$145 \$1 IOVSS IOVSS IOVSS VSS sg13g2_Filler4000
X$146 \$1 IOVSS IOVSS IOVSS VSS sg13g2_Filler400
X$147 \$1 IOVSS IOVSS IOVSS VSS sg13g2_Filler4000
X$148 \$1 IOVSS IOVSS IOVSS VSS sg13g2_Filler400
X$149 \$1 analog_io[3] IOVSS IOVDD IOVDD VSS analog_io_padres[3]
+ sg13g2_IOPadAnalog
X$151 \$1 analog_io[12] IOVSS IOVDD IOVDD VSS analog_io_padres[12]
+ sg13g2_IOPadAnalog
X$153 \$1 IOVSS IOVSS IOVSS VSS sg13g2_Filler4000
X$154 \$1 IOVSS IOVSS IOVSS VSS sg13g2_Filler400
X$155 \$1 IOVSS IOVSS IOVSS VSS sg13g2_Filler4000
X$156 \$1 IOVSS IOVSS IOVSS VSS sg13g2_Filler400
X$157 \$1 IOVDD IOVSS IOVSS VSS sg13g2_IOPadIOVdd
X$159 \$1 VDD IOVSS IOVSS VSS sg13g2_IOPadVdd
X$161 \$1 IOVSS IOVSS IOVSS VSS sg13g2_Filler4000
X$162 \$1 IOVSS IOVSS IOVSS VSS sg13g2_Filler400
X$163 \$1 IOVSS IOVSS IOVSS VSS sg13g2_Filler4000
X$164 \$1 IOVSS IOVSS IOVSS VSS sg13g2_Filler400
X$165 \$1 IOVSS IOVDD VSS sg13g2_IOPadIOVss
X$167 \$1 VSS IOVSS IOVSS IOVDD sg13g2_IOPadVss
X$169 \$1 IOVSS IOVSS IOVSS VSS sg13g2_Filler4000
X$170 \$1 IOVSS IOVSS IOVSS VSS sg13g2_Filler1000
X$171 \$1 IOVSS IOVSS IOVSS VSS sg13g2_Filler4000
X$172 \$1 IOVSS IOVSS IOVSS VSS sg13g2_Filler1000
X$173 \$1 IOVSS IOVSS IOVSS VSS sg13g2_Filler400
X$174 \$1 IOVSS IOVSS IOVSS VSS sg13g2_Filler200
X$175 \$1 IOVSS IOVSS IOVSS VSS sg13g2_Filler400
X$176 \$1 IOVSS IOVSS IOVSS VSS sg13g2_Filler200
X$178 \$1 IOVSS IOVSS IOVSS VSS sg13g2_Filler4000
X$179 \$1 IOVSS IOVSS IOVSS VSS sg13g2_Filler1000
X$180 \$1 IOVSS IOVSS IOVSS VSS sg13g2_Filler400
X$181 \$1 IOVSS IOVSS IOVSS VSS sg13g2_Filler200
X$182 \$1 IOVDD IOVSS IOVSS VSS sg13g2_IOPadIOVdd
X$183 \$1 IOVSS IOVSS IOVSS VSS sg13g2_Filler4000
X$184 \$1 IOVSS IOVSS IOVSS VSS sg13g2_Filler400
X$185 \$1 IOVSS IOVDD VSS sg13g2_IOPadIOVss
X$186 \$1 IOVSS IOVSS IOVSS VSS sg13g2_Filler4000
X$187 \$1 IOVSS IOVSS IOVSS VSS sg13g2_Filler400
X$188 \$1 analog_io[4] IOVSS IOVDD IOVDD VSS analog_io_padres[4]
+ sg13g2_IOPadAnalog
X$189 \$1 IOVSS IOVSS IOVSS VSS sg13g2_Filler4000
X$190 \$1 IOVSS IOVSS IOVSS VSS sg13g2_Filler400
X$191 \$1 analog_io[5] IOVSS IOVDD IOVDD VSS analog_io_padres[5]
+ sg13g2_IOPadAnalog
X$192 \$1 IOVSS IOVSS IOVSS VSS sg13g2_Filler4000
X$193 \$1 IOVSS IOVSS IOVSS VSS sg13g2_Filler400
X$194 \$1 analog_io[6] IOVSS IOVDD IOVDD VSS analog_io_padres[6]
+ sg13g2_IOPadAnalog
X$195 \$1 IOVSS IOVSS IOVSS VSS sg13g2_Filler4000
X$196 \$1 IOVSS IOVSS IOVSS VSS sg13g2_Filler400
X$197 \$1 analog_io[7] IOVSS IOVDD IOVDD VSS analog_io_padres[7]
+ sg13g2_IOPadAnalog
X$198 \$1 IOVSS IOVSS IOVSS VSS sg13g2_Filler4000
X$199 \$1 IOVSS IOVSS IOVSS VSS sg13g2_Filler400
X$200 \$1 analog_io[8] IOVSS IOVDD IOVDD VSS analog_io_padres[8]
+ sg13g2_IOPadAnalog
X$201 \$1 IOVSS IOVSS IOVSS VSS sg13g2_Filler4000
X$202 \$1 IOVSS IOVSS IOVSS VSS sg13g2_Filler400
X$203 \$1 analog_io[9] IOVSS IOVDD IOVDD VSS analog_io_padres[9]
+ sg13g2_IOPadAnalog
X$204 \$1 IOVSS IOVSS IOVSS VSS sg13g2_Filler4000
X$205 \$1 IOVSS IOVSS IOVSS VSS sg13g2_Filler400
X$206 \$1 ui_PAD[0] IOVSS IOVSS IOVDD VDD VSS ui_p2c[0] sg13g2_IOPadIn
X$207 \$1 IOVSS IOVSS IOVSS VSS sg13g2_Filler4000
X$208 \$1 IOVSS IOVSS IOVSS VSS sg13g2_Filler400
X$209 \$1 analog_io[10] IOVSS IOVDD IOVDD VSS analog_io_padres[10]
+ sg13g2_IOPadAnalog
X$210 \$1 IOVSS IOVSS IOVSS VSS sg13g2_Filler4000
X$211 \$1 IOVSS IOVSS IOVSS VSS sg13g2_Filler400
X$212 \$1 analog_io[11] IOVSS IOVDD IOVDD VSS analog_io_padres[11]
+ sg13g2_IOPadAnalog
X$213 \$1 IOVSS IOVSS IOVSS VSS sg13g2_Filler4000
X$214 \$1 IOVSS IOVSS IOVSS VSS sg13g2_Filler400
X$215 \$1 IOVDD IOVSS IOVSS VSS sg13g2_IOPadIOVdd
X$216 \$1 IOVSS IOVSS IOVSS VSS sg13g2_Filler4000
X$217 \$1 IOVSS IOVSS IOVSS VSS sg13g2_Filler400
X$218 \$1 IOVSS IOVDD VSS sg13g2_IOPadIOVss
X$219 \$1 IOVSS IOVSS IOVSS VSS sg13g2_Filler4000
X$220 \$1 IOVSS IOVSS IOVSS VSS sg13g2_Filler1000
X$221 \$1 IOVSS IOVSS IOVSS VSS sg13g2_Filler400
X$222 \$1 IOVSS IOVSS IOVSS VSS sg13g2_Filler200
R$1 VSS \$1 ptap1 A=52.7736p P=338.816u
R$2 IOVSS \$1 ptap1 A=40674.96p P=3929.688u
.ENDS user_project_wrapper

.SUBCKT Full_Layout Vsource VBAT VBAT2 VSS Vs VDDLS VHLS \$70 IN VOUT VH
M$1 \$61 Vs VSS VSS sg13_lv_nmos L=0.13u W=2.24u AS=1.0528p AD=1.0528p PS=5.24u
+ PD=5.24u rfmode=0
M$3 VFE|X|vfe \$71 VSS VSS sg13_lv_nmos L=0.13u W=0.74u AS=0.2516p AD=0.1331p
+ PS=2.16u PD=1.12u rfmode=0
M$4 VSS B|IN|Y \$75 VSS sg13_lv_nmos L=0.13u W=0.64u AS=0.1331p AD=0.1216p
+ PS=1.12u PD=1.02u rfmode=0
M$5 \$75 IN|Y \$71 VSS sg13_lv_nmos L=0.13u W=0.64u AS=0.1216p AD=0.2176p
+ PS=1.02u PD=1.96u rfmode=0
M$6 VRE|X|vre \$73 VSS VSS sg13_lv_nmos L=0.13u W=0.74u AS=0.2516p AD=0.1331p
+ PS=2.16u PD=1.12u rfmode=0
M$7 VSS B|IN|Y$1 \$76 VSS sg13_lv_nmos L=0.13u W=0.64u AS=0.1331p AD=0.1216p
+ PS=1.12u PD=1.02u rfmode=0
M$8 \$76 IN|Y$1 \$73 VSS sg13_lv_nmos L=0.13u W=0.64u AS=0.1216p AD=0.2176p
+ PS=1.02u PD=1.96u rfmode=0
M$9 B|IN|Y IN|Y$2 VSS VSS sg13_lv_nmos L=0.13u W=0.74u AS=0.2516p AD=0.2516p
+ PS=2.16u PD=2.16u rfmode=0
M$10 IN|Y$1 B|IN|Y VSS VSS sg13_lv_nmos L=0.13u W=0.74u AS=0.2516p AD=0.2516p
+ PS=2.16u PD=2.16u rfmode=0
M$11 IN|Y$2 B|IN|Y$1 VSS VSS sg13_lv_nmos L=0.13u W=0.74u AS=0.2516p AD=0.2516p
+ PS=2.16u PD=2.16u rfmode=0
M$12 B|IN|Y$1 IN|Y$3 VSS VSS sg13_lv_nmos L=0.13u W=0.74u AS=0.2516p AD=0.2516p
+ PS=2.16u PD=2.16u rfmode=0
M$13 IN|Y B|IN|Y$1 VSS VSS sg13_lv_nmos L=0.13u W=0.74u AS=0.2516p AD=0.2516p
+ PS=2.16u PD=2.16u rfmode=0
M$14 IN|Y$3 IN VSS VSS sg13_lv_nmos L=0.13u W=0.74u AS=0.2516p AD=0.2516p
+ PS=2.16u PD=2.16u rfmode=0
M$15 VBAT2 VBAT2 VSS VSS sg13_hv_nmos L=2u W=200u AS=39.5p AD=39.5p PS=217.9u
+ PD=217.9u rfmode=0
M$35 \$10 Q|Reset Vsource Vsource sg13_hv_nmos L=0.5u W=3u AS=1.02p AD=1.02p
+ PS=6.68u PD=6.68u rfmode=0
M$36 Vsource Q|Qn \$4 Vsource sg13_hv_nmos L=0.5u W=3u AS=1.02p AD=1.02p
+ PS=6.68u PD=6.68u rfmode=0
M$37 G1|TRIG|Trig \$4 Vsource Vsource sg13_hv_nmos L=0.5u W=72u AS=14.13p
+ AD=14.13p PS=84.42u PD=84.42u rfmode=0
M$61 G2|vg vgmd78 VSS VSS sg13_hv_nmos L=0.45u W=2000u AS=510.4p AD=510.4p
+ PS=2142.08u PD=2142.08u rfmode=0
M$161 \$23 VBAT2 VSS VSS sg13_hv_nmos L=2u W=200u AS=39.5p AD=39.5p PS=217.9u
+ PD=217.9u rfmode=0
M$281 RESET|Reset|reset VFE|X|vfe \$23 VSS sg13_hv_nmos L=0.5u W=30u AS=6.6p
+ AD=6.6p PS=38.2u PD=38.2u rfmode=0
M$286 \$23 VRE|X|vre Qn|set VSS sg13_hv_nmos L=0.5u W=30u AS=6.6p AD=6.6p
+ PS=38.2u PD=38.2u rfmode=0
M$291 Vsource Q|Qn \$59 Vsource sg13_hv_nmos L=3u W=5u AS=1.025p AD=1.025p
+ PS=9.6u PD=9.6u rfmode=0
M$301 Q|Reset RESET|Reset|reset \$59 Vsource sg13_hv_nmos L=3u W=5u AS=1.025p
+ AD=1.025p PS=9.6u PD=9.6u rfmode=0
M$311 Q|Qn Q|Reset \$35 Vsource sg13_hv_nmos L=3u W=5u AS=1.025p AD=1.025p
+ PS=9.6u PD=9.6u rfmode=0
M$321 Vsource Qn|set \$35 Vsource sg13_hv_nmos L=3u W=5u AS=1.025p AD=1.025p
+ PS=9.6u PD=9.6u rfmode=0
M$331 VSS Vs vgmd78 VSS sg13_hv_nmos L=0.45u W=250u AS=65.05p AD=64.5p
+ PS=273.01u PD=272.9u rfmode=0
M$356 vgmd5 \$61 VSS VSS sg13_hv_nmos L=0.45u W=60u AS=17.4p AD=16.95p
+ PS=73.48u PD=73.39u rfmode=0
M$362 vgmd1 Vs VSS VSS sg13_hv_nmos L=0.45u W=60u AS=17.1p AD=17.6p PS=73.42u
+ PD=73.52u rfmode=0
M$368 VOUT G2|vg VSS VSS sg13_hv_nmos L=0.45u W=40800u AS=14616p AD=14616p
+ PS=44523.2u PD=44523.2u rfmode=0
M$572 VOUT G1|TRIG|Trig VH VOUT sg13_hv_nmos L=0.45u W=40800u AS=14616p
+ AD=14616p PS=44523.2u PD=44523.2u rfmode=0
M$8528 \$61 Vs VDDLS VDDLS sg13_lv_pmos L=0.13u W=2.24u AS=1.0528p AD=1.0528p
+ PS=5.24u PD=5.24u rfmode=0
M$8530 B|IN|Y IN|Y$2 \$70 \$70 sg13_lv_pmos L=0.13u W=1.12u AS=0.3808p
+ AD=0.3808p PS=2.92u PD=2.92u rfmode=0
M$8531 IN|Y B|IN|Y$1 \$70 \$70 sg13_lv_pmos L=0.13u W=1.12u AS=0.3808p
+ AD=0.3808p PS=2.92u PD=2.92u rfmode=0
M$8532 IN|Y$2 B|IN|Y$1 \$70 \$70 sg13_lv_pmos L=0.13u W=1.12u AS=0.3808p
+ AD=0.3808p PS=2.92u PD=2.92u rfmode=0
M$8533 VFE|X|vfe \$71 \$70 \$70 sg13_lv_pmos L=0.13u W=1.12u AS=0.3808p
+ AD=0.1918p PS=2.92u PD=1.5u rfmode=0
M$8534 \$70 B|IN|Y \$71 \$70 sg13_lv_pmos L=0.13u W=0.84u AS=0.1918p AD=0.1596p
+ PS=1.5u PD=1.22u rfmode=0
M$8535 \$71 IN|Y \$70 \$70 sg13_lv_pmos L=0.13u W=0.84u AS=0.1596p AD=0.2856p
+ PS=1.22u PD=2.36u rfmode=0
M$8536 B|IN|Y$1 IN|Y$3 \$70 \$70 sg13_lv_pmos L=0.13u W=1.12u AS=0.3808p
+ AD=0.3808p PS=2.92u PD=2.92u rfmode=0
M$8537 IN|Y$1 B|IN|Y \$70 \$70 sg13_lv_pmos L=0.13u W=1.12u AS=0.3808p
+ AD=0.3808p PS=2.92u PD=2.92u rfmode=0
M$8538 IN|Y$3 IN \$70 \$70 sg13_lv_pmos L=0.13u W=1.12u AS=0.3808p AD=0.3808p
+ PS=2.92u PD=2.92u rfmode=0
M$8539 VRE|X|vre \$73 \$70 \$70 sg13_lv_pmos L=0.13u W=1.12u AS=0.3808p
+ AD=0.1918p PS=2.92u PD=1.5u rfmode=0
M$8540 \$70 B|IN|Y$1 \$73 \$70 sg13_lv_pmos L=0.13u W=0.84u AS=0.1918p
+ AD=0.1596p PS=1.5u PD=1.22u rfmode=0
M$8541 \$73 IN|Y$1 \$70 \$70 sg13_lv_pmos L=0.13u W=0.84u AS=0.1596p AD=0.2856p
+ PS=1.22u PD=2.36u rfmode=0
M$8542 G1|TRIG|Trig \$4 Vboot|vboot Vboot|vboot sg13_hv_pmos L=0.5u W=195u
+ AS=37.5p AD=37.5p PS=223u PD=223u rfmode=0
M$8607 RESET|Reset|reset RESET|Reset|reset \$49 \$49 sg13_hv_pmos L=0.5u W=1u
+ AS=0.34p AD=0.34p PS=2.68u PD=2.68u rfmode=0
M$8608 Qn|set Qn|set \$39 \$39 sg13_hv_pmos L=0.5u W=1u AS=0.34p AD=0.34p
+ PS=2.68u PD=2.68u rfmode=0
M$8609 \$49 Qn|set Vboot|vboot Vboot|vboot sg13_hv_pmos L=0.5u W=1u AS=0.34p
+ AD=0.34p PS=2.68u PD=2.68u rfmode=0
M$8610 \$39 RESET|Reset|reset Vboot|vboot Vboot|vboot sg13_hv_pmos L=0.5u W=1u
+ AS=0.34p AD=0.34p PS=2.68u PD=2.68u rfmode=0
M$8611 RESET|Reset|reset RESET|Reset|reset Vboot|vboot Vboot|vboot sg13_hv_pmos
+ L=1u W=0.5u AS=0.17p AD=0.17p PS=1.68u PD=1.68u rfmode=0
M$8612 Qn|set RESET|Reset|reset Vboot|vboot Vboot|vboot sg13_hv_pmos L=1u W=5u
+ AS=1.7p AD=1.7p PS=10.68u PD=10.68u rfmode=0
M$8613 Vboot|vboot Qn|set RESET|Reset|reset Vboot|vboot sg13_hv_pmos L=1u W=5u
+ AS=1.7p AD=1.7p PS=10.68u PD=10.68u rfmode=0
M$8614 Vboot|vboot Qn|set Qn|set Vboot|vboot sg13_hv_pmos L=1u W=0.5u AS=0.17p
+ AD=0.17p PS=1.68u PD=1.68u rfmode=0
M$8615 Vboot|vboot Vboot|vboot VBAT Vboot|vboot sg13_hv_pmos L=0.5u W=6u
+ AS=2.04p AD=2.04p PS=12.68u PD=12.68u rfmode=0
M$8616 \$4 \$10 Vboot|vboot Vboot|vboot sg13_hv_pmos L=0.5u W=3u AS=1.02p
+ AD=1.02p PS=6.68u PD=6.68u rfmode=0
M$8617 Vboot|vboot \$4 \$10 Vboot|vboot sg13_hv_pmos L=0.5u W=1u AS=0.34p
+ AD=0.34p PS=2.68u PD=2.68u rfmode=0
M$8618 Vboot|vboot Qn|set Q|Qn Vboot|vboot sg13_hv_pmos L=3u W=5u AS=1.025p
+ AD=1.025p PS=9.6u PD=9.6u rfmode=0
M$8628 Vboot|vboot Q|Reset Q|Qn Vboot|vboot sg13_hv_pmos L=3u W=5u AS=1.025p
+ AD=1.025p PS=9.6u PD=9.6u rfmode=0
M$8638 Vboot|vboot RESET|Reset|reset Q|Reset Vboot|vboot sg13_hv_pmos L=3u W=5u
+ AS=1.025p AD=1.025p PS=9.6u PD=9.6u rfmode=0
M$8648 Vboot|vboot Q|Qn Q|Reset Vboot|vboot sg13_hv_pmos L=3u W=5u AS=1.025p
+ AD=1.025p PS=9.6u PD=9.6u rfmode=0
M$8658 G2|vg vgmd78 VHLS VHLS sg13_hv_pmos L=0.4u W=2500u AS=638p AD=638p
+ PS=2677.6u PD=2677.6u rfmode=0
M$8708 vgmd78 vgmd5 VHLS VHLS sg13_hv_pmos L=0.4u W=300u AS=81.1p AD=81.6p
+ PS=326.22u PD=326.32u rfmode=0
M$8738 vgmd5 vgmd1 VHLS VHLS sg13_hv_pmos L=0.4u W=10u AS=5.6p AD=6.1p
+ PS=21.12u PD=21.22u rfmode=0
M$8739 vgmd1 vgmd5 VHLS VHLS sg13_hv_pmos L=0.4u W=10u AS=6.75p AD=7p PS=21.35u
+ PD=21.4u rfmode=0
C$8940 Vboot|vboot Vsource cap_cmim w=42u l=100u A=4200p P=284u m=56
C$8996 B|IN|Y VSS cap_cmim w=40u l=80u A=3200p P=240u m=3
.ENDS Full_Layout

.SUBCKT SAR_ADC VSS VDD bias vin_neg vin_pos En rst fclk_in fdac_clk D0 D1 D2
+ D3 D4 D5 D6 D7
M$1 VDD \$72 \$17 VSS sg13_lv_nmos L=0.13u W=1u AS=0.34p AD=0.34p PS=2.68u
+ PD=2.68u rfmode=0
M$2 \$28 \$83 VDD VSS sg13_lv_nmos L=0.13u W=1u AS=0.34p AD=0.34p PS=2.68u
+ PD=2.68u rfmode=0
M$3 VSS \$30 \$17 VSS sg13_lv_nmos L=0.13u W=1u AS=0.34p AD=0.34p PS=2.68u
+ PD=2.68u rfmode=0
M$4 \$28 \$39 VSS VSS sg13_lv_nmos L=0.13u W=1u AS=0.34p AD=0.34p PS=2.68u
+ PD=2.68u rfmode=0
M$5 VDD \$71 \$7 VSS sg13_lv_nmos L=0.13u W=1u AS=0.34p AD=0.34p PS=2.68u
+ PD=2.68u rfmode=0
M$6 VSS \$29 \$7 VSS sg13_lv_nmos L=0.13u W=1u AS=0.34p AD=0.34p PS=2.68u
+ PD=2.68u rfmode=0
M$7 VDD \$77 \$21 VSS sg13_lv_nmos L=0.13u W=1u AS=0.34p AD=0.34p PS=2.68u
+ PD=2.68u rfmode=0
M$8 \$22 \$78 VDD VSS sg13_lv_nmos L=0.13u W=1u AS=0.34p AD=0.34p PS=2.68u
+ PD=2.68u rfmode=0
M$9 \$9 \$40 VSS VSS sg13_lv_nmos L=0.13u W=1u AS=0.34p AD=0.34p PS=2.68u
+ PD=2.68u rfmode=0
M$10 \$9 \$84 VDD VSS sg13_lv_nmos L=0.13u W=1u AS=0.34p AD=0.34p PS=2.68u
+ PD=2.68u rfmode=0
M$11 VDD \$73 \$18 VSS sg13_lv_nmos L=0.13u W=1u AS=0.34p AD=0.34p PS=2.68u
+ PD=2.68u rfmode=0
M$12 VSS \$31 \$18 VSS sg13_lv_nmos L=0.13u W=1u AS=0.34p AD=0.34p PS=2.68u
+ PD=2.68u rfmode=0
M$13 VDD \$74 \$20 VSS sg13_lv_nmos L=0.13u W=1u AS=0.34p AD=0.34p PS=2.68u
+ PD=2.68u rfmode=0
M$14 VSS \$32 \$20 VSS sg13_lv_nmos L=0.13u W=1u AS=0.34p AD=0.34p PS=2.68u
+ PD=2.68u rfmode=0
M$15 VDD \$75 \$24 VSS sg13_lv_nmos L=0.13u W=1u AS=0.34p AD=0.34p PS=2.68u
+ PD=2.68u rfmode=0
M$16 VSS \$33 \$24 VSS sg13_lv_nmos L=0.13u W=1u AS=0.34p AD=0.34p PS=2.68u
+ PD=2.68u rfmode=0
M$17 VSS \$34 \$21 VSS sg13_lv_nmos L=0.13u W=1u AS=0.34p AD=0.34p PS=2.68u
+ PD=2.68u rfmode=0
M$18 \$22 \$35 VSS VSS sg13_lv_nmos L=0.13u W=1u AS=0.34p AD=0.34p PS=2.68u
+ PD=2.68u rfmode=0
M$19 \$27 \$36 VSS VSS sg13_lv_nmos L=0.13u W=1u AS=0.34p AD=0.34p PS=2.68u
+ PD=2.68u rfmode=0
M$20 \$27 \$80 VDD VSS sg13_lv_nmos L=0.13u W=1u AS=0.34p AD=0.34p PS=2.68u
+ PD=2.68u rfmode=0
M$21 \$23 \$37 VSS VSS sg13_lv_nmos L=0.13u W=1u AS=0.34p AD=0.34p PS=2.68u
+ PD=2.68u rfmode=0
M$22 \$23 \$81 VDD VSS sg13_lv_nmos L=0.13u W=1u AS=0.34p AD=0.34p PS=2.68u
+ PD=2.68u rfmode=0
M$23 \$19 \$38 VSS VSS sg13_lv_nmos L=0.13u W=1u AS=0.34p AD=0.34p PS=2.68u
+ PD=2.68u rfmode=0
M$24 \$19 \$82 VDD VSS sg13_lv_nmos L=0.13u W=1u AS=0.34p AD=0.34p PS=2.68u
+ PD=2.68u rfmode=0
M$25 VSS \$29 \$71 VSS sg13_lv_nmos L=0.13u W=0.4u AS=0.136p AD=0.136p PS=1.48u
+ PD=1.48u rfmode=0
M$26 VSS \$30 \$72 VSS sg13_lv_nmos L=0.13u W=0.4u AS=0.136p AD=0.136p PS=1.48u
+ PD=1.48u rfmode=0
M$27 VSS \$31 \$73 VSS sg13_lv_nmos L=0.13u W=0.4u AS=0.136p AD=0.136p PS=1.48u
+ PD=1.48u rfmode=0
M$28 VSS \$32 \$74 VSS sg13_lv_nmos L=0.13u W=0.4u AS=0.136p AD=0.136p PS=1.48u
+ PD=1.48u rfmode=0
M$29 VSS \$33 \$75 VSS sg13_lv_nmos L=0.13u W=0.4u AS=0.136p AD=0.136p PS=1.48u
+ PD=1.48u rfmode=0
M$30 VDD \$76 \$25 VSS sg13_lv_nmos L=0.13u W=1u AS=0.34p AD=0.34p PS=2.68u
+ PD=2.68u rfmode=0
M$31 VSS \$41 \$76 VSS sg13_lv_nmos L=0.13u W=0.4u AS=0.136p AD=0.136p PS=1.48u
+ PD=1.48u rfmode=0
M$32 VSS \$41 \$25 VSS sg13_lv_nmos L=0.13u W=1u AS=0.34p AD=0.34p PS=2.68u
+ PD=2.68u rfmode=0
M$33 VSS \$34 \$77 VSS sg13_lv_nmos L=0.13u W=0.4u AS=0.136p AD=0.136p PS=1.48u
+ PD=1.48u rfmode=0
M$34 VSS VSS VSS VSS sg13_lv_nmos L=0.2u W=16u AS=4.24p AD=4.24p PS=26.12u
+ PD=26.12u rfmode=0
M$35 VSS clk_comp \$201 VSS sg13_lv_nmos L=0.2u W=4u AS=0.76p AD=1.44p PS=4.38u
+ PD=4.72u rfmode=0
M$36 \$201 \$202 VSS VSS sg13_lv_nmos L=0.2u W=4u AS=1.44p AD=0.76p PS=4.72u
+ PD=4.38u rfmode=0
M$39 VSS \$201 \$202 VSS sg13_lv_nmos L=0.2u W=4u AS=0.76p AD=1.44p PS=4.38u
+ PD=4.72u rfmode=0
M$40 \$202 clk_comp VSS VSS sg13_lv_nmos L=0.2u W=4u AS=1.44p AD=0.76p PS=4.72u
+ PD=4.38u rfmode=0
M$42 \$78 \$35 VSS VSS sg13_lv_nmos L=0.13u W=0.4u AS=0.136p AD=0.136p PS=1.48u
+ PD=1.48u rfmode=0
M$43 \$26 \$42 VSS VSS sg13_lv_nmos L=0.13u W=1u AS=0.34p AD=0.34p PS=2.68u
+ PD=2.68u rfmode=0
M$44 \$79 \$42 VSS VSS sg13_lv_nmos L=0.13u W=0.4u AS=0.136p AD=0.136p PS=1.48u
+ PD=1.48u rfmode=0
M$45 \$26 \$79 VDD VSS sg13_lv_nmos L=0.13u W=1u AS=0.34p AD=0.34p PS=2.68u
+ PD=2.68u rfmode=0
M$46 \$80 \$36 VSS VSS sg13_lv_nmos L=0.13u W=0.4u AS=0.136p AD=0.136p PS=1.48u
+ PD=1.48u rfmode=0
M$47 \$81 \$37 VSS VSS sg13_lv_nmos L=0.13u W=0.4u AS=0.136p AD=0.136p PS=1.48u
+ PD=1.48u rfmode=0
M$48 \$82 \$38 VSS VSS sg13_lv_nmos L=0.13u W=0.4u AS=0.136p AD=0.136p PS=1.48u
+ PD=1.48u rfmode=0
M$49 \$83 \$39 VSS VSS sg13_lv_nmos L=0.13u W=0.4u AS=0.136p AD=0.136p PS=1.48u
+ PD=1.48u rfmode=0
M$50 \$84 \$40 VSS VSS sg13_lv_nmos L=0.13u W=0.4u AS=0.136p AD=0.136p PS=1.48u
+ PD=1.48u rfmode=0
M$51 \$11 \$257 vin_neg VSS sg13_lv_nmos L=0.13u W=2.5u AS=0.85p AD=0.85p
+ PS=5.68u PD=5.68u rfmode=0
M$52 vin_neg \$271 \$227 VSS sg13_lv_nmos L=0.13u W=3u AS=1.02p AD=1.02p
+ PS=6.68u PD=6.68u rfmode=0
M$53 Op \$201 VSS VSS sg13_lv_nmos L=0.2u W=4u AS=1.06p AD=1.06p PS=7.06u
+ PD=7.06u rfmode=0
M$55 Om \$202 VSS VSS sg13_lv_nmos L=0.2u W=4u AS=1.06p AD=1.06p PS=7.06u
+ PD=7.06u rfmode=0
M$57 \$228 \$237 vin_pos VSS sg13_lv_nmos L=0.13u W=3u AS=1.02p AD=1.02p
+ PS=6.68u PD=6.68u rfmode=0
M$58 vin_pos \$259 \$12 VSS sg13_lv_nmos L=0.13u W=2.5u AS=0.85p AD=0.85p
+ PS=5.68u PD=5.68u rfmode=0
M$59 \$271 VDD \$234 VSS sg13_lv_nmos L=0.13u W=3u AS=1.02p AD=1.02p PS=6.68u
+ PD=6.68u rfmode=0
M$60 \$234 \$225 VSS VSS sg13_lv_nmos L=0.13u W=3u AS=1.02p AD=1.02p PS=6.68u
+ PD=6.68u rfmode=0
M$61 VSS \$225 \$227 VSS sg13_lv_nmos L=0.4u W=1.3u AS=0.442p AD=0.442p
+ PS=3.28u PD=3.28u rfmode=0
M$62 \$228 \$226 VSS VSS sg13_lv_nmos L=0.4u W=1.3u AS=0.442p AD=0.442p
+ PS=3.28u PD=3.28u rfmode=0
M$63 VSS \$226 \$236 VSS sg13_lv_nmos L=0.13u W=3u AS=1.02p AD=1.02p PS=6.68u
+ PD=6.68u rfmode=0
M$64 \$236 VDD \$237 VSS sg13_lv_nmos L=0.13u W=3u AS=1.02p AD=1.02p PS=6.68u
+ PD=6.68u rfmode=0
M$65 \$278 \$274 VSS VSS sg13_lv_nmos L=0.13u W=0.4u AS=0.136p AD=0.136p
+ PS=1.48u PD=1.48u rfmode=0
M$66 VSS \$225 \$258 VSS sg13_lv_nmos L=0.13u W=0.5u AS=0.17p AD=0.17p PS=1.68u
+ PD=1.68u rfmode=0
M$67 \$258 VDD \$257 VSS sg13_lv_nmos L=0.13u W=0.5u AS=0.17p AD=0.17p PS=1.68u
+ PD=1.68u rfmode=0
M$68 \$221 \$225 VSS VSS sg13_lv_nmos L=0.13u W=0.4u AS=0.136p AD=0.136p
+ PS=1.48u PD=1.48u rfmode=0
M$69 \$225 fclk_samp VSS VSS sg13_lv_nmos L=0.13u W=0.4u AS=0.136p AD=0.136p
+ PS=1.48u PD=1.48u rfmode=0
M$70 VSS fclk_samp \$226 VSS sg13_lv_nmos L=0.13u W=0.4u AS=0.136p AD=0.136p
+ PS=1.48u PD=1.48u rfmode=0
M$71 VSS \$226 \$224 VSS sg13_lv_nmos L=0.13u W=0.4u AS=0.136p AD=0.136p
+ PS=1.48u PD=1.48u rfmode=0
M$72 \$259 VDD \$260 VSS sg13_lv_nmos L=0.13u W=0.5u AS=0.17p AD=0.17p PS=1.68u
+ PD=1.68u rfmode=0
M$73 \$260 \$226 VSS VSS sg13_lv_nmos L=0.13u W=0.5u AS=0.17p AD=0.17p PS=1.68u
+ PD=1.68u rfmode=0
M$74 VSS \$279 \$275 VSS sg13_lv_nmos L=0.13u W=0.4u AS=0.136p AD=0.136p
+ PS=1.48u PD=1.48u rfmode=0
M$75 \$280 \$295 VDD VSS sg13_lv_nmos L=0.13u W=1.3u AS=0.442p AD=0.442p
+ PS=3.28u PD=3.28u rfmode=0
M$76 VDD \$295 \$297 VSS sg13_lv_nmos L=0.13u W=1.3u AS=0.442p AD=0.442p
+ PS=3.28u PD=3.28u rfmode=0
M$77 \$295 \$297 VDD VSS sg13_lv_nmos L=0.13u W=1.3u AS=0.442p AD=0.442p
+ PS=3.28u PD=3.28u rfmode=0
M$78 VDD \$298 \$296 VSS sg13_lv_nmos L=0.13u W=1.3u AS=0.442p AD=0.442p
+ PS=3.28u PD=3.28u rfmode=0
M$79 \$298 \$296 VDD VSS sg13_lv_nmos L=0.13u W=1.3u AS=0.442p AD=0.442p
+ PS=3.28u PD=3.28u rfmode=0
M$80 VDD \$296 \$256 VSS sg13_lv_nmos L=0.13u W=1.3u AS=0.442p AD=0.442p
+ PS=3.28u PD=3.28u rfmode=0
M$81 \$34 \$347 VSS VSS sg13_lv_nmos L=0.13u W=0.74u AS=0.2886p AD=0.14875p
+ PS=2.26u PD=1.16u rfmode=0
M$82 VSS \$352 \$347 VSS sg13_lv_nmos L=0.13u W=0.55u AS=0.14875p AD=0.187p
+ PS=1.16u PD=1.78u rfmode=0
M$83 VSS Op \$348 VSS sg13_lv_nmos L=0.13u W=0.55u AS=0.14875p AD=0.187p
+ PS=1.16u PD=1.78u rfmode=0
M$84 VSS \$348 \$312 VSS sg13_lv_nmos L=0.13u W=0.74u AS=0.14875p AD=0.2886p
+ PS=1.16u PD=2.26u rfmode=0
M$85 VSS \$387 \$349 VSS sg13_lv_nmos L=0.13u W=0.55u AS=0.14875p AD=0.187p
+ PS=1.16u PD=1.78u rfmode=0
M$86 VSS \$349 clk_comp VSS sg13_lv_nmos L=0.13u W=0.74u AS=0.14875p AD=0.2886p
+ PS=1.16u PD=2.26u rfmode=0
M$87 \$327 \$366 VSS VSS sg13_lv_nmos L=0.13u W=0.74u AS=0.2886p AD=0.14875p
+ PS=2.26u PD=1.16u rfmode=0
M$88 VSS rst \$366 VSS sg13_lv_nmos L=0.13u W=0.55u AS=0.14875p AD=0.187p
+ PS=1.16u PD=1.78u rfmode=0
M$89 \$331 \$330 \$345 VSS sg13_lv_nmos L=0.13u W=0.42u AS=0.1428p AD=0.0609p
+ PS=1.52u PD=0.71u rfmode=0
M$90 \$345 \$370 VSS VSS sg13_lv_nmos L=0.13u W=0.42u AS=0.0609p AD=0.1626p
+ PS=0.71u PD=1.415u rfmode=0
M$91 VSS \$369 \$333 VSS sg13_lv_nmos L=0.13u W=0.74u AS=0.1626p AD=0.2516p
+ PS=1.415u PD=2.16u rfmode=0
M$92 \$302 Op \$305 VSS sg13_lv_nmos L=0.13u W=0.25u AS=0.1075p AD=0.0625p
+ PS=1.34u PD=0.74u rfmode=0
M$93 \$305 Om VSS VSS sg13_lv_nmos L=0.13u W=0.25u AS=0.0625p AD=0.1075p
+ PS=0.74u PD=1.34u rfmode=0
M$94 \$335 \$336 VSS VSS sg13_lv_nmos L=0.13u W=0.42u AS=0.1428p AD=0.0798p
+ PS=1.52u PD=0.8u rfmode=0
M$95 VSS \$370 \$346 VSS sg13_lv_nmos L=0.13u W=0.42u AS=0.0798p AD=0.0378p
+ PS=0.8u PD=0.6u rfmode=0
M$96 \$346 \$372 \$336 VSS sg13_lv_nmos L=0.13u W=0.42u AS=0.0378p AD=0.1428p
+ PS=0.6u PD=1.52u rfmode=0
M$97 \$337 \$372 VSS VSS sg13_lv_nmos L=0.13u W=0.74u AS=0.2516p AD=0.1406p
+ PS=2.16u PD=1.12u rfmode=0
M$98 VSS \$337 \$338 VSS sg13_lv_nmos L=0.13u W=0.74u AS=0.1406p AD=0.2516p
+ PS=1.12u PD=2.16u rfmode=0
M$99 \$339 \$569 VSS VSS sg13_lv_nmos L=0.15u W=0.74u AS=0.2516p AD=0.1406p
+ PS=2.16u PD=1.12u rfmode=0
M$100 VSS \$444 \$339 VSS sg13_lv_nmos L=0.15u W=0.74u AS=0.1406p AD=0.1406p
+ PS=1.12u PD=1.12u rfmode=0
M$101 \$339 \$391 \$340 VSS sg13_lv_nmos L=0.15u W=0.74u AS=0.1406p AD=0.2516p
+ PS=1.12u PD=2.16u rfmode=0
M$102 \$342 \$375 VSS VSS sg13_lv_nmos L=0.13u W=0.74u AS=0.2886p AD=0.14875p
+ PS=2.26u PD=1.16u rfmode=0
M$103 VSS \$669 \$375 VSS sg13_lv_nmos L=0.13u W=0.55u AS=0.14875p AD=0.187p
+ PS=1.16u PD=1.78u rfmode=0
M$104 VSS \$302 \$376 VSS sg13_lv_nmos L=0.13u W=0.55u AS=0.14875p AD=0.187p
+ PS=1.16u PD=1.78u rfmode=0
M$105 VSS \$376 \$343 VSS sg13_lv_nmos L=0.13u W=0.74u AS=0.14875p AD=0.2886p
+ PS=1.16u PD=2.26u rfmode=0
M$106 fclk_samp \$377 VSS VSS sg13_lv_nmos L=0.13u W=0.74u AS=0.2886p
+ AD=0.14875p PS=2.26u PD=1.16u rfmode=0
M$107 VSS \$391 \$377 VSS sg13_lv_nmos L=0.13u W=0.55u AS=0.14875p AD=0.187p
+ PS=1.16u PD=1.78u rfmode=0
M$108 \$374 \$378 VSS VSS sg13_lv_nmos L=0.13u W=0.74u AS=0.2886p AD=0.14875p
+ PS=2.26u PD=1.16u rfmode=0
M$109 VSS Om \$378 VSS sg13_lv_nmos L=0.13u W=0.55u AS=0.14875p AD=0.187p
+ PS=1.16u PD=1.78u rfmode=0
M$110 VSS \$467 \$379 VSS sg13_lv_nmos L=0.13u W=0.55u AS=0.14875p AD=0.187p
+ PS=1.16u PD=1.78u rfmode=0
M$111 VSS \$379 \$35 VSS sg13_lv_nmos L=0.13u W=0.74u AS=0.14875p AD=0.2886p
+ PS=1.16u PD=2.26u rfmode=0
M$112 VSS \$350 \$313 VSS sg13_lv_nmos L=0.13u W=0.55u AS=0.18945p AD=0.187p
+ PS=1.27u PD=1.78u rfmode=0
M$113 VSS \$350 \$380 VSS sg13_lv_nmos L=0.13u W=0.74u AS=0.18945p AD=0.13135p
+ PS=1.27u PD=1.095u rfmode=0
M$114 \$380 \$351 \$314 VSS sg13_lv_nmos L=0.13u W=0.74u AS=0.13135p AD=0.1628p
+ PS=1.095u PD=1.18u rfmode=0
M$115 \$314 \$352 \$381 VSS sg13_lv_nmos L=0.13u W=0.74u AS=0.1628p AD=0.3367p
+ PS=1.18u PD=1.65u rfmode=0
M$116 \$381 \$313 VSS VSS sg13_lv_nmos L=0.13u W=0.74u AS=0.3367p AD=0.148p
+ PS=1.65u PD=1.14u rfmode=0
M$117 VSS \$314 \$315 VSS sg13_lv_nmos L=0.13u W=0.74u AS=0.148p AD=0.4033p
+ PS=1.14u PD=2.57u rfmode=0
M$118 VSS \$317 \$316 VSS sg13_lv_nmos L=0.13u W=11.84u AS=2.3606p AD=2.2496p
+ PS=18.96u PD=17.92u rfmode=0
M$134 VSS fclk_in \$317 VSS sg13_lv_nmos L=0.13u W=4.44u AS=0.8436p AD=0.9546p
+ PS=6.72u PD=7.76u rfmode=0
M$140 VSS \$357 \$322 VSS sg13_lv_nmos L=0.13u W=0.74u AS=0.1898p AD=0.2516p
+ PS=1.36u PD=2.16u rfmode=0
M$141 VSS \$319 \$322 VSS sg13_lv_nmos L=0.13u W=0.74u AS=0.1898p AD=0.1406p
+ PS=1.36u PD=1.12u rfmode=0
M$142 \$322 \$321 \$389 VSS sg13_lv_nmos L=0.13u W=0.74u AS=0.1406p AD=0.2516p
+ PS=1.12u PD=2.16u rfmode=0
M$143 \$356 \$358 VSS VSS sg13_lv_nmos L=0.13u W=0.74u AS=0.2516p AD=0.1426p
+ PS=2.16u PD=1.16u rfmode=0
M$144 VSS \$359 \$358 VSS sg13_lv_nmos L=0.5u W=0.42u AS=0.1426p AD=0.1428p
+ PS=1.16u PD=1.52u rfmode=0
M$145 \$359 \$323 VSS VSS sg13_lv_nmos L=0.5u W=0.42u AS=0.1428p AD=0.0798p
+ PS=1.52u PD=0.8u rfmode=0
M$146 VSS \$360 \$323 VSS sg13_lv_nmos L=0.13u W=0.42u AS=0.0798p AD=0.1428p
+ PS=0.8u PD=1.52u rfmode=0
M$147 \$324 \$361 VSS VSS sg13_lv_nmos L=0.13u W=0.74u AS=0.2516p AD=0.1426p
+ PS=2.16u PD=1.16u rfmode=0
M$148 VSS \$362 \$361 VSS sg13_lv_nmos L=0.5u W=0.42u AS=0.1426p AD=0.1428p
+ PS=1.16u PD=1.52u rfmode=0
M$149 \$362 \$325 VSS VSS sg13_lv_nmos L=0.5u W=0.42u AS=0.1428p AD=0.0798p
+ PS=1.52u PD=0.8u rfmode=0
M$150 VSS \$389 \$325 VSS sg13_lv_nmos L=0.13u W=0.42u AS=0.0798p AD=0.1428p
+ PS=0.8u PD=1.52u rfmode=0
M$151 \$357 \$363 VSS VSS sg13_lv_nmos L=0.13u W=0.74u AS=0.2516p AD=0.1426p
+ PS=2.16u PD=1.16u rfmode=0
M$152 VSS \$364 \$363 VSS sg13_lv_nmos L=0.5u W=0.42u AS=0.1426p AD=0.1428p
+ PS=1.16u PD=1.52u rfmode=0
M$153 \$364 \$326 VSS VSS sg13_lv_nmos L=0.5u W=0.42u AS=0.1428p AD=0.0798p
+ PS=1.52u PD=0.8u rfmode=0
M$154 VSS \$365 \$326 VSS sg13_lv_nmos L=0.13u W=0.42u AS=0.0798p AD=0.1428p
+ PS=0.8u PD=1.52u rfmode=0
M$155 \$328 \$367 VSS VSS sg13_lv_nmos L=0.13u W=0.42u AS=0.1428p AD=0.0798p
+ PS=1.52u PD=0.8u rfmode=0
M$156 VSS \$328 \$329 VSS sg13_lv_nmos L=0.5u W=0.42u AS=0.0798p AD=0.1428p
+ PS=0.8u PD=1.52u rfmode=0
M$157 VSS \$329 \$368 VSS sg13_lv_nmos L=0.5u W=0.42u AS=0.1426p AD=0.1428p
+ PS=1.16u PD=1.52u rfmode=0
M$158 VSS \$368 \$330 VSS sg13_lv_nmos L=0.13u W=0.74u AS=0.1426p AD=0.2516p
+ PS=1.16u PD=2.16u rfmode=0
M$159 VSS \$631 \$370 VSS sg13_lv_nmos L=0.13u W=0.74u AS=0.2516p AD=0.2516p
+ PS=2.16u PD=2.16u rfmode=0
M$160 VSS \$312 \$373 VSS sg13_lv_nmos L=0.13u W=0.55u AS=0.17255p AD=0.187p
+ PS=1.25u PD=1.78u rfmode=0
M$161 VSS \$373 \$341 VSS sg13_lv_nmos L=0.13u W=0.74u AS=0.17255p AD=0.1406p
+ PS=1.25u PD=1.12u rfmode=0
M$162 \$341 \$374 VSS VSS sg13_lv_nmos L=0.13u W=0.74u AS=0.1406p AD=0.2516p
+ PS=1.12u PD=2.16u rfmode=0
M$163 VSS \$342 \$344 VSS sg13_lv_nmos L=0.13u W=0.74u AS=0.2516p AD=0.2516p
+ PS=2.16u PD=2.16u rfmode=0
M$164 VSS VDD VSS VSS sg13_lv_nmos L=1u W=249.9u AS=67.137p AD=67.137p
+ PS=700.64u PD=700.64u rfmode=0
M$172 VSS \$356 \$382 VSS sg13_lv_nmos L=0.13u W=0.74u AS=0.2886p AD=0.1406p
+ PS=2.26u PD=1.12u rfmode=0
M$173 \$382 \$353 \$383 VSS sg13_lv_nmos L=0.13u W=0.74u AS=0.1406p AD=0.1406p
+ PS=1.12u PD=1.12u rfmode=0
M$174 \$383 \$354 \$319 VSS sg13_lv_nmos L=0.13u W=0.74u AS=0.1406p AD=0.2516p
+ PS=1.12u PD=2.16u rfmode=0
M$175 VSS \$355 \$320 VSS sg13_lv_nmos L=0.13u W=0.74u AS=0.3108p AD=0.1628p
+ PS=2.32u PD=1.18u rfmode=0
M$176 \$320 \$356 \$384 VSS sg13_lv_nmos L=0.13u W=0.74u AS=0.1628p AD=0.0888p
+ PS=1.18u PD=0.98u rfmode=0
M$177 \$384 \$354 VSS VSS sg13_lv_nmos L=0.13u W=0.74u AS=0.0888p AD=0.15245p
+ PS=0.98u PD=1.17u rfmode=0
M$178 VSS \$356 \$355 VSS sg13_lv_nmos L=0.13u W=0.55u AS=0.15245p AD=0.174625p
+ PS=1.17u PD=1.185u rfmode=0
M$179 \$355 \$354 VSS VSS sg13_lv_nmos L=0.13u W=0.55u AS=0.174625p AD=0.374p
+ PS=1.185u PD=2.46u rfmode=0
M$180 VSS \$357 \$385 VSS sg13_lv_nmos L=0.13u W=0.64u AS=0.2272p AD=0.0784p
+ PS=1.99u PD=0.885u rfmode=0
M$181 \$385 \$319 \$321 VSS sg13_lv_nmos L=0.13u W=0.64u AS=0.0784p AD=0.2176p
+ PS=0.885u PD=1.96u rfmode=0
M$183 VSS \$370 \$386 VSS sg13_lv_nmos L=0.13u W=0.42u AS=0.1701p AD=0.0378p
+ PS=1.65u PD=0.6u rfmode=0
M$184 \$386 \$333 \$332 VSS sg13_lv_nmos L=0.13u W=0.42u AS=0.0378p AD=0.1428p
+ PS=0.6u PD=1.52u rfmode=0
M$185 \$331 \$334 \$369 VSS sg13_lv_nmos L=0.13u W=0.42u AS=0.1296p AD=0.0798p
+ PS=1.52u PD=0.8u rfmode=0
M$186 \$369 \$390 \$332 VSS sg13_lv_nmos L=0.13u W=0.42u AS=0.0798p AD=0.2373p
+ PS=0.8u PD=1.97u rfmode=0
M$187 VSS \$334 \$390 VSS sg13_lv_nmos L=0.13u W=0.74u AS=0.317325p AD=0.2516p
+ PS=1.805u PD=2.16u rfmode=0
M$188 VSS \$371 \$334 VSS sg13_lv_nmos L=0.13u W=0.74u AS=0.317325p AD=0.2516p
+ PS=1.805u PD=2.16u rfmode=0
M$189 \$372 \$334 \$335 VSS sg13_lv_nmos L=0.13u W=0.42u AS=0.12665p AD=0.1428p
+ PS=1.145u PD=1.52u rfmode=0
M$190 \$333 \$390 \$372 VSS sg13_lv_nmos L=0.13u W=0.74u AS=0.3473p AD=0.12665p
+ PS=2.71u PD=1.145u rfmode=0
M$217 \$413 \$417 \$415 VSS sg13_lv_nmos L=0.13u W=0.42u AS=0.1296p AD=0.0798p
+ PS=1.52u PD=0.8u rfmode=0
M$218 \$415 \$416 \$497 VSS sg13_lv_nmos L=0.13u W=0.42u AS=0.0798p AD=0.2373p
+ PS=0.8u PD=1.97u rfmode=0
M$219 \$423 \$428 \$425 VSS sg13_lv_nmos L=0.13u W=0.42u AS=0.1296p AD=0.0798p
+ PS=1.52u PD=0.8u rfmode=0
M$220 \$425 \$427 \$499 VSS sg13_lv_nmos L=0.13u W=0.42u AS=0.0798p AD=0.2373p
+ PS=0.8u PD=1.97u rfmode=0
M$221 \$432 \$437 \$434 VSS sg13_lv_nmos L=0.13u W=0.42u AS=0.1296p AD=0.0798p
+ PS=1.52u PD=0.8u rfmode=0
M$222 \$434 \$436 \$501 VSS sg13_lv_nmos L=0.13u W=0.42u AS=0.0798p AD=0.2373p
+ PS=0.8u PD=1.97u rfmode=0
M$223 \$447 \$451 \$449 VSS sg13_lv_nmos L=0.13u W=0.42u AS=0.1296p AD=0.0798p
+ PS=1.52u PD=0.8u rfmode=0
M$224 \$449 \$450 \$505 VSS sg13_lv_nmos L=0.13u W=0.42u AS=0.0798p AD=0.2373p
+ PS=0.8u PD=1.97u rfmode=0
M$225 \$459 \$463 \$461 VSS sg13_lv_nmos L=0.13u W=0.42u AS=0.1296p AD=0.0798p
+ PS=1.52u PD=0.8u rfmode=0
M$226 \$461 \$462 \$507 VSS sg13_lv_nmos L=0.13u W=0.42u AS=0.0798p AD=0.2373p
+ PS=0.8u PD=1.97u rfmode=0
M$227 \$471 \$475 \$473 VSS sg13_lv_nmos L=0.13u W=0.42u AS=0.1296p AD=0.0798p
+ PS=1.52u PD=0.8u rfmode=0
M$228 \$473 \$474 \$509 VSS sg13_lv_nmos L=0.13u W=0.42u AS=0.0798p AD=0.2373p
+ PS=0.8u PD=1.97u rfmode=0
M$229 \$416 \$417 VSS VSS sg13_lv_nmos L=0.13u W=0.74u AS=0.2516p AD=0.317325p
+ PS=2.16u PD=1.805u rfmode=0
M$230 VSS \$498 \$417 VSS sg13_lv_nmos L=0.13u W=0.74u AS=0.317325p AD=0.2516p
+ PS=1.805u PD=2.16u rfmode=0
M$231 \$510 \$417 \$418 VSS sg13_lv_nmos L=0.13u W=0.42u AS=0.1428p AD=0.12665p
+ PS=1.52u PD=1.145u rfmode=0
M$232 \$418 \$416 \$414 VSS sg13_lv_nmos L=0.13u W=0.74u AS=0.12665p AD=0.3473p
+ PS=1.145u PD=2.71u rfmode=0
M$233 \$427 \$428 VSS VSS sg13_lv_nmos L=0.13u W=0.74u AS=0.2516p AD=0.317325p
+ PS=2.16u PD=1.805u rfmode=0
M$234 VSS \$500 \$428 VSS sg13_lv_nmos L=0.13u W=0.74u AS=0.317325p AD=0.2516p
+ PS=1.805u PD=2.16u rfmode=0
M$235 \$511 \$428 \$429 VSS sg13_lv_nmos L=0.13u W=0.42u AS=0.1428p AD=0.12665p
+ PS=1.52u PD=1.145u rfmode=0
M$236 \$429 \$427 \$424 VSS sg13_lv_nmos L=0.13u W=0.74u AS=0.12665p AD=0.3473p
+ PS=1.145u PD=2.71u rfmode=0
M$237 \$436 \$437 VSS VSS sg13_lv_nmos L=0.13u W=0.74u AS=0.2516p AD=0.317325p
+ PS=2.16u PD=1.805u rfmode=0
M$238 VSS \$500 \$437 VSS sg13_lv_nmos L=0.13u W=0.74u AS=0.317325p AD=0.2516p
+ PS=1.805u PD=2.16u rfmode=0
M$239 \$512 \$437 \$438 VSS sg13_lv_nmos L=0.13u W=0.42u AS=0.1428p AD=0.12665p
+ PS=1.52u PD=1.145u rfmode=0
M$240 \$438 \$436 \$433 VSS sg13_lv_nmos L=0.13u W=0.74u AS=0.12665p AD=0.3473p
+ PS=1.145u PD=2.71u rfmode=0
M$241 \$450 \$451 VSS VSS sg13_lv_nmos L=0.13u W=0.74u AS=0.2516p AD=0.317325p
+ PS=2.16u PD=1.805u rfmode=0
M$242 VSS \$371 \$451 VSS sg13_lv_nmos L=0.13u W=0.74u AS=0.317325p AD=0.2516p
+ PS=1.805u PD=2.16u rfmode=0
M$243 \$513 \$451 \$452 VSS sg13_lv_nmos L=0.13u W=0.42u AS=0.1428p AD=0.12665p
+ PS=1.52u PD=1.145u rfmode=0
M$244 \$452 \$450 \$448 VSS sg13_lv_nmos L=0.13u W=0.74u AS=0.12665p AD=0.3473p
+ PS=1.145u PD=2.71u rfmode=0
M$245 VSS \$456 \$457 VSS sg13_lv_nmos L=0.13u W=0.74u AS=0.2516p AD=0.1406p
+ PS=2.16u PD=1.12u rfmode=0
M$246 \$457 \$350 \$533 VSS sg13_lv_nmos L=0.13u W=0.74u AS=0.1406p AD=0.1406p
+ PS=1.12u PD=1.12u rfmode=0
M$247 \$533 \$351 VSS VSS sg13_lv_nmos L=0.13u W=0.74u AS=0.1406p AD=0.2516p
+ PS=1.12u PD=2.16u rfmode=0
M$248 \$462 \$463 VSS VSS sg13_lv_nmos L=0.13u W=0.74u AS=0.2516p AD=0.317325p
+ PS=2.16u PD=1.805u rfmode=0
M$249 VSS \$508 \$463 VSS sg13_lv_nmos L=0.13u W=0.74u AS=0.317325p AD=0.2516p
+ PS=1.805u PD=2.16u rfmode=0
M$250 \$514 \$463 \$464 VSS sg13_lv_nmos L=0.13u W=0.42u AS=0.1428p AD=0.12665p
+ PS=1.52u PD=1.145u rfmode=0
M$251 \$464 \$462 \$460 VSS sg13_lv_nmos L=0.13u W=0.74u AS=0.12665p AD=0.3473p
+ PS=1.145u PD=2.71u rfmode=0
M$252 \$474 \$475 VSS VSS sg13_lv_nmos L=0.13u W=0.74u AS=0.2516p AD=0.317325p
+ PS=2.16u PD=1.805u rfmode=0
M$253 VSS \$508 \$475 VSS sg13_lv_nmos L=0.13u W=0.74u AS=0.317325p AD=0.2516p
+ PS=1.805u PD=2.16u rfmode=0
M$254 \$515 \$475 \$476 VSS sg13_lv_nmos L=0.13u W=0.42u AS=0.1428p AD=0.12665p
+ PS=1.52u PD=1.145u rfmode=0
M$255 \$476 \$474 \$472 VSS sg13_lv_nmos L=0.13u W=0.74u AS=0.12665p AD=0.3473p
+ PS=1.145u PD=2.71u rfmode=0
M$256 VSS \$408 \$409 VSS sg13_lv_nmos L=0.13u W=0.55u AS=0.14875p AD=0.187p
+ PS=1.16u PD=1.78u rfmode=0
M$257 \$41 \$409 VSS VSS sg13_lv_nmos L=0.13u W=0.74u AS=0.2886p AD=0.14875p
+ PS=2.26u PD=1.16u rfmode=0
M$270 \$410 \$411 VSS VSS sg13_lv_nmos L=0.13u W=0.74u AS=0.2516p AD=0.2516p
+ PS=2.16u PD=2.16u rfmode=0
M$271 VSS \$602 \$412 VSS sg13_lv_nmos L=0.13u W=0.55u AS=0.14875p AD=0.187p
+ PS=1.16u PD=1.78u rfmode=0
M$272 \$387 \$412 VSS VSS sg13_lv_nmos L=0.13u W=0.74u AS=0.2886p AD=0.14875p
+ PS=2.26u PD=1.16u rfmode=0
M$273 \$420 \$418 VSS VSS sg13_lv_nmos L=0.13u W=0.74u AS=0.2516p AD=0.1406p
+ PS=2.16u PD=1.12u rfmode=0
M$274 VSS \$420 \$352 VSS sg13_lv_nmos L=0.13u W=0.74u AS=0.1406p AD=0.2516p
+ PS=1.12u PD=2.16u rfmode=0
M$275 VSS \$421 \$422 VSS sg13_lv_nmos L=0.13u W=0.55u AS=0.14875p AD=0.187p
+ PS=1.16u PD=1.78u rfmode=0
M$276 \$411 \$422 VSS VSS sg13_lv_nmos L=0.13u W=0.74u AS=0.2886p AD=0.14875p
+ PS=2.26u PD=1.16u rfmode=0
M$277 \$431 \$429 VSS VSS sg13_lv_nmos L=0.13u W=0.74u AS=0.2516p AD=0.1406p
+ PS=2.16u PD=1.12u rfmode=0
M$278 VSS \$431 \$360 VSS sg13_lv_nmos L=0.13u W=0.74u AS=0.1406p AD=0.2516p
+ PS=1.12u PD=2.16u rfmode=0
M$279 \$440 \$438 VSS VSS sg13_lv_nmos L=0.13u W=0.74u AS=0.2516p AD=0.1406p
+ PS=2.16u PD=1.12u rfmode=0
M$280 VSS \$440 \$365 VSS sg13_lv_nmos L=0.13u W=0.74u AS=0.1406p AD=0.2516p
+ PS=1.12u PD=2.16u rfmode=0
M$281 \$443 \$442 VSS VSS sg13_lv_nmos L=0.5u W=0.42u AS=0.1428p AD=0.1426p
+ PS=1.52u PD=1.16u rfmode=0
M$282 VSS \$443 \$444 VSS sg13_lv_nmos L=0.13u W=0.74u AS=0.1426p AD=0.2516p
+ PS=1.16u PD=2.16u rfmode=0
M$283 VSS \$340 \$446 VSS sg13_lv_nmos L=0.13u W=0.55u AS=0.17255p AD=0.187p
+ PS=1.25u PD=1.78u rfmode=0
M$284 VSS \$330 \$445 VSS sg13_lv_nmos L=0.13u W=0.74u AS=0.2516p AD=0.1406p
+ PS=2.16u PD=1.12u rfmode=0
M$285 \$445 \$446 VSS VSS sg13_lv_nmos L=0.13u W=0.74u AS=0.1406p AD=0.17255p
+ PS=1.12u PD=1.25u rfmode=0
M$286 \$454 \$452 VSS VSS sg13_lv_nmos L=0.13u W=0.74u AS=0.2516p AD=0.1406p
+ PS=2.16u PD=1.12u rfmode=0
M$287 VSS \$454 \$455 VSS sg13_lv_nmos L=0.13u W=0.74u AS=0.1406p AD=0.2516p
+ PS=1.12u PD=2.16u rfmode=0
M$288 VSS \$350 \$456 VSS sg13_lv_nmos L=0.13u W=0.74u AS=0.2516p AD=0.1406p
+ PS=2.16u PD=1.12u rfmode=0
M$289 \$456 \$467 VSS VSS sg13_lv_nmos L=0.13u W=0.74u AS=0.1406p AD=0.2516p
+ PS=1.12u PD=2.16u rfmode=0
M$290 \$466 \$464 VSS VSS sg13_lv_nmos L=0.13u W=0.74u AS=0.2516p AD=0.1406p
+ PS=2.16u PD=1.12u rfmode=0
M$291 VSS \$466 \$467 VSS sg13_lv_nmos L=0.13u W=0.74u AS=0.1406p AD=0.2516p
+ PS=1.12u PD=2.16u rfmode=0
M$294 \$468 \$926 VSS VSS sg13_lv_nmos L=0.13u W=0.55u AS=0.187p AD=0.18945p
+ PS=1.78u PD=1.27u rfmode=0
M$295 VSS \$926 \$538 VSS sg13_lv_nmos L=0.13u W=0.74u AS=0.18945p AD=0.13135p
+ PS=1.27u PD=1.095u rfmode=0
M$296 \$538 \$621 \$469 VSS sg13_lv_nmos L=0.13u W=0.74u AS=0.13135p AD=0.1628p
+ PS=1.095u PD=1.18u rfmode=0
M$297 \$469 \$479 \$539 VSS sg13_lv_nmos L=0.13u W=0.74u AS=0.1628p AD=0.3367p
+ PS=1.18u PD=1.65u rfmode=0
M$298 \$539 \$468 VSS VSS sg13_lv_nmos L=0.13u W=0.74u AS=0.3367p AD=0.148p
+ PS=1.65u PD=1.14u rfmode=0
M$299 VSS \$469 \$470 VSS sg13_lv_nmos L=0.13u W=0.74u AS=0.148p AD=0.4033p
+ PS=1.14u PD=2.57u rfmode=0
M$300 \$478 \$476 VSS VSS sg13_lv_nmos L=0.13u W=0.74u AS=0.2516p AD=0.1406p
+ PS=2.16u PD=1.12u rfmode=0
M$301 VSS \$478 \$479 VSS sg13_lv_nmos L=0.13u W=0.74u AS=0.1406p AD=0.2516p
+ PS=1.12u PD=2.16u rfmode=0
M$312 \$480 \$479 VSS VSS sg13_lv_nmos L=0.13u W=0.55u AS=0.187p AD=0.14875p
+ PS=1.78u PD=1.16u rfmode=0
M$313 VSS \$480 \$42 VSS sg13_lv_nmos L=0.13u W=0.74u AS=0.14875p AD=0.2886p
+ PS=1.16u PD=2.26u rfmode=0
M$314 VSS \$411 \$542 VSS sg13_lv_nmos L=0.13u W=0.74u AS=0.2516p AD=0.2516p
+ PS=2.16u PD=2.16u rfmode=0
M$315 \$543 \$544 \$576 VSS sg13_lv_nmos L=0.13u W=0.42u AS=0.1428p AD=0.0609p
+ PS=1.52u PD=0.71u rfmode=0
M$316 \$576 \$542 VSS VSS sg13_lv_nmos L=0.13u W=0.42u AS=0.0609p AD=0.1626p
+ PS=0.71u PD=1.415u rfmode=0
M$317 VSS \$583 \$545 VSS sg13_lv_nmos L=0.13u W=0.74u AS=0.1626p AD=0.2516p
+ PS=1.415u PD=2.16u rfmode=0
M$318 VSS \$415 \$414 VSS sg13_lv_nmos L=0.13u W=0.74u AS=0.1626p AD=0.2516p
+ PS=1.415u PD=2.16u rfmode=0
M$319 \$413 \$315 \$517 VSS sg13_lv_nmos L=0.13u W=0.42u AS=0.1428p AD=0.0609p
+ PS=1.52u PD=0.71u rfmode=0
M$320 VSS \$410 \$517 VSS sg13_lv_nmos L=0.13u W=0.42u AS=0.1626p AD=0.0609p
+ PS=1.415u PD=0.71u rfmode=0
M$321 VSS \$410 \$518 VSS sg13_lv_nmos L=0.13u W=0.42u AS=0.1701p AD=0.0378p
+ PS=1.65u PD=0.6u rfmode=0
M$322 \$518 \$414 \$497 VSS sg13_lv_nmos L=0.13u W=0.42u AS=0.0378p AD=0.1428p
+ PS=0.6u PD=1.52u rfmode=0
M$323 \$548 \$550 VSS VSS sg13_lv_nmos L=0.13u W=0.42u AS=0.1428p AD=0.0798p
+ PS=1.52u PD=0.8u rfmode=0
M$324 VSS \$542 \$578 VSS sg13_lv_nmos L=0.13u W=0.42u AS=0.0798p AD=0.0378p
+ PS=0.8u PD=0.6u rfmode=0
M$325 \$578 \$549 \$550 VSS sg13_lv_nmos L=0.13u W=0.42u AS=0.0378p AD=0.1428p
+ PS=0.6u PD=1.52u rfmode=0
M$326 \$510 \$419 VSS VSS sg13_lv_nmos L=0.13u W=0.42u AS=0.1428p AD=0.0798p
+ PS=1.52u PD=0.8u rfmode=0
M$327 VSS \$410 \$519 VSS sg13_lv_nmos L=0.13u W=0.42u AS=0.0798p AD=0.0378p
+ PS=0.8u PD=0.6u rfmode=0
M$328 \$519 \$418 \$419 VSS sg13_lv_nmos L=0.13u W=0.42u AS=0.0378p AD=0.1428p
+ PS=0.6u PD=1.52u rfmode=0
M$329 \$551 \$549 VSS VSS sg13_lv_nmos L=0.13u W=0.74u AS=0.2516p AD=0.1406p
+ PS=2.16u PD=1.12u rfmode=0
M$330 VSS \$551 \$408 VSS sg13_lv_nmos L=0.13u W=0.74u AS=0.1406p AD=0.2516p
+ PS=1.12u PD=2.16u rfmode=0
M$331 VSS En \$552 VSS sg13_lv_nmos L=0.13u W=0.55u AS=0.14875p AD=0.187p
+ PS=1.16u PD=1.78u rfmode=0
M$332 VSS \$552 \$354 VSS sg13_lv_nmos L=0.13u W=0.74u AS=0.14875p AD=0.2886p
+ PS=1.16u PD=2.26u rfmode=0
M$333 VSS \$425 \$424 VSS sg13_lv_nmos L=0.13u W=0.74u AS=0.1626p AD=0.2516p
+ PS=1.415u PD=2.16u rfmode=0
M$334 \$423 \$320 \$521 VSS sg13_lv_nmos L=0.13u W=0.42u AS=0.1428p AD=0.0609p
+ PS=1.52u PD=0.71u rfmode=0
M$335 VSS \$426 \$521 VSS sg13_lv_nmos L=0.13u W=0.42u AS=0.1626p AD=0.0609p
+ PS=1.415u PD=0.71u rfmode=0
M$336 \$498 \$553 VSS VSS sg13_lv_nmos L=0.13u W=0.74u AS=0.2886p AD=0.14875p
+ PS=2.26u PD=1.16u rfmode=0
M$337 VSS \$741 \$553 VSS sg13_lv_nmos L=0.13u W=0.55u AS=0.14875p AD=0.187p
+ PS=1.16u PD=1.78u rfmode=0
M$338 VSS \$426 \$522 VSS sg13_lv_nmos L=0.13u W=0.42u AS=0.1701p AD=0.0378p
+ PS=1.65u PD=0.6u rfmode=0
M$339 \$522 \$424 \$499 VSS sg13_lv_nmos L=0.13u W=0.42u AS=0.0378p AD=0.1428p
+ PS=0.6u PD=1.52u rfmode=0
M$340 \$426 \$411 VSS VSS sg13_lv_nmos L=0.13u W=0.74u AS=0.2516p AD=0.2516p
+ PS=2.16u PD=2.16u rfmode=0
M$341 \$554 \$555 \$579 VSS sg13_lv_nmos L=0.13u W=0.42u AS=0.1428p AD=0.0609p
+ PS=1.52u PD=0.71u rfmode=0
M$342 \$579 \$585 VSS VSS sg13_lv_nmos L=0.13u W=0.42u AS=0.0609p AD=0.1626p
+ PS=0.71u PD=1.415u rfmode=0
M$343 VSS \$586 \$556 VSS sg13_lv_nmos L=0.13u W=0.74u AS=0.1626p AD=0.2516p
+ PS=1.415u PD=2.16u rfmode=0
M$344 \$511 \$430 VSS VSS sg13_lv_nmos L=0.13u W=0.42u AS=0.1428p AD=0.0798p
+ PS=1.52u PD=0.8u rfmode=0
M$345 VSS \$426 \$523 VSS sg13_lv_nmos L=0.13u W=0.42u AS=0.0798p AD=0.0378p
+ PS=0.8u PD=0.6u rfmode=0
M$346 \$523 \$429 \$430 VSS sg13_lv_nmos L=0.13u W=0.42u AS=0.0378p AD=0.1428p
+ PS=0.6u PD=1.52u rfmode=0
M$347 VSS \$434 \$433 VSS sg13_lv_nmos L=0.13u W=0.74u AS=0.1626p AD=0.2516p
+ PS=1.415u PD=2.16u rfmode=0
M$348 \$432 \$324 \$524 VSS sg13_lv_nmos L=0.13u W=0.42u AS=0.1428p AD=0.0609p
+ PS=1.52u PD=0.71u rfmode=0
M$349 VSS \$435 \$524 VSS sg13_lv_nmos L=0.13u W=0.42u AS=0.1626p AD=0.0609p
+ PS=1.415u PD=0.71u rfmode=0
M$350 \$559 \$561 VSS VSS sg13_lv_nmos L=0.13u W=0.42u AS=0.1428p AD=0.0798p
+ PS=1.52u PD=0.8u rfmode=0
M$351 VSS \$585 \$581 VSS sg13_lv_nmos L=0.13u W=0.42u AS=0.0798p AD=0.0378p
+ PS=0.8u PD=0.6u rfmode=0
M$352 \$581 \$560 \$561 VSS sg13_lv_nmos L=0.13u W=0.42u AS=0.0378p AD=0.1428p
+ PS=0.6u PD=1.52u rfmode=0
M$353 VSS \$435 \$525 VSS sg13_lv_nmos L=0.13u W=0.42u AS=0.1701p AD=0.0378p
+ PS=1.65u PD=0.6u rfmode=0
M$354 \$525 \$433 \$501 VSS sg13_lv_nmos L=0.13u W=0.42u AS=0.0378p AD=0.1428p
+ PS=0.6u PD=1.52u rfmode=0
M$355 \$562 \$560 VSS VSS sg13_lv_nmos L=0.13u W=0.74u AS=0.2516p AD=0.1406p
+ PS=2.16u PD=1.12u rfmode=0
M$356 VSS \$562 \$563 VSS sg13_lv_nmos L=0.13u W=0.74u AS=0.1406p AD=0.2516p
+ PS=1.12u PD=2.16u rfmode=0
M$357 \$353 \$564 VSS VSS sg13_lv_nmos L=0.13u W=0.74u AS=0.2516p AD=0.1426p
+ PS=2.16u PD=1.16u rfmode=0
M$358 VSS \$565 \$564 VSS sg13_lv_nmos L=0.5u W=0.42u AS=0.1426p AD=0.1428p
+ PS=1.16u PD=1.52u rfmode=0
M$359 \$565 \$566 VSS VSS sg13_lv_nmos L=0.5u W=0.42u AS=0.1428p AD=0.0798p
+ PS=1.52u PD=0.8u rfmode=0
M$360 VSS \$563 \$566 VSS sg13_lv_nmos L=0.13u W=0.42u AS=0.0798p AD=0.1428p
+ PS=0.8u PD=1.52u rfmode=0
M$361 \$512 \$439 VSS VSS sg13_lv_nmos L=0.13u W=0.42u AS=0.1428p AD=0.0798p
+ PS=1.52u PD=0.8u rfmode=0
M$362 VSS \$435 \$526 VSS sg13_lv_nmos L=0.13u W=0.42u AS=0.0798p AD=0.0378p
+ PS=0.8u PD=0.6u rfmode=0
M$363 \$526 \$438 \$439 VSS sg13_lv_nmos L=0.13u W=0.42u AS=0.0378p AD=0.1428p
+ PS=0.6u PD=1.52u rfmode=0
M$364 VSS \$567 \$568 VSS sg13_lv_nmos L=0.13u W=11.84u AS=2.3606p AD=2.2496p
+ PS=18.96u PD=17.92u rfmode=0
M$380 VSS \$677 \$567 VSS sg13_lv_nmos L=0.13u W=4.44u AS=0.8436p AD=0.9546p
+ PS=6.72u PD=7.76u rfmode=0
M$386 \$441 \$502 VSS VSS sg13_lv_nmos L=0.13u W=0.42u AS=0.1428p AD=0.0798p
+ PS=1.52u PD=0.8u rfmode=0
M$387 VSS \$441 \$442 VSS sg13_lv_nmos L=0.5u W=0.42u AS=0.0798p AD=0.1428p
+ PS=0.8u PD=1.52u rfmode=0
M$388 VSS \$449 \$448 VSS sg13_lv_nmos L=0.13u W=0.74u AS=0.1626p AD=0.2516p
+ PS=1.415u PD=2.16u rfmode=0
M$389 \$447 \$504 \$528 VSS sg13_lv_nmos L=0.13u W=0.42u AS=0.1428p AD=0.0609p
+ PS=1.52u PD=0.71u rfmode=0
M$390 VSS \$503 \$528 VSS sg13_lv_nmos L=0.13u W=0.42u AS=0.1626p AD=0.0609p
+ PS=1.415u PD=0.71u rfmode=0
M$391 VSS \$503 \$529 VSS sg13_lv_nmos L=0.13u W=0.42u AS=0.1701p AD=0.0378p
+ PS=1.65u PD=0.6u rfmode=0
M$392 \$529 \$448 \$505 VSS sg13_lv_nmos L=0.13u W=0.42u AS=0.0378p AD=0.1428p
+ PS=0.6u PD=1.52u rfmode=0
M$393 \$569 \$570 VSS VSS sg13_lv_nmos L=0.13u W=0.74u AS=0.2516p AD=0.1426p
+ PS=2.16u PD=1.16u rfmode=0
M$394 VSS \$571 \$570 VSS sg13_lv_nmos L=0.5u W=0.42u AS=0.1426p AD=0.1428p
+ PS=1.16u PD=1.52u rfmode=0
M$395 \$571 \$572 VSS VSS sg13_lv_nmos L=0.5u W=0.42u AS=0.1428p AD=0.0798p
+ PS=1.52u PD=0.8u rfmode=0
M$396 VSS \$455 \$572 VSS sg13_lv_nmos L=0.13u W=0.42u AS=0.0798p AD=0.1428p
+ PS=0.8u PD=1.52u rfmode=0
M$397 VSS \$568 \$573 VSS sg13_lv_nmos L=0.13u W=4.44u AS=0.9546p AD=0.8436p
+ PS=7.76u PD=6.72u rfmode=0
M$403 VSS \$573 \$371 VSS sg13_lv_nmos L=0.13u W=11.84u AS=2.2496p AD=2.3606p
+ PS=17.92u PD=18.96u rfmode=0
M$419 \$513 \$453 VSS VSS sg13_lv_nmos L=0.13u W=0.42u AS=0.1428p AD=0.0798p
+ PS=1.52u PD=0.8u rfmode=0
M$420 VSS \$503 \$531 VSS sg13_lv_nmos L=0.13u W=0.42u AS=0.0798p AD=0.0378p
+ PS=0.8u PD=0.6u rfmode=0
M$421 \$531 \$452 \$453 VSS sg13_lv_nmos L=0.13u W=0.42u AS=0.0378p AD=0.1428p
+ PS=0.6u PD=1.52u rfmode=0
M$422 VSS \$461 \$460 VSS sg13_lv_nmos L=0.13u W=0.74u AS=0.1626p AD=0.2516p
+ PS=1.415u PD=2.16u rfmode=0
M$423 \$459 \$457 \$534 VSS sg13_lv_nmos L=0.13u W=0.42u AS=0.1428p AD=0.0609p
+ PS=1.52u PD=0.71u rfmode=0
M$424 VSS \$506 \$534 VSS sg13_lv_nmos L=0.13u W=0.42u AS=0.1626p AD=0.0609p
+ PS=1.415u PD=0.71u rfmode=0
M$425 VSS \$506 \$535 VSS sg13_lv_nmos L=0.13u W=0.42u AS=0.1701p AD=0.0378p
+ PS=1.65u PD=0.6u rfmode=0
M$426 \$535 \$460 \$507 VSS sg13_lv_nmos L=0.13u W=0.42u AS=0.0378p AD=0.1428p
+ PS=0.6u PD=1.52u rfmode=0
M$427 \$351 \$574 \$582 VSS sg13_lv_nmos L=0.13u W=0.74u AS=0.333p AD=0.1406p
+ PS=2.38u PD=1.12u rfmode=0
M$428 \$582 \$312 VSS VSS sg13_lv_nmos L=0.13u W=0.74u AS=0.1406p AD=0.14505p
+ PS=1.12u PD=1.15u rfmode=0
M$429 VSS \$374 \$574 VSS sg13_lv_nmos L=0.13u W=0.55u AS=0.14505p AD=0.187p
+ PS=1.15u PD=1.78u rfmode=0
M$430 \$506 \$342 VSS VSS sg13_lv_nmos L=0.13u W=0.74u AS=0.2516p AD=0.2516p
+ PS=2.16u PD=2.16u rfmode=0
M$431 \$514 \$465 VSS VSS sg13_lv_nmos L=0.13u W=0.42u AS=0.1428p AD=0.0798p
+ PS=1.52u PD=0.8u rfmode=0
M$432 VSS \$506 \$536 VSS sg13_lv_nmos L=0.13u W=0.42u AS=0.0798p AD=0.0378p
+ PS=0.8u PD=0.6u rfmode=0
M$433 \$536 \$464 \$465 VSS sg13_lv_nmos L=0.13u W=0.42u AS=0.0378p AD=0.1428p
+ PS=0.6u PD=1.52u rfmode=0
M$434 VSS \$473 \$472 VSS sg13_lv_nmos L=0.13u W=0.74u AS=0.1626p AD=0.2516p
+ PS=1.415u PD=2.16u rfmode=0
M$435 \$471 \$470 \$540 VSS sg13_lv_nmos L=0.13u W=0.42u AS=0.1428p AD=0.0609p
+ PS=1.52u PD=0.71u rfmode=0
M$436 VSS \$344 \$540 VSS sg13_lv_nmos L=0.13u W=0.42u AS=0.1626p AD=0.0609p
+ PS=1.415u PD=0.71u rfmode=0
M$437 VSS \$344 \$541 VSS sg13_lv_nmos L=0.13u W=0.42u AS=0.1701p AD=0.0378p
+ PS=1.65u PD=0.6u rfmode=0
M$438 \$541 \$472 \$509 VSS sg13_lv_nmos L=0.13u W=0.42u AS=0.0378p AD=0.1428p
+ PS=0.6u PD=1.52u rfmode=0
M$439 \$508 \$575 VSS VSS sg13_lv_nmos L=0.13u W=0.74u AS=0.2886p AD=0.14875p
+ PS=2.26u PD=1.16u rfmode=0
M$440 VSS \$343 \$575 VSS sg13_lv_nmos L=0.13u W=0.55u AS=0.14875p AD=0.187p
+ PS=1.16u PD=1.78u rfmode=0
M$441 \$515 \$477 VSS VSS sg13_lv_nmos L=0.13u W=0.42u AS=0.1428p AD=0.0798p
+ PS=1.52u PD=0.8u rfmode=0
M$442 VSS \$344 \$530 VSS sg13_lv_nmos L=0.13u W=0.42u AS=0.0798p AD=0.0378p
+ PS=0.8u PD=0.6u rfmode=0
M$443 \$530 \$476 \$477 VSS sg13_lv_nmos L=0.13u W=0.42u AS=0.0378p AD=0.1428p
+ PS=0.6u PD=1.52u rfmode=0
M$459 VSS \$542 \$577 VSS sg13_lv_nmos L=0.13u W=0.42u AS=0.1701p AD=0.0378p
+ PS=1.65u PD=0.6u rfmode=0
M$460 \$577 \$545 \$546 VSS sg13_lv_nmos L=0.13u W=0.42u AS=0.0378p AD=0.1428p
+ PS=0.6u PD=1.52u rfmode=0
M$461 \$543 \$547 \$583 VSS sg13_lv_nmos L=0.13u W=0.42u AS=0.1296p AD=0.0798p
+ PS=1.52u PD=0.8u rfmode=0
M$462 \$583 \$584 \$546 VSS sg13_lv_nmos L=0.13u W=0.42u AS=0.0798p AD=0.2373p
+ PS=0.8u PD=1.97u rfmode=0
M$463 VSS \$547 \$584 VSS sg13_lv_nmos L=0.13u W=0.74u AS=0.317325p AD=0.2516p
+ PS=1.805u PD=2.16u rfmode=0
M$464 VSS \$498 \$547 VSS sg13_lv_nmos L=0.13u W=0.74u AS=0.317325p AD=0.2516p
+ PS=1.805u PD=2.16u rfmode=0
M$465 \$549 \$547 \$548 VSS sg13_lv_nmos L=0.13u W=0.42u AS=0.12665p AD=0.1428p
+ PS=1.145u PD=1.52u rfmode=0
M$466 \$545 \$584 \$549 VSS sg13_lv_nmos L=0.13u W=0.74u AS=0.3473p AD=0.12665p
+ PS=2.71u PD=1.145u rfmode=0
M$467 VSS \$585 \$580 VSS sg13_lv_nmos L=0.13u W=0.42u AS=0.1701p AD=0.0378p
+ PS=1.65u PD=0.6u rfmode=0
M$468 \$580 \$556 \$557 VSS sg13_lv_nmos L=0.13u W=0.42u AS=0.0378p AD=0.1428p
+ PS=0.6u PD=1.52u rfmode=0
M$469 \$554 \$558 \$586 VSS sg13_lv_nmos L=0.13u W=0.42u AS=0.1296p AD=0.0798p
+ PS=1.52u PD=0.8u rfmode=0
M$470 \$586 \$587 \$557 VSS sg13_lv_nmos L=0.13u W=0.42u AS=0.0798p AD=0.2373p
+ PS=0.8u PD=1.97u rfmode=0
M$471 VSS \$558 \$587 VSS sg13_lv_nmos L=0.13u W=0.74u AS=0.317325p AD=0.2516p
+ PS=1.805u PD=2.16u rfmode=0
M$472 VSS \$500 \$558 VSS sg13_lv_nmos L=0.13u W=0.74u AS=0.317325p AD=0.2516p
+ PS=1.805u PD=2.16u rfmode=0
M$473 \$560 \$558 \$559 VSS sg13_lv_nmos L=0.13u W=0.42u AS=0.12665p AD=0.1428p
+ PS=1.145u PD=1.52u rfmode=0
M$474 \$556 \$587 \$560 VSS sg13_lv_nmos L=0.13u W=0.74u AS=0.3473p AD=0.12665p
+ PS=2.71u PD=1.145u rfmode=0
M$475 \$611 \$569 \$643 VSS sg13_lv_nmos L=0.13u W=0.64u AS=0.2176p AD=0.1216p
+ PS=1.96u PD=1.02u rfmode=0
M$476 \$643 \$444 VSS VSS sg13_lv_nmos L=0.13u W=0.64u AS=0.1216p AD=0.1331p
+ PS=1.02u PD=1.12u rfmode=0
M$477 VSS \$611 \$504 VSS sg13_lv_nmos L=0.13u W=0.74u AS=0.1331p AD=0.2516p
+ PS=1.12u PD=2.16u rfmode=0
M$478 \$612 \$617 \$613 VSS sg13_lv_nmos L=0.13u W=0.42u AS=0.1296p AD=0.0798p
+ PS=1.52u PD=0.8u rfmode=0
M$479 \$613 \$616 \$632 VSS sg13_lv_nmos L=0.13u W=0.42u AS=0.0798p AD=0.2373p
+ PS=0.8u PD=1.97u rfmode=0
M$508 \$367 \$502 VSS VSS sg13_lv_nmos L=0.13u W=0.77u AS=0.2618p AD=0.1463p
+ PS=2.22u PD=1.15u rfmode=0
M$509 VSS \$391 \$367 VSS sg13_lv_nmos L=0.13u W=0.77u AS=0.1463p AD=0.1694p
+ PS=1.15u PD=1.21u rfmode=0
M$510 \$367 \$569 VSS VSS sg13_lv_nmos L=0.13u W=0.77u AS=0.1694p AD=0.2618p
+ PS=1.21u PD=2.22u rfmode=0
M$511 \$616 \$617 VSS VSS sg13_lv_nmos L=0.13u W=0.74u AS=0.2516p AD=0.317325p
+ PS=2.16u PD=1.805u rfmode=0
M$512 VSS \$371 \$617 VSS sg13_lv_nmos L=0.13u W=0.74u AS=0.317325p AD=0.2516p
+ PS=1.805u PD=2.16u rfmode=0
M$513 \$633 \$617 \$618 VSS sg13_lv_nmos L=0.13u W=0.42u AS=0.1428p AD=0.12665p
+ PS=1.52u PD=1.145u rfmode=0
M$514 \$618 \$616 \$614 VSS sg13_lv_nmos L=0.13u W=0.74u AS=0.12665p AD=0.3473p
+ PS=1.145u PD=2.71u rfmode=0
M$515 VSS \$316 \$601 VSS sg13_lv_nmos L=0.13u W=4.44u AS=0.9546p AD=0.8436p
+ PS=7.76u PD=6.72u rfmode=0
M$521 VSS \$601 \$602 VSS sg13_lv_nmos L=0.13u W=11.84u AS=2.2496p AD=2.3606p
+ PS=17.92u PD=18.96u rfmode=0
M$537 VSS \$605 \$604 VSS sg13_lv_nmos L=0.13u W=0.55u AS=0.18945p AD=0.187p
+ PS=1.27u PD=1.78u rfmode=0
M$538 \$603 \$630 VSS VSS sg13_lv_nmos L=0.13u W=0.74u AS=0.4033p AD=0.148p
+ PS=2.57u PD=1.14u rfmode=0
M$539 VSS \$604 \$648 VSS sg13_lv_nmos L=0.13u W=0.74u AS=0.148p AD=0.3367p
+ PS=1.14u PD=1.65u rfmode=0
M$540 \$648 \$712 \$630 VSS sg13_lv_nmos L=0.13u W=0.74u AS=0.3367p AD=0.1628p
+ PS=1.65u PD=1.18u rfmode=0
M$541 \$630 \$351 \$650 VSS sg13_lv_nmos L=0.13u W=0.74u AS=0.1628p AD=0.13135p
+ PS=1.18u PD=1.095u rfmode=0
M$542 \$650 \$605 VSS VSS sg13_lv_nmos L=0.13u W=0.74u AS=0.13135p AD=0.18945p
+ PS=1.095u PD=1.27u rfmode=0
M$543 VSS \$411 \$585 VSS sg13_lv_nmos L=0.13u W=0.74u AS=0.2516p AD=0.2516p
+ PS=2.16u PD=2.16u rfmode=0
M$544 VSS \$606 \$500 VSS sg13_lv_nmos L=0.13u W=11.84u AS=2.3606p AD=2.2496p
+ PS=18.96u PD=17.92u rfmode=0
M$560 VSS \$568 \$606 VSS sg13_lv_nmos L=0.13u W=4.44u AS=0.8436p AD=0.9546p
+ PS=6.72u PD=7.76u rfmode=0
M$566 VSS \$360 \$651 VSS sg13_lv_nmos L=0.13u W=0.74u AS=0.2516p AD=0.1406p
+ PS=2.16u PD=1.12u rfmode=0
M$567 \$651 \$353 \$649 VSS sg13_lv_nmos L=0.13u W=0.74u AS=0.1406p AD=0.1406p
+ PS=1.12u PD=1.12u rfmode=0
M$568 \$649 \$357 \$647 VSS sg13_lv_nmos L=0.13u W=0.74u AS=0.1406p AD=0.1406p
+ PS=1.12u PD=1.12u rfmode=0
M$569 \$647 \$354 \$502 VSS sg13_lv_nmos L=0.13u W=0.74u AS=0.1406p AD=0.2516p
+ PS=1.12u PD=2.16u rfmode=0
M$570 \$607 \$354 \$646 VSS sg13_lv_nmos L=0.13u W=0.74u AS=0.2516p AD=0.1406p
+ PS=2.16u PD=1.12u rfmode=0
M$571 \$646 \$391 VSS VSS sg13_lv_nmos L=0.13u W=0.74u AS=0.1406p AD=0.2516p
+ PS=1.12u PD=2.16u rfmode=0
M$572 \$608 \$668 VSS VSS sg13_lv_nmos L=0.13u W=0.55u AS=0.187p AD=0.18575p
+ PS=1.78u PD=1.26u rfmode=0
M$573 VSS \$354 \$644 VSS sg13_lv_nmos L=0.13u W=0.74u AS=0.18575p AD=0.1406p
+ PS=1.26u PD=1.12u rfmode=0
M$574 \$644 \$610 \$645 VSS sg13_lv_nmos L=0.13u W=0.74u AS=0.1406p AD=0.1406p
+ PS=1.12u PD=1.12u rfmode=0
M$575 \$645 \$608 \$609 VSS sg13_lv_nmos L=0.13u W=0.74u AS=0.1406p AD=0.3404p
+ PS=1.12u PD=2.4u rfmode=0
M$576 VSS \$631 \$503 VSS sg13_lv_nmos L=0.13u W=0.74u AS=0.2516p AD=0.2516p
+ PS=2.16u PD=2.16u rfmode=0
M$577 VSS \$342 \$623 VSS sg13_lv_nmos L=0.13u W=0.74u AS=0.2516p AD=0.2516p
+ PS=2.16u PD=2.16u rfmode=0
M$580 \$33 \$652 VSS VSS sg13_lv_nmos L=0.13u W=0.74u AS=0.2886p AD=0.14875p
+ PS=2.26u PD=1.16u rfmode=0
M$581 VSS \$712 \$652 VSS sg13_lv_nmos L=0.13u W=0.55u AS=0.14875p AD=0.187p
+ PS=1.16u PD=1.78u rfmode=0
M$594 \$656 \$603 \$701 VSS sg13_lv_nmos L=0.13u W=0.42u AS=0.1428p AD=0.0609p
+ PS=1.52u PD=0.71u rfmode=0
M$595 \$701 \$655 VSS VSS sg13_lv_nmos L=0.13u W=0.42u AS=0.0609p AD=0.1626p
+ PS=0.71u PD=1.415u rfmode=0
M$596 VSS \$713 \$657 VSS sg13_lv_nmos L=0.13u W=0.74u AS=0.1626p AD=0.2516p
+ PS=1.415u PD=2.16u rfmode=0
M$598 \$660 \$662 VSS VSS sg13_lv_nmos L=0.13u W=0.42u AS=0.1428p AD=0.0798p
+ PS=1.52u PD=0.8u rfmode=0
M$599 VSS \$655 \$703 VSS sg13_lv_nmos L=0.13u W=0.42u AS=0.0798p AD=0.0378p
+ PS=0.8u PD=0.6u rfmode=0
M$600 \$703 \$661 \$662 VSS sg13_lv_nmos L=0.13u W=0.42u AS=0.0378p AD=0.1428p
+ PS=0.6u PD=1.52u rfmode=0
M$601 \$663 \$661 VSS VSS sg13_lv_nmos L=0.13u W=0.74u AS=0.2516p AD=0.1406p
+ PS=2.16u PD=1.12u rfmode=0
M$602 VSS \$663 \$712 VSS sg13_lv_nmos L=0.13u W=0.74u AS=0.1406p AD=0.2516p
+ PS=1.12u PD=2.16u rfmode=0
M$603 \$669 \$670 VSS VSS sg13_lv_nmos L=0.13u W=0.74u AS=0.2886p AD=0.14875p
+ PS=2.26u PD=1.16u rfmode=0
M$604 VSS \$327 \$670 VSS sg13_lv_nmos L=0.13u W=0.55u AS=0.14875p AD=0.187p
+ PS=1.16u PD=1.78u rfmode=0
M$605 VSS \$669 \$671 VSS sg13_lv_nmos L=0.13u W=0.55u AS=0.14875p AD=0.187p
+ PS=1.16u PD=1.78u rfmode=0
M$606 VSS \$671 \$631 VSS sg13_lv_nmos L=0.13u W=0.74u AS=0.14875p AD=0.2886p
+ PS=1.16u PD=2.26u rfmode=0
M$607 \$674 \$391 VSS VSS sg13_lv_nmos L=0.15u W=0.74u AS=0.2516p AD=0.1406p
+ PS=2.16u PD=1.12u rfmode=0
M$608 VSS \$667 \$674 VSS sg13_lv_nmos L=0.15u W=0.74u AS=0.1406p AD=0.1406p
+ PS=1.12u PD=1.12u rfmode=0
M$609 \$674 \$354 \$675 VSS sg13_lv_nmos L=0.15u W=0.74u AS=0.1406p AD=0.2516p
+ PS=1.12u PD=2.16u rfmode=0
M$610 VSS \$613 \$614 VSS sg13_lv_nmos L=0.13u W=0.74u AS=0.1626p AD=0.2516p
+ PS=1.415u PD=2.16u rfmode=0
M$611 \$612 \$445 \$642 VSS sg13_lv_nmos L=0.13u W=0.42u AS=0.1428p AD=0.0609p
+ PS=1.52u PD=0.71u rfmode=0
M$612 VSS \$615 \$642 VSS sg13_lv_nmos L=0.13u W=0.42u AS=0.1626p AD=0.0609p
+ PS=1.415u PD=0.71u rfmode=0
M$613 VSS \$615 \$641 VSS sg13_lv_nmos L=0.13u W=0.42u AS=0.1701p AD=0.0378p
+ PS=1.65u PD=0.6u rfmode=0
M$614 \$641 \$614 \$632 VSS sg13_lv_nmos L=0.13u W=0.42u AS=0.0378p AD=0.1428p
+ PS=0.6u PD=1.52u rfmode=0
M$615 fdac_clk \$679 VSS VSS sg13_lv_nmos L=0.13u W=0.74u AS=0.2886p
+ AD=0.14875p PS=2.26u PD=1.16u rfmode=0
M$616 VSS \$338 \$679 VSS sg13_lv_nmos L=0.13u W=0.55u AS=0.14875p AD=0.187p
+ PS=1.16u PD=1.78u rfmode=0
M$617 \$633 \$619 VSS VSS sg13_lv_nmos L=0.13u W=0.42u AS=0.1428p AD=0.0798p
+ PS=1.52u PD=0.8u rfmode=0
M$618 VSS \$615 \$640 VSS sg13_lv_nmos L=0.13u W=0.42u AS=0.0798p AD=0.0378p
+ PS=0.8u PD=0.6u rfmode=0
M$619 \$640 \$618 \$619 VSS sg13_lv_nmos L=0.13u W=0.42u AS=0.0378p AD=0.1428p
+ PS=0.6u PD=1.52u rfmode=0
M$620 \$620 \$618 VSS VSS sg13_lv_nmos L=0.13u W=0.74u AS=0.2516p AD=0.1406p
+ PS=2.16u PD=1.12u rfmode=0
M$621 VSS \$620 \$610 VSS sg13_lv_nmos L=0.13u W=0.74u AS=0.1406p AD=0.2516p
+ PS=1.12u PD=2.16u rfmode=0
M$624 VSS \$621 \$622 VSS sg13_lv_nmos L=0.13u W=0.55u AS=0.14875p AD=0.187p
+ PS=1.16u PD=1.78u rfmode=0
M$625 \$687 \$622 VSS VSS sg13_lv_nmos L=0.13u W=0.74u AS=0.2886p AD=0.14875p
+ PS=2.26u PD=1.16u rfmode=0
M$626 \$690 \$689 \$710 VSS sg13_lv_nmos L=0.13u W=0.42u AS=0.1428p AD=0.0609p
+ PS=1.52u PD=0.71u rfmode=0
M$627 \$710 \$623 VSS VSS sg13_lv_nmos L=0.13u W=0.42u AS=0.0609p AD=0.1626p
+ PS=0.71u PD=1.415u rfmode=0
M$628 VSS \$717 \$691 VSS sg13_lv_nmos L=0.13u W=0.74u AS=0.1626p AD=0.2516p
+ PS=1.415u PD=2.16u rfmode=0
M$633 \$694 \$696 VSS VSS sg13_lv_nmos L=0.13u W=0.42u AS=0.1428p AD=0.0798p
+ PS=1.52u PD=0.8u rfmode=0
M$634 VSS \$623 \$707 VSS sg13_lv_nmos L=0.13u W=0.42u AS=0.0798p AD=0.0378p
+ PS=0.8u PD=0.6u rfmode=0
M$635 \$707 \$695 \$696 VSS sg13_lv_nmos L=0.13u W=0.42u AS=0.0378p AD=0.1428p
+ PS=0.6u PD=1.52u rfmode=0
M$638 \$697 \$695 VSS VSS sg13_lv_nmos L=0.13u W=0.74u AS=0.2516p AD=0.1406p
+ PS=2.16u PD=1.12u rfmode=0
M$639 VSS \$697 \$688 VSS sg13_lv_nmos L=0.13u W=0.74u AS=0.1406p AD=0.2516p
+ PS=1.12u PD=2.16u rfmode=0
M$666 VSS \$688 \$698 VSS sg13_lv_nmos L=0.13u W=0.55u AS=0.14875p AD=0.187p
+ PS=1.16u PD=1.78u rfmode=0
M$667 VSS \$698 \$36 VSS sg13_lv_nmos L=0.13u W=0.74u AS=0.14875p AD=0.2886p
+ PS=1.16u PD=2.26u rfmode=0
M$668 \$544 \$653 VSS VSS sg13_lv_nmos L=0.13u W=0.74u AS=0.4033p AD=0.148p
+ PS=2.57u PD=1.14u rfmode=0
M$669 VSS \$654 \$699 VSS sg13_lv_nmos L=0.13u W=0.74u AS=0.148p AD=0.3367p
+ PS=1.14u PD=1.65u rfmode=0
M$670 \$699 \$408 \$653 VSS sg13_lv_nmos L=0.13u W=0.74u AS=0.3367p AD=0.1628p
+ PS=1.65u PD=1.18u rfmode=0
M$671 \$653 \$351 \$700 VSS sg13_lv_nmos L=0.13u W=0.74u AS=0.1628p AD=0.13135p
+ PS=1.18u PD=1.095u rfmode=0
M$672 \$700 \$926 VSS VSS sg13_lv_nmos L=0.13u W=0.74u AS=0.13135p AD=0.18945p
+ PS=1.095u PD=1.27u rfmode=0
M$673 VSS \$926 \$654 VSS sg13_lv_nmos L=0.13u W=0.55u AS=0.18945p AD=0.187p
+ PS=1.27u PD=1.78u rfmode=0
M$674 VSS \$411 \$655 VSS sg13_lv_nmos L=0.13u W=0.74u AS=0.2516p AD=0.2516p
+ PS=2.16u PD=2.16u rfmode=0
M$675 \$667 \$668 VSS VSS sg13_lv_nmos L=0.13u W=0.74u AS=0.2516p AD=0.2516p
+ PS=2.16u PD=2.16u rfmode=0
M$676 VSS fclk_in \$676 VSS sg13_lv_nmos L=0.13u W=4.44u AS=0.9546p AD=0.8436p
+ PS=7.76u PD=6.72u rfmode=0
M$682 VSS \$676 \$677 VSS sg13_lv_nmos L=0.13u W=11.84u AS=2.2496p AD=2.3606p
+ PS=17.92u PD=18.96u rfmode=0
M$698 VSS \$421 \$680 VSS sg13_lv_nmos L=0.13u W=0.74u AS=0.2516p AD=0.2516p
+ PS=2.16u PD=2.16u rfmode=0
M$699 \$391 \$681 VSS VSS sg13_lv_nmos L=0.13u W=0.74u AS=0.2516p AD=0.2516p
+ PS=2.16u PD=2.16u rfmode=0
M$700 \$681 \$682 VSS VSS sg13_lv_nmos L=0.13u W=0.74u AS=0.2516p AD=0.1426p
+ PS=2.16u PD=1.16u rfmode=0
M$701 VSS \$683 \$682 VSS sg13_lv_nmos L=0.5u W=0.42u AS=0.1426p AD=0.1428p
+ PS=1.16u PD=1.52u rfmode=0
M$702 \$683 \$684 VSS VSS sg13_lv_nmos L=0.5u W=0.42u AS=0.1428p AD=0.0798p
+ PS=1.52u PD=0.8u rfmode=0
M$703 VSS \$610 \$684 VSS sg13_lv_nmos L=0.13u W=0.42u AS=0.0798p AD=0.1428p
+ PS=0.8u PD=1.52u rfmode=0
M$704 VSS \$605 \$685 VSS sg13_lv_nmos L=0.13u W=0.55u AS=0.18945p AD=0.187p
+ PS=1.27u PD=1.78u rfmode=0
M$705 VSS \$605 \$708 VSS sg13_lv_nmos L=0.13u W=0.74u AS=0.18945p AD=0.13135p
+ PS=1.27u PD=1.095u rfmode=0
M$706 \$708 \$687 \$686 VSS sg13_lv_nmos L=0.13u W=0.74u AS=0.13135p AD=0.1628p
+ PS=1.095u PD=1.18u rfmode=0
M$707 \$686 \$688 \$709 VSS sg13_lv_nmos L=0.13u W=0.74u AS=0.1628p AD=0.3367p
+ PS=1.18u PD=1.65u rfmode=0
M$708 \$709 \$685 VSS VSS sg13_lv_nmos L=0.13u W=0.74u AS=0.3367p AD=0.148p
+ PS=1.65u PD=1.14u rfmode=0
M$709 VSS \$686 \$689 VSS sg13_lv_nmos L=0.13u W=0.74u AS=0.148p AD=0.4033p
+ PS=1.14u PD=2.57u rfmode=0
M$725 VSS \$655 \$702 VSS sg13_lv_nmos L=0.13u W=0.42u AS=0.1701p AD=0.0378p
+ PS=1.65u PD=0.6u rfmode=0
M$726 \$702 \$657 \$658 VSS sg13_lv_nmos L=0.13u W=0.42u AS=0.0378p AD=0.1428p
+ PS=0.6u PD=1.52u rfmode=0
M$727 VSS \$659 \$714 VSS sg13_lv_nmos L=0.13u W=0.74u AS=0.317325p AD=0.2516p
+ PS=1.805u PD=2.16u rfmode=0
M$728 VSS \$498 \$659 VSS sg13_lv_nmos L=0.13u W=0.74u AS=0.317325p AD=0.2516p
+ PS=1.805u PD=2.16u rfmode=0
M$729 \$661 \$659 \$660 VSS sg13_lv_nmos L=0.13u W=0.42u AS=0.12665p AD=0.1428p
+ PS=1.145u PD=1.52u rfmode=0
M$730 \$657 \$714 \$661 VSS sg13_lv_nmos L=0.13u W=0.74u AS=0.3473p AD=0.12665p
+ PS=2.71u PD=1.145u rfmode=0
M$731 \$555 \$665 VSS VSS sg13_lv_nmos L=0.13u W=0.74u AS=0.2516p AD=0.1331p
+ PS=2.16u PD=1.12u rfmode=0
M$732 VSS \$664 \$704 VSS sg13_lv_nmos L=0.13u W=0.64u AS=0.1331p AD=0.1216p
+ PS=1.12u PD=1.02u rfmode=0
M$733 \$704 \$319 \$665 VSS sg13_lv_nmos L=0.13u W=0.64u AS=0.1216p AD=0.2176p
+ PS=1.02u PD=1.96u rfmode=0
M$734 \$664 \$666 VSS VSS sg13_lv_nmos L=0.13u W=0.74u AS=0.2351p AD=0.15745p
+ PS=2.16u PD=1.175u rfmode=0
M$735 VSS \$353 \$666 VSS sg13_lv_nmos L=0.13u W=0.64u AS=0.15745p AD=0.1216p
+ PS=1.175u PD=1.02u rfmode=0
M$736 \$666 \$354 \$705 VSS sg13_lv_nmos L=0.13u W=0.64u AS=0.1216p AD=0.0816p
+ PS=1.02u PD=0.895u rfmode=0
M$737 \$705 \$356 VSS VSS sg13_lv_nmos L=0.13u W=0.64u AS=0.0816p AD=0.2176p
+ PS=0.895u PD=1.96u rfmode=0
M$738 \$673 \$672 VSS VSS sg13_lv_nmos L=0.13u W=0.74u AS=0.2351p AD=0.15745p
+ PS=2.16u PD=1.175u rfmode=0
M$739 VSS \$793 \$672 VSS sg13_lv_nmos L=0.13u W=0.64u AS=0.15745p AD=0.1216p
+ PS=1.175u PD=1.02u rfmode=0
M$740 \$672 \$668 \$706 VSS sg13_lv_nmos L=0.13u W=0.64u AS=0.1216p AD=0.0816p
+ PS=1.02u PD=0.895u rfmode=0
M$741 \$706 \$607 VSS VSS sg13_lv_nmos L=0.13u W=0.64u AS=0.0816p AD=0.2176p
+ PS=0.895u PD=1.96u rfmode=0
M$742 VSS \$623 \$711 VSS sg13_lv_nmos L=0.13u W=0.42u AS=0.1701p AD=0.0378p
+ PS=1.65u PD=0.6u rfmode=0
M$743 \$711 \$691 \$692 VSS sg13_lv_nmos L=0.13u W=0.42u AS=0.0378p AD=0.1428p
+ PS=0.6u PD=1.52u rfmode=0
M$744 VSS \$693 \$718 VSS sg13_lv_nmos L=0.13u W=0.74u AS=0.317325p AD=0.2516p
+ PS=1.805u PD=2.16u rfmode=0
M$745 VSS \$508 \$693 VSS sg13_lv_nmos L=0.13u W=0.74u AS=0.317325p AD=0.2516p
+ PS=1.805u PD=2.16u rfmode=0
M$746 \$695 \$693 \$694 VSS sg13_lv_nmos L=0.13u W=0.42u AS=0.12665p AD=0.1428p
+ PS=1.145u PD=1.52u rfmode=0
M$747 \$691 \$718 \$695 VSS sg13_lv_nmos L=0.13u W=0.74u AS=0.3473p AD=0.12665p
+ PS=2.71u PD=1.145u rfmode=0
M$795 \$656 \$659 \$713 VSS sg13_lv_nmos L=0.13u W=0.42u AS=0.1296p AD=0.0798p
+ PS=1.52u PD=0.8u rfmode=0
M$796 \$713 \$714 \$658 VSS sg13_lv_nmos L=0.13u W=0.42u AS=0.0798p AD=0.2373p
+ PS=0.8u PD=1.97u rfmode=0
M$798 VSS \$733 \$731 VSS sg13_lv_nmos L=0.13u W=0.55u AS=0.18945p AD=0.187p
+ PS=1.27u PD=1.78u rfmode=0
M$799 \$730 \$764 VSS VSS sg13_lv_nmos L=0.13u W=0.74u AS=0.4033p AD=0.148p
+ PS=2.57u PD=1.14u rfmode=0
M$800 VSS \$731 \$779 VSS sg13_lv_nmos L=0.13u W=0.74u AS=0.148p AD=0.3367p
+ PS=1.14u PD=1.65u rfmode=0
M$801 \$779 \$732 \$764 VSS sg13_lv_nmos L=0.13u W=0.74u AS=0.3367p AD=0.1628p
+ PS=1.65u PD=1.18u rfmode=0
M$802 \$764 \$351 \$780 VSS sg13_lv_nmos L=0.13u W=0.74u AS=0.1628p AD=0.13135p
+ PS=1.18u PD=1.095u rfmode=0
M$803 \$780 \$733 VSS VSS sg13_lv_nmos L=0.13u W=0.74u AS=0.13135p AD=0.18945p
+ PS=1.095u PD=1.27u rfmode=0
M$808 \$435 \$631 VSS VSS sg13_lv_nmos L=0.13u W=0.74u AS=0.2516p AD=0.2516p
+ PS=2.16u PD=2.16u rfmode=0
M$809 VSS \$669 \$734 VSS sg13_lv_nmos L=0.13u W=0.55u AS=0.14875p AD=0.187p
+ PS=1.16u PD=1.78u rfmode=0
M$810 \$421 \$734 VSS VSS sg13_lv_nmos L=0.13u W=0.74u AS=0.2886p AD=0.14875p
+ PS=2.26u PD=1.16u rfmode=0
M$811 VSS \$736 \$737 VSS sg13_lv_nmos L=0.13u W=0.74u AS=0.1626p AD=0.2516p
+ PS=1.415u PD=2.16u rfmode=0
M$812 \$735 \$673 \$782 VSS sg13_lv_nmos L=0.13u W=0.42u AS=0.1428p AD=0.0609p
+ PS=1.52u PD=0.71u rfmode=0
M$813 VSS \$738 \$782 VSS sg13_lv_nmos L=0.13u W=0.42u AS=0.1626p AD=0.0609p
+ PS=1.415u PD=0.71u rfmode=0
M$814 VSS \$738 \$781 VSS sg13_lv_nmos L=0.13u W=0.42u AS=0.1701p AD=0.0378p
+ PS=1.65u PD=0.6u rfmode=0
M$815 \$781 \$737 \$765 VSS sg13_lv_nmos L=0.13u W=0.42u AS=0.0378p AD=0.1428p
+ PS=0.6u PD=1.52u rfmode=0
M$816 \$735 \$740 \$736 VSS sg13_lv_nmos L=0.13u W=0.42u AS=0.1296p AD=0.0798p
+ PS=1.52u PD=0.8u rfmode=0
M$817 \$736 \$739 \$765 VSS sg13_lv_nmos L=0.13u W=0.42u AS=0.0798p AD=0.2373p
+ PS=0.8u PD=1.97u rfmode=0
M$818 \$739 \$740 VSS VSS sg13_lv_nmos L=0.13u W=0.74u AS=0.2516p AD=0.317325p
+ PS=2.16u PD=1.805u rfmode=0
M$819 VSS \$741 \$740 VSS sg13_lv_nmos L=0.13u W=0.74u AS=0.317325p AD=0.2516p
+ PS=1.805u PD=2.16u rfmode=0
M$820 \$766 \$740 \$742 VSS sg13_lv_nmos L=0.13u W=0.42u AS=0.1428p AD=0.12665p
+ PS=1.52u PD=1.145u rfmode=0
M$821 \$742 \$739 \$737 VSS sg13_lv_nmos L=0.13u W=0.74u AS=0.12665p AD=0.3473p
+ PS=1.145u PD=2.71u rfmode=0
M$822 \$766 \$743 VSS VSS sg13_lv_nmos L=0.13u W=0.42u AS=0.1428p AD=0.0798p
+ PS=1.52u PD=0.8u rfmode=0
M$823 VSS \$738 \$778 VSS sg13_lv_nmos L=0.13u W=0.42u AS=0.0798p AD=0.0378p
+ PS=0.8u PD=0.6u rfmode=0
M$824 \$778 \$742 \$743 VSS sg13_lv_nmos L=0.13u W=0.42u AS=0.0378p AD=0.1428p
+ PS=0.6u PD=1.52u rfmode=0
M$825 \$744 \$742 VSS VSS sg13_lv_nmos L=0.13u W=0.74u AS=0.2516p AD=0.1406p
+ PS=2.16u PD=1.12u rfmode=0
M$826 VSS \$744 \$668 VSS sg13_lv_nmos L=0.13u W=0.74u AS=0.1406p AD=0.2516p
+ PS=1.12u PD=2.16u rfmode=0
M$827 VSS \$631 \$615 VSS sg13_lv_nmos L=0.13u W=0.74u AS=0.2516p AD=0.2516p
+ PS=2.16u PD=2.16u rfmode=0
M$828 VSS \$675 \$777 VSS sg13_lv_nmos L=0.13u W=0.74u AS=0.2516p AD=0.1406p
+ PS=2.16u PD=1.12u rfmode=0
M$829 \$777 \$767 \$745 VSS sg13_lv_nmos L=0.13u W=0.74u AS=0.1406p AD=0.2516p
+ PS=1.12u PD=2.16u rfmode=0
M$830 \$768 \$767 VSS VSS sg13_lv_nmos L=0.15u W=0.74u AS=0.2516p AD=0.1406p
+ PS=2.16u PD=1.12u rfmode=0
M$831 VSS \$796 \$768 VSS sg13_lv_nmos L=0.15u W=0.74u AS=0.1406p AD=0.1406p
+ PS=1.12u PD=1.12u rfmode=0
M$832 \$768 \$745 \$746 VSS sg13_lv_nmos L=0.15u W=0.74u AS=0.1406p AD=0.2516p
+ PS=1.12u PD=2.16u rfmode=0
M$833 VSS \$748 \$749 VSS sg13_lv_nmos L=0.13u W=0.74u AS=0.1626p AD=0.2516p
+ PS=1.415u PD=2.16u rfmode=0
M$834 \$747 \$746 \$776 VSS sg13_lv_nmos L=0.13u W=0.42u AS=0.1428p AD=0.0609p
+ PS=1.52u PD=0.71u rfmode=0
M$835 VSS \$680 \$776 VSS sg13_lv_nmos L=0.13u W=0.42u AS=0.1626p AD=0.0609p
+ PS=1.415u PD=0.71u rfmode=0
M$836 VSS \$680 \$775 VSS sg13_lv_nmos L=0.13u W=0.42u AS=0.1701p AD=0.0378p
+ PS=1.65u PD=0.6u rfmode=0
M$837 \$775 \$749 \$769 VSS sg13_lv_nmos L=0.13u W=0.42u AS=0.0378p AD=0.1428p
+ PS=0.6u PD=1.52u rfmode=0
M$838 \$747 \$751 \$748 VSS sg13_lv_nmos L=0.13u W=0.42u AS=0.1296p AD=0.0798p
+ PS=1.52u PD=0.8u rfmode=0
M$839 \$748 \$750 \$769 VSS sg13_lv_nmos L=0.13u W=0.42u AS=0.0798p AD=0.2373p
+ PS=0.8u PD=1.97u rfmode=0
M$840 \$750 \$751 VSS VSS sg13_lv_nmos L=0.13u W=0.74u AS=0.2516p AD=0.317325p
+ PS=2.16u PD=1.805u rfmode=0
M$841 VSS \$741 \$751 VSS sg13_lv_nmos L=0.13u W=0.74u AS=0.317325p AD=0.2516p
+ PS=1.805u PD=2.16u rfmode=0
M$842 \$770 \$751 \$752 VSS sg13_lv_nmos L=0.13u W=0.42u AS=0.1428p AD=0.12665p
+ PS=1.52u PD=1.145u rfmode=0
M$843 \$752 \$750 \$749 VSS sg13_lv_nmos L=0.13u W=0.74u AS=0.12665p AD=0.3473p
+ PS=1.145u PD=2.71u rfmode=0
M$844 \$770 \$753 VSS VSS sg13_lv_nmos L=0.13u W=0.42u AS=0.1428p AD=0.0798p
+ PS=1.52u PD=0.8u rfmode=0
M$845 VSS \$680 \$774 VSS sg13_lv_nmos L=0.13u W=0.42u AS=0.0798p AD=0.0378p
+ PS=0.8u PD=0.6u rfmode=0
M$846 \$774 \$752 \$753 VSS sg13_lv_nmos L=0.13u W=0.42u AS=0.0378p AD=0.1428p
+ PS=0.6u PD=1.52u rfmode=0
M$847 \$754 \$752 VSS VSS sg13_lv_nmos L=0.13u W=0.74u AS=0.2516p AD=0.1406p
+ PS=2.16u PD=1.12u rfmode=0
M$848 VSS \$754 \$767 VSS sg13_lv_nmos L=0.13u W=0.74u AS=0.1406p AD=0.2516p
+ PS=1.12u PD=2.16u rfmode=0
M$851 VSS \$341 \$755 VSS sg13_lv_nmos L=0.13u W=0.55u AS=0.14875p AD=0.187p
+ PS=1.16u PD=1.78u rfmode=0
M$852 \$621 \$755 VSS VSS sg13_lv_nmos L=0.13u W=0.74u AS=0.2886p AD=0.14875p
+ PS=2.26u PD=1.16u rfmode=0
M$855 \$690 \$693 \$717 VSS sg13_lv_nmos L=0.13u W=0.42u AS=0.1296p AD=0.0798p
+ PS=1.52u PD=0.8u rfmode=0
M$856 \$717 \$718 \$692 VSS sg13_lv_nmos L=0.13u W=0.42u AS=0.0798p AD=0.2373p
+ PS=0.8u PD=1.97u rfmode=0
M$858 VSS \$342 \$756 VSS sg13_lv_nmos L=0.13u W=0.74u AS=0.2516p AD=0.2516p
+ PS=2.16u PD=2.16u rfmode=0
M$909 VSS \$411 \$783 VSS sg13_lv_nmos L=0.13u W=0.74u AS=0.2516p AD=0.2516p
+ PS=2.16u PD=2.16u rfmode=0
M$910 \$784 \$730 \$812 VSS sg13_lv_nmos L=0.13u W=0.42u AS=0.1428p AD=0.0609p
+ PS=1.52u PD=0.71u rfmode=0
M$911 \$812 \$783 VSS VSS sg13_lv_nmos L=0.13u W=0.42u AS=0.0609p AD=0.1626p
+ PS=0.71u PD=1.415u rfmode=0
M$912 VSS \$819 \$785 VSS sg13_lv_nmos L=0.13u W=0.74u AS=0.1626p AD=0.2516p
+ PS=1.415u PD=2.16u rfmode=0
M$913 VSS \$783 \$813 VSS sg13_lv_nmos L=0.13u W=0.42u AS=0.1701p AD=0.0378p
+ PS=1.65u PD=0.6u rfmode=0
M$914 \$813 \$785 \$786 VSS sg13_lv_nmos L=0.13u W=0.42u AS=0.0378p AD=0.1428p
+ PS=0.6u PD=1.52u rfmode=0
M$915 VSS \$787 \$820 VSS sg13_lv_nmos L=0.13u W=0.74u AS=0.317325p AD=0.2516p
+ PS=1.805u PD=2.16u rfmode=0
M$916 VSS \$498 \$787 VSS sg13_lv_nmos L=0.13u W=0.74u AS=0.317325p AD=0.2516p
+ PS=1.805u PD=2.16u rfmode=0
M$917 \$789 \$787 \$788 VSS sg13_lv_nmos L=0.13u W=0.42u AS=0.12665p AD=0.1428p
+ PS=1.145u PD=1.52u rfmode=0
M$918 \$785 \$820 \$789 VSS sg13_lv_nmos L=0.13u W=0.74u AS=0.3473p AD=0.12665p
+ PS=2.71u PD=1.145u rfmode=0
M$919 \$788 \$790 VSS VSS sg13_lv_nmos L=0.13u W=0.42u AS=0.1428p AD=0.0798p
+ PS=1.52u PD=0.8u rfmode=0
M$920 VSS \$783 \$814 VSS sg13_lv_nmos L=0.13u W=0.42u AS=0.0798p AD=0.0378p
+ PS=0.8u PD=0.6u rfmode=0
M$921 \$814 \$789 \$790 VSS sg13_lv_nmos L=0.13u W=0.42u AS=0.0378p AD=0.1428p
+ PS=0.6u PD=1.52u rfmode=0
M$922 \$791 \$789 VSS VSS sg13_lv_nmos L=0.13u W=0.74u AS=0.2516p AD=0.1406p
+ PS=2.16u PD=1.12u rfmode=0
M$923 VSS \$791 \$732 VSS sg13_lv_nmos L=0.13u W=0.74u AS=0.1406p AD=0.2516p
+ PS=1.12u PD=2.16u rfmode=0
M$926 VSS \$421 \$738 VSS sg13_lv_nmos L=0.13u W=0.74u AS=0.2516p AD=0.2516p
+ PS=2.16u PD=2.16u rfmode=0
M$929 VSS \$792 \$793 VSS sg13_lv_nmos L=0.13u W=0.74u AS=0.2516p AD=0.1406p
+ PS=2.16u PD=1.12u rfmode=0
M$930 \$793 \$794 VSS VSS sg13_lv_nmos L=0.13u W=0.74u AS=0.1406p AD=0.2516p
+ PS=1.12u PD=2.16u rfmode=0
M$931 VSS \$854 \$733 VSS sg13_lv_nmos L=0.13u W=0.77u AS=0.2618p AD=0.1694p
+ PS=2.22u PD=1.21u rfmode=0
M$932 \$733 \$794 VSS VSS sg13_lv_nmos L=0.13u W=0.77u AS=0.1694p AD=0.1463p
+ PS=1.21u PD=1.15u rfmode=0
M$933 VSS \$796 \$733 VSS sg13_lv_nmos L=0.13u W=0.77u AS=0.1463p AD=0.2618p
+ PS=1.15u PD=2.22u rfmode=0
M$934 VSS \$796 \$797 VSS sg13_lv_nmos L=0.13u W=0.55u AS=0.187p AD=0.1045p
+ PS=1.78u PD=0.93u rfmode=0
M$935 \$797 \$795 VSS VSS sg13_lv_nmos L=0.13u W=0.55u AS=0.1045p AD=0.1469p
+ PS=0.93u PD=1.155u rfmode=0
M$936 VSS \$797 \$792 VSS sg13_lv_nmos L=0.13u W=0.74u AS=0.1469p AD=0.2516p
+ PS=1.155u PD=2.16u rfmode=0
M$937 VSS \$795 \$798 VSS sg13_lv_nmos L=0.13u W=0.74u AS=0.2516p AD=0.1406p
+ PS=2.16u PD=1.12u rfmode=0
M$938 \$798 \$796 VSS VSS sg13_lv_nmos L=0.13u W=0.74u AS=0.1406p AD=0.2516p
+ PS=1.12u PD=2.16u rfmode=0
M$941 \$796 \$799 VSS VSS sg13_lv_nmos L=0.13u W=0.74u AS=0.2886p AD=0.14875p
+ PS=2.26u PD=1.16u rfmode=0
M$942 VSS \$609 \$799 VSS sg13_lv_nmos L=0.13u W=0.55u AS=0.14875p AD=0.187p
+ PS=1.16u PD=1.78u rfmode=0
M$947 \$741 \$800 VSS VSS sg13_lv_nmos L=0.13u W=0.74u AS=0.2886p AD=0.14875p
+ PS=2.26u PD=1.16u rfmode=0
M$948 VSS \$343 \$800 VSS sg13_lv_nmos L=0.13u W=0.55u AS=0.14875p AD=0.187p
+ PS=1.16u PD=1.78u rfmode=0
M$954 VSS \$733 \$801 VSS sg13_lv_nmos L=0.13u W=0.74u AS=0.2516p AD=0.1406p
+ PS=2.16u PD=1.12u rfmode=0
M$955 \$801 \$802 VSS VSS sg13_lv_nmos L=0.13u W=0.74u AS=0.1406p AD=0.2516p
+ PS=1.12u PD=2.16u rfmode=0
M$956 VSS \$351 \$815 VSS sg13_lv_nmos L=0.13u W=0.74u AS=0.2516p AD=0.1406p
+ PS=2.16u PD=1.12u rfmode=0
M$957 \$815 \$733 \$803 VSS sg13_lv_nmos L=0.13u W=0.74u AS=0.1406p AD=0.1406p
+ PS=1.12u PD=1.12u rfmode=0
M$958 \$803 \$801 VSS VSS sg13_lv_nmos L=0.13u W=0.74u AS=0.1406p AD=0.2516p
+ PS=1.12u PD=2.16u rfmode=0
M$959 \$804 \$803 \$817 VSS sg13_lv_nmos L=0.13u W=0.42u AS=0.1428p AD=0.0609p
+ PS=1.52u PD=0.71u rfmode=0
M$960 \$817 \$756 VSS VSS sg13_lv_nmos L=0.13u W=0.42u AS=0.0609p AD=0.1626p
+ PS=0.71u PD=1.415u rfmode=0
M$961 VSS \$822 \$805 VSS sg13_lv_nmos L=0.13u W=0.74u AS=0.1626p AD=0.2516p
+ PS=1.415u PD=2.16u rfmode=0
M$962 VSS \$756 \$818 VSS sg13_lv_nmos L=0.13u W=0.42u AS=0.1701p AD=0.0378p
+ PS=1.65u PD=0.6u rfmode=0
M$963 \$818 \$805 \$806 VSS sg13_lv_nmos L=0.13u W=0.42u AS=0.0378p AD=0.1428p
+ PS=0.6u PD=1.52u rfmode=0
M$964 VSS \$807 \$823 VSS sg13_lv_nmos L=0.13u W=0.74u AS=0.317325p AD=0.2516p
+ PS=1.805u PD=2.16u rfmode=0
M$965 VSS \$508 \$807 VSS sg13_lv_nmos L=0.13u W=0.74u AS=0.317325p AD=0.2516p
+ PS=1.805u PD=2.16u rfmode=0
M$966 \$809 \$807 \$808 VSS sg13_lv_nmos L=0.13u W=0.42u AS=0.12665p AD=0.1428p
+ PS=1.145u PD=1.52u rfmode=0
M$967 \$805 \$823 \$809 VSS sg13_lv_nmos L=0.13u W=0.74u AS=0.3473p AD=0.12665p
+ PS=2.71u PD=1.145u rfmode=0
M$968 \$808 \$810 VSS VSS sg13_lv_nmos L=0.13u W=0.42u AS=0.1428p AD=0.0798p
+ PS=1.52u PD=0.8u rfmode=0
M$969 VSS \$756 \$816 VSS sg13_lv_nmos L=0.13u W=0.42u AS=0.0798p AD=0.0378p
+ PS=0.8u PD=0.6u rfmode=0
M$970 \$816 \$809 \$810 VSS sg13_lv_nmos L=0.13u W=0.42u AS=0.0378p AD=0.1428p
+ PS=0.6u PD=1.52u rfmode=0
M$971 \$811 \$809 VSS VSS sg13_lv_nmos L=0.13u W=0.74u AS=0.2516p AD=0.1406p
+ PS=2.16u PD=1.12u rfmode=0
M$972 VSS \$811 \$802 VSS sg13_lv_nmos L=0.13u W=0.74u AS=0.1406p AD=0.2516p
+ PS=1.12u PD=2.16u rfmode=0
M$996 VSS \$732 \$838 VSS sg13_lv_nmos L=0.13u W=0.55u AS=0.14875p AD=0.187p
+ PS=1.16u PD=1.78u rfmode=0
M$997 \$32 \$838 VSS VSS sg13_lv_nmos L=0.13u W=0.74u AS=0.2886p AD=0.14875p
+ PS=2.26u PD=1.16u rfmode=0
M$1012 VSS \$839 \$840 VSS sg13_lv_nmos L=0.13u W=0.74u AS=0.2516p AD=0.1406p
+ PS=2.16u PD=1.12u rfmode=0
M$1013 \$840 \$350 \$898 VSS sg13_lv_nmos L=0.13u W=0.74u AS=0.1406p AD=0.1406p
+ PS=1.12u PD=1.12u rfmode=0
M$1014 \$898 \$351 VSS VSS sg13_lv_nmos L=0.13u W=0.74u AS=0.1406p AD=0.2516p
+ PS=1.12u PD=2.16u rfmode=0
M$1023 \$784 \$787 \$819 VSS sg13_lv_nmos L=0.13u W=0.42u AS=0.1296p AD=0.0798p
+ PS=1.52u PD=0.8u rfmode=0
M$1024 \$819 \$820 \$786 VSS sg13_lv_nmos L=0.13u W=0.42u AS=0.0798p AD=0.2373p
+ PS=0.8u PD=1.97u rfmode=0
M$1026 \$842 \$733 VSS VSS sg13_lv_nmos L=0.13u W=0.55u AS=0.187p AD=0.14505p
+ PS=1.78u PD=1.15u rfmode=0
M$1027 VSS \$843 \$905 VSS sg13_lv_nmos L=0.13u W=0.74u AS=0.14505p AD=0.1406p
+ PS=1.15u PD=1.12u rfmode=0
M$1028 \$905 \$842 \$844 VSS sg13_lv_nmos L=0.13u W=0.74u AS=0.1406p AD=0.333p
+ PS=1.12u PD=2.38u rfmode=0
M$1029 VSS \$848 \$908 VSS sg13_lv_nmos L=0.13u W=0.42u AS=0.1701p AD=0.0378p
+ PS=1.65u PD=0.6u rfmode=0
M$1030 \$908 \$847 \$881 VSS sg13_lv_nmos L=0.13u W=0.42u AS=0.0378p AD=0.1428p
+ PS=0.6u PD=1.52u rfmode=0
M$1031 \$845 \$850 \$846 VSS sg13_lv_nmos L=0.13u W=0.42u AS=0.1296p AD=0.0798p
+ PS=1.52u PD=0.8u rfmode=0
M$1032 \$846 \$849 \$881 VSS sg13_lv_nmos L=0.13u W=0.42u AS=0.0798p AD=0.2373p
+ PS=0.8u PD=1.97u rfmode=0
M$1033 \$849 \$850 VSS VSS sg13_lv_nmos L=0.13u W=0.74u AS=0.2516p AD=0.317325p
+ PS=2.16u PD=1.805u rfmode=0
M$1034 VSS \$741 \$850 VSS sg13_lv_nmos L=0.13u W=0.74u AS=0.317325p AD=0.2516p
+ PS=1.805u PD=2.16u rfmode=0
M$1035 \$882 \$850 \$851 VSS sg13_lv_nmos L=0.13u W=0.42u AS=0.1428p
+ AD=0.12665p PS=1.52u PD=1.145u rfmode=0
M$1036 \$851 \$849 \$847 VSS sg13_lv_nmos L=0.13u W=0.74u AS=0.12665p
+ AD=0.3473p PS=1.145u PD=2.71u rfmode=0
M$1037 \$853 \$851 VSS VSS sg13_lv_nmos L=0.13u W=0.74u AS=0.2516p AD=0.1406p
+ PS=2.16u PD=1.12u rfmode=0
M$1038 VSS \$853 \$854 VSS sg13_lv_nmos L=0.13u W=0.74u AS=0.1406p AD=0.2516p
+ PS=1.12u PD=2.16u rfmode=0
M$1039 VSS \$675 \$904 VSS sg13_lv_nmos L=0.13u W=0.74u AS=0.2553p AD=0.13875p
+ PS=2.17u PD=1.115u rfmode=0
M$1040 \$904 \$854 \$843 VSS sg13_lv_nmos L=0.13u W=0.74u AS=0.13875p
+ AD=0.2664p PS=1.115u PD=1.46u rfmode=0
M$1041 \$843 \$794 \$903 VSS sg13_lv_nmos L=0.13u W=0.74u AS=0.2664p AD=0.0962p
+ PS=1.46u PD=1u rfmode=0
M$1042 \$903 \$798 VSS VSS sg13_lv_nmos L=0.13u W=0.74u AS=0.0962p AD=0.2516p
+ PS=1u PD=2.16u rfmode=0
M$1043 \$794 \$883 \$902 VSS sg13_lv_nmos L=0.13u W=0.74u AS=0.2516p AD=0.1406p
+ PS=2.16u PD=1.12u rfmode=0
M$1044 \$902 \$767 VSS VSS sg13_lv_nmos L=0.13u W=0.74u AS=0.1406p AD=0.2516p
+ PS=1.12u PD=2.16u rfmode=0
M$1045 VSS \$883 \$605 VSS sg13_lv_nmos L=0.13u W=0.77u AS=0.2618p AD=0.1694p
+ PS=2.22u PD=1.21u rfmode=0
M$1046 \$605 \$767 VSS VSS sg13_lv_nmos L=0.13u W=0.77u AS=0.1694p AD=0.1463p
+ PS=1.21u PD=1.15u rfmode=0
M$1047 VSS \$792 \$605 VSS sg13_lv_nmos L=0.13u W=0.77u AS=0.1463p AD=0.2618p
+ PS=1.15u PD=2.22u rfmode=0
M$1048 VSS \$675 \$901 VSS sg13_lv_nmos L=0.13u W=0.64u AS=0.2176p AD=0.0816p
+ PS=1.96u PD=0.895u rfmode=0
M$1049 \$901 \$883 \$858 VSS sg13_lv_nmos L=0.13u W=0.64u AS=0.0816p AD=0.1216p
+ PS=0.895u PD=1.02u rfmode=0
M$1050 \$858 \$857 VSS VSS sg13_lv_nmos L=0.13u W=0.64u AS=0.1216p AD=0.15745p
+ PS=1.02u PD=1.175u rfmode=0
M$1051 VSS \$858 \$859 VSS sg13_lv_nmos L=0.13u W=0.74u AS=0.15745p AD=0.2351p
+ PS=1.175u PD=2.16u rfmode=0
M$1052 \$860 \$342 VSS VSS sg13_lv_nmos L=0.13u W=0.74u AS=0.2516p AD=0.2516p
+ PS=2.16u PD=2.16u rfmode=0
M$1053 VSS \$860 \$899 VSS sg13_lv_nmos L=0.13u W=0.42u AS=0.1701p AD=0.0378p
+ PS=1.65u PD=0.6u rfmode=0
M$1054 \$899 \$863 \$884 VSS sg13_lv_nmos L=0.13u W=0.42u AS=0.0378p AD=0.1428p
+ PS=0.6u PD=1.52u rfmode=0
M$1055 \$861 \$865 \$862 VSS sg13_lv_nmos L=0.13u W=0.42u AS=0.1296p AD=0.0798p
+ PS=1.52u PD=0.8u rfmode=0
M$1056 \$862 \$864 \$884 VSS sg13_lv_nmos L=0.13u W=0.42u AS=0.0798p AD=0.2373p
+ PS=0.8u PD=1.97u rfmode=0
M$1057 \$864 \$865 VSS VSS sg13_lv_nmos L=0.13u W=0.74u AS=0.2516p AD=0.317325p
+ PS=2.16u PD=1.805u rfmode=0
M$1058 VSS \$741 \$865 VSS sg13_lv_nmos L=0.13u W=0.74u AS=0.317325p AD=0.2516p
+ PS=1.805u PD=2.16u rfmode=0
M$1059 \$885 \$865 \$866 VSS sg13_lv_nmos L=0.13u W=0.42u AS=0.1428p
+ AD=0.12665p PS=1.52u PD=1.145u rfmode=0
M$1060 \$866 \$864 \$863 VSS sg13_lv_nmos L=0.13u W=0.74u AS=0.12665p
+ AD=0.3473p PS=1.145u PD=2.71u rfmode=0
M$1061 \$868 \$866 VSS VSS sg13_lv_nmos L=0.13u W=0.74u AS=0.2516p AD=0.1406p
+ PS=2.16u PD=1.12u rfmode=0
M$1062 VSS \$868 \$883 VSS sg13_lv_nmos L=0.13u W=0.74u AS=0.1406p AD=0.2516p
+ PS=1.12u PD=2.16u rfmode=0
M$1063 VSS \$886 \$869 VSS sg13_lv_nmos L=0.13u W=0.74u AS=0.2516p AD=0.1406p
+ PS=2.16u PD=1.12u rfmode=0
M$1064 \$869 \$733 VSS VSS sg13_lv_nmos L=0.13u W=0.74u AS=0.1406p AD=0.2516p
+ PS=1.12u PD=2.16u rfmode=0
M$1065 VSS \$869 \$870 VSS sg13_lv_nmos L=0.13u W=0.74u AS=0.2516p AD=0.1406p
+ PS=2.16u PD=1.12u rfmode=0
M$1066 \$870 \$733 \$896 VSS sg13_lv_nmos L=0.13u W=0.74u AS=0.1406p AD=0.1406p
+ PS=1.12u PD=1.12u rfmode=0
M$1067 \$896 \$351 VSS VSS sg13_lv_nmos L=0.13u W=0.74u AS=0.1406p AD=0.2516p
+ PS=1.12u PD=2.16u rfmode=0
M$1072 \$804 \$807 \$822 VSS sg13_lv_nmos L=0.13u W=0.42u AS=0.1296p AD=0.0798p
+ PS=1.52u PD=0.8u rfmode=0
M$1073 \$822 \$823 \$806 VSS sg13_lv_nmos L=0.13u W=0.42u AS=0.0798p AD=0.2373p
+ PS=0.8u PD=1.97u rfmode=0
M$1080 VSS \$887 \$872 VSS sg13_lv_nmos L=0.13u W=0.74u AS=0.2516p AD=0.2516p
+ PS=2.16u PD=2.16u rfmode=0
M$1101 \$873 \$802 VSS VSS sg13_lv_nmos L=0.13u W=0.55u AS=0.187p AD=0.14875p
+ PS=1.78u PD=1.16u rfmode=0
M$1102 VSS \$873 \$37 VSS sg13_lv_nmos L=0.13u W=0.74u AS=0.14875p AD=0.2886p
+ PS=1.16u PD=2.26u rfmode=0
M$1117 VSS \$411 \$909 VSS sg13_lv_nmos L=0.13u W=0.74u AS=0.2516p AD=0.2516p
+ PS=2.16u PD=2.16u rfmode=0
M$1118 \$912 \$840 \$948 VSS sg13_lv_nmos L=0.13u W=0.42u AS=0.1428p AD=0.0609p
+ PS=1.52u PD=0.71u rfmode=0
M$1119 \$948 \$909 VSS VSS sg13_lv_nmos L=0.13u W=0.42u AS=0.0609p AD=0.1626p
+ PS=0.71u PD=1.415u rfmode=0
M$1120 VSS \$963 \$910 VSS sg13_lv_nmos L=0.13u W=0.74u AS=0.1626p AD=0.2516p
+ PS=1.415u PD=2.16u rfmode=0
M$1121 VSS \$909 \$949 VSS sg13_lv_nmos L=0.13u W=0.42u AS=0.1701p AD=0.0378p
+ PS=1.65u PD=0.6u rfmode=0
M$1122 \$949 \$910 \$911 VSS sg13_lv_nmos L=0.13u W=0.42u AS=0.0378p AD=0.1428p
+ PS=0.6u PD=1.52u rfmode=0
M$1123 \$915 \$913 \$914 VSS sg13_lv_nmos L=0.13u W=0.42u AS=0.12665p
+ AD=0.1428p PS=1.145u PD=1.52u rfmode=0
M$1124 \$910 \$964 \$915 VSS sg13_lv_nmos L=0.13u W=0.74u AS=0.3473p
+ AD=0.12665p PS=2.71u PD=1.145u rfmode=0
M$1125 \$914 \$917 VSS VSS sg13_lv_nmos L=0.13u W=0.42u AS=0.1428p AD=0.0798p
+ PS=1.52u PD=0.8u rfmode=0
M$1126 VSS \$909 \$950 VSS sg13_lv_nmos L=0.13u W=0.42u AS=0.0798p AD=0.0378p
+ PS=0.8u PD=0.6u rfmode=0
M$1127 \$950 \$915 \$917 VSS sg13_lv_nmos L=0.13u W=0.42u AS=0.0378p AD=0.1428p
+ PS=0.6u PD=1.52u rfmode=0
M$1128 \$918 \$915 VSS VSS sg13_lv_nmos L=0.13u W=0.74u AS=0.2516p AD=0.1406p
+ PS=2.16u PD=1.12u rfmode=0
M$1129 VSS \$918 \$919 VSS sg13_lv_nmos L=0.13u W=0.74u AS=0.1406p AD=0.2516p
+ PS=1.12u PD=2.16u rfmode=0
M$1133 VSS \$846 \$847 VSS sg13_lv_nmos L=0.13u W=0.74u AS=0.1626p AD=0.2516p
+ PS=1.415u PD=2.16u rfmode=0
M$1134 \$845 \$844 \$907 VSS sg13_lv_nmos L=0.13u W=0.42u AS=0.1428p AD=0.0609p
+ PS=1.52u PD=0.71u rfmode=0
M$1135 VSS \$848 \$907 VSS sg13_lv_nmos L=0.13u W=0.42u AS=0.1626p AD=0.0609p
+ PS=1.415u PD=0.71u rfmode=0
M$1136 VSS \$421 \$848 VSS sg13_lv_nmos L=0.13u W=0.74u AS=0.2516p AD=0.2516p
+ PS=2.16u PD=2.16u rfmode=0
M$1143 \$882 \$852 VSS VSS sg13_lv_nmos L=0.13u W=0.42u AS=0.1428p AD=0.0798p
+ PS=1.52u PD=0.8u rfmode=0
M$1144 VSS \$848 \$906 VSS sg13_lv_nmos L=0.13u W=0.42u AS=0.0798p AD=0.0378p
+ PS=0.8u PD=0.6u rfmode=0
M$1145 \$906 \$851 \$852 VSS sg13_lv_nmos L=0.13u W=0.42u AS=0.0378p AD=0.1428p
+ PS=0.6u PD=1.52u rfmode=0
M$1146 VSS \$795 \$350 VSS sg13_lv_nmos L=0.13u W=0.77u AS=0.2618p AD=0.1694p
+ PS=2.22u PD=1.21u rfmode=0
M$1147 \$350 \$796 VSS VSS sg13_lv_nmos L=0.13u W=0.77u AS=0.1694p AD=0.1463p
+ PS=1.21u PD=1.15u rfmode=0
M$1148 VSS \$922 \$350 VSS sg13_lv_nmos L=0.13u W=0.77u AS=0.1463p AD=0.2618p
+ PS=1.15u PD=2.22u rfmode=0
M$1149 VSS \$854 \$921 VSS sg13_lv_nmos L=0.13u W=0.77u AS=0.2618p AD=0.1694p
+ PS=2.22u PD=1.21u rfmode=0
M$1150 \$921 \$609 VSS VSS sg13_lv_nmos L=0.13u W=0.77u AS=0.1694p AD=0.1463p
+ PS=1.21u PD=1.15u rfmode=0
M$1151 VSS \$922 \$921 VSS sg13_lv_nmos L=0.13u W=0.77u AS=0.1463p AD=0.2618p
+ PS=1.15u PD=2.22u rfmode=0
M$1152 \$922 \$923 \$953 VSS sg13_lv_nmos L=0.13u W=0.74u AS=0.333p AD=0.1406p
+ PS=2.38u PD=1.12u rfmode=0
M$1153 \$953 \$883 VSS VSS sg13_lv_nmos L=0.13u W=0.74u AS=0.1406p AD=0.14505p
+ PS=1.12u PD=1.15u rfmode=0
M$1154 VSS \$767 \$923 VSS sg13_lv_nmos L=0.13u W=0.55u AS=0.14505p AD=0.187p
+ PS=1.15u PD=1.78u rfmode=0
M$1155 VSS \$883 \$925 VSS sg13_lv_nmos L=0.13u W=0.55u AS=0.14505p AD=0.187p
+ PS=1.15u PD=1.78u rfmode=0
M$1156 VSS \$767 \$957 VSS sg13_lv_nmos L=0.13u W=0.74u AS=0.14505p AD=0.1406p
+ PS=1.15u PD=1.12u rfmode=0
M$1157 \$957 \$925 \$924 VSS sg13_lv_nmos L=0.13u W=0.74u AS=0.1406p AD=0.333p
+ PS=1.12u PD=2.38u rfmode=0
M$1158 VSS \$924 \$926 VSS sg13_lv_nmos L=0.13u W=0.74u AS=0.2516p AD=0.1406p
+ PS=2.16u PD=1.12u rfmode=0
M$1159 \$926 \$792 VSS VSS sg13_lv_nmos L=0.13u W=0.74u AS=0.1406p AD=0.2516p
+ PS=1.12u PD=2.16u rfmode=0
M$1162 VSS \$862 \$863 VSS sg13_lv_nmos L=0.13u W=0.74u AS=0.1626p AD=0.2516p
+ PS=1.415u PD=2.16u rfmode=0
M$1163 \$861 \$859 \$900 VSS sg13_lv_nmos L=0.13u W=0.42u AS=0.1428p AD=0.0609p
+ PS=1.52u PD=0.71u rfmode=0
M$1164 VSS \$860 \$900 VSS sg13_lv_nmos L=0.13u W=0.42u AS=0.1626p AD=0.0609p
+ PS=1.415u PD=0.71u rfmode=0
M$1169 \$885 \$867 VSS VSS sg13_lv_nmos L=0.13u W=0.42u AS=0.1428p AD=0.0798p
+ PS=1.52u PD=0.8u rfmode=0
M$1170 VSS \$860 \$897 VSS sg13_lv_nmos L=0.13u W=0.42u AS=0.0798p AD=0.0378p
+ PS=0.8u PD=0.6u rfmode=0
M$1171 \$897 \$866 \$867 VSS sg13_lv_nmos L=0.13u W=0.42u AS=0.0378p AD=0.1428p
+ PS=0.6u PD=1.52u rfmode=0
M$1174 VSS \$342 \$927 VSS sg13_lv_nmos L=0.13u W=0.74u AS=0.2516p AD=0.2516p
+ PS=2.16u PD=2.16u rfmode=0
M$1175 \$930 \$870 \$960 VSS sg13_lv_nmos L=0.13u W=0.42u AS=0.1428p AD=0.0609p
+ PS=1.52u PD=0.71u rfmode=0
M$1176 \$960 \$927 VSS VSS sg13_lv_nmos L=0.13u W=0.42u AS=0.0609p AD=0.1626p
+ PS=0.71u PD=1.415u rfmode=0
M$1177 VSS \$967 \$928 VSS sg13_lv_nmos L=0.13u W=0.74u AS=0.1626p AD=0.2516p
+ PS=1.415u PD=2.16u rfmode=0
M$1178 VSS \$927 \$962 VSS sg13_lv_nmos L=0.13u W=0.42u AS=0.1701p AD=0.0378p
+ PS=1.65u PD=0.6u rfmode=0
M$1179 \$962 \$928 \$929 VSS sg13_lv_nmos L=0.13u W=0.42u AS=0.0378p AD=0.1428p
+ PS=0.6u PD=1.52u rfmode=0
M$1180 \$933 \$931 \$932 VSS sg13_lv_nmos L=0.13u W=0.42u AS=0.12665p
+ AD=0.1428p PS=1.145u PD=1.52u rfmode=0
M$1181 \$928 \$968 \$933 VSS sg13_lv_nmos L=0.13u W=0.74u AS=0.3473p
+ AD=0.12665p PS=2.71u PD=1.145u rfmode=0
M$1182 \$932 \$934 VSS VSS sg13_lv_nmos L=0.13u W=0.42u AS=0.1428p AD=0.0798p
+ PS=1.52u PD=0.8u rfmode=0
M$1183 VSS \$927 \$961 VSS sg13_lv_nmos L=0.13u W=0.42u AS=0.0798p AD=0.0378p
+ PS=0.8u PD=0.6u rfmode=0
M$1184 \$961 \$933 \$934 VSS sg13_lv_nmos L=0.13u W=0.42u AS=0.0378p AD=0.1428p
+ PS=0.6u PD=1.52u rfmode=0
M$1185 \$935 \$933 VSS VSS sg13_lv_nmos L=0.13u W=0.74u AS=0.2516p AD=0.1406p
+ PS=2.16u PD=1.12u rfmode=0
M$1186 VSS \$935 \$886 VSS sg13_lv_nmos L=0.13u W=0.74u AS=0.1406p AD=0.2516p
+ PS=1.12u PD=2.16u rfmode=0
M$1187 VSS \$921 \$936 VSS sg13_lv_nmos L=0.13u W=0.55u AS=0.18945p AD=0.187p
+ PS=1.27u PD=1.78u rfmode=0
M$1188 VSS \$921 \$959 VSS sg13_lv_nmos L=0.13u W=0.74u AS=0.18945p AD=0.13135p
+ PS=1.27u PD=1.095u rfmode=0
M$1189 \$959 \$687 \$937 VSS sg13_lv_nmos L=0.13u W=0.74u AS=0.13135p
+ AD=0.1628p PS=1.095u PD=1.18u rfmode=0
M$1190 \$937 \$938 \$958 VSS sg13_lv_nmos L=0.13u W=0.74u AS=0.1628p AD=0.3367p
+ PS=1.18u PD=1.65u rfmode=0
M$1191 \$958 \$936 VSS VSS sg13_lv_nmos L=0.13u W=0.74u AS=0.3367p AD=0.148p
+ PS=1.65u PD=1.14u rfmode=0
M$1192 VSS \$937 \$939 VSS sg13_lv_nmos L=0.13u W=0.74u AS=0.148p AD=0.4033p
+ PS=1.14u PD=2.57u rfmode=0
M$1193 \$942 \$939 \$956 VSS sg13_lv_nmos L=0.13u W=0.42u AS=0.1428p AD=0.0609p
+ PS=1.52u PD=0.71u rfmode=0
M$1194 \$956 \$872 VSS VSS sg13_lv_nmos L=0.13u W=0.42u AS=0.0609p AD=0.1626p
+ PS=0.71u PD=1.415u rfmode=0
M$1195 VSS \$969 \$940 VSS sg13_lv_nmos L=0.13u W=0.74u AS=0.1626p AD=0.2516p
+ PS=1.415u PD=2.16u rfmode=0
M$1196 VSS \$872 \$954 VSS sg13_lv_nmos L=0.13u W=0.42u AS=0.1701p AD=0.0378p
+ PS=1.65u PD=0.6u rfmode=0
M$1197 \$954 \$940 \$941 VSS sg13_lv_nmos L=0.13u W=0.42u AS=0.0378p AD=0.1428p
+ PS=0.6u PD=1.52u rfmode=0
M$1198 \$945 \$943 \$944 VSS sg13_lv_nmos L=0.13u W=0.42u AS=0.12665p
+ AD=0.1428p PS=1.145u PD=1.52u rfmode=0
M$1199 \$940 \$970 \$945 VSS sg13_lv_nmos L=0.13u W=0.74u AS=0.3473p
+ AD=0.12665p PS=2.71u PD=1.145u rfmode=0
M$1200 \$944 \$946 VSS VSS sg13_lv_nmos L=0.13u W=0.42u AS=0.1428p AD=0.0798p
+ PS=1.52u PD=0.8u rfmode=0
M$1201 VSS \$872 \$952 VSS sg13_lv_nmos L=0.13u W=0.42u AS=0.0798p AD=0.0378p
+ PS=0.8u PD=0.6u rfmode=0
M$1202 \$952 \$945 \$946 VSS sg13_lv_nmos L=0.13u W=0.42u AS=0.0378p AD=0.1428p
+ PS=0.6u PD=1.52u rfmode=0
M$1203 \$947 \$945 VSS VSS sg13_lv_nmos L=0.13u W=0.74u AS=0.2516p AD=0.1406p
+ PS=2.16u PD=1.12u rfmode=0
M$1204 VSS \$947 \$938 VSS sg13_lv_nmos L=0.13u W=0.74u AS=0.1406p AD=0.2516p
+ PS=1.12u PD=2.16u rfmode=0
M$1220 VSS \$993 \$994 VSS sg13_lv_nmos L=0.13u W=0.55u AS=0.14875p AD=0.187p
+ PS=1.16u PD=1.78u rfmode=0
M$1221 \$31 \$994 VSS VSS sg13_lv_nmos L=0.13u W=0.74u AS=0.2886p AD=0.14875p
+ PS=2.26u PD=1.16u rfmode=0
M$1236 VSS \$350 \$839 VSS sg13_lv_nmos L=0.13u W=0.74u AS=0.2516p AD=0.1406p
+ PS=2.16u PD=1.12u rfmode=0
M$1237 \$839 \$919 VSS VSS sg13_lv_nmos L=0.13u W=0.74u AS=0.1406p AD=0.2516p
+ PS=1.12u PD=2.16u rfmode=0
M$1238 \$912 \$913 \$963 VSS sg13_lv_nmos L=0.13u W=0.42u AS=0.1296p AD=0.0798p
+ PS=1.52u PD=0.8u rfmode=0
M$1239 \$963 \$964 \$911 VSS sg13_lv_nmos L=0.13u W=0.42u AS=0.0798p AD=0.2373p
+ PS=0.8u PD=1.97u rfmode=0
M$1242 VSS \$913 \$964 VSS sg13_lv_nmos L=0.13u W=0.74u AS=0.317325p AD=0.2516p
+ PS=1.805u PD=2.16u rfmode=0
M$1243 VSS \$498 \$913 VSS sg13_lv_nmos L=0.13u W=0.74u AS=0.317325p AD=0.2516p
+ PS=1.805u PD=2.16u rfmode=0
M$1244 \$995 \$421 VSS VSS sg13_lv_nmos L=0.13u W=0.74u AS=0.2516p AD=0.2516p
+ PS=2.16u PD=2.16u rfmode=0
M$1245 \$996 \$1000 \$997 VSS sg13_lv_nmos L=0.13u W=0.42u AS=0.1296p
+ AD=0.0798p PS=1.52u PD=0.8u rfmode=0
M$1246 \$997 \$999 \$1033 VSS sg13_lv_nmos L=0.13u W=0.42u AS=0.0798p
+ AD=0.2373p PS=0.8u PD=1.97u rfmode=0
M$1247 \$999 \$1000 VSS VSS sg13_lv_nmos L=0.13u W=0.74u AS=0.2516p
+ AD=0.317325p PS=2.16u PD=1.805u rfmode=0
M$1248 VSS \$498 \$1000 VSS sg13_lv_nmos L=0.13u W=0.74u AS=0.317325p
+ AD=0.2516p PS=1.805u PD=2.16u rfmode=0
M$1249 \$1034 \$1000 \$1001 VSS sg13_lv_nmos L=0.13u W=0.42u AS=0.1428p
+ AD=0.12665p PS=1.52u PD=1.145u rfmode=0
M$1250 \$1001 \$999 \$998 VSS sg13_lv_nmos L=0.13u W=0.74u AS=0.12665p
+ AD=0.3473p PS=1.145u PD=2.71u rfmode=0
M$1251 VSS \$920 \$916 VSS sg13_lv_nmos L=0.13u W=0.74u AS=0.2516p AD=0.1406p
+ PS=2.16u PD=1.12u rfmode=0
M$1252 \$916 \$621 \$951 VSS sg13_lv_nmos L=0.13u W=0.74u AS=0.1406p AD=0.1406p
+ PS=1.12u PD=1.12u rfmode=0
M$1253 \$951 \$921 VSS VSS sg13_lv_nmos L=0.13u W=0.74u AS=0.1406p AD=0.2516p
+ PS=1.12u PD=2.16u rfmode=0
M$1254 \$1003 \$1001 VSS VSS sg13_lv_nmos L=0.13u W=0.74u AS=0.2516p AD=0.1406p
+ PS=2.16u PD=1.12u rfmode=0
M$1255 VSS \$1003 \$993 VSS sg13_lv_nmos L=0.13u W=0.74u AS=0.1406p AD=0.2516p
+ PS=1.12u PD=2.16u rfmode=0
M$1256 VSS \$993 \$920 VSS sg13_lv_nmos L=0.13u W=0.74u AS=0.2516p AD=0.1406p
+ PS=2.16u PD=1.12u rfmode=0
M$1257 \$920 \$921 VSS VSS sg13_lv_nmos L=0.13u W=0.74u AS=0.1406p AD=0.2516p
+ PS=1.12u PD=2.16u rfmode=0
M$1266 \$795 \$854 VSS VSS sg13_lv_nmos L=0.13u W=0.74u AS=0.2516p AD=0.2516p
+ PS=2.16u PD=2.16u rfmode=0
M$1267 VSS \$854 \$1004 VSS sg13_lv_nmos L=0.13u W=0.77u AS=0.2618p AD=0.1694p
+ PS=2.22u PD=1.21u rfmode=0
M$1268 \$1004 \$883 VSS VSS sg13_lv_nmos L=0.13u W=0.77u AS=0.1694p AD=0.1463p
+ PS=1.21u PD=1.15u rfmode=0
M$1269 VSS \$796 \$1004 VSS sg13_lv_nmos L=0.13u W=0.77u AS=0.1463p AD=0.2618p
+ PS=1.15u PD=2.22u rfmode=0
M$1270 VSS \$922 \$955 VSS sg13_lv_nmos L=0.13u W=0.74u AS=0.2516p AD=0.1406p
+ PS=2.16u PD=1.12u rfmode=0
M$1271 \$955 \$924 \$857 VSS sg13_lv_nmos L=0.13u W=0.74u AS=0.1406p AD=0.1406p
+ PS=1.12u PD=1.12u rfmode=0
M$1272 \$857 \$796 VSS VSS sg13_lv_nmos L=0.13u W=0.74u AS=0.1406p AD=0.2516p
+ PS=1.12u PD=2.16u rfmode=0
M$1273 VSS \$854 \$1005 VSS sg13_lv_nmos L=0.13u W=0.77u AS=0.2618p AD=0.1694p
+ PS=2.22u PD=1.21u rfmode=0
M$1274 \$1005 \$796 VSS VSS sg13_lv_nmos L=0.13u W=0.77u AS=0.1694p AD=0.1463p
+ PS=1.21u PD=1.15u rfmode=0
M$1275 VSS \$924 \$1005 VSS sg13_lv_nmos L=0.13u W=0.77u AS=0.1463p AD=0.2618p
+ PS=1.15u PD=2.22u rfmode=0
M$1276 VSS \$924 \$1006 VSS sg13_lv_nmos L=0.13u W=0.74u AS=0.2516p AD=0.1406p
+ PS=2.16u PD=1.12u rfmode=0
M$1277 \$1006 \$621 VSS VSS sg13_lv_nmos L=0.13u W=0.74u AS=0.1406p AD=0.2516p
+ PS=1.12u PD=2.16u rfmode=0
M$1282 VSS \$883 \$1007 VSS sg13_lv_nmos L=0.13u W=0.77u AS=0.2618p AD=0.1694p
+ PS=2.22u PD=1.21u rfmode=0
M$1283 \$1007 \$767 VSS VSS sg13_lv_nmos L=0.13u W=0.77u AS=0.1694p AD=0.1463p
+ PS=1.21u PD=1.15u rfmode=0
M$1284 VSS \$687 \$1007 VSS sg13_lv_nmos L=0.13u W=0.77u AS=0.1463p AD=0.2618p
+ PS=1.15u PD=2.22u rfmode=0
M$1285 \$1035 \$1004 VSS VSS sg13_lv_nmos L=0.15u W=0.74u AS=0.2516p AD=0.1406p
+ PS=2.16u PD=1.12u rfmode=0
M$1286 VSS \$350 \$1035 VSS sg13_lv_nmos L=0.15u W=0.74u AS=0.1406p AD=0.1406p
+ PS=1.12u PD=1.12u rfmode=0
M$1287 \$1035 \$1007 \$1008 VSS sg13_lv_nmos L=0.15u W=0.74u AS=0.1406p
+ AD=0.2516p PS=1.12u PD=2.16u rfmode=0
M$1292 \$930 \$931 \$967 VSS sg13_lv_nmos L=0.13u W=0.42u AS=0.1296p AD=0.0798p
+ PS=1.52u PD=0.8u rfmode=0
M$1293 \$967 \$968 \$929 VSS sg13_lv_nmos L=0.13u W=0.42u AS=0.0798p AD=0.2373p
+ PS=0.8u PD=1.97u rfmode=0
M$1294 VSS \$921 \$1010 VSS sg13_lv_nmos L=0.13u W=0.55u AS=0.18945p AD=0.187p
+ PS=1.27u PD=1.78u rfmode=0
M$1295 \$1009 \$1036 VSS VSS sg13_lv_nmos L=0.13u W=0.74u AS=0.4033p AD=0.148p
+ PS=2.57u PD=1.14u rfmode=0
M$1296 VSS \$1010 \$1050 VSS sg13_lv_nmos L=0.13u W=0.74u AS=0.148p AD=0.3367p
+ PS=1.14u PD=1.65u rfmode=0
M$1297 \$1050 \$1011 \$1036 VSS sg13_lv_nmos L=0.13u W=0.74u AS=0.3367p
+ AD=0.1628p PS=1.65u PD=1.18u rfmode=0
M$1298 \$1036 \$687 \$1051 VSS sg13_lv_nmos L=0.13u W=0.74u AS=0.1628p
+ AD=0.13135p PS=1.18u PD=1.095u rfmode=0
M$1299 \$1051 \$921 VSS VSS sg13_lv_nmos L=0.13u W=0.74u AS=0.13135p
+ AD=0.18945p PS=1.095u PD=1.27u rfmode=0
M$1300 VSS \$931 \$968 VSS sg13_lv_nmos L=0.13u W=0.74u AS=0.317325p AD=0.2516p
+ PS=1.805u PD=2.16u rfmode=0
M$1301 VSS \$508 \$931 VSS sg13_lv_nmos L=0.13u W=0.74u AS=0.317325p AD=0.2516p
+ PS=1.805u PD=2.16u rfmode=0
M$1304 \$1012 \$1005 VSS VSS sg13_lv_nmos L=0.13u W=0.55u AS=0.187p AD=0.18945p
+ PS=1.78u PD=1.27u rfmode=0
M$1305 VSS \$1005 \$1049 VSS sg13_lv_nmos L=0.13u W=0.74u AS=0.18945p
+ AD=0.13135p PS=1.27u PD=1.095u rfmode=0
M$1306 \$1049 \$687 \$1013 VSS sg13_lv_nmos L=0.13u W=0.74u AS=0.13135p
+ AD=0.1628p PS=1.095u PD=1.18u rfmode=0
M$1307 \$1013 \$1037 \$1048 VSS sg13_lv_nmos L=0.13u W=0.74u AS=0.1628p
+ AD=0.3367p PS=1.18u PD=1.65u rfmode=0
M$1308 \$1048 \$1012 VSS VSS sg13_lv_nmos L=0.13u W=0.74u AS=0.3367p AD=0.148p
+ PS=1.65u PD=1.14u rfmode=0
M$1309 VSS \$1013 \$1014 VSS sg13_lv_nmos L=0.13u W=0.74u AS=0.148p AD=0.4033p
+ PS=1.14u PD=2.57u rfmode=0
M$1310 \$1015 \$669 VSS VSS sg13_lv_nmos L=0.13u W=0.55u AS=0.187p AD=0.14875p
+ PS=1.78u PD=1.16u rfmode=0
M$1311 VSS \$1015 \$887 VSS sg13_lv_nmos L=0.13u W=0.74u AS=0.14875p AD=0.2886p
+ PS=1.16u PD=2.26u rfmode=0
M$1312 \$942 \$943 \$969 VSS sg13_lv_nmos L=0.13u W=0.42u AS=0.1296p AD=0.0798p
+ PS=1.52u PD=0.8u rfmode=0
M$1313 \$969 \$970 \$941 VSS sg13_lv_nmos L=0.13u W=0.42u AS=0.0798p AD=0.2373p
+ PS=0.8u PD=1.97u rfmode=0
M$1316 VSS \$943 \$970 VSS sg13_lv_nmos L=0.13u W=0.74u AS=0.317325p AD=0.2516p
+ PS=1.805u PD=2.16u rfmode=0
M$1317 VSS \$508 \$943 VSS sg13_lv_nmos L=0.13u W=0.74u AS=0.317325p AD=0.2516p
+ PS=1.805u PD=2.16u rfmode=0
M$1336 \$1016 \$938 VSS VSS sg13_lv_nmos L=0.13u W=0.55u AS=0.187p AD=0.14875p
+ PS=1.78u PD=1.16u rfmode=0
M$1337 VSS \$1016 \$38 VSS sg13_lv_nmos L=0.13u W=0.74u AS=0.14875p AD=0.2886p
+ PS=1.16u PD=2.26u rfmode=0
M$1358 VSS \$997 \$998 VSS sg13_lv_nmos L=0.13u W=0.74u AS=0.1626p AD=0.2516p
+ PS=1.415u PD=2.16u rfmode=0
M$1359 \$996 \$916 \$1052 VSS sg13_lv_nmos L=0.13u W=0.42u AS=0.1428p
+ AD=0.0609p PS=1.52u PD=0.71u rfmode=0
M$1360 VSS \$995 \$1052 VSS sg13_lv_nmos L=0.13u W=0.42u AS=0.1626p AD=0.0609p
+ PS=1.415u PD=0.71u rfmode=0
M$1361 \$1055 \$1056 \$1110 VSS sg13_lv_nmos L=0.13u W=0.42u AS=0.1428p
+ AD=0.0609p PS=1.52u PD=0.71u rfmode=0
M$1362 \$1110 \$1058 VSS VSS sg13_lv_nmos L=0.13u W=0.42u AS=0.0609p AD=0.1626p
+ PS=0.71u PD=1.415u rfmode=0
M$1363 VSS \$1123 \$1057 VSS sg13_lv_nmos L=0.13u W=0.74u AS=0.1626p AD=0.2516p
+ PS=1.415u PD=2.16u rfmode=0
M$1364 VSS \$995 \$1053 VSS sg13_lv_nmos L=0.13u W=0.42u AS=0.1701p AD=0.0378p
+ PS=1.65u PD=0.6u rfmode=0
M$1365 \$1053 \$998 \$1033 VSS sg13_lv_nmos L=0.13u W=0.42u AS=0.0378p
+ AD=0.1428p PS=0.6u PD=1.52u rfmode=0
M$1366 VSS \$1058 \$1111 VSS sg13_lv_nmos L=0.13u W=0.42u AS=0.1701p AD=0.0378p
+ PS=1.65u PD=0.6u rfmode=0
M$1367 \$1111 \$1057 \$1059 VSS sg13_lv_nmos L=0.13u W=0.42u AS=0.0378p
+ AD=0.1428p PS=0.6u PD=1.52u rfmode=0
M$1368 \$1062 \$1060 \$1061 VSS sg13_lv_nmos L=0.13u W=0.42u AS=0.12665p
+ AD=0.1428p PS=1.145u PD=1.52u rfmode=0
M$1369 \$1057 \$1124 \$1062 VSS sg13_lv_nmos L=0.13u W=0.74u AS=0.3473p
+ AD=0.12665p PS=2.71u PD=1.145u rfmode=0
M$1370 \$1034 \$1002 VSS VSS sg13_lv_nmos L=0.13u W=0.42u AS=0.1428p AD=0.0798p
+ PS=1.52u PD=0.8u rfmode=0
M$1371 VSS \$995 \$1054 VSS sg13_lv_nmos L=0.13u W=0.42u AS=0.0798p AD=0.0378p
+ PS=0.8u PD=0.6u rfmode=0
M$1372 \$1054 \$1001 \$1002 VSS sg13_lv_nmos L=0.13u W=0.42u AS=0.0378p
+ AD=0.1428p PS=0.6u PD=1.52u rfmode=0
M$1373 \$1061 \$1063 VSS VSS sg13_lv_nmos L=0.13u W=0.42u AS=0.1428p AD=0.0798p
+ PS=1.52u PD=0.8u rfmode=0
M$1374 VSS \$1058 \$1112 VSS sg13_lv_nmos L=0.13u W=0.42u AS=0.0798p AD=0.0378p
+ PS=0.8u PD=0.6u rfmode=0
M$1375 \$1112 \$1062 \$1063 VSS sg13_lv_nmos L=0.13u W=0.42u AS=0.0378p
+ AD=0.1428p PS=0.6u PD=1.52u rfmode=0
M$1376 \$1064 \$1062 VSS VSS sg13_lv_nmos L=0.13u W=0.74u AS=0.2516p AD=0.1406p
+ PS=2.16u PD=1.12u rfmode=0
M$1377 VSS \$1064 \$1065 VSS sg13_lv_nmos L=0.13u W=0.74u AS=0.1406p AD=0.2516p
+ PS=1.12u PD=2.16u rfmode=0
M$1378 VSS \$411 \$1233 VSS sg13_lv_nmos L=0.13u W=0.74u AS=0.2516p AD=0.2516p
+ PS=2.16u PD=2.16u rfmode=0
M$1383 \$1066 \$1067 VSS VSS sg13_lv_nmos L=0.13u W=0.74u AS=0.4033p AD=0.148p
+ PS=2.57u PD=1.14u rfmode=0
M$1384 VSS \$1125 \$1115 VSS sg13_lv_nmos L=0.13u W=0.74u AS=0.148p AD=0.3367p
+ PS=1.14u PD=1.65u rfmode=0
M$1385 \$1115 \$1068 \$1067 VSS sg13_lv_nmos L=0.13u W=0.74u AS=0.3367p
+ AD=0.1628p PS=1.65u PD=1.18u rfmode=0
M$1386 \$1067 \$621 \$1116 VSS sg13_lv_nmos L=0.13u W=0.74u AS=0.1628p
+ AD=0.13135p PS=1.18u PD=1.095u rfmode=0
M$1387 \$1116 \$605 VSS VSS sg13_lv_nmos L=0.13u W=0.74u AS=0.13135p
+ AD=0.18945p PS=1.095u PD=1.27u rfmode=0
M$1388 VSS \$605 \$1125 VSS sg13_lv_nmos L=0.13u W=0.55u AS=0.18945p AD=0.187p
+ PS=1.27u PD=1.78u rfmode=0
M$1393 VSS \$1069 \$1070 VSS sg13_lv_nmos L=0.13u W=0.74u AS=0.2516p AD=0.2516p
+ PS=2.16u PD=2.16u rfmode=0
M$1394 \$1071 \$1070 VSS VSS sg13_lv_nmos L=0.15u W=0.74u AS=0.2516p AD=0.1406p
+ PS=2.16u PD=1.12u rfmode=0
M$1395 VSS \$1005 \$1071 VSS sg13_lv_nmos L=0.15u W=0.74u AS=0.1406p AD=0.1406p
+ PS=1.12u PD=1.12u rfmode=0
M$1396 \$1071 \$1072 \$1073 VSS sg13_lv_nmos L=0.15u W=0.74u AS=0.1406p
+ AD=0.2516p PS=1.12u PD=2.16u rfmode=0
M$1397 \$1072 \$1006 \$1074 VSS sg13_lv_nmos L=0.15u W=0.74u AS=0.2516p
+ AD=0.1406p PS=2.16u PD=1.12u rfmode=0
M$1398 \$1074 \$350 VSS VSS sg13_lv_nmos L=0.15u W=0.74u AS=0.1406p AD=0.1406p
+ PS=1.12u PD=1.12u rfmode=0
M$1399 VSS \$1004 \$1074 VSS sg13_lv_nmos L=0.15u W=0.74u AS=0.1406p AD=0.2516p
+ PS=1.12u PD=2.16u rfmode=0
M$1403 VSS \$1004 \$1075 VSS sg13_lv_nmos L=0.13u W=0.55u AS=0.17255p AD=0.187p
+ PS=1.25u PD=1.78u rfmode=0
M$1404 VSS \$1075 \$1126 VSS sg13_lv_nmos L=0.13u W=0.74u AS=0.17255p
+ AD=0.1406p PS=1.25u PD=1.12u rfmode=0
M$1405 \$1126 \$767 VSS VSS sg13_lv_nmos L=0.13u W=0.74u AS=0.1406p AD=0.2516p
+ PS=1.12u PD=2.16u rfmode=0
M$1406 \$1076 \$1127 VSS VSS sg13_lv_nmos L=0.15u W=0.74u AS=0.2516p AD=0.1406p
+ PS=2.16u PD=1.12u rfmode=0
M$1407 VSS \$1126 \$1076 VSS sg13_lv_nmos L=0.15u W=0.74u AS=0.1406p AD=0.1406p
+ PS=1.12u PD=1.12u rfmode=0
M$1408 \$1076 \$1008 \$1077 VSS sg13_lv_nmos L=0.15u W=0.74u AS=0.1406p
+ AD=0.2516p PS=1.12u PD=2.16u rfmode=0
M$1409 \$1078 \$342 VSS VSS sg13_lv_nmos L=0.13u W=0.74u AS=0.2516p AD=0.2516p
+ PS=2.16u PD=2.16u rfmode=0
M$1412 VSS \$342 \$1079 VSS sg13_lv_nmos L=0.13u W=0.74u AS=0.2516p AD=0.2516p
+ PS=2.16u PD=2.16u rfmode=0
M$1414 \$1080 \$1009 \$1119 VSS sg13_lv_nmos L=0.13u W=0.42u AS=0.1428p
+ AD=0.0609p PS=1.52u PD=0.71u rfmode=0
M$1415 \$1119 \$1079 VSS VSS sg13_lv_nmos L=0.13u W=0.42u AS=0.0609p AD=0.1626p
+ PS=0.71u PD=1.415u rfmode=0
M$1416 VSS \$1128 \$1081 VSS sg13_lv_nmos L=0.13u W=0.74u AS=0.1626p AD=0.2516p
+ PS=1.415u PD=2.16u rfmode=0
M$1417 VSS \$1079 \$1120 VSS sg13_lv_nmos L=0.13u W=0.42u AS=0.1701p AD=0.0378p
+ PS=1.65u PD=0.6u rfmode=0
M$1418 \$1120 \$1081 \$1082 VSS sg13_lv_nmos L=0.13u W=0.42u AS=0.0378p
+ AD=0.1428p PS=0.6u PD=1.52u rfmode=0
M$1419 \$1085 \$1083 \$1084 VSS sg13_lv_nmos L=0.13u W=0.42u AS=0.12665p
+ AD=0.1428p PS=1.145u PD=1.52u rfmode=0
M$1420 \$1081 \$1129 \$1085 VSS sg13_lv_nmos L=0.13u W=0.74u AS=0.3473p
+ AD=0.12665p PS=2.71u PD=1.145u rfmode=0
M$1421 \$1084 \$1086 VSS VSS sg13_lv_nmos L=0.13u W=0.42u AS=0.1428p AD=0.0798p
+ PS=1.52u PD=0.8u rfmode=0
M$1422 VSS \$1079 \$1122 VSS sg13_lv_nmos L=0.13u W=0.42u AS=0.0798p AD=0.0378p
+ PS=0.8u PD=0.6u rfmode=0
M$1423 \$1122 \$1085 \$1086 VSS sg13_lv_nmos L=0.13u W=0.42u AS=0.0378p
+ AD=0.1428p PS=0.6u PD=1.52u rfmode=0
M$1425 \$1087 \$1085 VSS VSS sg13_lv_nmos L=0.13u W=0.74u AS=0.2516p AD=0.1406p
+ PS=2.16u PD=1.12u rfmode=0
M$1426 VSS \$1087 \$1011 VSS sg13_lv_nmos L=0.13u W=0.74u AS=0.1406p AD=0.2516p
+ PS=1.12u PD=2.16u rfmode=0
M$1427 \$1088 \$887 VSS VSS sg13_lv_nmos L=0.13u W=0.74u AS=0.2516p AD=0.2516p
+ PS=2.16u PD=2.16u rfmode=0
M$1428 VSS \$887 \$1089 VSS sg13_lv_nmos L=0.13u W=0.74u AS=0.2516p AD=0.2516p
+ PS=2.16u PD=2.16u rfmode=0
M$1429 \$1090 \$1014 \$1121 VSS sg13_lv_nmos L=0.13u W=0.42u AS=0.1428p
+ AD=0.0609p PS=1.52u PD=0.71u rfmode=0
M$1430 \$1121 \$1089 VSS VSS sg13_lv_nmos L=0.13u W=0.42u AS=0.0609p AD=0.1626p
+ PS=0.71u PD=1.415u rfmode=0
M$1431 VSS \$1130 \$1091 VSS sg13_lv_nmos L=0.13u W=0.74u AS=0.1626p AD=0.2516p
+ PS=1.415u PD=2.16u rfmode=0
M$1432 VSS \$1089 \$1118 VSS sg13_lv_nmos L=0.13u W=0.42u AS=0.1701p AD=0.0378p
+ PS=1.65u PD=0.6u rfmode=0
M$1433 \$1118 \$1091 \$1092 VSS sg13_lv_nmos L=0.13u W=0.42u AS=0.0378p
+ AD=0.1428p PS=0.6u PD=1.52u rfmode=0
M$1434 \$1096 \$1093 \$1095 VSS sg13_lv_nmos L=0.13u W=0.42u AS=0.12665p
+ AD=0.1428p PS=1.145u PD=1.52u rfmode=0
M$1435 \$1091 \$1131 \$1096 VSS sg13_lv_nmos L=0.13u W=0.74u AS=0.3473p
+ AD=0.12665p PS=2.71u PD=1.145u rfmode=0
M$1436 \$1095 \$1097 VSS VSS sg13_lv_nmos L=0.13u W=0.42u AS=0.1428p AD=0.0798p
+ PS=1.52u PD=0.8u rfmode=0
M$1437 VSS \$1089 \$1117 VSS sg13_lv_nmos L=0.13u W=0.42u AS=0.0798p AD=0.0378p
+ PS=0.8u PD=0.6u rfmode=0
M$1438 \$1117 \$1096 \$1097 VSS sg13_lv_nmos L=0.13u W=0.42u AS=0.0378p
+ AD=0.1428p PS=0.6u PD=1.52u rfmode=0
M$1439 \$1098 \$1096 VSS VSS sg13_lv_nmos L=0.13u W=0.74u AS=0.2516p AD=0.1406p
+ PS=2.16u PD=1.12u rfmode=0
M$1440 VSS \$1098 \$1037 VSS sg13_lv_nmos L=0.13u W=0.74u AS=0.1406p AD=0.2516p
+ PS=1.12u PD=2.16u rfmode=0
M$1442 VSS \$887 \$1099 VSS sg13_lv_nmos L=0.13u W=0.74u AS=0.2516p AD=0.2516p
+ PS=2.16u PD=2.16u rfmode=0
M$1443 \$1100 \$1301 \$1114 VSS sg13_lv_nmos L=0.13u W=0.42u AS=0.1428p
+ AD=0.0609p PS=1.52u PD=0.71u rfmode=0
M$1444 \$1114 \$1099 VSS VSS sg13_lv_nmos L=0.13u W=0.42u AS=0.0609p AD=0.1626p
+ PS=0.71u PD=1.415u rfmode=0
M$1445 VSS \$1132 \$1101 VSS sg13_lv_nmos L=0.13u W=0.74u AS=0.1626p AD=0.2516p
+ PS=1.415u PD=2.16u rfmode=0
M$1446 VSS \$1099 \$1113 VSS sg13_lv_nmos L=0.13u W=0.42u AS=0.1701p AD=0.0378p
+ PS=1.65u PD=0.6u rfmode=0
M$1447 \$1113 \$1101 \$1102 VSS sg13_lv_nmos L=0.13u W=0.42u AS=0.0378p
+ AD=0.1428p PS=0.6u PD=1.52u rfmode=0
M$1448 \$1105 \$1103 \$1104 VSS sg13_lv_nmos L=0.13u W=0.42u AS=0.12665p
+ AD=0.1428p PS=1.145u PD=1.52u rfmode=0
M$1449 \$1101 \$1133 \$1105 VSS sg13_lv_nmos L=0.13u W=0.74u AS=0.3473p
+ AD=0.12665p PS=2.71u PD=1.145u rfmode=0
M$1450 \$1104 \$1106 VSS VSS sg13_lv_nmos L=0.13u W=0.42u AS=0.1428p AD=0.0798p
+ PS=1.52u PD=0.8u rfmode=0
M$1451 VSS \$1099 \$1109 VSS sg13_lv_nmos L=0.13u W=0.42u AS=0.0798p AD=0.0378p
+ PS=0.8u PD=0.6u rfmode=0
M$1452 \$1109 \$1105 \$1106 VSS sg13_lv_nmos L=0.13u W=0.42u AS=0.0378p
+ AD=0.1428p PS=0.6u PD=1.52u rfmode=0
M$1453 \$1107 \$1105 VSS VSS sg13_lv_nmos L=0.13u W=0.74u AS=0.2516p AD=0.1406p
+ PS=2.16u PD=1.12u rfmode=0
M$1454 VSS \$1107 \$1108 VSS sg13_lv_nmos L=0.13u W=0.74u AS=0.1406p AD=0.2516p
+ PS=1.12u PD=2.16u rfmode=0
M$1480 VSS \$421 \$1058 VSS sg13_lv_nmos L=0.13u W=0.74u AS=0.2516p AD=0.2516p
+ PS=2.16u PD=2.16u rfmode=0
M$1481 \$1055 \$1060 \$1123 VSS sg13_lv_nmos L=0.13u W=0.42u AS=0.1296p
+ AD=0.0798p PS=1.52u PD=0.8u rfmode=0
M$1482 \$1123 \$1124 \$1059 VSS sg13_lv_nmos L=0.13u W=0.42u AS=0.0798p
+ AD=0.2373p PS=0.8u PD=1.97u rfmode=0
M$1483 VSS \$926 \$1155 VSS sg13_lv_nmos L=0.13u W=0.55u AS=0.18945p AD=0.187p
+ PS=1.27u PD=1.78u rfmode=0
M$1484 \$1056 \$1232 VSS VSS sg13_lv_nmos L=0.13u W=0.74u AS=0.4033p AD=0.148p
+ PS=2.57u PD=1.14u rfmode=0
M$1485 VSS \$1155 \$1251 VSS sg13_lv_nmos L=0.13u W=0.74u AS=0.148p AD=0.3367p
+ PS=1.14u PD=1.65u rfmode=0
M$1486 \$1251 \$1065 \$1232 VSS sg13_lv_nmos L=0.13u W=0.74u AS=0.3367p
+ AD=0.1628p PS=1.65u PD=1.18u rfmode=0
M$1487 \$1232 \$621 \$1252 VSS sg13_lv_nmos L=0.13u W=0.74u AS=0.1628p
+ AD=0.13135p PS=1.18u PD=1.095u rfmode=0
M$1488 \$1252 \$926 VSS VSS sg13_lv_nmos L=0.13u W=0.74u AS=0.13135p
+ AD=0.18945p PS=1.095u PD=1.27u rfmode=0
M$1489 VSS \$1060 \$1124 VSS sg13_lv_nmos L=0.13u W=0.74u AS=0.317325p
+ AD=0.2516p PS=1.805u PD=2.16u rfmode=0
M$1490 VSS \$498 \$1060 VSS sg13_lv_nmos L=0.13u W=0.74u AS=0.317325p
+ AD=0.2516p PS=1.805u PD=2.16u rfmode=0
M$1491 \$1156 \$1160 \$1158 VSS sg13_lv_nmos L=0.13u W=0.42u AS=0.1296p
+ AD=0.0798p PS=1.52u PD=0.8u rfmode=0
M$1492 \$1158 \$1159 \$1236 VSS sg13_lv_nmos L=0.13u W=0.42u AS=0.0798p
+ AD=0.2373p PS=0.8u PD=1.97u rfmode=0
M$1493 \$1159 \$1160 VSS VSS sg13_lv_nmos L=0.13u W=0.74u AS=0.2516p
+ AD=0.317325p PS=2.16u PD=1.805u rfmode=0
M$1494 VSS \$498 \$1160 VSS sg13_lv_nmos L=0.13u W=0.74u AS=0.317325p
+ AD=0.2516p PS=1.805u PD=2.16u rfmode=0
M$1495 \$1237 \$1160 \$1161 VSS sg13_lv_nmos L=0.13u W=0.42u AS=0.1428p
+ AD=0.12665p PS=1.52u PD=1.145u rfmode=0
M$1496 \$1161 \$1159 \$1157 VSS sg13_lv_nmos L=0.13u W=0.74u AS=0.12665p
+ AD=0.3473p PS=1.145u PD=2.71u rfmode=0
M$1497 \$1163 \$1161 VSS VSS sg13_lv_nmos L=0.13u W=0.74u AS=0.2516p AD=0.1406p
+ PS=2.16u PD=1.12u rfmode=0
M$1498 VSS \$1163 \$1282 VSS sg13_lv_nmos L=0.13u W=0.74u AS=0.1406p AD=0.2516p
+ PS=1.12u PD=2.16u rfmode=0
M$1499 \$1164 \$1169 \$1166 VSS sg13_lv_nmos L=0.13u W=0.42u AS=0.1296p
+ AD=0.0798p PS=1.52u PD=0.8u rfmode=0
M$1500 \$1166 \$1168 \$1238 VSS sg13_lv_nmos L=0.13u W=0.42u AS=0.0798p
+ AD=0.2373p PS=0.8u PD=1.97u rfmode=0
M$1501 \$1168 \$1169 VSS VSS sg13_lv_nmos L=0.13u W=0.74u AS=0.2516p
+ AD=0.317325p PS=2.16u PD=1.805u rfmode=0
M$1502 VSS \$741 \$1169 VSS sg13_lv_nmos L=0.13u W=0.74u AS=0.317325p
+ AD=0.2516p PS=1.805u PD=2.16u rfmode=0
M$1503 \$1239 \$1169 \$1170 VSS sg13_lv_nmos L=0.13u W=0.42u AS=0.1428p
+ AD=0.12665p PS=1.52u PD=1.145u rfmode=0
M$1504 \$1170 \$1168 \$1165 VSS sg13_lv_nmos L=0.13u W=0.74u AS=0.12665p
+ AD=0.3473p PS=1.145u PD=2.71u rfmode=0
M$1505 \$1172 \$1170 VSS VSS sg13_lv_nmos L=0.13u W=0.74u AS=0.2516p AD=0.1406p
+ PS=2.16u PD=1.12u rfmode=0
M$1506 VSS \$1172 \$1068 VSS sg13_lv_nmos L=0.13u W=0.74u AS=0.1406p AD=0.2516p
+ PS=1.12u PD=2.16u rfmode=0
M$1507 \$1173 \$1178 \$1175 VSS sg13_lv_nmos L=0.13u W=0.42u AS=0.1296p
+ AD=0.0798p PS=1.52u PD=0.8u rfmode=0
M$1508 \$1175 \$1177 \$1240 VSS sg13_lv_nmos L=0.13u W=0.42u AS=0.0798p
+ AD=0.2373p PS=0.8u PD=1.97u rfmode=0
M$1509 \$1177 \$1178 VSS VSS sg13_lv_nmos L=0.13u W=0.74u AS=0.2516p
+ AD=0.317325p PS=2.16u PD=1.805u rfmode=0
M$1510 VSS \$741 \$1178 VSS sg13_lv_nmos L=0.13u W=0.74u AS=0.317325p
+ AD=0.2516p PS=1.805u PD=2.16u rfmode=0
M$1511 \$1241 \$1178 \$1179 VSS sg13_lv_nmos L=0.13u W=0.42u AS=0.1428p
+ AD=0.12665p PS=1.52u PD=1.145u rfmode=0
M$1512 \$1179 \$1177 \$1174 VSS sg13_lv_nmos L=0.13u W=0.74u AS=0.12665p
+ AD=0.3473p PS=1.145u PD=2.71u rfmode=0
M$1513 \$1181 \$1179 VSS VSS sg13_lv_nmos L=0.13u W=0.74u AS=0.2516p AD=0.1406p
+ PS=2.16u PD=1.12u rfmode=0
M$1514 VSS \$1181 \$1069 VSS sg13_lv_nmos L=0.13u W=0.74u AS=0.1406p AD=0.2516p
+ PS=1.12u PD=2.16u rfmode=0
M$1515 \$1182 \$1186 \$1184 VSS sg13_lv_nmos L=0.13u W=0.42u AS=0.1296p
+ AD=0.0798p PS=1.52u PD=0.8u rfmode=0
M$1516 \$1184 \$1185 \$1242 VSS sg13_lv_nmos L=0.13u W=0.42u AS=0.0798p
+ AD=0.2373p PS=0.8u PD=1.97u rfmode=0
M$1517 \$1185 \$1186 VSS VSS sg13_lv_nmos L=0.13u W=0.74u AS=0.2516p
+ AD=0.317325p PS=2.16u PD=1.805u rfmode=0
M$1518 VSS \$508 \$1186 VSS sg13_lv_nmos L=0.13u W=0.74u AS=0.317325p
+ AD=0.2516p PS=1.805u PD=2.16u rfmode=0
M$1519 \$1243 \$1186 \$1187 VSS sg13_lv_nmos L=0.13u W=0.42u AS=0.1428p
+ AD=0.12665p PS=1.52u PD=1.145u rfmode=0
M$1520 \$1187 \$1185 \$1183 VSS sg13_lv_nmos L=0.13u W=0.74u AS=0.12665p
+ AD=0.3473p PS=1.145u PD=2.71u rfmode=0
M$1521 \$1189 \$1187 VSS VSS sg13_lv_nmos L=0.13u W=0.74u AS=0.2516p AD=0.1406p
+ PS=2.16u PD=1.12u rfmode=0
M$1522 VSS \$1189 \$1190 VSS sg13_lv_nmos L=0.13u W=0.74u AS=0.1406p AD=0.2516p
+ PS=1.12u PD=2.16u rfmode=0
M$1523 \$1080 \$1083 \$1128 VSS sg13_lv_nmos L=0.13u W=0.42u AS=0.1296p
+ AD=0.0798p PS=1.52u PD=0.8u rfmode=0
M$1524 \$1128 \$1129 \$1082 VSS sg13_lv_nmos L=0.13u W=0.42u AS=0.0798p
+ AD=0.2373p PS=0.8u PD=1.97u rfmode=0
M$1527 VSS \$1083 \$1129 VSS sg13_lv_nmos L=0.13u W=0.74u AS=0.317325p
+ AD=0.2516p PS=1.805u PD=2.16u rfmode=0
M$1528 VSS \$508 \$1083 VSS sg13_lv_nmos L=0.13u W=0.74u AS=0.317325p
+ AD=0.2516p PS=1.805u PD=2.16u rfmode=0
M$1529 \$1191 \$1005 VSS VSS sg13_lv_nmos L=0.13u W=0.55u AS=0.187p AD=0.18945p
+ PS=1.78u PD=1.27u rfmode=0
M$1530 VSS \$1005 \$1268 VSS sg13_lv_nmos L=0.13u W=0.74u AS=0.18945p
+ AD=0.13135p PS=1.27u PD=1.095u rfmode=0
M$1531 \$1268 \$687 \$1192 VSS sg13_lv_nmos L=0.13u W=0.74u AS=0.13135p
+ AD=0.1628p PS=1.095u PD=1.18u rfmode=0
M$1532 \$1192 \$1202 \$1269 VSS sg13_lv_nmos L=0.13u W=0.74u AS=0.1628p
+ AD=0.3367p PS=1.18u PD=1.65u rfmode=0
M$1533 \$1269 \$1191 VSS VSS sg13_lv_nmos L=0.13u W=0.74u AS=0.3367p AD=0.148p
+ PS=1.65u PD=1.14u rfmode=0
M$1534 VSS \$1192 \$1193 VSS sg13_lv_nmos L=0.13u W=0.74u AS=0.148p AD=0.4033p
+ PS=1.14u PD=2.57u rfmode=0
M$1535 \$1194 \$1198 \$1196 VSS sg13_lv_nmos L=0.13u W=0.42u AS=0.1296p
+ AD=0.0798p PS=1.52u PD=0.8u rfmode=0
M$1536 \$1196 \$1197 \$1244 VSS sg13_lv_nmos L=0.13u W=0.42u AS=0.0798p
+ AD=0.2373p PS=0.8u PD=1.97u rfmode=0
M$1537 \$1197 \$1198 VSS VSS sg13_lv_nmos L=0.13u W=0.74u AS=0.2516p
+ AD=0.317325p PS=2.16u PD=1.805u rfmode=0
M$1538 VSS \$1094 \$1198 VSS sg13_lv_nmos L=0.13u W=0.74u AS=0.317325p
+ AD=0.2516p PS=1.805u PD=2.16u rfmode=0
M$1539 \$1245 \$1198 \$1199 VSS sg13_lv_nmos L=0.13u W=0.42u AS=0.1428p
+ AD=0.12665p PS=1.52u PD=1.145u rfmode=0
M$1540 \$1199 \$1197 \$1195 VSS sg13_lv_nmos L=0.13u W=0.74u AS=0.12665p
+ AD=0.3473p PS=1.145u PD=2.71u rfmode=0
M$1541 \$1090 \$1093 \$1130 VSS sg13_lv_nmos L=0.13u W=0.42u AS=0.1296p
+ AD=0.0798p PS=1.52u PD=0.8u rfmode=0
M$1542 \$1130 \$1131 \$1092 VSS sg13_lv_nmos L=0.13u W=0.42u AS=0.0798p
+ AD=0.2373p PS=0.8u PD=1.97u rfmode=0
M$1543 VSS \$1093 \$1131 VSS sg13_lv_nmos L=0.13u W=0.74u AS=0.317325p
+ AD=0.2516p PS=1.805u PD=2.16u rfmode=0
M$1544 VSS \$1094 \$1093 VSS sg13_lv_nmos L=0.13u W=0.74u AS=0.317325p
+ AD=0.2516p PS=1.805u PD=2.16u rfmode=0
M$1545 \$1201 \$1199 VSS VSS sg13_lv_nmos L=0.13u W=0.74u AS=0.2516p AD=0.1406p
+ PS=2.16u PD=1.12u rfmode=0
M$1546 VSS \$1201 \$1202 VSS sg13_lv_nmos L=0.13u W=0.74u AS=0.1406p AD=0.2516p
+ PS=1.12u PD=2.16u rfmode=0
M$1549 \$1203 \$1126 VSS VSS sg13_lv_nmos L=0.13u W=0.55u AS=0.187p AD=0.18945p
+ PS=1.78u PD=1.27u rfmode=0
M$1550 VSS \$1126 \$1276 VSS sg13_lv_nmos L=0.13u W=0.74u AS=0.18945p
+ AD=0.13135p PS=1.27u PD=1.095u rfmode=0
M$1551 \$1276 \$687 \$1204 VSS sg13_lv_nmos L=0.13u W=0.74u AS=0.13135p
+ AD=0.1628p PS=1.095u PD=1.18u rfmode=0
M$1552 \$1204 \$1234 \$1277 VSS sg13_lv_nmos L=0.13u W=0.74u AS=0.1628p
+ AD=0.3367p PS=1.18u PD=1.65u rfmode=0
M$1553 \$1277 \$1203 VSS VSS sg13_lv_nmos L=0.13u W=0.74u AS=0.3367p AD=0.148p
+ PS=1.65u PD=1.14u rfmode=0
M$1554 VSS \$1204 \$1205 VSS sg13_lv_nmos L=0.13u W=0.74u AS=0.148p AD=0.4033p
+ PS=1.14u PD=2.57u rfmode=0
M$1555 \$1206 \$1210 \$1208 VSS sg13_lv_nmos L=0.13u W=0.42u AS=0.1296p
+ AD=0.0798p PS=1.52u PD=0.8u rfmode=0
M$1556 \$1208 \$1209 \$1246 VSS sg13_lv_nmos L=0.13u W=0.42u AS=0.0798p
+ AD=0.2373p PS=0.8u PD=1.97u rfmode=0
M$1557 \$1100 \$1103 \$1132 VSS sg13_lv_nmos L=0.13u W=0.42u AS=0.1296p
+ AD=0.0798p PS=1.52u PD=0.8u rfmode=0
M$1558 \$1132 \$1133 \$1102 VSS sg13_lv_nmos L=0.13u W=0.42u AS=0.0798p
+ AD=0.2373p PS=0.8u PD=1.97u rfmode=0
M$1559 VSS \$1103 \$1133 VSS sg13_lv_nmos L=0.13u W=0.74u AS=0.317325p
+ AD=0.2516p PS=1.805u PD=2.16u rfmode=0
M$1560 VSS \$1094 \$1103 VSS sg13_lv_nmos L=0.13u W=0.74u AS=0.317325p
+ AD=0.2516p PS=1.805u PD=2.16u rfmode=0
M$1561 \$1209 \$1210 VSS VSS sg13_lv_nmos L=0.13u W=0.74u AS=0.2516p
+ AD=0.317325p PS=2.16u PD=1.805u rfmode=0
M$1562 VSS \$1094 \$1210 VSS sg13_lv_nmos L=0.13u W=0.74u AS=0.317325p
+ AD=0.2516p PS=1.805u PD=2.16u rfmode=0
M$1563 \$1247 \$1210 \$1211 VSS sg13_lv_nmos L=0.13u W=0.42u AS=0.1428p
+ AD=0.12665p PS=1.52u PD=1.145u rfmode=0
M$1564 \$1211 \$1209 \$1207 VSS sg13_lv_nmos L=0.13u W=0.74u AS=0.12665p
+ AD=0.3473p PS=1.145u PD=2.71u rfmode=0
M$1565 \$1213 \$1211 VSS VSS sg13_lv_nmos L=0.13u W=0.74u AS=0.2516p AD=0.1406p
+ PS=2.16u PD=1.12u rfmode=0
M$1566 VSS \$1213 \$1234 VSS sg13_lv_nmos L=0.13u W=0.74u AS=0.1406p AD=0.2516p
+ PS=1.12u PD=2.16u rfmode=0
M$1571 \$30 \$1278 VSS VSS sg13_lv_nmos L=0.13u W=0.74u AS=0.2886p AD=0.14875p
+ PS=2.26u PD=1.16u rfmode=0
M$1572 VSS \$1069 \$1278 VSS sg13_lv_nmos L=0.13u W=0.55u AS=0.14875p AD=0.187p
+ PS=1.16u PD=1.78u rfmode=0
M$1573 \$29 \$1279 VSS VSS sg13_lv_nmos L=0.13u W=0.74u AS=0.2886p AD=0.14875p
+ PS=2.26u PD=1.16u rfmode=0
M$1574 VSS \$1190 \$1279 VSS sg13_lv_nmos L=0.13u W=0.55u AS=0.14875p AD=0.187p
+ PS=1.16u PD=1.78u rfmode=0
M$1577 D0 \$1281 VSS VSS sg13_lv_nmos L=0.13u W=0.74u AS=0.2886p AD=0.14875p
+ PS=2.26u PD=1.16u rfmode=0
M$1578 VSS \$1282 \$1281 VSS sg13_lv_nmos L=0.13u W=0.55u AS=0.14875p AD=0.187p
+ PS=1.16u PD=1.78u rfmode=0
M$1589 D1 \$1284 VSS VSS sg13_lv_nmos L=0.13u W=0.74u AS=0.2886p AD=0.14875p
+ PS=2.26u PD=1.16u rfmode=0
M$1590 VSS \$919 \$1284 VSS sg13_lv_nmos L=0.13u W=0.55u AS=0.14875p AD=0.187p
+ PS=1.16u PD=1.78u rfmode=0
M$1601 VSS \$1158 \$1157 VSS sg13_lv_nmos L=0.13u W=0.74u AS=0.1626p AD=0.2516p
+ PS=1.415u PD=2.16u rfmode=0
M$1602 \$1156 \$1287 \$1253 VSS sg13_lv_nmos L=0.13u W=0.42u AS=0.1428p
+ AD=0.0609p PS=1.52u PD=0.71u rfmode=0
M$1603 VSS \$1233 \$1253 VSS sg13_lv_nmos L=0.13u W=0.42u AS=0.1626p AD=0.0609p
+ PS=1.415u PD=0.71u rfmode=0
M$1604 D2 \$1286 VSS VSS sg13_lv_nmos L=0.13u W=0.74u AS=0.2886p AD=0.14875p
+ PS=2.26u PD=1.16u rfmode=0
M$1605 VSS \$1065 \$1286 VSS sg13_lv_nmos L=0.13u W=0.55u AS=0.14875p AD=0.187p
+ PS=1.16u PD=1.78u rfmode=0
M$1606 VSS \$1233 \$1254 VSS sg13_lv_nmos L=0.13u W=0.42u AS=0.1701p AD=0.0378p
+ PS=1.65u PD=0.6u rfmode=0
M$1607 \$1254 \$1157 \$1236 VSS sg13_lv_nmos L=0.13u W=0.42u AS=0.0378p
+ AD=0.1428p PS=0.6u PD=1.52u rfmode=0
M$1608 \$1287 \$1288 VSS VSS sg13_lv_nmos L=0.13u W=0.74u AS=0.4033p AD=0.148p
+ PS=2.57u PD=1.14u rfmode=0
M$1609 VSS \$1289 \$1306 VSS sg13_lv_nmos L=0.13u W=0.74u AS=0.148p AD=0.3367p
+ PS=1.14u PD=1.65u rfmode=0
M$1610 \$1306 \$1282 \$1288 VSS sg13_lv_nmos L=0.13u W=0.74u AS=0.3367p
+ AD=0.1628p PS=1.65u PD=1.18u rfmode=0
M$1611 \$1288 \$621 \$1307 VSS sg13_lv_nmos L=0.13u W=0.74u AS=0.1628p
+ AD=0.13135p PS=1.18u PD=1.095u rfmode=0
M$1612 \$1307 \$793 VSS VSS sg13_lv_nmos L=0.13u W=0.74u AS=0.13135p
+ AD=0.18945p PS=1.095u PD=1.27u rfmode=0
M$1613 VSS \$793 \$1289 VSS sg13_lv_nmos L=0.13u W=0.55u AS=0.18945p AD=0.187p
+ PS=1.27u PD=1.78u rfmode=0
M$1616 \$1237 \$1162 VSS VSS sg13_lv_nmos L=0.13u W=0.42u AS=0.1428p AD=0.0798p
+ PS=1.52u PD=0.8u rfmode=0
M$1617 VSS \$1233 \$1256 VSS sg13_lv_nmos L=0.13u W=0.42u AS=0.0798p AD=0.0378p
+ PS=0.8u PD=0.6u rfmode=0
M$1618 \$1256 \$1161 \$1162 VSS sg13_lv_nmos L=0.13u W=0.42u AS=0.0378p
+ AD=0.1428p PS=0.6u PD=1.52u rfmode=0
M$1620 VSS \$1166 \$1165 VSS sg13_lv_nmos L=0.13u W=0.74u AS=0.1626p AD=0.2516p
+ PS=1.415u PD=2.16u rfmode=0
M$1621 \$1164 \$1066 \$1257 VSS sg13_lv_nmos L=0.13u W=0.42u AS=0.1428p
+ AD=0.0609p PS=1.52u PD=0.71u rfmode=0
M$1622 VSS \$1167 \$1257 VSS sg13_lv_nmos L=0.13u W=0.42u AS=0.1626p AD=0.0609p
+ PS=1.415u PD=0.71u rfmode=0
M$1623 VSS \$421 \$1167 VSS sg13_lv_nmos L=0.13u W=0.74u AS=0.2516p AD=0.2516p
+ PS=2.16u PD=2.16u rfmode=0
M$1624 VSS \$1167 \$1258 VSS sg13_lv_nmos L=0.13u W=0.42u AS=0.1701p AD=0.0378p
+ PS=1.65u PD=0.6u rfmode=0
M$1625 \$1258 \$1165 \$1238 VSS sg13_lv_nmos L=0.13u W=0.42u AS=0.0378p
+ AD=0.1428p PS=0.6u PD=1.52u rfmode=0
M$1629 D3 \$1291 VSS VSS sg13_lv_nmos L=0.13u W=0.74u AS=0.2886p AD=0.14875p
+ PS=2.26u PD=1.16u rfmode=0
M$1630 VSS \$1068 \$1291 VSS sg13_lv_nmos L=0.13u W=0.55u AS=0.14875p AD=0.187p
+ PS=1.16u PD=1.78u rfmode=0
M$1631 \$1239 \$1171 VSS VSS sg13_lv_nmos L=0.13u W=0.42u AS=0.1428p AD=0.0798p
+ PS=1.52u PD=0.8u rfmode=0
M$1632 VSS \$1167 \$1259 VSS sg13_lv_nmos L=0.13u W=0.42u AS=0.0798p AD=0.0378p
+ PS=0.8u PD=0.6u rfmode=0
M$1633 \$1259 \$1170 \$1171 VSS sg13_lv_nmos L=0.13u W=0.42u AS=0.0378p
+ AD=0.1428p PS=0.6u PD=1.52u rfmode=0
M$1636 VSS \$1175 \$1174 VSS sg13_lv_nmos L=0.13u W=0.74u AS=0.1626p AD=0.2516p
+ PS=1.415u PD=2.16u rfmode=0
M$1637 \$1173 \$1073 \$1260 VSS sg13_lv_nmos L=0.13u W=0.42u AS=0.1428p
+ AD=0.0609p PS=1.52u PD=0.71u rfmode=0
M$1638 VSS \$1176 \$1260 VSS sg13_lv_nmos L=0.13u W=0.42u AS=0.1626p AD=0.0609p
+ PS=1.415u PD=0.71u rfmode=0
M$1639 VSS \$421 \$1176 VSS sg13_lv_nmos L=0.13u W=0.74u AS=0.2516p AD=0.2516p
+ PS=2.16u PD=2.16u rfmode=0
M$1640 VSS \$1176 \$1261 VSS sg13_lv_nmos L=0.13u W=0.42u AS=0.1701p AD=0.0378p
+ PS=1.65u PD=0.6u rfmode=0
M$1641 \$1261 \$1174 \$1240 VSS sg13_lv_nmos L=0.13u W=0.42u AS=0.0378p
+ AD=0.1428p PS=0.6u PD=1.52u rfmode=0
M$1646 \$1241 \$1180 VSS VSS sg13_lv_nmos L=0.13u W=0.42u AS=0.1428p AD=0.0798p
+ PS=1.52u PD=0.8u rfmode=0
M$1647 VSS \$1176 \$1262 VSS sg13_lv_nmos L=0.13u W=0.42u AS=0.0798p AD=0.0378p
+ PS=0.8u PD=0.6u rfmode=0
M$1648 \$1262 \$1179 \$1180 VSS sg13_lv_nmos L=0.13u W=0.42u AS=0.0378p
+ AD=0.1428p PS=0.6u PD=1.52u rfmode=0
M$1651 VSS \$1184 \$1183 VSS sg13_lv_nmos L=0.13u W=0.74u AS=0.1626p AD=0.2516p
+ PS=1.415u PD=2.16u rfmode=0
M$1652 \$1182 \$1077 \$1264 VSS sg13_lv_nmos L=0.13u W=0.42u AS=0.1428p
+ AD=0.0609p PS=1.52u PD=0.71u rfmode=0
M$1653 VSS \$1078 \$1264 VSS sg13_lv_nmos L=0.13u W=0.42u AS=0.1626p AD=0.0609p
+ PS=1.415u PD=0.71u rfmode=0
M$1654 VSS \$1190 \$1127 VSS sg13_lv_nmos L=0.13u W=0.74u AS=0.2516p AD=0.2516p
+ PS=2.16u PD=2.16u rfmode=0
M$1655 D4 \$1293 VSS VSS sg13_lv_nmos L=0.13u W=0.74u AS=0.2886p AD=0.14875p
+ PS=2.26u PD=1.16u rfmode=0
M$1656 VSS \$886 \$1293 VSS sg13_lv_nmos L=0.13u W=0.55u AS=0.14875p AD=0.187p
+ PS=1.16u PD=1.78u rfmode=0
M$1657 VSS \$1078 \$1265 VSS sg13_lv_nmos L=0.13u W=0.42u AS=0.1701p AD=0.0378p
+ PS=1.65u PD=0.6u rfmode=0
M$1658 \$1265 \$1183 \$1242 VSS sg13_lv_nmos L=0.13u W=0.42u AS=0.0378p
+ AD=0.1428p PS=0.6u PD=1.52u rfmode=0
M$1663 \$1243 \$1188 VSS VSS sg13_lv_nmos L=0.13u W=0.42u AS=0.1428p AD=0.0798p
+ PS=1.52u PD=0.8u rfmode=0
M$1664 VSS \$1078 \$1266 VSS sg13_lv_nmos L=0.13u W=0.42u AS=0.0798p AD=0.0378p
+ PS=0.8u PD=0.6u rfmode=0
M$1665 \$1266 \$1187 \$1188 VSS sg13_lv_nmos L=0.13u W=0.42u AS=0.0378p
+ AD=0.1428p PS=0.6u PD=1.52u rfmode=0
M$1672 D5 \$1295 VSS VSS sg13_lv_nmos L=0.13u W=0.74u AS=0.2886p AD=0.14875p
+ PS=2.26u PD=1.16u rfmode=0
M$1673 VSS \$1011 \$1295 VSS sg13_lv_nmos L=0.13u W=0.55u AS=0.14875p AD=0.187p
+ PS=1.16u PD=1.78u rfmode=0
M$1674 VSS \$1196 \$1195 VSS sg13_lv_nmos L=0.13u W=0.74u AS=0.1626p AD=0.2516p
+ PS=1.415u PD=2.16u rfmode=0
M$1675 \$1194 \$1193 \$1270 VSS sg13_lv_nmos L=0.13u W=0.42u AS=0.1428p
+ AD=0.0609p PS=1.52u PD=0.71u rfmode=0
M$1676 VSS \$1088 \$1270 VSS sg13_lv_nmos L=0.13u W=0.42u AS=0.1626p AD=0.0609p
+ PS=1.415u PD=0.71u rfmode=0
M$1679 VSS \$1088 \$1271 VSS sg13_lv_nmos L=0.13u W=0.42u AS=0.1701p AD=0.0378p
+ PS=1.65u PD=0.6u rfmode=0
M$1680 \$1271 \$1195 \$1244 VSS sg13_lv_nmos L=0.13u W=0.42u AS=0.0378p
+ AD=0.1428p PS=0.6u PD=1.52u rfmode=0
M$1682 \$1094 \$1296 VSS VSS sg13_lv_nmos L=0.13u W=0.74u AS=0.2886p
+ AD=0.14875p PS=2.26u PD=1.16u rfmode=0
M$1683 VSS \$343 \$1296 VSS sg13_lv_nmos L=0.13u W=0.55u AS=0.14875p AD=0.187p
+ PS=1.16u PD=1.78u rfmode=0
M$1686 \$1245 \$1200 VSS VSS sg13_lv_nmos L=0.13u W=0.42u AS=0.1428p AD=0.0798p
+ PS=1.52u PD=0.8u rfmode=0
M$1687 VSS \$1088 \$1273 VSS sg13_lv_nmos L=0.13u W=0.42u AS=0.0798p AD=0.0378p
+ PS=0.8u PD=0.6u rfmode=0
M$1688 \$1273 \$1199 \$1200 VSS sg13_lv_nmos L=0.13u W=0.42u AS=0.0378p
+ AD=0.1428p PS=0.6u PD=1.52u rfmode=0
M$1691 VSS \$1202 \$1297 VSS sg13_lv_nmos L=0.13u W=0.55u AS=0.14875p AD=0.187p
+ PS=1.16u PD=1.78u rfmode=0
M$1692 VSS \$1297 D6 VSS sg13_lv_nmos L=0.13u W=0.74u AS=0.14875p AD=0.2886p
+ PS=1.16u PD=2.26u rfmode=0
M$1693 VSS \$1126 \$1299 VSS sg13_lv_nmos L=0.13u W=0.55u AS=0.18945p AD=0.187p
+ PS=1.27u PD=1.78u rfmode=0
M$1694 VSS \$1126 \$1309 VSS sg13_lv_nmos L=0.13u W=0.74u AS=0.18945p
+ AD=0.13135p PS=1.27u PD=1.095u rfmode=0
M$1695 \$1309 \$687 \$1300 VSS sg13_lv_nmos L=0.13u W=0.74u AS=0.13135p
+ AD=0.1628p PS=1.095u PD=1.18u rfmode=0
M$1696 \$1300 \$1108 \$1308 VSS sg13_lv_nmos L=0.13u W=0.74u AS=0.1628p
+ AD=0.3367p PS=1.18u PD=1.65u rfmode=0
M$1697 \$1308 \$1299 VSS VSS sg13_lv_nmos L=0.13u W=0.74u AS=0.3367p AD=0.148p
+ PS=1.65u PD=1.14u rfmode=0
M$1698 VSS \$1300 \$1301 VSS sg13_lv_nmos L=0.13u W=0.74u AS=0.148p AD=0.4033p
+ PS=1.14u PD=2.57u rfmode=0
M$1699 VSS \$1208 \$1207 VSS sg13_lv_nmos L=0.13u W=0.74u AS=0.1626p AD=0.2516p
+ PS=1.415u PD=2.16u rfmode=0
M$1700 \$1206 \$1205 \$1275 VSS sg13_lv_nmos L=0.13u W=0.42u AS=0.1428p
+ AD=0.0609p PS=1.52u PD=0.71u rfmode=0
M$1701 VSS \$1235 \$1275 VSS sg13_lv_nmos L=0.13u W=0.42u AS=0.1626p AD=0.0609p
+ PS=1.415u PD=0.71u rfmode=0
M$1702 VSS \$887 \$1235 VSS sg13_lv_nmos L=0.13u W=0.74u AS=0.2516p AD=0.2516p
+ PS=2.16u PD=2.16u rfmode=0
M$1703 VSS \$1235 \$1272 VSS sg13_lv_nmos L=0.13u W=0.42u AS=0.1701p AD=0.0378p
+ PS=1.65u PD=0.6u rfmode=0
M$1704 \$1272 \$1207 \$1246 VSS sg13_lv_nmos L=0.13u W=0.42u AS=0.0378p
+ AD=0.1428p PS=0.6u PD=1.52u rfmode=0
M$1709 \$1247 \$1212 VSS VSS sg13_lv_nmos L=0.13u W=0.42u AS=0.1428p AD=0.0798p
+ PS=1.52u PD=0.8u rfmode=0
M$1710 VSS \$1235 \$1255 VSS sg13_lv_nmos L=0.13u W=0.42u AS=0.0798p AD=0.0378p
+ PS=0.8u PD=0.6u rfmode=0
M$1711 \$1255 \$1211 \$1212 VSS sg13_lv_nmos L=0.13u W=0.42u AS=0.0378p
+ AD=0.1428p PS=0.6u PD=1.52u rfmode=0
M$1716 D7 \$1303 VSS VSS sg13_lv_nmos L=0.13u W=0.74u AS=0.2886p AD=0.14875p
+ PS=2.26u PD=1.16u rfmode=0
M$1717 VSS \$1234 \$1303 VSS sg13_lv_nmos L=0.13u W=0.55u AS=0.14875p AD=0.187p
+ PS=1.16u PD=1.78u rfmode=0
M$1718 VSS \$1108 \$1304 VSS sg13_lv_nmos L=0.13u W=0.55u AS=0.14875p AD=0.187p
+ PS=1.16u PD=1.78u rfmode=0
M$1719 VSS \$1304 \$40 VSS sg13_lv_nmos L=0.13u W=0.74u AS=0.14875p AD=0.2886p
+ PS=1.16u PD=2.26u rfmode=0
M$1721 VSS \$1037 \$1305 VSS sg13_lv_nmos L=0.13u W=0.55u AS=0.14875p AD=0.187p
+ PS=1.16u PD=1.78u rfmode=0
M$1722 VSS \$1305 \$39 VSS sg13_lv_nmos L=0.13u W=0.74u AS=0.14875p AD=0.2886p
+ PS=1.16u PD=2.26u rfmode=0
M$1723 VDD \$30 \$17 VDD sg13_lv_pmos L=0.13u W=2u AS=0.68p AD=0.68p PS=4.68u
+ PD=4.68u rfmode=0
M$1724 \$28 \$39 VDD VDD sg13_lv_pmos L=0.13u W=2u AS=0.68p AD=0.68p PS=4.68u
+ PD=4.68u rfmode=0
M$1725 VSS \$72 \$17 VDD sg13_lv_pmos L=0.13u W=2u AS=0.68p AD=0.68p PS=4.68u
+ PD=4.68u rfmode=0
M$1726 \$28 \$83 VSS VDD sg13_lv_pmos L=0.13u W=2u AS=0.68p AD=0.68p PS=4.68u
+ PD=4.68u rfmode=0
M$1727 VDD \$29 \$7 VDD sg13_lv_pmos L=0.13u W=2u AS=0.68p AD=0.68p PS=4.68u
+ PD=4.68u rfmode=0
M$1728 VSS \$71 \$7 VDD sg13_lv_pmos L=0.13u W=2u AS=0.68p AD=0.68p PS=4.68u
+ PD=4.68u rfmode=0
M$1729 VDD \$34 \$21 VDD sg13_lv_pmos L=0.13u W=2u AS=0.68p AD=0.68p PS=4.68u
+ PD=4.68u rfmode=0
M$1730 \$22 \$35 VDD VDD sg13_lv_pmos L=0.13u W=2u AS=0.68p AD=0.68p PS=4.68u
+ PD=4.68u rfmode=0
M$1731 \$9 \$84 VSS VDD sg13_lv_pmos L=0.13u W=2u AS=0.68p AD=0.68p PS=4.68u
+ PD=4.68u rfmode=0
M$1732 \$9 \$40 VDD VDD sg13_lv_pmos L=0.13u W=2u AS=0.68p AD=0.68p PS=4.68u
+ PD=4.68u rfmode=0
M$1733 VDD \$31 \$18 VDD sg13_lv_pmos L=0.13u W=2u AS=0.68p AD=0.68p PS=4.68u
+ PD=4.68u rfmode=0
M$1734 VSS \$73 \$18 VDD sg13_lv_pmos L=0.13u W=2u AS=0.68p AD=0.68p PS=4.68u
+ PD=4.68u rfmode=0
M$1735 VDD \$32 \$20 VDD sg13_lv_pmos L=0.13u W=2u AS=0.68p AD=0.68p PS=4.68u
+ PD=4.68u rfmode=0
M$1736 VSS \$74 \$20 VDD sg13_lv_pmos L=0.13u W=2u AS=0.68p AD=0.68p PS=4.68u
+ PD=4.68u rfmode=0
M$1737 VDD \$33 \$24 VDD sg13_lv_pmos L=0.13u W=2u AS=0.68p AD=0.68p PS=4.68u
+ PD=4.68u rfmode=0
M$1738 VSS \$75 \$24 VDD sg13_lv_pmos L=0.13u W=2u AS=0.68p AD=0.68p PS=4.68u
+ PD=4.68u rfmode=0
M$1739 VSS \$77 \$21 VDD sg13_lv_pmos L=0.13u W=2u AS=0.68p AD=0.68p PS=4.68u
+ PD=4.68u rfmode=0
M$1740 \$22 \$78 VSS VDD sg13_lv_pmos L=0.13u W=2u AS=0.68p AD=0.68p PS=4.68u
+ PD=4.68u rfmode=0
M$1741 \$27 \$80 VSS VDD sg13_lv_pmos L=0.13u W=2u AS=0.68p AD=0.68p PS=4.68u
+ PD=4.68u rfmode=0
M$1742 \$27 \$36 VDD VDD sg13_lv_pmos L=0.13u W=2u AS=0.68p AD=0.68p PS=4.68u
+ PD=4.68u rfmode=0
M$1743 \$23 \$81 VSS VDD sg13_lv_pmos L=0.13u W=2u AS=0.68p AD=0.68p PS=4.68u
+ PD=4.68u rfmode=0
M$1744 \$23 \$37 VDD VDD sg13_lv_pmos L=0.13u W=2u AS=0.68p AD=0.68p PS=4.68u
+ PD=4.68u rfmode=0
M$1745 \$19 \$82 VSS VDD sg13_lv_pmos L=0.13u W=2u AS=0.68p AD=0.68p PS=4.68u
+ PD=4.68u rfmode=0
M$1746 \$19 \$38 VDD VDD sg13_lv_pmos L=0.13u W=2u AS=0.68p AD=0.68p PS=4.68u
+ PD=4.68u rfmode=0
M$1747 VDD \$29 \$71 VDD sg13_lv_pmos L=0.13u W=0.8u AS=0.272p AD=0.272p
+ PS=2.28u PD=2.28u rfmode=0
M$1748 VDD \$30 \$72 VDD sg13_lv_pmos L=0.13u W=0.8u AS=0.272p AD=0.272p
+ PS=2.28u PD=2.28u rfmode=0
M$1749 VDD \$31 \$73 VDD sg13_lv_pmos L=0.13u W=0.8u AS=0.272p AD=0.272p
+ PS=2.28u PD=2.28u rfmode=0
M$1750 VDD \$32 \$74 VDD sg13_lv_pmos L=0.13u W=0.8u AS=0.272p AD=0.272p
+ PS=2.28u PD=2.28u rfmode=0
M$1751 VDD \$33 \$75 VDD sg13_lv_pmos L=0.13u W=0.8u AS=0.272p AD=0.272p
+ PS=2.28u PD=2.28u rfmode=0
M$1752 VDD \$41 \$25 VDD sg13_lv_pmos L=0.13u W=2u AS=0.68p AD=0.68p PS=4.68u
+ PD=4.68u rfmode=0
M$1753 VDD \$41 \$76 VDD sg13_lv_pmos L=0.13u W=0.8u AS=0.272p AD=0.272p
+ PS=2.28u PD=2.28u rfmode=0
M$1754 VSS \$76 \$25 VDD sg13_lv_pmos L=0.13u W=2u AS=0.68p AD=0.68p PS=4.68u
+ PD=4.68u rfmode=0
M$1755 VDD \$34 \$77 VDD sg13_lv_pmos L=0.13u W=0.8u AS=0.272p AD=0.272p
+ PS=2.28u PD=2.28u rfmode=0
M$1756 \$204 clk_comp \$200 \$199 sg13_lv_pmos L=0.3u W=18u AS=4.095p AD=4.095p
+ PS=24.32u PD=24.32u rfmode=0
M$1760 \$200 bias VDD \$199 sg13_lv_pmos L=0.3u W=18u AS=4.095p AD=4.095p
+ PS=24.32u PD=24.32u rfmode=0
M$1764 \$78 \$35 VDD VDD sg13_lv_pmos L=0.13u W=0.8u AS=0.272p AD=0.272p
+ PS=2.28u PD=2.28u rfmode=0
M$1765 \$26 \$79 VSS VDD sg13_lv_pmos L=0.13u W=2u AS=0.68p AD=0.68p PS=4.68u
+ PD=4.68u rfmode=0
M$1766 \$79 \$42 VDD VDD sg13_lv_pmos L=0.13u W=0.8u AS=0.272p AD=0.272p
+ PS=2.28u PD=2.28u rfmode=0
M$1767 \$26 \$42 VDD VDD sg13_lv_pmos L=0.13u W=2u AS=0.68p AD=0.68p PS=4.68u
+ PD=4.68u rfmode=0
M$1768 \$80 \$36 VDD VDD sg13_lv_pmos L=0.13u W=0.8u AS=0.272p AD=0.272p
+ PS=2.28u PD=2.28u rfmode=0
M$1769 \$81 \$37 VDD VDD sg13_lv_pmos L=0.13u W=0.8u AS=0.272p AD=0.272p
+ PS=2.28u PD=2.28u rfmode=0
M$1770 \$82 \$38 VDD VDD sg13_lv_pmos L=0.13u W=0.8u AS=0.272p AD=0.272p
+ PS=2.28u PD=2.28u rfmode=0
M$1771 \$83 \$39 VDD VDD sg13_lv_pmos L=0.13u W=0.8u AS=0.272p AD=0.272p
+ PS=2.28u PD=2.28u rfmode=0
M$1772 \$84 \$40 VDD VDD sg13_lv_pmos L=0.13u W=0.8u AS=0.272p AD=0.272p
+ PS=2.28u PD=2.28u rfmode=0
M$1773 Op \$201 VDD \$199 sg13_lv_pmos L=0.2u W=8u AS=2.12p AD=2.12p PS=13.06u
+ PD=13.06u rfmode=0
M$1775 Om \$202 VDD \$199 sg13_lv_pmos L=0.2u W=8u AS=2.12p AD=2.12p PS=13.06u
+ PD=13.06u rfmode=0
M$1777 \$221 \$225 VDD VDD sg13_lv_pmos L=0.13u W=0.8u AS=0.272p AD=0.272p
+ PS=2.28u PD=2.28u rfmode=0
M$1778 \$225 fclk_samp VDD VDD sg13_lv_pmos L=0.13u W=0.8u AS=0.272p AD=0.272p
+ PS=2.28u PD=2.28u rfmode=0
M$1779 VDD fclk_samp \$226 VDD sg13_lv_pmos L=0.13u W=0.8u AS=0.272p AD=0.272p
+ PS=2.28u PD=2.28u rfmode=0
M$1780 VDD \$226 \$224 VDD sg13_lv_pmos L=0.13u W=0.8u AS=0.272p AD=0.272p
+ PS=2.28u PD=2.28u rfmode=0
M$1781 \$204 \$10 \$201 \$199 sg13_lv_pmos L=0.2u W=32u AS=8.48p AD=8.48p
+ PS=52.24u PD=52.24u rfmode=0
M$1783 \$204 \$8 \$202 \$199 sg13_lv_pmos L=0.2u W=32u AS=8.48p AD=8.48p
+ PS=52.24u PD=52.24u rfmode=0
M$1793 \$257 \$278 \$280 \$280 sg13_lv_pmos L=0.13u W=0.5u AS=0.17p AD=0.17p
+ PS=1.68u PD=1.68u rfmode=0
M$1794 \$278 \$274 VDD VDD sg13_lv_pmos L=0.13u W=0.8u AS=0.272p AD=0.272p
+ PS=2.28u PD=2.28u rfmode=0
M$1795 VDD \$274 \$271 VDD sg13_lv_pmos L=0.13u W=0.5u AS=0.17p AD=0.17p
+ PS=1.68u PD=1.68u rfmode=0
M$1796 \$237 \$279 VDD VDD sg13_lv_pmos L=0.13u W=0.5u AS=0.17p AD=0.17p
+ PS=1.68u PD=1.68u rfmode=0
M$1797 VDD \$279 \$275 VDD sg13_lv_pmos L=0.13u W=0.8u AS=0.272p AD=0.272p
+ PS=2.28u PD=2.28u rfmode=0
M$1798 \$256 \$275 \$259 \$256 sg13_lv_pmos L=0.13u W=0.5u AS=0.17p AD=0.17p
+ PS=1.68u PD=1.68u rfmode=0
M$1801 VDD Op \$302 VDD sg13_lv_pmos L=0.13u W=0.5u AS=0.17p AD=0.095p PS=1.68u
+ PD=0.88u rfmode=0
M$1802 \$302 Om VDD VDD sg13_lv_pmos L=0.13u W=0.5u AS=0.095p AD=0.17p PS=0.88u
+ PD=1.68u rfmode=0
M$1805 \$390 \$334 VDD VDD sg13_lv_pmos L=0.13u W=1.12u AS=0.3864p AD=0.41165p
+ PS=2.93u PD=2.12u rfmode=0
M$1806 VDD \$371 \$334 VDD sg13_lv_pmos L=0.13u W=1.12u AS=0.41165p AD=0.4088p
+ PS=2.12u PD=2.97u rfmode=0
M$1807 \$34 \$347 VDD VDD sg13_lv_pmos L=0.13u W=1.12u AS=0.42p AD=0.2114p
+ PS=2.99u PD=1.54u rfmode=0
M$1808 VDD \$352 \$347 VDD sg13_lv_pmos L=0.13u W=0.84u AS=0.2114p AD=0.2856p
+ PS=1.54u PD=2.36u rfmode=0
M$1809 VDD Op \$348 VDD sg13_lv_pmos L=0.13u W=0.84u AS=0.2114p AD=0.2856p
+ PS=1.54u PD=2.36u rfmode=0
M$1810 VDD \$348 \$312 VDD sg13_lv_pmos L=0.13u W=1.12u AS=0.2114p AD=0.42p
+ PS=1.54u PD=2.99u rfmode=0
M$1811 VDD \$387 \$349 VDD sg13_lv_pmos L=0.13u W=0.84u AS=0.2114p AD=0.2856p
+ PS=1.54u PD=2.36u rfmode=0
M$1812 VDD \$349 clk_comp VDD sg13_lv_pmos L=0.13u W=1.12u AS=0.2114p AD=0.42p
+ PS=1.54u PD=2.99u rfmode=0
M$1813 \$313 \$350 VDD VDD sg13_lv_pmos L=0.13u W=0.84u AS=0.2856p AD=0.253p
+ PS=2.36u PD=1.53u rfmode=0
M$1814 VDD \$350 \$396 VDD sg13_lv_pmos L=0.13u W=1u AS=0.253p AD=0.3325p
+ PS=1.53u PD=1.665u rfmode=0
M$1815 \$396 \$352 \$314 VDD sg13_lv_pmos L=0.13u W=1u AS=0.3325p AD=0.2225p
+ PS=1.665u PD=1.445u rfmode=0
M$1816 \$314 \$351 \$398 VDD sg13_lv_pmos L=0.13u W=1u AS=0.2225p AD=0.2975p
+ PS=1.445u PD=1.595u rfmode=0
M$1817 \$398 \$313 VDD VDD sg13_lv_pmos L=0.13u W=1u AS=0.2975p AD=0.2198p
+ PS=1.595u PD=1.52u rfmode=0
M$1818 VDD \$314 \$315 VDD sg13_lv_pmos L=0.13u W=1.12u AS=0.2198p AD=0.6048p
+ PS=1.52u PD=3.32u rfmode=0
M$1819 VDD \$317 \$316 VDD sg13_lv_pmos L=0.13u W=17.92u AS=3.5896p AD=3.4048p
+ PS=25.45u PD=24u rfmode=0
M$1835 VDD fclk_in \$317 VDD sg13_lv_pmos L=0.13u W=6.72u AS=1.2768p AD=1.4448p
+ PS=9u PD=10.42u rfmode=0
M$1841 \$320 \$355 \$388 VDD sg13_lv_pmos L=0.13u W=1.12u AS=0.3808p AD=0.2128p
+ PS=2.92u PD=1.5u rfmode=0
M$1842 \$388 \$356 VDD VDD sg13_lv_pmos L=0.13u W=1.12u AS=0.2128p AD=0.2128p
+ PS=1.5u PD=1.5u rfmode=0
M$1843 VDD \$354 \$388 VDD sg13_lv_pmos L=0.13u W=1.12u AS=0.2128p AD=0.3808p
+ PS=1.5u PD=2.92u rfmode=0
M$1844 VDD \$357 \$321 VDD sg13_lv_pmos L=0.13u W=0.84u AS=0.4536p AD=0.1596p
+ PS=2.76u PD=1.22u rfmode=0
M$1845 VDD \$319 \$321 VDD sg13_lv_pmos L=0.13u W=0.84u AS=0.2891p AD=0.1596p
+ PS=1.695u PD=1.22u rfmode=0
M$1846 VDD \$357 \$406 VDD sg13_lv_pmos L=0.13u W=1.12u AS=0.2891p AD=0.1428p
+ PS=1.695u PD=1.375u rfmode=0
M$1847 \$406 \$319 \$389 VDD sg13_lv_pmos L=0.13u W=1.12u AS=0.1428p AD=0.2408p
+ PS=1.375u PD=1.55u rfmode=0
M$1848 \$389 \$321 VDD VDD sg13_lv_pmos L=0.13u W=1.12u AS=0.2408p AD=0.3808p
+ PS=1.55u PD=2.92u rfmode=0
M$1849 VDD \$359 \$358 VDD sg13_lv_pmos L=0.5u W=1u AS=0.2254p AD=0.34p
+ PS=1.53u PD=2.68u rfmode=0
M$1850 \$356 \$358 VDD VDD sg13_lv_pmos L=0.13u W=1.12u AS=0.4256p AD=0.2254p
+ PS=3u PD=1.53u rfmode=0
M$1851 VDD \$362 \$361 VDD sg13_lv_pmos L=0.5u W=1u AS=0.2254p AD=0.34p
+ PS=1.53u PD=2.68u rfmode=0
M$1852 \$324 \$361 VDD VDD sg13_lv_pmos L=0.13u W=1.12u AS=0.4256p AD=0.2254p
+ PS=3u PD=1.53u rfmode=0
M$1853 VDD \$364 \$363 VDD sg13_lv_pmos L=0.5u W=1u AS=0.2254p AD=0.34p
+ PS=1.53u PD=2.68u rfmode=0
M$1854 \$357 \$363 VDD VDD sg13_lv_pmos L=0.13u W=1.12u AS=0.4256p AD=0.2254p
+ PS=3u PD=1.53u rfmode=0
M$1855 \$327 \$366 VDD VDD sg13_lv_pmos L=0.13u W=1.12u AS=0.42p AD=0.2114p
+ PS=2.99u PD=1.54u rfmode=0
M$1856 VDD rst \$366 VDD sg13_lv_pmos L=0.13u W=0.84u AS=0.2114p AD=0.2856p
+ PS=1.54u PD=2.36u rfmode=0
M$1857 \$368 \$329 VDD VDD sg13_lv_pmos L=0.5u W=1u AS=0.34p AD=0.2254p
+ PS=2.68u PD=1.53u rfmode=0
M$1858 VDD \$368 \$330 VDD sg13_lv_pmos L=0.13u W=1.12u AS=0.2254p AD=0.4256p
+ PS=1.53u PD=3u rfmode=0
M$1859 \$337 \$372 VDD VDD sg13_lv_pmos L=0.13u W=1.12u AS=0.3864p AD=0.2128p
+ PS=2.93u PD=1.5u rfmode=0
M$1860 VDD \$337 \$338 VDD sg13_lv_pmos L=0.13u W=1.12u AS=0.2128p AD=0.3808p
+ PS=1.5u PD=2.92u rfmode=0
M$1861 \$373 \$312 VDD VDD sg13_lv_pmos L=0.13u W=0.84u AS=0.2856p AD=0.2618p
+ PS=2.36u PD=1.63u rfmode=0
M$1862 VDD \$373 \$399 VDD sg13_lv_pmos L=0.13u W=1.12u AS=0.2618p AD=0.1176p
+ PS=1.63u PD=1.33u rfmode=0
M$1863 \$399 \$374 \$341 VDD sg13_lv_pmos L=0.13u W=1.12u AS=0.1176p AD=0.3808p
+ PS=1.33u PD=2.92u rfmode=0
M$1864 \$342 \$375 VDD VDD sg13_lv_pmos L=0.13u W=1.12u AS=0.42p AD=0.2114p
+ PS=2.99u PD=1.54u rfmode=0
M$1865 VDD \$669 \$375 VDD sg13_lv_pmos L=0.13u W=0.84u AS=0.2114p AD=0.2856p
+ PS=1.54u PD=2.36u rfmode=0
M$1866 VDD \$302 \$376 VDD sg13_lv_pmos L=0.13u W=0.84u AS=0.2114p AD=0.2856p
+ PS=1.54u PD=2.36u rfmode=0
M$1867 VDD \$376 \$343 VDD sg13_lv_pmos L=0.13u W=1.12u AS=0.2114p AD=0.42p
+ PS=1.54u PD=2.99u rfmode=0
M$1868 fclk_samp \$377 VDD VDD sg13_lv_pmos L=0.13u W=1.12u AS=0.42p AD=0.2114p
+ PS=2.99u PD=1.54u rfmode=0
M$1869 VDD \$391 \$377 VDD sg13_lv_pmos L=0.13u W=0.84u AS=0.2114p AD=0.2856p
+ PS=1.54u PD=2.36u rfmode=0
M$1870 \$374 \$378 VDD VDD sg13_lv_pmos L=0.13u W=1.12u AS=0.42p AD=0.2114p
+ PS=2.99u PD=1.54u rfmode=0
M$1871 VDD Om \$378 VDD sg13_lv_pmos L=0.13u W=0.84u AS=0.2114p AD=0.2856p
+ PS=1.54u PD=2.36u rfmode=0
M$1872 VDD \$467 \$379 VDD sg13_lv_pmos L=0.13u W=0.84u AS=0.2114p AD=0.2856p
+ PS=1.54u PD=2.36u rfmode=0
M$1873 VDD \$379 \$35 VDD sg13_lv_pmos L=0.13u W=1.12u AS=0.2114p AD=0.42p
+ PS=1.54u PD=2.99u rfmode=0
M$1874 VDD VSS VDD VDD sg13_lv_pmos L=1u W=595u AS=159.85p AD=159.85p
+ PS=1226.7u PD=1226.7u rfmode=0
M$1882 VDD \$356 \$319 VDD sg13_lv_pmos L=0.13u W=1.12u AS=0.3808p AD=0.2128p
+ PS=2.92u PD=1.5u rfmode=0
M$1883 \$319 \$353 VDD VDD sg13_lv_pmos L=0.13u W=1.12u AS=0.2128p AD=0.2128p
+ PS=1.5u PD=1.5u rfmode=0
M$1884 VDD \$354 \$319 VDD sg13_lv_pmos L=0.13u W=1.12u AS=0.2128p AD=0.3808p
+ PS=1.5u PD=2.92u rfmode=0
M$1885 \$355 \$356 \$405 VDD sg13_lv_pmos L=0.13u W=1u AS=0.34p AD=0.1225p
+ PS=2.68u PD=1.245u rfmode=0
M$1886 \$405 \$354 VDD VDD sg13_lv_pmos L=0.13u W=1u AS=0.1225p AD=0.36p
+ PS=1.245u PD=2.72u rfmode=0
M$1887 VDD \$360 \$323 VDD sg13_lv_pmos L=0.13u W=0.42u AS=0.1523p AD=0.1428p
+ PS=1.38u PD=1.52u rfmode=0
M$1888 \$359 \$323 VDD VDD sg13_lv_pmos L=0.5u W=1u AS=0.34p AD=0.1523p
+ PS=2.68u PD=1.38u rfmode=0
M$1890 VDD \$389 \$325 VDD sg13_lv_pmos L=0.13u W=0.42u AS=0.1523p AD=0.1428p
+ PS=1.38u PD=1.52u rfmode=0
M$1891 \$362 \$325 VDD VDD sg13_lv_pmos L=0.5u W=1u AS=0.34p AD=0.1523p
+ PS=2.68u PD=1.38u rfmode=0
M$1892 VDD \$365 \$326 VDD sg13_lv_pmos L=0.13u W=0.42u AS=0.1523p AD=0.1428p
+ PS=1.38u PD=1.52u rfmode=0
M$1893 \$364 \$326 VDD VDD sg13_lv_pmos L=0.5u W=1u AS=0.34p AD=0.1523p
+ PS=2.68u PD=1.38u rfmode=0
M$1894 VDD \$367 \$328 VDD sg13_lv_pmos L=0.13u W=0.42u AS=0.1523p AD=0.1428p
+ PS=1.38u PD=1.52u rfmode=0
M$1895 VDD \$328 \$329 VDD sg13_lv_pmos L=0.5u W=1u AS=0.1523p AD=0.34p
+ PS=1.38u PD=2.68u rfmode=0
M$1896 VDD \$330 \$331 VDD sg13_lv_pmos L=0.13u W=0.42u AS=0.1428p AD=0.0798p
+ PS=1.52u PD=0.8u rfmode=0
M$1897 VDD \$370 \$331 VDD sg13_lv_pmos L=0.13u W=0.42u AS=0.3623875p
+ AD=0.0798p PS=2.605u PD=0.8u rfmode=0
M$1898 VDD \$369 \$333 VDD sg13_lv_pmos L=0.13u W=1u AS=0.3623875p AD=0.34p
+ PS=2.605u PD=2.68u rfmode=0
M$1899 \$372 \$390 \$392 VDD sg13_lv_pmos L=0.13u W=0.42u AS=0.2048p
+ AD=0.09345p PS=1.63u PD=0.865u rfmode=0
M$1900 \$392 \$336 VDD VDD sg13_lv_pmos L=0.13u W=0.42u AS=0.09345p AD=0.204p
+ PS=0.865u PD=1.835u rfmode=0
M$1901 VDD \$370 \$336 VDD sg13_lv_pmos L=0.13u W=0.42u AS=0.204p AD=0.0798p
+ PS=1.835u PD=0.8u rfmode=0
M$1902 \$336 \$372 VDD VDD sg13_lv_pmos L=0.13u W=0.42u AS=0.0798p AD=0.4659p
+ PS=0.8u PD=3.65u rfmode=0
M$1903 \$333 \$334 \$372 VDD sg13_lv_pmos L=0.13u W=1u AS=0.34p AD=0.2048p
+ PS=2.68u PD=1.63u rfmode=0
M$1904 VDD \$569 \$401 VDD sg13_lv_pmos L=0.15u W=1.12u AS=0.3808p AD=0.2128p
+ PS=2.92u PD=1.5u rfmode=0
M$1905 \$401 \$444 \$340 VDD sg13_lv_pmos L=0.15u W=1.12u AS=0.2128p AD=0.2128p
+ PS=1.5u PD=1.5u rfmode=0
M$1906 \$340 \$391 VDD VDD sg13_lv_pmos L=0.15u W=1.12u AS=0.2128p AD=0.3808p
+ PS=1.5u PD=2.92u rfmode=0
M$1907 VDD \$631 \$370 VDD sg13_lv_pmos L=0.13u W=1.12u AS=0.3808p AD=0.3808p
+ PS=2.92u PD=2.92u rfmode=0
M$1919 VDD \$342 \$344 VDD sg13_lv_pmos L=0.13u W=1.12u AS=0.3808p AD=0.3808p
+ PS=2.92u PD=2.92u rfmode=0
M$1935 VDD \$408 \$409 VDD sg13_lv_pmos L=0.13u W=0.84u AS=0.2114p AD=0.2856p
+ PS=1.54u PD=2.36u rfmode=0
M$1936 \$41 \$409 VDD VDD sg13_lv_pmos L=0.13u W=1.12u AS=0.42p AD=0.2114p
+ PS=2.99u PD=1.54u rfmode=0
M$1949 \$410 \$411 VDD VDD sg13_lv_pmos L=0.13u W=1.12u AS=0.3808p AD=0.3808p
+ PS=2.92u PD=2.92u rfmode=0
M$1950 VDD \$602 \$412 VDD sg13_lv_pmos L=0.13u W=0.84u AS=0.2114p AD=0.2856p
+ PS=1.54u PD=2.36u rfmode=0
M$1951 \$387 \$412 VDD VDD sg13_lv_pmos L=0.13u W=1.12u AS=0.42p AD=0.2114p
+ PS=2.99u PD=1.54u rfmode=0
M$1952 VDD \$315 \$413 VDD sg13_lv_pmos L=0.13u W=0.42u AS=0.1428p AD=0.0798p
+ PS=1.52u PD=0.8u rfmode=0
M$1953 VDD \$410 \$413 VDD sg13_lv_pmos L=0.13u W=0.42u AS=0.3623875p
+ AD=0.0798p PS=2.605u PD=0.8u rfmode=0
M$1954 VDD \$415 \$414 VDD sg13_lv_pmos L=0.13u W=1u AS=0.3623875p AD=0.34p
+ PS=2.605u PD=2.68u rfmode=0
M$1955 VDD \$410 \$415 VDD sg13_lv_pmos L=0.13u W=0.42u AS=0.1563p AD=0.147p
+ PS=1.22u PD=1.54u rfmode=0
M$1956 VDD \$414 \$481 VDD sg13_lv_pmos L=0.13u W=0.42u AS=0.1563p AD=0.063p
+ PS=1.22u PD=0.72u rfmode=0
M$1957 \$481 \$417 \$415 VDD sg13_lv_pmos L=0.13u W=0.42u AS=0.063p AD=0.0798p
+ PS=0.72u PD=0.8u rfmode=0
M$1958 \$415 \$416 \$413 VDD sg13_lv_pmos L=0.13u W=0.42u AS=0.0798p AD=0.1428p
+ PS=0.8u PD=1.52u rfmode=0
M$1959 VDD \$417 \$416 VDD sg13_lv_pmos L=0.13u W=1.12u AS=0.41165p AD=0.3864p
+ PS=2.12u PD=2.93u rfmode=0
M$1960 VDD \$498 \$417 VDD sg13_lv_pmos L=0.13u W=1.12u AS=0.41165p AD=0.4088p
+ PS=2.12u PD=2.97u rfmode=0
M$1961 \$414 \$417 \$418 VDD sg13_lv_pmos L=0.13u W=1u AS=0.34p AD=0.2048p
+ PS=2.68u PD=1.63u rfmode=0
M$1962 \$418 \$416 \$482 VDD sg13_lv_pmos L=0.13u W=0.42u AS=0.2048p
+ AD=0.09345p PS=1.63u PD=0.865u rfmode=0
M$1963 VDD \$419 \$482 VDD sg13_lv_pmos L=0.13u W=0.42u AS=0.204p AD=0.09345p
+ PS=1.835u PD=0.865u rfmode=0
M$1964 VDD \$410 \$419 VDD sg13_lv_pmos L=0.13u W=0.42u AS=0.204p AD=0.0798p
+ PS=1.835u PD=0.8u rfmode=0
M$1965 VDD \$418 \$419 VDD sg13_lv_pmos L=0.13u W=0.42u AS=0.4659p AD=0.0798p
+ PS=3.65u PD=0.8u rfmode=0
M$1966 \$420 \$418 VDD VDD sg13_lv_pmos L=0.13u W=1.12u AS=0.3864p AD=0.2128p
+ PS=2.93u PD=1.5u rfmode=0
M$1967 VDD \$420 \$352 VDD sg13_lv_pmos L=0.13u W=1.12u AS=0.2128p AD=0.3808p
+ PS=1.5u PD=2.92u rfmode=0
M$1968 VDD \$421 \$422 VDD sg13_lv_pmos L=0.13u W=0.84u AS=0.2114p AD=0.2856p
+ PS=1.54u PD=2.36u rfmode=0
M$1969 \$411 \$422 VDD VDD sg13_lv_pmos L=0.13u W=1.12u AS=0.42p AD=0.2114p
+ PS=2.99u PD=1.54u rfmode=0
M$1970 VDD \$320 \$423 VDD sg13_lv_pmos L=0.13u W=0.42u AS=0.1428p AD=0.0798p
+ PS=1.52u PD=0.8u rfmode=0
M$1971 VDD \$426 \$423 VDD sg13_lv_pmos L=0.13u W=0.42u AS=0.3623875p
+ AD=0.0798p PS=2.605u PD=0.8u rfmode=0
M$1972 VDD \$425 \$424 VDD sg13_lv_pmos L=0.13u W=1u AS=0.3623875p AD=0.34p
+ PS=2.605u PD=2.68u rfmode=0
M$1973 VDD \$426 \$425 VDD sg13_lv_pmos L=0.13u W=0.42u AS=0.1563p AD=0.147p
+ PS=1.22u PD=1.54u rfmode=0
M$1974 VDD \$424 \$483 VDD sg13_lv_pmos L=0.13u W=0.42u AS=0.1563p AD=0.063p
+ PS=1.22u PD=0.72u rfmode=0
M$1975 \$483 \$428 \$425 VDD sg13_lv_pmos L=0.13u W=0.42u AS=0.063p AD=0.0798p
+ PS=0.72u PD=0.8u rfmode=0
M$1976 \$425 \$427 \$423 VDD sg13_lv_pmos L=0.13u W=0.42u AS=0.0798p AD=0.1428p
+ PS=0.8u PD=1.52u rfmode=0
M$1977 VDD \$428 \$427 VDD sg13_lv_pmos L=0.13u W=1.12u AS=0.41165p AD=0.3864p
+ PS=2.12u PD=2.93u rfmode=0
M$1978 VDD \$500 \$428 VDD sg13_lv_pmos L=0.13u W=1.12u AS=0.41165p AD=0.4088p
+ PS=2.12u PD=2.97u rfmode=0
M$1979 \$424 \$428 \$429 VDD sg13_lv_pmos L=0.13u W=1u AS=0.34p AD=0.2048p
+ PS=2.68u PD=1.63u rfmode=0
M$1980 \$429 \$427 \$484 VDD sg13_lv_pmos L=0.13u W=0.42u AS=0.2048p
+ AD=0.09345p PS=1.63u PD=0.865u rfmode=0
M$1981 VDD \$430 \$484 VDD sg13_lv_pmos L=0.13u W=0.42u AS=0.204p AD=0.09345p
+ PS=1.835u PD=0.865u rfmode=0
M$1982 VDD \$426 \$430 VDD sg13_lv_pmos L=0.13u W=0.42u AS=0.204p AD=0.0798p
+ PS=1.835u PD=0.8u rfmode=0
M$1983 VDD \$429 \$430 VDD sg13_lv_pmos L=0.13u W=0.42u AS=0.4659p AD=0.0798p
+ PS=3.65u PD=0.8u rfmode=0
M$1984 \$431 \$429 VDD VDD sg13_lv_pmos L=0.13u W=1.12u AS=0.3864p AD=0.2128p
+ PS=2.93u PD=1.5u rfmode=0
M$1985 VDD \$431 \$360 VDD sg13_lv_pmos L=0.13u W=1.12u AS=0.2128p AD=0.3808p
+ PS=1.5u PD=2.92u rfmode=0
M$1986 VDD \$324 \$432 VDD sg13_lv_pmos L=0.13u W=0.42u AS=0.1428p AD=0.0798p
+ PS=1.52u PD=0.8u rfmode=0
M$1987 VDD \$435 \$432 VDD sg13_lv_pmos L=0.13u W=0.42u AS=0.3623875p
+ AD=0.0798p PS=2.605u PD=0.8u rfmode=0
M$1988 VDD \$434 \$433 VDD sg13_lv_pmos L=0.13u W=1u AS=0.3623875p AD=0.34p
+ PS=2.605u PD=2.68u rfmode=0
M$1989 VDD \$435 \$434 VDD sg13_lv_pmos L=0.13u W=0.42u AS=0.1563p AD=0.147p
+ PS=1.22u PD=1.54u rfmode=0
M$1990 VDD \$433 \$485 VDD sg13_lv_pmos L=0.13u W=0.42u AS=0.1563p AD=0.063p
+ PS=1.22u PD=0.72u rfmode=0
M$1991 \$485 \$437 \$434 VDD sg13_lv_pmos L=0.13u W=0.42u AS=0.063p AD=0.0798p
+ PS=0.72u PD=0.8u rfmode=0
M$1992 \$434 \$436 \$432 VDD sg13_lv_pmos L=0.13u W=0.42u AS=0.0798p AD=0.1428p
+ PS=0.8u PD=1.52u rfmode=0
M$1993 VDD \$437 \$436 VDD sg13_lv_pmos L=0.13u W=1.12u AS=0.41165p AD=0.3864p
+ PS=2.12u PD=2.93u rfmode=0
M$1994 VDD \$500 \$437 VDD sg13_lv_pmos L=0.13u W=1.12u AS=0.41165p AD=0.4088p
+ PS=2.12u PD=2.97u rfmode=0
M$1995 \$433 \$437 \$438 VDD sg13_lv_pmos L=0.13u W=1u AS=0.34p AD=0.2048p
+ PS=2.68u PD=1.63u rfmode=0
M$1996 \$438 \$436 \$486 VDD sg13_lv_pmos L=0.13u W=0.42u AS=0.2048p
+ AD=0.09345p PS=1.63u PD=0.865u rfmode=0
M$1997 VDD \$439 \$486 VDD sg13_lv_pmos L=0.13u W=0.42u AS=0.204p AD=0.09345p
+ PS=1.835u PD=0.865u rfmode=0
M$1998 VDD \$435 \$439 VDD sg13_lv_pmos L=0.13u W=0.42u AS=0.204p AD=0.0798p
+ PS=1.835u PD=0.8u rfmode=0
M$1999 VDD \$438 \$439 VDD sg13_lv_pmos L=0.13u W=0.42u AS=0.4659p AD=0.0798p
+ PS=3.65u PD=0.8u rfmode=0
M$2000 \$440 \$438 VDD VDD sg13_lv_pmos L=0.13u W=1.12u AS=0.3864p AD=0.2128p
+ PS=2.93u PD=1.5u rfmode=0
M$2001 VDD \$440 \$365 VDD sg13_lv_pmos L=0.13u W=1.12u AS=0.2128p AD=0.3808p
+ PS=1.5u PD=2.92u rfmode=0
M$2002 VDD \$502 \$441 VDD sg13_lv_pmos L=0.13u W=0.42u AS=0.1523p AD=0.1428p
+ PS=1.38u PD=1.52u rfmode=0
M$2003 VDD \$441 \$442 VDD sg13_lv_pmos L=0.5u W=1u AS=0.1523p AD=0.34p
+ PS=1.38u PD=2.68u rfmode=0
M$2004 VDD \$442 \$443 VDD sg13_lv_pmos L=0.5u W=1u AS=0.2254p AD=0.34p
+ PS=1.53u PD=2.68u rfmode=0
M$2005 VDD \$443 \$444 VDD sg13_lv_pmos L=0.13u W=1.12u AS=0.2254p AD=0.4256p
+ PS=1.53u PD=3u rfmode=0
M$2006 \$445 \$330 \$487 VDD sg13_lv_pmos L=0.13u W=1.12u AS=0.3808p AD=0.1176p
+ PS=2.92u PD=1.33u rfmode=0
M$2007 \$487 \$446 VDD VDD sg13_lv_pmos L=0.13u W=1.12u AS=0.1176p AD=0.2618p
+ PS=1.33u PD=1.63u rfmode=0
M$2008 VDD \$340 \$446 VDD sg13_lv_pmos L=0.13u W=0.84u AS=0.2618p AD=0.2856p
+ PS=1.63u PD=2.36u rfmode=0
M$2009 \$369 \$370 VDD VDD sg13_lv_pmos L=0.13u W=0.42u AS=0.147p AD=0.1563p
+ PS=1.54u PD=1.22u rfmode=0
M$2010 VDD \$333 \$404 VDD sg13_lv_pmos L=0.13u W=0.42u AS=0.1563p AD=0.063p
+ PS=1.22u PD=0.72u rfmode=0
M$2011 \$404 \$334 \$369 VDD sg13_lv_pmos L=0.13u W=0.42u AS=0.063p AD=0.0798p
+ PS=0.72u PD=0.8u rfmode=0
M$2012 \$369 \$390 \$331 VDD sg13_lv_pmos L=0.13u W=0.42u AS=0.0798p AD=0.1428p
+ PS=0.8u PD=1.52u rfmode=0
M$2013 VDD \$504 \$447 VDD sg13_lv_pmos L=0.13u W=0.42u AS=0.1428p AD=0.0798p
+ PS=1.52u PD=0.8u rfmode=0
M$2014 VDD \$503 \$447 VDD sg13_lv_pmos L=0.13u W=0.42u AS=0.3623875p
+ AD=0.0798p PS=2.605u PD=0.8u rfmode=0
M$2015 VDD \$449 \$448 VDD sg13_lv_pmos L=0.13u W=1u AS=0.3623875p AD=0.34p
+ PS=2.605u PD=2.68u rfmode=0
M$2016 VDD \$503 \$449 VDD sg13_lv_pmos L=0.13u W=0.42u AS=0.1563p AD=0.147p
+ PS=1.22u PD=1.54u rfmode=0
M$2017 VDD \$448 \$488 VDD sg13_lv_pmos L=0.13u W=0.42u AS=0.1563p AD=0.063p
+ PS=1.22u PD=0.72u rfmode=0
M$2018 \$488 \$451 \$449 VDD sg13_lv_pmos L=0.13u W=0.42u AS=0.063p AD=0.0798p
+ PS=0.72u PD=0.8u rfmode=0
M$2019 \$449 \$450 \$447 VDD sg13_lv_pmos L=0.13u W=0.42u AS=0.0798p AD=0.1428p
+ PS=0.8u PD=1.52u rfmode=0
M$2020 VDD \$451 \$450 VDD sg13_lv_pmos L=0.13u W=1.12u AS=0.41165p AD=0.3864p
+ PS=2.12u PD=2.93u rfmode=0
M$2021 VDD \$371 \$451 VDD sg13_lv_pmos L=0.13u W=1.12u AS=0.41165p AD=0.4088p
+ PS=2.12u PD=2.97u rfmode=0
M$2022 \$448 \$451 \$452 VDD sg13_lv_pmos L=0.13u W=1u AS=0.34p AD=0.2048p
+ PS=2.68u PD=1.63u rfmode=0
M$2023 \$452 \$450 \$489 VDD sg13_lv_pmos L=0.13u W=0.42u AS=0.2048p
+ AD=0.09345p PS=1.63u PD=0.865u rfmode=0
M$2024 VDD \$453 \$489 VDD sg13_lv_pmos L=0.13u W=0.42u AS=0.204p AD=0.09345p
+ PS=1.835u PD=0.865u rfmode=0
M$2025 VDD \$503 \$453 VDD sg13_lv_pmos L=0.13u W=0.42u AS=0.204p AD=0.0798p
+ PS=1.835u PD=0.8u rfmode=0
M$2026 VDD \$452 \$453 VDD sg13_lv_pmos L=0.13u W=0.42u AS=0.4659p AD=0.0798p
+ PS=3.65u PD=0.8u rfmode=0
M$2027 \$454 \$452 VDD VDD sg13_lv_pmos L=0.13u W=1.12u AS=0.3864p AD=0.2128p
+ PS=2.93u PD=1.5u rfmode=0
M$2028 VDD \$454 \$455 VDD sg13_lv_pmos L=0.13u W=1.12u AS=0.2128p AD=0.3808p
+ PS=1.5u PD=2.92u rfmode=0
M$2029 \$456 \$350 \$491 VDD sg13_lv_pmos L=0.13u W=1.12u AS=0.3808p AD=0.1176p
+ PS=2.92u PD=1.33u rfmode=0
M$2030 \$491 \$467 VDD VDD sg13_lv_pmos L=0.13u W=1.12u AS=0.1176p AD=0.4032p
+ PS=1.33u PD=2.96u rfmode=0
M$2031 \$457 \$456 \$458 VDD sg13_lv_pmos L=0.13u W=1.12u AS=0.3808p AD=0.2128p
+ PS=2.92u PD=1.5u rfmode=0
M$2032 \$458 \$350 VDD VDD sg13_lv_pmos L=0.13u W=1.12u AS=0.2128p AD=0.2128p
+ PS=1.5u PD=1.5u rfmode=0
M$2033 VDD \$351 \$458 VDD sg13_lv_pmos L=0.13u W=1.12u AS=0.2128p AD=0.3808p
+ PS=1.5u PD=2.92u rfmode=0
M$2034 VDD \$457 \$459 VDD sg13_lv_pmos L=0.13u W=0.42u AS=0.1428p AD=0.0798p
+ PS=1.52u PD=0.8u rfmode=0
M$2035 VDD \$506 \$459 VDD sg13_lv_pmos L=0.13u W=0.42u AS=0.3623875p
+ AD=0.0798p PS=2.605u PD=0.8u rfmode=0
M$2036 VDD \$461 \$460 VDD sg13_lv_pmos L=0.13u W=1u AS=0.3623875p AD=0.34p
+ PS=2.605u PD=2.68u rfmode=0
M$2037 VDD \$506 \$461 VDD sg13_lv_pmos L=0.13u W=0.42u AS=0.1563p AD=0.147p
+ PS=1.22u PD=1.54u rfmode=0
M$2038 VDD \$460 \$492 VDD sg13_lv_pmos L=0.13u W=0.42u AS=0.1563p AD=0.063p
+ PS=1.22u PD=0.72u rfmode=0
M$2039 \$492 \$463 \$461 VDD sg13_lv_pmos L=0.13u W=0.42u AS=0.063p AD=0.0798p
+ PS=0.72u PD=0.8u rfmode=0
M$2040 \$461 \$462 \$459 VDD sg13_lv_pmos L=0.13u W=0.42u AS=0.0798p AD=0.1428p
+ PS=0.8u PD=1.52u rfmode=0
M$2041 VDD \$463 \$462 VDD sg13_lv_pmos L=0.13u W=1.12u AS=0.41165p AD=0.3864p
+ PS=2.12u PD=2.93u rfmode=0
M$2042 VDD \$508 \$463 VDD sg13_lv_pmos L=0.13u W=1.12u AS=0.41165p AD=0.4088p
+ PS=2.12u PD=2.97u rfmode=0
M$2043 \$460 \$463 \$464 VDD sg13_lv_pmos L=0.13u W=1u AS=0.34p AD=0.2048p
+ PS=2.68u PD=1.63u rfmode=0
M$2044 \$464 \$462 \$494 VDD sg13_lv_pmos L=0.13u W=0.42u AS=0.2048p
+ AD=0.09345p PS=1.63u PD=0.865u rfmode=0
M$2045 VDD \$465 \$494 VDD sg13_lv_pmos L=0.13u W=0.42u AS=0.204p AD=0.09345p
+ PS=1.835u PD=0.865u rfmode=0
M$2046 VDD \$506 \$465 VDD sg13_lv_pmos L=0.13u W=0.42u AS=0.204p AD=0.0798p
+ PS=1.835u PD=0.8u rfmode=0
M$2047 VDD \$464 \$465 VDD sg13_lv_pmos L=0.13u W=0.42u AS=0.4659p AD=0.0798p
+ PS=3.65u PD=0.8u rfmode=0
M$2048 \$466 \$464 VDD VDD sg13_lv_pmos L=0.13u W=1.12u AS=0.3864p AD=0.2128p
+ PS=2.93u PD=1.5u rfmode=0
M$2049 VDD \$466 \$467 VDD sg13_lv_pmos L=0.13u W=1.12u AS=0.2128p AD=0.3808p
+ PS=1.5u PD=2.92u rfmode=0
M$2052 VDD \$926 \$468 VDD sg13_lv_pmos L=0.13u W=0.84u AS=0.253p AD=0.2856p
+ PS=1.53u PD=2.36u rfmode=0
M$2053 VDD \$926 \$495 VDD sg13_lv_pmos L=0.13u W=1u AS=0.253p AD=0.3325p
+ PS=1.53u PD=1.665u rfmode=0
M$2054 \$495 \$479 \$469 VDD sg13_lv_pmos L=0.13u W=1u AS=0.3325p AD=0.2225p
+ PS=1.665u PD=1.445u rfmode=0
M$2055 \$469 \$621 \$496 VDD sg13_lv_pmos L=0.13u W=1u AS=0.2225p AD=0.2975p
+ PS=1.445u PD=1.595u rfmode=0
M$2056 VDD \$468 \$496 VDD sg13_lv_pmos L=0.13u W=1u AS=0.2198p AD=0.2975p
+ PS=1.52u PD=1.595u rfmode=0
M$2057 VDD \$469 \$470 VDD sg13_lv_pmos L=0.13u W=1.12u AS=0.2198p AD=0.6048p
+ PS=1.52u PD=3.32u rfmode=0
M$2058 VDD \$470 \$471 VDD sg13_lv_pmos L=0.13u W=0.42u AS=0.1428p AD=0.0798p
+ PS=1.52u PD=0.8u rfmode=0
M$2059 VDD \$344 \$471 VDD sg13_lv_pmos L=0.13u W=0.42u AS=0.3623875p
+ AD=0.0798p PS=2.605u PD=0.8u rfmode=0
M$2060 VDD \$473 \$472 VDD sg13_lv_pmos L=0.13u W=1u AS=0.3623875p AD=0.34p
+ PS=2.605u PD=2.68u rfmode=0
M$2061 VDD \$344 \$473 VDD sg13_lv_pmos L=0.13u W=0.42u AS=0.1563p AD=0.147p
+ PS=1.22u PD=1.54u rfmode=0
M$2062 VDD \$472 \$493 VDD sg13_lv_pmos L=0.13u W=0.42u AS=0.1563p AD=0.063p
+ PS=1.22u PD=0.72u rfmode=0
M$2063 \$493 \$475 \$473 VDD sg13_lv_pmos L=0.13u W=0.42u AS=0.063p AD=0.0798p
+ PS=0.72u PD=0.8u rfmode=0
M$2064 \$473 \$474 \$471 VDD sg13_lv_pmos L=0.13u W=0.42u AS=0.0798p AD=0.1428p
+ PS=0.8u PD=1.52u rfmode=0
M$2065 VDD \$475 \$474 VDD sg13_lv_pmos L=0.13u W=1.12u AS=0.41165p AD=0.3864p
+ PS=2.12u PD=2.93u rfmode=0
M$2066 VDD \$508 \$475 VDD sg13_lv_pmos L=0.13u W=1.12u AS=0.41165p AD=0.4088p
+ PS=2.12u PD=2.97u rfmode=0
M$2067 \$472 \$475 \$476 VDD sg13_lv_pmos L=0.13u W=1u AS=0.34p AD=0.2048p
+ PS=2.68u PD=1.63u rfmode=0
M$2068 \$476 \$474 \$490 VDD sg13_lv_pmos L=0.13u W=0.42u AS=0.2048p
+ AD=0.09345p PS=1.63u PD=0.865u rfmode=0
M$2069 VDD \$477 \$490 VDD sg13_lv_pmos L=0.13u W=0.42u AS=0.204p AD=0.09345p
+ PS=1.835u PD=0.865u rfmode=0
M$2070 VDD \$344 \$477 VDD sg13_lv_pmos L=0.13u W=0.42u AS=0.204p AD=0.0798p
+ PS=1.835u PD=0.8u rfmode=0
M$2071 VDD \$476 \$477 VDD sg13_lv_pmos L=0.13u W=0.42u AS=0.4659p AD=0.0798p
+ PS=3.65u PD=0.8u rfmode=0
M$2072 \$478 \$476 VDD VDD sg13_lv_pmos L=0.13u W=1.12u AS=0.3864p AD=0.2128p
+ PS=2.93u PD=1.5u rfmode=0
M$2073 VDD \$478 \$479 VDD sg13_lv_pmos L=0.13u W=1.12u AS=0.2128p AD=0.3808p
+ PS=1.5u PD=2.92u rfmode=0
M$2085 \$480 \$479 VDD VDD sg13_lv_pmos L=0.13u W=0.84u AS=0.2856p AD=0.2114p
+ PS=2.36u PD=1.54u rfmode=0
M$2086 VDD \$480 \$42 VDD sg13_lv_pmos L=0.13u W=1.12u AS=0.2114p AD=0.42p
+ PS=1.54u PD=2.99u rfmode=0
M$2101 VDD \$411 \$542 VDD sg13_lv_pmos L=0.13u W=1.12u AS=0.3808p AD=0.3808p
+ PS=2.92u PD=2.92u rfmode=0
M$2102 VDD \$544 \$543 VDD sg13_lv_pmos L=0.13u W=0.42u AS=0.1428p AD=0.0798p
+ PS=1.52u PD=0.8u rfmode=0
M$2103 VDD \$542 \$543 VDD sg13_lv_pmos L=0.13u W=0.42u AS=0.3623875p
+ AD=0.0798p PS=2.605u PD=0.8u rfmode=0
M$2104 VDD \$583 \$545 VDD sg13_lv_pmos L=0.13u W=1u AS=0.3623875p AD=0.34p
+ PS=2.605u PD=2.68u rfmode=0
M$2105 \$584 \$547 VDD VDD sg13_lv_pmos L=0.13u W=1.12u AS=0.3864p AD=0.41165p
+ PS=2.93u PD=2.12u rfmode=0
M$2106 VDD \$498 \$547 VDD sg13_lv_pmos L=0.13u W=1.12u AS=0.41165p AD=0.4088p
+ PS=2.12u PD=2.97u rfmode=0
M$2107 \$549 \$584 \$588 VDD sg13_lv_pmos L=0.13u W=0.42u AS=0.2048p
+ AD=0.09345p PS=1.63u PD=0.865u rfmode=0
M$2108 \$588 \$550 VDD VDD sg13_lv_pmos L=0.13u W=0.42u AS=0.09345p AD=0.204p
+ PS=0.865u PD=1.835u rfmode=0
M$2109 VDD \$542 \$550 VDD sg13_lv_pmos L=0.13u W=0.42u AS=0.204p AD=0.0798p
+ PS=1.835u PD=0.8u rfmode=0
M$2110 \$550 \$549 VDD VDD sg13_lv_pmos L=0.13u W=0.42u AS=0.0798p AD=0.4659p
+ PS=0.8u PD=3.65u rfmode=0
M$2111 \$545 \$547 \$549 VDD sg13_lv_pmos L=0.13u W=1u AS=0.34p AD=0.2048p
+ PS=2.68u PD=1.63u rfmode=0
M$2112 \$551 \$549 VDD VDD sg13_lv_pmos L=0.13u W=1.12u AS=0.3864p AD=0.2128p
+ PS=2.93u PD=1.5u rfmode=0
M$2113 VDD \$551 \$408 VDD sg13_lv_pmos L=0.13u W=1.12u AS=0.2128p AD=0.3808p
+ PS=1.5u PD=2.92u rfmode=0
M$2114 VDD En \$552 VDD sg13_lv_pmos L=0.13u W=0.84u AS=0.2114p AD=0.2856p
+ PS=1.54u PD=2.36u rfmode=0
M$2115 VDD \$552 \$354 VDD sg13_lv_pmos L=0.13u W=1.12u AS=0.2114p AD=0.42p
+ PS=1.54u PD=2.99u rfmode=0
M$2116 \$498 \$553 VDD VDD sg13_lv_pmos L=0.13u W=1.12u AS=0.42p AD=0.2114p
+ PS=2.99u PD=1.54u rfmode=0
M$2117 VDD \$741 \$553 VDD sg13_lv_pmos L=0.13u W=0.84u AS=0.2114p AD=0.2856p
+ PS=1.54u PD=2.36u rfmode=0
M$2118 \$426 \$411 VDD VDD sg13_lv_pmos L=0.13u W=1.12u AS=0.3808p AD=0.3808p
+ PS=2.92u PD=2.92u rfmode=0
M$2119 VDD \$555 \$554 VDD sg13_lv_pmos L=0.13u W=0.42u AS=0.1428p AD=0.0798p
+ PS=1.52u PD=0.8u rfmode=0
M$2120 VDD \$585 \$554 VDD sg13_lv_pmos L=0.13u W=0.42u AS=0.3623875p
+ AD=0.0798p PS=2.605u PD=0.8u rfmode=0
M$2121 VDD \$586 \$556 VDD sg13_lv_pmos L=0.13u W=1u AS=0.3623875p AD=0.34p
+ PS=2.605u PD=2.68u rfmode=0
M$2122 \$587 \$558 VDD VDD sg13_lv_pmos L=0.13u W=1.12u AS=0.3864p AD=0.41165p
+ PS=2.93u PD=2.12u rfmode=0
M$2123 VDD \$500 \$558 VDD sg13_lv_pmos L=0.13u W=1.12u AS=0.41165p AD=0.4088p
+ PS=2.12u PD=2.97u rfmode=0
M$2124 \$560 \$587 \$589 VDD sg13_lv_pmos L=0.13u W=0.42u AS=0.2048p
+ AD=0.09345p PS=1.63u PD=0.865u rfmode=0
M$2125 \$589 \$561 VDD VDD sg13_lv_pmos L=0.13u W=0.42u AS=0.09345p AD=0.204p
+ PS=0.865u PD=1.835u rfmode=0
M$2126 VDD \$585 \$561 VDD sg13_lv_pmos L=0.13u W=0.42u AS=0.204p AD=0.0798p
+ PS=1.835u PD=0.8u rfmode=0
M$2127 \$561 \$560 VDD VDD sg13_lv_pmos L=0.13u W=0.42u AS=0.0798p AD=0.4659p
+ PS=0.8u PD=3.65u rfmode=0
M$2128 \$556 \$558 \$560 VDD sg13_lv_pmos L=0.13u W=1u AS=0.34p AD=0.2048p
+ PS=2.68u PD=1.63u rfmode=0
M$2129 \$562 \$560 VDD VDD sg13_lv_pmos L=0.13u W=1.12u AS=0.3864p AD=0.2128p
+ PS=2.93u PD=1.5u rfmode=0
M$2130 VDD \$562 \$563 VDD sg13_lv_pmos L=0.13u W=1.12u AS=0.2128p AD=0.3808p
+ PS=1.5u PD=2.92u rfmode=0
M$2131 VDD \$565 \$564 VDD sg13_lv_pmos L=0.5u W=1u AS=0.2254p AD=0.34p
+ PS=1.53u PD=2.68u rfmode=0
M$2132 \$353 \$564 VDD VDD sg13_lv_pmos L=0.13u W=1.12u AS=0.4256p AD=0.2254p
+ PS=3u PD=1.53u rfmode=0
M$2133 VDD \$563 \$566 VDD sg13_lv_pmos L=0.13u W=0.42u AS=0.1523p AD=0.1428p
+ PS=1.38u PD=1.52u rfmode=0
M$2134 \$565 \$566 VDD VDD sg13_lv_pmos L=0.5u W=1u AS=0.34p AD=0.1523p
+ PS=2.68u PD=1.38u rfmode=0
M$2135 VDD \$567 \$568 VDD sg13_lv_pmos L=0.13u W=17.92u AS=3.5896p AD=3.4048p
+ PS=25.45u PD=24u rfmode=0
M$2151 VDD \$677 \$567 VDD sg13_lv_pmos L=0.13u W=6.72u AS=1.2768p AD=1.4448p
+ PS=9u PD=10.42u rfmode=0
M$2157 VDD \$571 \$570 VDD sg13_lv_pmos L=0.5u W=1u AS=0.2254p AD=0.34p
+ PS=1.53u PD=2.68u rfmode=0
M$2158 \$569 \$570 VDD VDD sg13_lv_pmos L=0.13u W=1.12u AS=0.4256p AD=0.2254p
+ PS=3u PD=1.53u rfmode=0
M$2159 VDD \$455 \$572 VDD sg13_lv_pmos L=0.13u W=0.42u AS=0.1523p AD=0.1428p
+ PS=1.38u PD=1.52u rfmode=0
M$2160 \$571 \$572 VDD VDD sg13_lv_pmos L=0.5u W=1u AS=0.34p AD=0.1523p
+ PS=2.68u PD=1.38u rfmode=0
M$2161 VDD \$568 \$573 VDD sg13_lv_pmos L=0.13u W=6.72u AS=1.4448p AD=1.2768p
+ PS=10.42u PD=9u rfmode=0
M$2167 VDD \$573 \$371 VDD sg13_lv_pmos L=0.13u W=17.92u AS=3.4048p AD=3.5896p
+ PS=24u PD=25.45u rfmode=0
M$2183 VDD \$374 \$574 VDD sg13_lv_pmos L=0.13u W=0.84u AS=0.2198p AD=0.2856p
+ PS=1.53u PD=2.36u rfmode=0
M$2184 VDD \$574 \$351 VDD sg13_lv_pmos L=0.13u W=1.12u AS=0.3808p AD=0.2128p
+ PS=2.92u PD=1.5u rfmode=0
M$2185 \$351 \$312 VDD VDD sg13_lv_pmos L=0.13u W=1.12u AS=0.2128p AD=0.2198p
+ PS=1.5u PD=1.53u rfmode=0
M$2186 \$506 \$342 VDD VDD sg13_lv_pmos L=0.13u W=1.12u AS=0.3808p AD=0.3808p
+ PS=2.92u PD=2.92u rfmode=0
M$2200 \$508 \$575 VDD VDD sg13_lv_pmos L=0.13u W=1.12u AS=0.42p AD=0.2114p
+ PS=2.99u PD=1.54u rfmode=0
M$2201 VDD \$343 \$575 VDD sg13_lv_pmos L=0.13u W=0.84u AS=0.2114p AD=0.2856p
+ PS=1.54u PD=2.36u rfmode=0
M$2231 VDD \$316 \$601 VDD sg13_lv_pmos L=0.13u W=6.72u AS=1.4448p AD=1.2768p
+ PS=10.42u PD=9u rfmode=0
M$2237 VDD \$601 \$602 VDD sg13_lv_pmos L=0.13u W=17.92u AS=3.4048p AD=3.5896p
+ PS=24u PD=25.45u rfmode=0
M$2253 \$583 \$542 VDD VDD sg13_lv_pmos L=0.13u W=0.42u AS=0.147p AD=0.1563p
+ PS=1.54u PD=1.22u rfmode=0
M$2254 VDD \$545 \$593 VDD sg13_lv_pmos L=0.13u W=0.42u AS=0.1563p AD=0.063p
+ PS=1.22u PD=0.72u rfmode=0
M$2255 \$593 \$547 \$583 VDD sg13_lv_pmos L=0.13u W=0.42u AS=0.063p AD=0.0798p
+ PS=0.72u PD=0.8u rfmode=0
M$2256 \$583 \$584 \$543 VDD sg13_lv_pmos L=0.13u W=0.42u AS=0.0798p AD=0.1428p
+ PS=0.8u PD=1.52u rfmode=0
M$2257 \$603 \$630 VDD VDD sg13_lv_pmos L=0.13u W=1.12u AS=0.6048p AD=0.2198p
+ PS=3.32u PD=1.52u rfmode=0
M$2258 VDD \$604 \$624 VDD sg13_lv_pmos L=0.13u W=1u AS=0.2198p AD=0.2975p
+ PS=1.52u PD=1.595u rfmode=0
M$2259 \$624 \$351 \$630 VDD sg13_lv_pmos L=0.13u W=1u AS=0.2975p AD=0.2225p
+ PS=1.595u PD=1.445u rfmode=0
M$2260 \$630 \$712 \$625 VDD sg13_lv_pmos L=0.13u W=1u AS=0.2225p AD=0.3325p
+ PS=1.445u PD=1.665u rfmode=0
M$2261 \$625 \$605 VDD VDD sg13_lv_pmos L=0.13u W=1u AS=0.3325p AD=0.253p
+ PS=1.665u PD=1.53u rfmode=0
M$2262 VDD \$605 \$604 VDD sg13_lv_pmos L=0.13u W=0.84u AS=0.253p AD=0.2856p
+ PS=1.53u PD=2.36u rfmode=0
M$2264 VDD \$411 \$585 VDD sg13_lv_pmos L=0.13u W=1.12u AS=0.3808p AD=0.3808p
+ PS=2.92u PD=2.92u rfmode=0
M$2265 VDD \$606 \$500 VDD sg13_lv_pmos L=0.13u W=17.92u AS=3.5896p AD=3.4048p
+ PS=25.45u PD=24u rfmode=0
M$2281 VDD \$568 \$606 VDD sg13_lv_pmos L=0.13u W=6.72u AS=1.2768p AD=1.4448p
+ PS=9u PD=10.42u rfmode=0
M$2287 \$586 \$585 VDD VDD sg13_lv_pmos L=0.13u W=0.42u AS=0.147p AD=0.1563p
+ PS=1.54u PD=1.22u rfmode=0
M$2288 VDD \$556 \$599 VDD sg13_lv_pmos L=0.13u W=0.42u AS=0.1563p AD=0.063p
+ PS=1.22u PD=0.72u rfmode=0
M$2289 \$599 \$558 \$586 VDD sg13_lv_pmos L=0.13u W=0.42u AS=0.063p AD=0.0798p
+ PS=0.72u PD=0.8u rfmode=0
M$2290 \$586 \$587 \$554 VDD sg13_lv_pmos L=0.13u W=0.42u AS=0.0798p AD=0.1428p
+ PS=0.8u PD=1.52u rfmode=0
M$2291 VDD \$360 \$502 VDD sg13_lv_pmos L=0.13u W=1.12u AS=0.3808p AD=0.2128p
+ PS=2.92u PD=1.5u rfmode=0
M$2292 \$502 \$353 VDD VDD sg13_lv_pmos L=0.13u W=1.12u AS=0.2128p AD=0.2128p
+ PS=1.5u PD=1.5u rfmode=0
M$2293 VDD \$357 \$502 VDD sg13_lv_pmos L=0.13u W=1.12u AS=0.2128p AD=0.2128p
+ PS=1.5u PD=1.5u rfmode=0
M$2294 \$502 \$354 VDD VDD sg13_lv_pmos L=0.13u W=1.12u AS=0.2128p AD=0.3808p
+ PS=1.5u PD=2.92u rfmode=0
M$2295 VDD \$354 \$607 VDD sg13_lv_pmos L=0.13u W=1.12u AS=0.3808p AD=0.2128p
+ PS=2.92u PD=1.5u rfmode=0
M$2296 \$607 \$391 VDD VDD sg13_lv_pmos L=0.13u W=1.12u AS=0.2128p AD=0.3808p
+ PS=1.5u PD=2.92u rfmode=0
M$2297 \$367 \$502 \$626 VDD sg13_lv_pmos L=0.13u W=1.12u AS=0.3808p AD=0.2128p
+ PS=2.92u PD=1.5u rfmode=0
M$2298 \$626 \$391 \$627 VDD sg13_lv_pmos L=0.13u W=1.12u AS=0.2128p AD=0.2464p
+ PS=1.5u PD=1.56u rfmode=0
M$2299 \$627 \$569 VDD VDD sg13_lv_pmos L=0.13u W=1.12u AS=0.2464p AD=0.3808p
+ PS=1.56u PD=2.92u rfmode=0
M$2300 VDD \$668 \$608 VDD sg13_lv_pmos L=0.13u W=0.84u AS=0.2198p AD=0.2856p
+ PS=1.53u PD=2.36u rfmode=0
M$2301 VDD \$354 \$609 VDD sg13_lv_pmos L=0.13u W=1.12u AS=0.2198p AD=0.2128p
+ PS=1.53u PD=1.5u rfmode=0
M$2302 \$609 \$610 VDD VDD sg13_lv_pmos L=0.13u W=1.12u AS=0.2128p AD=0.2128p
+ PS=1.5u PD=1.5u rfmode=0
M$2303 VDD \$608 \$609 VDD sg13_lv_pmos L=0.13u W=1.12u AS=0.2128p AD=0.3808p
+ PS=1.5u PD=2.92u rfmode=0
M$2304 VDD \$569 \$611 VDD sg13_lv_pmos L=0.13u W=0.84u AS=0.2856p AD=0.1596p
+ PS=2.36u PD=1.22u rfmode=0
M$2305 \$611 \$444 VDD VDD sg13_lv_pmos L=0.13u W=0.84u AS=0.1596p AD=0.1918p
+ PS=1.22u PD=1.5u rfmode=0
M$2306 VDD \$611 \$504 VDD sg13_lv_pmos L=0.13u W=1.12u AS=0.1918p AD=0.3808p
+ PS=1.5u PD=2.92u rfmode=0
M$2307 VDD \$631 \$503 VDD sg13_lv_pmos L=0.13u W=1.12u AS=0.3808p AD=0.3808p
+ PS=2.92u PD=2.92u rfmode=0
M$2308 \$620 \$618 VDD VDD sg13_lv_pmos L=0.13u W=1.12u AS=0.3864p AD=0.2128p
+ PS=2.93u PD=1.5u rfmode=0
M$2309 VDD \$620 \$610 VDD sg13_lv_pmos L=0.13u W=1.12u AS=0.2128p AD=0.3808p
+ PS=1.5u PD=2.92u rfmode=0
M$2312 VDD \$621 \$622 VDD sg13_lv_pmos L=0.13u W=0.84u AS=0.2114p AD=0.2856p
+ PS=1.54u PD=2.36u rfmode=0
M$2313 \$687 \$622 VDD VDD sg13_lv_pmos L=0.13u W=1.12u AS=0.42p AD=0.2114p
+ PS=2.99u PD=1.54u rfmode=0
M$2314 VDD \$342 \$623 VDD sg13_lv_pmos L=0.13u W=1.12u AS=0.3808p AD=0.3808p
+ PS=2.92u PD=2.92u rfmode=0
M$2347 \$33 \$652 VDD VDD sg13_lv_pmos L=0.13u W=1.12u AS=0.42p AD=0.2114p
+ PS=2.99u PD=1.54u rfmode=0
M$2348 VDD \$712 \$652 VDD sg13_lv_pmos L=0.13u W=0.84u AS=0.2114p AD=0.2856p
+ PS=1.54u PD=2.36u rfmode=0
M$2363 VDD \$926 \$654 VDD sg13_lv_pmos L=0.13u W=0.84u AS=0.253p AD=0.2856p
+ PS=1.53u PD=2.36u rfmode=0
M$2364 VDD \$654 \$721 VDD sg13_lv_pmos L=0.13u W=1u AS=0.2198p AD=0.2975p
+ PS=1.52u PD=1.595u rfmode=0
M$2365 \$721 \$351 \$653 VDD sg13_lv_pmos L=0.13u W=1u AS=0.2975p AD=0.2225p
+ PS=1.595u PD=1.445u rfmode=0
M$2366 \$653 \$408 \$723 VDD sg13_lv_pmos L=0.13u W=1u AS=0.2225p AD=0.3325p
+ PS=1.445u PD=1.665u rfmode=0
M$2367 \$723 \$926 VDD VDD sg13_lv_pmos L=0.13u W=1u AS=0.3325p AD=0.253p
+ PS=1.665u PD=1.53u rfmode=0
M$2368 \$544 \$653 VDD VDD sg13_lv_pmos L=0.13u W=1.12u AS=0.6048p AD=0.2198p
+ PS=3.32u PD=1.52u rfmode=0
M$2370 VDD \$411 \$655 VDD sg13_lv_pmos L=0.13u W=1.12u AS=0.3808p AD=0.3808p
+ PS=2.92u PD=2.92u rfmode=0
M$2371 VDD \$603 \$656 VDD sg13_lv_pmos L=0.13u W=0.42u AS=0.1428p AD=0.0798p
+ PS=1.52u PD=0.8u rfmode=0
M$2372 VDD \$655 \$656 VDD sg13_lv_pmos L=0.13u W=0.42u AS=0.3623875p
+ AD=0.0798p PS=2.605u PD=0.8u rfmode=0
M$2373 VDD \$713 \$657 VDD sg13_lv_pmos L=0.13u W=1u AS=0.3623875p AD=0.34p
+ PS=2.605u PD=2.68u rfmode=0
M$2374 \$714 \$659 VDD VDD sg13_lv_pmos L=0.13u W=1.12u AS=0.3864p AD=0.41165p
+ PS=2.93u PD=2.12u rfmode=0
M$2375 VDD \$498 \$659 VDD sg13_lv_pmos L=0.13u W=1.12u AS=0.41165p AD=0.4088p
+ PS=2.12u PD=2.97u rfmode=0
M$2376 \$661 \$714 \$720 VDD sg13_lv_pmos L=0.13u W=0.42u AS=0.2048p
+ AD=0.09345p PS=1.63u PD=0.865u rfmode=0
M$2377 \$720 \$662 VDD VDD sg13_lv_pmos L=0.13u W=0.42u AS=0.09345p AD=0.204p
+ PS=0.865u PD=1.835u rfmode=0
M$2378 VDD \$655 \$662 VDD sg13_lv_pmos L=0.13u W=0.42u AS=0.204p AD=0.0798p
+ PS=1.835u PD=0.8u rfmode=0
M$2379 \$662 \$661 VDD VDD sg13_lv_pmos L=0.13u W=0.42u AS=0.0798p AD=0.4659p
+ PS=0.8u PD=3.65u rfmode=0
M$2380 \$657 \$659 \$661 VDD sg13_lv_pmos L=0.13u W=1u AS=0.34p AD=0.2048p
+ PS=2.68u PD=1.63u rfmode=0
M$2381 \$663 \$661 VDD VDD sg13_lv_pmos L=0.13u W=1.12u AS=0.3864p AD=0.2128p
+ PS=2.93u PD=1.5u rfmode=0
M$2382 VDD \$663 \$712 VDD sg13_lv_pmos L=0.13u W=1.12u AS=0.2128p AD=0.3808p
+ PS=1.5u PD=2.92u rfmode=0
M$2383 \$555 \$665 VDD VDD sg13_lv_pmos L=0.13u W=1.12u AS=0.3808p AD=0.1918p
+ PS=2.92u PD=1.5u rfmode=0
M$2384 VDD \$664 \$665 VDD sg13_lv_pmos L=0.13u W=0.84u AS=0.1918p AD=0.1596p
+ PS=1.5u PD=1.22u rfmode=0
M$2385 \$665 \$319 VDD VDD sg13_lv_pmos L=0.13u W=0.84u AS=0.1596p AD=0.2856p
+ PS=1.22u PD=2.36u rfmode=0
M$2386 \$664 \$666 VDD VDD sg13_lv_pmos L=0.13u W=1.12u AS=0.3808p AD=0.3808p
+ PS=2.92u PD=2.92u rfmode=0
M$2387 \$666 \$353 \$715 VDD sg13_lv_pmos L=0.13u W=1u AS=0.35p AD=0.2125p
+ PS=2.7u PD=1.425u rfmode=0
M$2388 \$715 \$354 VDD VDD sg13_lv_pmos L=0.13u W=1u AS=0.2125p AD=0.19p
+ PS=1.425u PD=1.38u rfmode=0
M$2389 VDD \$356 \$715 VDD sg13_lv_pmos L=0.13u W=1u AS=0.19p AD=0.34p PS=1.38u
+ PD=2.68u rfmode=0
M$2390 \$667 \$668 VDD VDD sg13_lv_pmos L=0.13u W=1.12u AS=0.3808p AD=0.3808p
+ PS=2.92u PD=2.92u rfmode=0
M$2391 \$669 \$670 VDD VDD sg13_lv_pmos L=0.13u W=1.12u AS=0.42p AD=0.2114p
+ PS=2.99u PD=1.54u rfmode=0
M$2392 VDD \$327 \$670 VDD sg13_lv_pmos L=0.13u W=0.84u AS=0.2114p AD=0.2856p
+ PS=1.54u PD=2.36u rfmode=0
M$2393 VDD \$669 \$671 VDD sg13_lv_pmos L=0.13u W=0.84u AS=0.2114p AD=0.2856p
+ PS=1.54u PD=2.36u rfmode=0
M$2394 VDD \$671 \$631 VDD sg13_lv_pmos L=0.13u W=1.12u AS=0.2114p AD=0.42p
+ PS=1.54u PD=2.99u rfmode=0
M$2395 \$673 \$672 VDD VDD sg13_lv_pmos L=0.13u W=1.12u AS=0.3808p AD=0.3808p
+ PS=2.92u PD=2.92u rfmode=0
M$2396 \$672 \$793 \$716 VDD sg13_lv_pmos L=0.13u W=1u AS=0.35p AD=0.2125p
+ PS=2.7u PD=1.425u rfmode=0
M$2397 \$716 \$668 VDD VDD sg13_lv_pmos L=0.13u W=1u AS=0.2125p AD=0.19p
+ PS=1.425u PD=1.38u rfmode=0
M$2398 VDD \$607 \$716 VDD sg13_lv_pmos L=0.13u W=1u AS=0.19p AD=0.34p PS=1.38u
+ PD=2.68u rfmode=0
M$2399 VDD \$391 \$729 VDD sg13_lv_pmos L=0.15u W=1.12u AS=0.3808p AD=0.2128p
+ PS=2.92u PD=1.5u rfmode=0
M$2400 \$729 \$667 \$675 VDD sg13_lv_pmos L=0.15u W=1.12u AS=0.2128p AD=0.2128p
+ PS=1.5u PD=1.5u rfmode=0
M$2401 \$675 \$354 VDD VDD sg13_lv_pmos L=0.15u W=1.12u AS=0.2128p AD=0.3808p
+ PS=1.5u PD=2.92u rfmode=0
M$2402 VDD fclk_in \$676 VDD sg13_lv_pmos L=0.13u W=6.72u AS=1.4448p AD=1.2768p
+ PS=10.42u PD=9u rfmode=0
M$2408 VDD \$676 \$677 VDD sg13_lv_pmos L=0.13u W=17.92u AS=3.4048p AD=3.5896p
+ PS=24u PD=25.45u rfmode=0
M$2424 VDD \$445 \$612 VDD sg13_lv_pmos L=0.13u W=0.42u AS=0.1428p AD=0.0798p
+ PS=1.52u PD=0.8u rfmode=0
M$2425 VDD \$615 \$612 VDD sg13_lv_pmos L=0.13u W=0.42u AS=0.3623875p
+ AD=0.0798p PS=2.605u PD=0.8u rfmode=0
M$2426 VDD \$613 \$614 VDD sg13_lv_pmos L=0.13u W=1u AS=0.3623875p AD=0.34p
+ PS=2.605u PD=2.68u rfmode=0
M$2427 VDD \$615 \$613 VDD sg13_lv_pmos L=0.13u W=0.42u AS=0.1563p AD=0.147p
+ PS=1.22u PD=1.54u rfmode=0
M$2428 VDD \$614 \$628 VDD sg13_lv_pmos L=0.13u W=0.42u AS=0.1563p AD=0.063p
+ PS=1.22u PD=0.72u rfmode=0
M$2429 \$628 \$617 \$613 VDD sg13_lv_pmos L=0.13u W=0.42u AS=0.063p AD=0.0798p
+ PS=0.72u PD=0.8u rfmode=0
M$2430 \$613 \$616 \$612 VDD sg13_lv_pmos L=0.13u W=0.42u AS=0.0798p AD=0.1428p
+ PS=0.8u PD=1.52u rfmode=0
M$2431 fdac_clk \$679 VDD VDD sg13_lv_pmos L=0.13u W=1.12u AS=0.42p AD=0.2114p
+ PS=2.99u PD=1.54u rfmode=0
M$2432 VDD \$338 \$679 VDD sg13_lv_pmos L=0.13u W=0.84u AS=0.2114p AD=0.2856p
+ PS=1.54u PD=2.36u rfmode=0
M$2433 VDD \$617 \$616 VDD sg13_lv_pmos L=0.13u W=1.12u AS=0.41165p AD=0.3864p
+ PS=2.12u PD=2.93u rfmode=0
M$2434 VDD \$371 \$617 VDD sg13_lv_pmos L=0.13u W=1.12u AS=0.41165p AD=0.4088p
+ PS=2.12u PD=2.97u rfmode=0
M$2435 VDD \$421 \$680 VDD sg13_lv_pmos L=0.13u W=1.12u AS=0.3808p AD=0.3808p
+ PS=2.92u PD=2.92u rfmode=0
M$2436 \$614 \$617 \$618 VDD sg13_lv_pmos L=0.13u W=1u AS=0.34p AD=0.2048p
+ PS=2.68u PD=1.63u rfmode=0
M$2437 \$618 \$616 \$629 VDD sg13_lv_pmos L=0.13u W=0.42u AS=0.2048p
+ AD=0.09345p PS=1.63u PD=0.865u rfmode=0
M$2438 VDD \$619 \$629 VDD sg13_lv_pmos L=0.13u W=0.42u AS=0.204p AD=0.09345p
+ PS=1.835u PD=0.865u rfmode=0
M$2439 VDD \$615 \$619 VDD sg13_lv_pmos L=0.13u W=0.42u AS=0.204p AD=0.0798p
+ PS=1.835u PD=0.8u rfmode=0
M$2440 VDD \$618 \$619 VDD sg13_lv_pmos L=0.13u W=0.42u AS=0.4659p AD=0.0798p
+ PS=3.65u PD=0.8u rfmode=0
M$2441 \$391 \$681 VDD VDD sg13_lv_pmos L=0.13u W=1.12u AS=0.3808p AD=0.3808p
+ PS=2.92u PD=2.92u rfmode=0
M$2442 VDD \$683 \$682 VDD sg13_lv_pmos L=0.5u W=1u AS=0.2254p AD=0.34p
+ PS=1.53u PD=2.68u rfmode=0
M$2443 \$681 \$682 VDD VDD sg13_lv_pmos L=0.13u W=1.12u AS=0.4256p AD=0.2254p
+ PS=3u PD=1.53u rfmode=0
M$2444 VDD \$610 \$684 VDD sg13_lv_pmos L=0.13u W=0.42u AS=0.1523p AD=0.1428p
+ PS=1.38u PD=1.52u rfmode=0
M$2445 \$683 \$684 VDD VDD sg13_lv_pmos L=0.5u W=1u AS=0.34p AD=0.1523p
+ PS=2.68u PD=1.38u rfmode=0
M$2446 \$685 \$605 VDD VDD sg13_lv_pmos L=0.13u W=0.84u AS=0.2856p AD=0.253p
+ PS=2.36u PD=1.53u rfmode=0
M$2447 VDD \$605 \$725 VDD sg13_lv_pmos L=0.13u W=1u AS=0.253p AD=0.3325p
+ PS=1.53u PD=1.665u rfmode=0
M$2448 \$725 \$688 \$686 VDD sg13_lv_pmos L=0.13u W=1u AS=0.3325p AD=0.2225p
+ PS=1.665u PD=1.445u rfmode=0
M$2449 \$686 \$687 \$724 VDD sg13_lv_pmos L=0.13u W=1u AS=0.2225p AD=0.2975p
+ PS=1.445u PD=1.595u rfmode=0
M$2450 \$724 \$685 VDD VDD sg13_lv_pmos L=0.13u W=1u AS=0.2975p AD=0.2198p
+ PS=1.595u PD=1.52u rfmode=0
M$2451 VDD \$686 \$689 VDD sg13_lv_pmos L=0.13u W=1.12u AS=0.2198p AD=0.6048p
+ PS=1.52u PD=3.32u rfmode=0
M$2452 VDD \$689 \$690 VDD sg13_lv_pmos L=0.13u W=0.42u AS=0.1428p AD=0.0798p
+ PS=1.52u PD=0.8u rfmode=0
M$2453 VDD \$623 \$690 VDD sg13_lv_pmos L=0.13u W=0.42u AS=0.3623875p
+ AD=0.0798p PS=2.605u PD=0.8u rfmode=0
M$2454 VDD \$717 \$691 VDD sg13_lv_pmos L=0.13u W=1u AS=0.3623875p AD=0.34p
+ PS=2.605u PD=2.68u rfmode=0
M$2455 \$718 \$693 VDD VDD sg13_lv_pmos L=0.13u W=1.12u AS=0.3864p AD=0.41165p
+ PS=2.93u PD=2.12u rfmode=0
M$2456 VDD \$508 \$693 VDD sg13_lv_pmos L=0.13u W=1.12u AS=0.41165p AD=0.4088p
+ PS=2.12u PD=2.97u rfmode=0
M$2457 \$695 \$718 \$719 VDD sg13_lv_pmos L=0.13u W=0.42u AS=0.2048p
+ AD=0.09345p PS=1.63u PD=0.865u rfmode=0
M$2458 \$719 \$696 VDD VDD sg13_lv_pmos L=0.13u W=0.42u AS=0.09345p AD=0.204p
+ PS=0.865u PD=1.835u rfmode=0
M$2459 VDD \$623 \$696 VDD sg13_lv_pmos L=0.13u W=0.42u AS=0.204p AD=0.0798p
+ PS=1.835u PD=0.8u rfmode=0
M$2460 \$696 \$695 VDD VDD sg13_lv_pmos L=0.13u W=0.42u AS=0.0798p AD=0.4659p
+ PS=0.8u PD=3.65u rfmode=0
M$2461 \$691 \$693 \$695 VDD sg13_lv_pmos L=0.13u W=1u AS=0.34p AD=0.2048p
+ PS=2.68u PD=1.63u rfmode=0
M$2462 \$697 \$695 VDD VDD sg13_lv_pmos L=0.13u W=1.12u AS=0.3864p AD=0.2128p
+ PS=2.93u PD=1.5u rfmode=0
M$2463 VDD \$697 \$688 VDD sg13_lv_pmos L=0.13u W=1.12u AS=0.2128p AD=0.3808p
+ PS=1.5u PD=2.92u rfmode=0
M$2489 VDD \$688 \$698 VDD sg13_lv_pmos L=0.13u W=0.84u AS=0.2114p AD=0.2856p
+ PS=1.54u PD=2.36u rfmode=0
M$2490 VDD \$698 \$36 VDD sg13_lv_pmos L=0.13u W=1.12u AS=0.2114p AD=0.42p
+ PS=1.54u PD=2.99u rfmode=0
M$2513 \$713 \$655 VDD VDD sg13_lv_pmos L=0.13u W=0.42u AS=0.147p AD=0.1563p
+ PS=1.54u PD=1.22u rfmode=0
M$2514 VDD \$657 \$726 VDD sg13_lv_pmos L=0.13u W=0.42u AS=0.1563p AD=0.063p
+ PS=1.22u PD=0.72u rfmode=0
M$2515 \$726 \$659 \$713 VDD sg13_lv_pmos L=0.13u W=0.42u AS=0.063p AD=0.0798p
+ PS=0.72u PD=0.8u rfmode=0
M$2516 \$713 \$714 \$656 VDD sg13_lv_pmos L=0.13u W=0.42u AS=0.0798p AD=0.1428p
+ PS=0.8u PD=1.52u rfmode=0
M$2518 \$730 \$764 VDD VDD sg13_lv_pmos L=0.13u W=1.12u AS=0.6048p AD=0.2198p
+ PS=3.32u PD=1.52u rfmode=0
M$2519 VDD \$731 \$757 VDD sg13_lv_pmos L=0.13u W=1u AS=0.2198p AD=0.2975p
+ PS=1.52u PD=1.595u rfmode=0
M$2520 \$757 \$351 \$764 VDD sg13_lv_pmos L=0.13u W=1u AS=0.2975p AD=0.2225p
+ PS=1.595u PD=1.445u rfmode=0
M$2521 \$764 \$732 \$758 VDD sg13_lv_pmos L=0.13u W=1u AS=0.2225p AD=0.3325p
+ PS=1.445u PD=1.665u rfmode=0
M$2522 \$758 \$733 VDD VDD sg13_lv_pmos L=0.13u W=1u AS=0.3325p AD=0.253p
+ PS=1.665u PD=1.53u rfmode=0
M$2523 VDD \$733 \$731 VDD sg13_lv_pmos L=0.13u W=0.84u AS=0.253p AD=0.2856p
+ PS=1.53u PD=2.36u rfmode=0
M$2528 \$435 \$631 VDD VDD sg13_lv_pmos L=0.13u W=1.12u AS=0.3808p AD=0.3808p
+ PS=2.92u PD=2.92u rfmode=0
M$2529 VDD \$669 \$734 VDD sg13_lv_pmos L=0.13u W=0.84u AS=0.2114p AD=0.2856p
+ PS=1.54u PD=2.36u rfmode=0
M$2530 \$421 \$734 VDD VDD sg13_lv_pmos L=0.13u W=1.12u AS=0.42p AD=0.2114p
+ PS=2.99u PD=1.54u rfmode=0
M$2531 VDD \$673 \$735 VDD sg13_lv_pmos L=0.13u W=0.42u AS=0.1428p AD=0.0798p
+ PS=1.52u PD=0.8u rfmode=0
M$2532 VDD \$738 \$735 VDD sg13_lv_pmos L=0.13u W=0.42u AS=0.3623875p
+ AD=0.0798p PS=2.605u PD=0.8u rfmode=0
M$2533 VDD \$736 \$737 VDD sg13_lv_pmos L=0.13u W=1u AS=0.3623875p AD=0.34p
+ PS=2.605u PD=2.68u rfmode=0
M$2534 VDD \$738 \$736 VDD sg13_lv_pmos L=0.13u W=0.42u AS=0.1563p AD=0.147p
+ PS=1.22u PD=1.54u rfmode=0
M$2535 VDD \$737 \$759 VDD sg13_lv_pmos L=0.13u W=0.42u AS=0.1563p AD=0.063p
+ PS=1.22u PD=0.72u rfmode=0
M$2536 \$759 \$740 \$736 VDD sg13_lv_pmos L=0.13u W=0.42u AS=0.063p AD=0.0798p
+ PS=0.72u PD=0.8u rfmode=0
M$2537 \$736 \$739 \$735 VDD sg13_lv_pmos L=0.13u W=0.42u AS=0.0798p AD=0.1428p
+ PS=0.8u PD=1.52u rfmode=0
M$2538 VDD \$740 \$739 VDD sg13_lv_pmos L=0.13u W=1.12u AS=0.41165p AD=0.3864p
+ PS=2.12u PD=2.93u rfmode=0
M$2539 VDD \$741 \$740 VDD sg13_lv_pmos L=0.13u W=1.12u AS=0.41165p AD=0.4088p
+ PS=2.12u PD=2.97u rfmode=0
M$2540 \$737 \$740 \$742 VDD sg13_lv_pmos L=0.13u W=1u AS=0.34p AD=0.2048p
+ PS=2.68u PD=1.63u rfmode=0
M$2541 \$742 \$739 \$760 VDD sg13_lv_pmos L=0.13u W=0.42u AS=0.2048p
+ AD=0.09345p PS=1.63u PD=0.865u rfmode=0
M$2542 VDD \$743 \$760 VDD sg13_lv_pmos L=0.13u W=0.42u AS=0.204p AD=0.09345p
+ PS=1.835u PD=0.865u rfmode=0
M$2543 VDD \$738 \$743 VDD sg13_lv_pmos L=0.13u W=0.42u AS=0.204p AD=0.0798p
+ PS=1.835u PD=0.8u rfmode=0
M$2544 VDD \$742 \$743 VDD sg13_lv_pmos L=0.13u W=0.42u AS=0.4659p AD=0.0798p
+ PS=3.65u PD=0.8u rfmode=0
M$2545 \$744 \$742 VDD VDD sg13_lv_pmos L=0.13u W=1.12u AS=0.3864p AD=0.2128p
+ PS=2.93u PD=1.5u rfmode=0
M$2546 VDD \$744 \$668 VDD sg13_lv_pmos L=0.13u W=1.12u AS=0.2128p AD=0.3808p
+ PS=1.5u PD=2.92u rfmode=0
M$2547 VDD \$631 \$615 VDD sg13_lv_pmos L=0.13u W=1.12u AS=0.3808p AD=0.3808p
+ PS=2.92u PD=2.92u rfmode=0
M$2548 VDD \$675 \$745 VDD sg13_lv_pmos L=0.13u W=1.12u AS=0.3808p AD=0.2128p
+ PS=2.92u PD=1.5u rfmode=0
M$2549 \$745 \$767 VDD VDD sg13_lv_pmos L=0.13u W=1.12u AS=0.2128p AD=0.3808p
+ PS=1.5u PD=2.92u rfmode=0
M$2550 VDD \$767 \$761 VDD sg13_lv_pmos L=0.15u W=1.12u AS=0.3808p AD=0.2128p
+ PS=2.92u PD=1.5u rfmode=0
M$2551 \$761 \$796 \$746 VDD sg13_lv_pmos L=0.15u W=1.12u AS=0.2128p AD=0.2128p
+ PS=1.5u PD=1.5u rfmode=0
M$2552 \$746 \$745 VDD VDD sg13_lv_pmos L=0.15u W=1.12u AS=0.2128p AD=0.3808p
+ PS=1.5u PD=2.92u rfmode=0
M$2553 VDD \$746 \$747 VDD sg13_lv_pmos L=0.13u W=0.42u AS=0.1428p AD=0.0798p
+ PS=1.52u PD=0.8u rfmode=0
M$2554 VDD \$680 \$747 VDD sg13_lv_pmos L=0.13u W=0.42u AS=0.3623875p
+ AD=0.0798p PS=2.605u PD=0.8u rfmode=0
M$2555 VDD \$748 \$749 VDD sg13_lv_pmos L=0.13u W=1u AS=0.3623875p AD=0.34p
+ PS=2.605u PD=2.68u rfmode=0
M$2556 VDD \$680 \$748 VDD sg13_lv_pmos L=0.13u W=0.42u AS=0.1563p AD=0.147p
+ PS=1.22u PD=1.54u rfmode=0
M$2557 VDD \$749 \$762 VDD sg13_lv_pmos L=0.13u W=0.42u AS=0.1563p AD=0.063p
+ PS=1.22u PD=0.72u rfmode=0
M$2558 \$762 \$751 \$748 VDD sg13_lv_pmos L=0.13u W=0.42u AS=0.063p AD=0.0798p
+ PS=0.72u PD=0.8u rfmode=0
M$2559 \$748 \$750 \$747 VDD sg13_lv_pmos L=0.13u W=0.42u AS=0.0798p AD=0.1428p
+ PS=0.8u PD=1.52u rfmode=0
M$2560 VDD \$751 \$750 VDD sg13_lv_pmos L=0.13u W=1.12u AS=0.41165p AD=0.3864p
+ PS=2.12u PD=2.93u rfmode=0
M$2561 VDD \$741 \$751 VDD sg13_lv_pmos L=0.13u W=1.12u AS=0.41165p AD=0.4088p
+ PS=2.12u PD=2.97u rfmode=0
M$2562 \$749 \$751 \$752 VDD sg13_lv_pmos L=0.13u W=1u AS=0.34p AD=0.2048p
+ PS=2.68u PD=1.63u rfmode=0
M$2563 \$752 \$750 \$763 VDD sg13_lv_pmos L=0.13u W=0.42u AS=0.2048p
+ AD=0.09345p PS=1.63u PD=0.865u rfmode=0
M$2564 VDD \$753 \$763 VDD sg13_lv_pmos L=0.13u W=0.42u AS=0.204p AD=0.09345p
+ PS=1.835u PD=0.865u rfmode=0
M$2565 VDD \$680 \$753 VDD sg13_lv_pmos L=0.13u W=0.42u AS=0.204p AD=0.0798p
+ PS=1.835u PD=0.8u rfmode=0
M$2566 VDD \$752 \$753 VDD sg13_lv_pmos L=0.13u W=0.42u AS=0.4659p AD=0.0798p
+ PS=3.65u PD=0.8u rfmode=0
M$2567 \$754 \$752 VDD VDD sg13_lv_pmos L=0.13u W=1.12u AS=0.3864p AD=0.2128p
+ PS=2.93u PD=1.5u rfmode=0
M$2568 VDD \$754 \$767 VDD sg13_lv_pmos L=0.13u W=1.12u AS=0.2128p AD=0.3808p
+ PS=1.5u PD=2.92u rfmode=0
M$2571 VDD \$341 \$755 VDD sg13_lv_pmos L=0.13u W=0.84u AS=0.2114p AD=0.2856p
+ PS=1.54u PD=2.36u rfmode=0
M$2572 \$621 \$755 VDD VDD sg13_lv_pmos L=0.13u W=1.12u AS=0.42p AD=0.2114p
+ PS=2.99u PD=1.54u rfmode=0
M$2575 \$717 \$623 VDD VDD sg13_lv_pmos L=0.13u W=0.42u AS=0.147p AD=0.1563p
+ PS=1.54u PD=1.22u rfmode=0
M$2576 VDD \$691 \$722 VDD sg13_lv_pmos L=0.13u W=0.42u AS=0.1563p AD=0.063p
+ PS=1.22u PD=0.72u rfmode=0
M$2577 \$722 \$693 \$717 VDD sg13_lv_pmos L=0.13u W=0.42u AS=0.063p AD=0.0798p
+ PS=0.72u PD=0.8u rfmode=0
M$2578 \$717 \$718 \$690 VDD sg13_lv_pmos L=0.13u W=0.42u AS=0.0798p AD=0.1428p
+ PS=0.8u PD=1.52u rfmode=0
M$2580 VDD \$342 \$756 VDD sg13_lv_pmos L=0.13u W=1.12u AS=0.3808p AD=0.3808p
+ PS=2.92u PD=2.92u rfmode=0
M$2631 VDD \$411 \$783 VDD sg13_lv_pmos L=0.13u W=1.12u AS=0.3808p AD=0.3808p
+ PS=2.92u PD=2.92u rfmode=0
M$2632 VDD \$730 \$784 VDD sg13_lv_pmos L=0.13u W=0.42u AS=0.1428p AD=0.0798p
+ PS=1.52u PD=0.8u rfmode=0
M$2633 VDD \$783 \$784 VDD sg13_lv_pmos L=0.13u W=0.42u AS=0.3623875p
+ AD=0.0798p PS=2.605u PD=0.8u rfmode=0
M$2634 VDD \$819 \$785 VDD sg13_lv_pmos L=0.13u W=1u AS=0.3623875p AD=0.34p
+ PS=2.605u PD=2.68u rfmode=0
M$2635 \$820 \$787 VDD VDD sg13_lv_pmos L=0.13u W=1.12u AS=0.3864p AD=0.41165p
+ PS=2.93u PD=2.12u rfmode=0
M$2636 VDD \$498 \$787 VDD sg13_lv_pmos L=0.13u W=1.12u AS=0.41165p AD=0.4088p
+ PS=2.12u PD=2.97u rfmode=0
M$2637 \$789 \$820 \$825 VDD sg13_lv_pmos L=0.13u W=0.42u AS=0.2048p
+ AD=0.09345p PS=1.63u PD=0.865u rfmode=0
M$2638 \$825 \$790 VDD VDD sg13_lv_pmos L=0.13u W=0.42u AS=0.09345p AD=0.204p
+ PS=0.865u PD=1.835u rfmode=0
M$2639 VDD \$783 \$790 VDD sg13_lv_pmos L=0.13u W=0.42u AS=0.204p AD=0.0798p
+ PS=1.835u PD=0.8u rfmode=0
M$2640 \$790 \$789 VDD VDD sg13_lv_pmos L=0.13u W=0.42u AS=0.0798p AD=0.4659p
+ PS=0.8u PD=3.65u rfmode=0
M$2641 \$785 \$787 \$789 VDD sg13_lv_pmos L=0.13u W=1u AS=0.34p AD=0.2048p
+ PS=2.68u PD=1.63u rfmode=0
M$2642 \$791 \$789 VDD VDD sg13_lv_pmos L=0.13u W=1.12u AS=0.3864p AD=0.2128p
+ PS=2.93u PD=1.5u rfmode=0
M$2643 VDD \$791 \$732 VDD sg13_lv_pmos L=0.13u W=1.12u AS=0.2128p AD=0.3808p
+ PS=1.5u PD=2.92u rfmode=0
M$2646 VDD \$421 \$738 VDD sg13_lv_pmos L=0.13u W=1.12u AS=0.3808p AD=0.3808p
+ PS=2.92u PD=2.92u rfmode=0
M$2649 \$793 \$792 \$837 VDD sg13_lv_pmos L=0.13u W=1.12u AS=0.3808p AD=0.1176p
+ PS=2.92u PD=1.33u rfmode=0
M$2650 \$837 \$794 VDD VDD sg13_lv_pmos L=0.13u W=1.12u AS=0.1176p AD=0.4032p
+ PS=1.33u PD=2.96u rfmode=0
M$2651 VDD \$854 \$836 VDD sg13_lv_pmos L=0.13u W=1.12u AS=0.3808p AD=0.2464p
+ PS=2.92u PD=1.56u rfmode=0
M$2652 \$836 \$794 \$835 VDD sg13_lv_pmos L=0.13u W=1.12u AS=0.2464p AD=0.2128p
+ PS=1.56u PD=1.5u rfmode=0
M$2653 \$835 \$796 \$733 VDD sg13_lv_pmos L=0.13u W=1.12u AS=0.2128p AD=0.3808p
+ PS=1.5u PD=2.92u rfmode=0
M$2654 VDD \$795 \$831 VDD sg13_lv_pmos L=0.13u W=1.12u AS=0.4032p AD=0.1176p
+ PS=2.96u PD=1.33u rfmode=0
M$2655 \$831 \$796 \$798 VDD sg13_lv_pmos L=0.13u W=1.12u AS=0.1176p AD=0.3808p
+ PS=1.33u PD=2.92u rfmode=0
M$2658 \$796 \$799 VDD VDD sg13_lv_pmos L=0.13u W=1.12u AS=0.42p AD=0.2114p
+ PS=2.99u PD=1.54u rfmode=0
M$2659 VDD \$609 \$799 VDD sg13_lv_pmos L=0.13u W=0.84u AS=0.2114p AD=0.2856p
+ PS=1.54u PD=2.36u rfmode=0
M$2664 \$741 \$800 VDD VDD sg13_lv_pmos L=0.13u W=1.12u AS=0.42p AD=0.2114p
+ PS=2.99u PD=1.54u rfmode=0
M$2665 VDD \$343 \$800 VDD sg13_lv_pmos L=0.13u W=0.84u AS=0.2114p AD=0.2856p
+ PS=1.54u PD=2.36u rfmode=0
M$2671 \$801 \$733 \$828 VDD sg13_lv_pmos L=0.13u W=1.12u AS=0.3808p AD=0.1176p
+ PS=2.92u PD=1.33u rfmode=0
M$2672 \$828 \$802 VDD VDD sg13_lv_pmos L=0.13u W=1.12u AS=0.1176p AD=0.4032p
+ PS=1.33u PD=2.96u rfmode=0
M$2673 \$821 \$351 VDD VDD sg13_lv_pmos L=0.13u W=1.12u AS=0.3808p AD=0.2128p
+ PS=2.92u PD=1.5u rfmode=0
M$2674 VDD \$733 \$821 VDD sg13_lv_pmos L=0.13u W=1.12u AS=0.2128p AD=0.2128p
+ PS=1.5u PD=1.5u rfmode=0
M$2675 \$821 \$801 \$803 VDD sg13_lv_pmos L=0.13u W=1.12u AS=0.2128p AD=0.3808p
+ PS=1.5u PD=2.92u rfmode=0
M$2676 VDD \$803 \$804 VDD sg13_lv_pmos L=0.13u W=0.42u AS=0.1428p AD=0.0798p
+ PS=1.52u PD=0.8u rfmode=0
M$2677 VDD \$756 \$804 VDD sg13_lv_pmos L=0.13u W=0.42u AS=0.3623875p
+ AD=0.0798p PS=2.605u PD=0.8u rfmode=0
M$2678 VDD \$822 \$805 VDD sg13_lv_pmos L=0.13u W=1u AS=0.3623875p AD=0.34p
+ PS=2.605u PD=2.68u rfmode=0
M$2679 \$823 \$807 VDD VDD sg13_lv_pmos L=0.13u W=1.12u AS=0.3864p AD=0.41165p
+ PS=2.93u PD=2.12u rfmode=0
M$2680 VDD \$508 \$807 VDD sg13_lv_pmos L=0.13u W=1.12u AS=0.41165p AD=0.4088p
+ PS=2.12u PD=2.97u rfmode=0
M$2681 \$809 \$823 \$824 VDD sg13_lv_pmos L=0.13u W=0.42u AS=0.2048p
+ AD=0.09345p PS=1.63u PD=0.865u rfmode=0
M$2682 \$824 \$810 VDD VDD sg13_lv_pmos L=0.13u W=0.42u AS=0.09345p AD=0.204p
+ PS=0.865u PD=1.835u rfmode=0
M$2683 VDD \$756 \$810 VDD sg13_lv_pmos L=0.13u W=0.42u AS=0.204p AD=0.0798p
+ PS=1.835u PD=0.8u rfmode=0
M$2684 \$810 \$809 VDD VDD sg13_lv_pmos L=0.13u W=0.42u AS=0.0798p AD=0.4659p
+ PS=0.8u PD=3.65u rfmode=0
M$2685 \$805 \$807 \$809 VDD sg13_lv_pmos L=0.13u W=1u AS=0.34p AD=0.2048p
+ PS=2.68u PD=1.63u rfmode=0
M$2686 \$811 \$809 VDD VDD sg13_lv_pmos L=0.13u W=1.12u AS=0.3864p AD=0.2128p
+ PS=2.93u PD=1.5u rfmode=0
M$2687 VDD \$811 \$802 VDD sg13_lv_pmos L=0.13u W=1.12u AS=0.2128p AD=0.3808p
+ PS=1.5u PD=2.92u rfmode=0
M$2711 VDD \$732 \$838 VDD sg13_lv_pmos L=0.13u W=0.84u AS=0.2114p AD=0.2856p
+ PS=1.54u PD=2.36u rfmode=0
M$2712 \$32 \$838 VDD VDD sg13_lv_pmos L=0.13u W=1.12u AS=0.42p AD=0.2114p
+ PS=2.99u PD=1.54u rfmode=0
M$2727 \$840 \$839 \$841 VDD sg13_lv_pmos L=0.13u W=1.12u AS=0.3808p AD=0.2128p
+ PS=2.92u PD=1.5u rfmode=0
M$2728 \$841 \$350 VDD VDD sg13_lv_pmos L=0.13u W=1.12u AS=0.2128p AD=0.2128p
+ PS=1.5u PD=1.5u rfmode=0
M$2729 VDD \$351 \$841 VDD sg13_lv_pmos L=0.13u W=1.12u AS=0.2128p AD=0.3808p
+ PS=1.5u PD=2.92u rfmode=0
M$2738 \$819 \$783 VDD VDD sg13_lv_pmos L=0.13u W=0.42u AS=0.147p AD=0.1563p
+ PS=1.54u PD=1.22u rfmode=0
M$2739 VDD \$785 \$830 VDD sg13_lv_pmos L=0.13u W=0.42u AS=0.1563p AD=0.063p
+ PS=1.22u PD=0.72u rfmode=0
M$2740 \$830 \$787 \$819 VDD sg13_lv_pmos L=0.13u W=0.42u AS=0.063p AD=0.0798p
+ PS=0.72u PD=0.8u rfmode=0
M$2741 \$819 \$820 \$784 VDD sg13_lv_pmos L=0.13u W=0.42u AS=0.0798p AD=0.1428p
+ PS=0.8u PD=1.52u rfmode=0
M$2743 VDD \$733 \$842 VDD sg13_lv_pmos L=0.13u W=0.84u AS=0.2198p AD=0.2856p
+ PS=1.53u PD=2.36u rfmode=0
M$2744 VDD \$843 \$844 VDD sg13_lv_pmos L=0.13u W=1.12u AS=0.2198p AD=0.2128p
+ PS=1.53u PD=1.5u rfmode=0
M$2745 \$844 \$842 VDD VDD sg13_lv_pmos L=0.13u W=1.12u AS=0.2128p AD=0.3808p
+ PS=1.5u PD=2.92u rfmode=0
M$2746 VDD \$850 \$849 VDD sg13_lv_pmos L=0.13u W=1.12u AS=0.41165p AD=0.3864p
+ PS=2.12u PD=2.93u rfmode=0
M$2747 VDD \$741 \$850 VDD sg13_lv_pmos L=0.13u W=1.12u AS=0.41165p AD=0.4088p
+ PS=2.12u PD=2.97u rfmode=0
M$2748 \$853 \$851 VDD VDD sg13_lv_pmos L=0.13u W=1.12u AS=0.3864p AD=0.2128p
+ PS=2.93u PD=1.5u rfmode=0
M$2749 VDD \$853 \$854 VDD sg13_lv_pmos L=0.13u W=1.12u AS=0.2128p AD=0.3808p
+ PS=1.5u PD=2.92u rfmode=0
M$2750 VDD \$794 \$855 VDD sg13_lv_pmos L=0.13u W=1.12u AS=0.3808p AD=0.2716p
+ PS=2.92u PD=1.605u rfmode=0
M$2751 \$855 \$675 \$843 VDD sg13_lv_pmos L=0.13u W=1.12u AS=0.2716p AD=0.2128p
+ PS=1.605u PD=1.5u rfmode=0
M$2752 \$843 \$854 \$855 VDD sg13_lv_pmos L=0.13u W=1.12u AS=0.2128p AD=0.2744p
+ PS=1.5u PD=1.61u rfmode=0
M$2753 \$855 \$798 VDD VDD sg13_lv_pmos L=0.13u W=1.12u AS=0.2744p AD=0.3808p
+ PS=1.61u PD=2.92u rfmode=0
M$2754 \$797 \$796 \$832 VDD sg13_lv_pmos L=0.13u W=0.84u AS=0.2856p AD=0.1596p
+ PS=2.36u PD=1.22u rfmode=0
M$2755 VDD \$795 \$832 VDD sg13_lv_pmos L=0.13u W=0.84u AS=0.2226p AD=0.1596p
+ PS=1.535u PD=1.22u rfmode=0
M$2756 VDD \$797 \$792 VDD sg13_lv_pmos L=0.13u W=1.12u AS=0.2226p AD=0.3976p
+ PS=1.535u PD=2.95u rfmode=0
M$2757 VDD \$883 \$794 VDD sg13_lv_pmos L=0.13u W=1.12u AS=0.3808p AD=0.2128p
+ PS=2.92u PD=1.5u rfmode=0
M$2758 \$794 \$767 VDD VDD sg13_lv_pmos L=0.13u W=1.12u AS=0.2128p AD=0.3808p
+ PS=1.5u PD=2.92u rfmode=0
M$2759 VDD \$883 \$876 VDD sg13_lv_pmos L=0.13u W=1.12u AS=0.3808p AD=0.2464p
+ PS=2.92u PD=1.56u rfmode=0
M$2760 \$876 \$767 \$877 VDD sg13_lv_pmos L=0.13u W=1.12u AS=0.2464p AD=0.2128p
+ PS=1.56u PD=1.5u rfmode=0
M$2761 \$877 \$792 \$605 VDD sg13_lv_pmos L=0.13u W=1.12u AS=0.2128p AD=0.3808p
+ PS=1.5u PD=2.92u rfmode=0
M$2762 \$856 \$675 VDD VDD sg13_lv_pmos L=0.13u W=1u AS=0.34p AD=0.19p PS=2.68u
+ PD=1.38u rfmode=0
M$2763 VDD \$883 \$856 VDD sg13_lv_pmos L=0.13u W=1u AS=0.19p AD=0.2125p
+ PS=1.38u PD=1.425u rfmode=0
M$2764 \$856 \$857 \$858 VDD sg13_lv_pmos L=0.13u W=1u AS=0.2125p AD=0.35p
+ PS=1.425u PD=2.7u rfmode=0
M$2765 VDD \$858 \$859 VDD sg13_lv_pmos L=0.13u W=1.12u AS=0.3808p AD=0.3808p
+ PS=2.92u PD=2.92u rfmode=0
M$2766 \$860 \$342 VDD VDD sg13_lv_pmos L=0.13u W=1.12u AS=0.3808p AD=0.3808p
+ PS=2.92u PD=2.92u rfmode=0
M$2767 VDD \$865 \$864 VDD sg13_lv_pmos L=0.13u W=1.12u AS=0.41165p AD=0.3864p
+ PS=2.12u PD=2.93u rfmode=0
M$2768 VDD \$741 \$865 VDD sg13_lv_pmos L=0.13u W=1.12u AS=0.41165p AD=0.4088p
+ PS=2.12u PD=2.97u rfmode=0
M$2769 \$868 \$866 VDD VDD sg13_lv_pmos L=0.13u W=1.12u AS=0.3864p AD=0.2128p
+ PS=2.93u PD=1.5u rfmode=0
M$2770 VDD \$868 \$883 VDD sg13_lv_pmos L=0.13u W=1.12u AS=0.2128p AD=0.3808p
+ PS=1.5u PD=2.92u rfmode=0
M$2771 VDD \$886 \$880 VDD sg13_lv_pmos L=0.13u W=1.12u AS=0.4032p AD=0.1176p
+ PS=2.96u PD=1.33u rfmode=0
M$2772 \$880 \$733 \$869 VDD sg13_lv_pmos L=0.13u W=1.12u AS=0.1176p AD=0.3808p
+ PS=1.33u PD=2.92u rfmode=0
M$2773 \$870 \$869 \$871 VDD sg13_lv_pmos L=0.13u W=1.12u AS=0.3808p AD=0.2128p
+ PS=2.92u PD=1.5u rfmode=0
M$2774 \$871 \$733 VDD VDD sg13_lv_pmos L=0.13u W=1.12u AS=0.2128p AD=0.2128p
+ PS=1.5u PD=1.5u rfmode=0
M$2775 VDD \$351 \$871 VDD sg13_lv_pmos L=0.13u W=1.12u AS=0.2128p AD=0.3808p
+ PS=1.5u PD=2.92u rfmode=0
M$2780 \$822 \$756 VDD VDD sg13_lv_pmos L=0.13u W=0.42u AS=0.147p AD=0.1563p
+ PS=1.54u PD=1.22u rfmode=0
M$2781 VDD \$805 \$827 VDD sg13_lv_pmos L=0.13u W=0.42u AS=0.1563p AD=0.063p
+ PS=1.22u PD=0.72u rfmode=0
M$2782 \$827 \$807 \$822 VDD sg13_lv_pmos L=0.13u W=0.42u AS=0.063p AD=0.0798p
+ PS=0.72u PD=0.8u rfmode=0
M$2783 \$822 \$823 \$804 VDD sg13_lv_pmos L=0.13u W=0.42u AS=0.0798p AD=0.1428p
+ PS=0.8u PD=1.52u rfmode=0
M$2790 VDD \$887 \$872 VDD sg13_lv_pmos L=0.13u W=1.12u AS=0.3808p AD=0.3808p
+ PS=2.92u PD=2.92u rfmode=0
M$2811 \$873 \$802 VDD VDD sg13_lv_pmos L=0.13u W=0.84u AS=0.2856p AD=0.2114p
+ PS=2.36u PD=1.54u rfmode=0
M$2812 VDD \$873 \$37 VDD sg13_lv_pmos L=0.13u W=1.12u AS=0.2114p AD=0.42p
+ PS=1.54u PD=2.99u rfmode=0
M$2827 VDD \$411 \$909 VDD sg13_lv_pmos L=0.13u W=1.12u AS=0.3808p AD=0.3808p
+ PS=2.92u PD=2.92u rfmode=0
M$2828 VDD \$840 \$912 VDD sg13_lv_pmos L=0.13u W=0.42u AS=0.1428p AD=0.0798p
+ PS=1.52u PD=0.8u rfmode=0
M$2829 VDD \$909 \$912 VDD sg13_lv_pmos L=0.13u W=0.42u AS=0.3623875p
+ AD=0.0798p PS=2.605u PD=0.8u rfmode=0
M$2830 VDD \$963 \$910 VDD sg13_lv_pmos L=0.13u W=1u AS=0.3623875p AD=0.34p
+ PS=2.605u PD=2.68u rfmode=0
M$2831 \$964 \$913 VDD VDD sg13_lv_pmos L=0.13u W=1.12u AS=0.3864p AD=0.41165p
+ PS=2.93u PD=2.12u rfmode=0
M$2832 VDD \$498 \$913 VDD sg13_lv_pmos L=0.13u W=1.12u AS=0.41165p AD=0.4088p
+ PS=2.12u PD=2.97u rfmode=0
M$2833 \$915 \$964 \$972 VDD sg13_lv_pmos L=0.13u W=0.42u AS=0.2048p
+ AD=0.09345p PS=1.63u PD=0.865u rfmode=0
M$2834 \$972 \$917 VDD VDD sg13_lv_pmos L=0.13u W=0.42u AS=0.09345p AD=0.204p
+ PS=0.865u PD=1.835u rfmode=0
M$2835 VDD \$909 \$917 VDD sg13_lv_pmos L=0.13u W=0.42u AS=0.204p AD=0.0798p
+ PS=1.835u PD=0.8u rfmode=0
M$2836 \$917 \$915 VDD VDD sg13_lv_pmos L=0.13u W=0.42u AS=0.0798p AD=0.4659p
+ PS=0.8u PD=3.65u rfmode=0
M$2837 \$910 \$913 \$915 VDD sg13_lv_pmos L=0.13u W=1u AS=0.34p AD=0.2048p
+ PS=2.68u PD=1.63u rfmode=0
M$2838 \$918 \$915 VDD VDD sg13_lv_pmos L=0.13u W=1.12u AS=0.3864p AD=0.2128p
+ PS=2.93u PD=1.5u rfmode=0
M$2839 VDD \$918 \$919 VDD sg13_lv_pmos L=0.13u W=1.12u AS=0.2128p AD=0.3808p
+ PS=1.5u PD=2.92u rfmode=0
M$2842 \$916 \$920 \$965 VDD sg13_lv_pmos L=0.13u W=1.12u AS=0.3808p AD=0.2128p
+ PS=2.92u PD=1.5u rfmode=0
M$2843 \$965 \$621 VDD VDD sg13_lv_pmos L=0.13u W=1.12u AS=0.2128p AD=0.2128p
+ PS=1.5u PD=1.5u rfmode=0
M$2844 VDD \$921 \$965 VDD sg13_lv_pmos L=0.13u W=1.12u AS=0.2128p AD=0.3808p
+ PS=1.5u PD=2.92u rfmode=0
M$2846 VDD \$844 \$845 VDD sg13_lv_pmos L=0.13u W=0.42u AS=0.1428p AD=0.0798p
+ PS=1.52u PD=0.8u rfmode=0
M$2847 VDD \$848 \$845 VDD sg13_lv_pmos L=0.13u W=0.42u AS=0.3623875p
+ AD=0.0798p PS=2.605u PD=0.8u rfmode=0
M$2848 VDD \$846 \$847 VDD sg13_lv_pmos L=0.13u W=1u AS=0.3623875p AD=0.34p
+ PS=2.605u PD=2.68u rfmode=0
M$2849 VDD \$421 \$848 VDD sg13_lv_pmos L=0.13u W=1.12u AS=0.3808p AD=0.3808p
+ PS=2.92u PD=2.92u rfmode=0
M$2852 VDD \$848 \$846 VDD sg13_lv_pmos L=0.13u W=0.42u AS=0.1563p AD=0.147p
+ PS=1.22u PD=1.54u rfmode=0
M$2853 VDD \$847 \$874 VDD sg13_lv_pmos L=0.13u W=0.42u AS=0.1563p AD=0.063p
+ PS=1.22u PD=0.72u rfmode=0
M$2854 \$874 \$850 \$846 VDD sg13_lv_pmos L=0.13u W=0.42u AS=0.063p AD=0.0798p
+ PS=0.72u PD=0.8u rfmode=0
M$2855 \$846 \$849 \$845 VDD sg13_lv_pmos L=0.13u W=0.42u AS=0.0798p AD=0.1428p
+ PS=0.8u PD=1.52u rfmode=0
M$2858 \$847 \$850 \$851 VDD sg13_lv_pmos L=0.13u W=1u AS=0.34p AD=0.2048p
+ PS=2.68u PD=1.63u rfmode=0
M$2859 \$851 \$849 \$875 VDD sg13_lv_pmos L=0.13u W=0.42u AS=0.2048p
+ AD=0.09345p PS=1.63u PD=0.865u rfmode=0
M$2860 VDD \$852 \$875 VDD sg13_lv_pmos L=0.13u W=0.42u AS=0.204p AD=0.09345p
+ PS=1.835u PD=0.865u rfmode=0
M$2861 VDD \$848 \$852 VDD sg13_lv_pmos L=0.13u W=0.42u AS=0.204p AD=0.0798p
+ PS=1.835u PD=0.8u rfmode=0
M$2862 VDD \$851 \$852 VDD sg13_lv_pmos L=0.13u W=0.42u AS=0.4659p AD=0.0798p
+ PS=3.65u PD=0.8u rfmode=0
M$2865 VDD \$795 \$992 VDD sg13_lv_pmos L=0.13u W=1.12u AS=0.3808p AD=0.2464p
+ PS=2.92u PD=1.56u rfmode=0
M$2866 \$992 \$796 \$991 VDD sg13_lv_pmos L=0.13u W=1.12u AS=0.2464p AD=0.2128p
+ PS=1.56u PD=1.5u rfmode=0
M$2867 \$991 \$922 \$350 VDD sg13_lv_pmos L=0.13u W=1.12u AS=0.2128p AD=0.3808p
+ PS=1.5u PD=2.92u rfmode=0
M$2868 VDD \$854 \$989 VDD sg13_lv_pmos L=0.13u W=1.12u AS=0.3808p AD=0.2464p
+ PS=2.92u PD=1.56u rfmode=0
M$2869 \$989 \$609 \$990 VDD sg13_lv_pmos L=0.13u W=1.12u AS=0.2464p AD=0.2128p
+ PS=1.56u PD=1.5u rfmode=0
M$2870 \$990 \$922 \$921 VDD sg13_lv_pmos L=0.13u W=1.12u AS=0.2128p AD=0.3808p
+ PS=1.5u PD=2.92u rfmode=0
M$2871 VDD \$767 \$923 VDD sg13_lv_pmos L=0.13u W=0.84u AS=0.2198p AD=0.2856p
+ PS=1.53u PD=2.36u rfmode=0
M$2872 VDD \$923 \$922 VDD sg13_lv_pmos L=0.13u W=1.12u AS=0.3808p AD=0.2128p
+ PS=2.92u PD=1.5u rfmode=0
M$2873 \$922 \$883 VDD VDD sg13_lv_pmos L=0.13u W=1.12u AS=0.2128p AD=0.2198p
+ PS=1.5u PD=1.53u rfmode=0
M$2874 \$966 \$922 VDD VDD sg13_lv_pmos L=0.13u W=1.12u AS=0.3808p AD=0.2128p
+ PS=2.92u PD=1.5u rfmode=0
M$2875 VDD \$924 \$966 VDD sg13_lv_pmos L=0.13u W=1.12u AS=0.2128p AD=0.2128p
+ PS=1.5u PD=1.5u rfmode=0
M$2876 \$966 \$796 \$857 VDD sg13_lv_pmos L=0.13u W=1.12u AS=0.2128p AD=0.3808p
+ PS=1.5u PD=2.92u rfmode=0
M$2877 \$925 \$883 VDD VDD sg13_lv_pmos L=0.13u W=0.84u AS=0.2856p AD=0.2198p
+ PS=2.36u PD=1.53u rfmode=0
M$2878 VDD \$767 \$924 VDD sg13_lv_pmos L=0.13u W=1.12u AS=0.2198p AD=0.2128p
+ PS=1.53u PD=1.5u rfmode=0
M$2879 \$924 \$925 VDD VDD sg13_lv_pmos L=0.13u W=1.12u AS=0.2128p AD=0.3808p
+ PS=1.5u PD=2.92u rfmode=0
M$2880 \$926 \$924 \$988 VDD sg13_lv_pmos L=0.13u W=1.12u AS=0.3808p AD=0.1176p
+ PS=2.92u PD=1.33u rfmode=0
M$2881 \$988 \$792 VDD VDD sg13_lv_pmos L=0.13u W=1.12u AS=0.1176p AD=0.4032p
+ PS=1.33u PD=2.96u rfmode=0
M$2884 VDD \$859 \$861 VDD sg13_lv_pmos L=0.13u W=0.42u AS=0.1428p AD=0.0798p
+ PS=1.52u PD=0.8u rfmode=0
M$2885 VDD \$860 \$861 VDD sg13_lv_pmos L=0.13u W=0.42u AS=0.3623875p
+ AD=0.0798p PS=2.605u PD=0.8u rfmode=0
M$2886 VDD \$862 \$863 VDD sg13_lv_pmos L=0.13u W=1u AS=0.3623875p AD=0.34p
+ PS=2.605u PD=2.68u rfmode=0
M$2887 VDD \$860 \$862 VDD sg13_lv_pmos L=0.13u W=0.42u AS=0.1563p AD=0.147p
+ PS=1.22u PD=1.54u rfmode=0
M$2888 VDD \$863 \$878 VDD sg13_lv_pmos L=0.13u W=0.42u AS=0.1563p AD=0.063p
+ PS=1.22u PD=0.72u rfmode=0
M$2889 \$878 \$865 \$862 VDD sg13_lv_pmos L=0.13u W=0.42u AS=0.063p AD=0.0798p
+ PS=0.72u PD=0.8u rfmode=0
M$2890 \$862 \$864 \$861 VDD sg13_lv_pmos L=0.13u W=0.42u AS=0.0798p AD=0.1428p
+ PS=0.8u PD=1.52u rfmode=0
M$2895 \$863 \$865 \$866 VDD sg13_lv_pmos L=0.13u W=1u AS=0.34p AD=0.2048p
+ PS=2.68u PD=1.63u rfmode=0
M$2896 \$866 \$864 \$879 VDD sg13_lv_pmos L=0.13u W=0.42u AS=0.2048p
+ AD=0.09345p PS=1.63u PD=0.865u rfmode=0
M$2897 VDD \$867 \$879 VDD sg13_lv_pmos L=0.13u W=0.42u AS=0.204p AD=0.09345p
+ PS=1.835u PD=0.865u rfmode=0
M$2898 VDD \$860 \$867 VDD sg13_lv_pmos L=0.13u W=0.42u AS=0.204p AD=0.0798p
+ PS=1.835u PD=0.8u rfmode=0
M$2899 VDD \$866 \$867 VDD sg13_lv_pmos L=0.13u W=0.42u AS=0.4659p AD=0.0798p
+ PS=3.65u PD=0.8u rfmode=0
M$2902 VDD \$342 \$927 VDD sg13_lv_pmos L=0.13u W=1.12u AS=0.3808p AD=0.3808p
+ PS=2.92u PD=2.92u rfmode=0
M$2903 VDD \$870 \$930 VDD sg13_lv_pmos L=0.13u W=0.42u AS=0.1428p AD=0.0798p
+ PS=1.52u PD=0.8u rfmode=0
M$2904 VDD \$927 \$930 VDD sg13_lv_pmos L=0.13u W=0.42u AS=0.3623875p
+ AD=0.0798p PS=2.605u PD=0.8u rfmode=0
M$2905 VDD \$967 \$928 VDD sg13_lv_pmos L=0.13u W=1u AS=0.3623875p AD=0.34p
+ PS=2.605u PD=2.68u rfmode=0
M$2906 \$968 \$931 VDD VDD sg13_lv_pmos L=0.13u W=1.12u AS=0.3864p AD=0.41165p
+ PS=2.93u PD=2.12u rfmode=0
M$2907 VDD \$508 \$931 VDD sg13_lv_pmos L=0.13u W=1.12u AS=0.41165p AD=0.4088p
+ PS=2.12u PD=2.97u rfmode=0
M$2908 \$933 \$968 \$981 VDD sg13_lv_pmos L=0.13u W=0.42u AS=0.2048p
+ AD=0.09345p PS=1.63u PD=0.865u rfmode=0
M$2909 \$981 \$934 VDD VDD sg13_lv_pmos L=0.13u W=0.42u AS=0.09345p AD=0.204p
+ PS=0.865u PD=1.835u rfmode=0
M$2910 VDD \$927 \$934 VDD sg13_lv_pmos L=0.13u W=0.42u AS=0.204p AD=0.0798p
+ PS=1.835u PD=0.8u rfmode=0
M$2911 \$934 \$933 VDD VDD sg13_lv_pmos L=0.13u W=0.42u AS=0.0798p AD=0.4659p
+ PS=0.8u PD=3.65u rfmode=0
M$2912 \$928 \$931 \$933 VDD sg13_lv_pmos L=0.13u W=1u AS=0.34p AD=0.2048p
+ PS=2.68u PD=1.63u rfmode=0
M$2913 \$935 \$933 VDD VDD sg13_lv_pmos L=0.13u W=1.12u AS=0.3864p AD=0.2128p
+ PS=2.93u PD=1.5u rfmode=0
M$2914 VDD \$935 \$886 VDD sg13_lv_pmos L=0.13u W=1.12u AS=0.2128p AD=0.3808p
+ PS=1.5u PD=2.92u rfmode=0
M$2915 \$936 \$921 VDD VDD sg13_lv_pmos L=0.13u W=0.84u AS=0.2856p AD=0.253p
+ PS=2.36u PD=1.53u rfmode=0
M$2916 VDD \$921 \$985 VDD sg13_lv_pmos L=0.13u W=1u AS=0.253p AD=0.3325p
+ PS=1.53u PD=1.665u rfmode=0
M$2917 \$985 \$938 \$937 VDD sg13_lv_pmos L=0.13u W=1u AS=0.3325p AD=0.2225p
+ PS=1.665u PD=1.445u rfmode=0
M$2918 \$937 \$687 \$984 VDD sg13_lv_pmos L=0.13u W=1u AS=0.2225p AD=0.2975p
+ PS=1.445u PD=1.595u rfmode=0
M$2919 \$984 \$936 VDD VDD sg13_lv_pmos L=0.13u W=1u AS=0.2975p AD=0.2198p
+ PS=1.595u PD=1.52u rfmode=0
M$2920 VDD \$937 \$939 VDD sg13_lv_pmos L=0.13u W=1.12u AS=0.2198p AD=0.6048p
+ PS=1.52u PD=3.32u rfmode=0
M$2921 VDD \$939 \$942 VDD sg13_lv_pmos L=0.13u W=0.42u AS=0.1428p AD=0.0798p
+ PS=1.52u PD=0.8u rfmode=0
M$2922 VDD \$872 \$942 VDD sg13_lv_pmos L=0.13u W=0.42u AS=0.3623875p
+ AD=0.0798p PS=2.605u PD=0.8u rfmode=0
M$2923 VDD \$969 \$940 VDD sg13_lv_pmos L=0.13u W=1u AS=0.3623875p AD=0.34p
+ PS=2.605u PD=2.68u rfmode=0
M$2924 \$970 \$943 VDD VDD sg13_lv_pmos L=0.13u W=1.12u AS=0.3864p AD=0.41165p
+ PS=2.93u PD=2.12u rfmode=0
M$2925 VDD \$508 \$943 VDD sg13_lv_pmos L=0.13u W=1.12u AS=0.41165p AD=0.4088p
+ PS=2.12u PD=2.97u rfmode=0
M$2926 \$945 \$970 \$975 VDD sg13_lv_pmos L=0.13u W=0.42u AS=0.2048p
+ AD=0.09345p PS=1.63u PD=0.865u rfmode=0
M$2927 \$975 \$946 VDD VDD sg13_lv_pmos L=0.13u W=0.42u AS=0.09345p AD=0.204p
+ PS=0.865u PD=1.835u rfmode=0
M$2928 VDD \$872 \$946 VDD sg13_lv_pmos L=0.13u W=0.42u AS=0.204p AD=0.0798p
+ PS=1.835u PD=0.8u rfmode=0
M$2929 \$946 \$945 VDD VDD sg13_lv_pmos L=0.13u W=0.42u AS=0.0798p AD=0.4659p
+ PS=0.8u PD=3.65u rfmode=0
M$2930 \$940 \$943 \$945 VDD sg13_lv_pmos L=0.13u W=1u AS=0.34p AD=0.2048p
+ PS=2.68u PD=1.63u rfmode=0
M$2931 \$947 \$945 VDD VDD sg13_lv_pmos L=0.13u W=1.12u AS=0.3864p AD=0.2128p
+ PS=2.93u PD=1.5u rfmode=0
M$2932 VDD \$947 \$938 VDD sg13_lv_pmos L=0.13u W=1.12u AS=0.2128p AD=0.3808p
+ PS=1.5u PD=2.92u rfmode=0
M$2948 VDD \$993 \$994 VDD sg13_lv_pmos L=0.13u W=0.84u AS=0.2114p AD=0.2856p
+ PS=1.54u PD=2.36u rfmode=0
M$2949 \$31 \$994 VDD VDD sg13_lv_pmos L=0.13u W=1.12u AS=0.42p AD=0.2114p
+ PS=2.99u PD=1.54u rfmode=0
M$2964 \$963 \$909 VDD VDD sg13_lv_pmos L=0.13u W=0.42u AS=0.147p AD=0.1563p
+ PS=1.54u PD=1.22u rfmode=0
M$2965 VDD \$910 \$987 VDD sg13_lv_pmos L=0.13u W=0.42u AS=0.1563p AD=0.063p
+ PS=1.22u PD=0.72u rfmode=0
M$2966 \$987 \$913 \$963 VDD sg13_lv_pmos L=0.13u W=0.42u AS=0.063p AD=0.0798p
+ PS=0.72u PD=0.8u rfmode=0
M$2967 \$963 \$964 \$912 VDD sg13_lv_pmos L=0.13u W=0.42u AS=0.0798p AD=0.1428p
+ PS=0.8u PD=1.52u rfmode=0
M$2968 \$839 \$350 \$1017 VDD sg13_lv_pmos L=0.13u W=1.12u AS=0.3808p
+ AD=0.1176p PS=2.92u PD=1.33u rfmode=0
M$2969 \$1017 \$919 VDD VDD sg13_lv_pmos L=0.13u W=1.12u AS=0.1176p AD=0.4032p
+ PS=1.33u PD=2.96u rfmode=0
M$2972 \$995 \$421 VDD VDD sg13_lv_pmos L=0.13u W=1.12u AS=0.3808p AD=0.3808p
+ PS=2.92u PD=2.92u rfmode=0
M$2973 VDD \$916 \$996 VDD sg13_lv_pmos L=0.13u W=0.42u AS=0.1428p AD=0.0798p
+ PS=1.52u PD=0.8u rfmode=0
M$2974 VDD \$995 \$996 VDD sg13_lv_pmos L=0.13u W=0.42u AS=0.3623875p
+ AD=0.0798p PS=2.605u PD=0.8u rfmode=0
M$2975 VDD \$997 \$998 VDD sg13_lv_pmos L=0.13u W=1u AS=0.3623875p AD=0.34p
+ PS=2.605u PD=2.68u rfmode=0
M$2976 VDD \$1000 \$999 VDD sg13_lv_pmos L=0.13u W=1.12u AS=0.41165p AD=0.3864p
+ PS=2.12u PD=2.93u rfmode=0
M$2977 VDD \$498 \$1000 VDD sg13_lv_pmos L=0.13u W=1.12u AS=0.41165p AD=0.4088p
+ PS=2.12u PD=2.97u rfmode=0
M$2978 \$998 \$1000 \$1001 VDD sg13_lv_pmos L=0.13u W=1u AS=0.34p AD=0.2048p
+ PS=2.68u PD=1.63u rfmode=0
M$2979 \$1001 \$999 \$1019 VDD sg13_lv_pmos L=0.13u W=0.42u AS=0.2048p
+ AD=0.09345p PS=1.63u PD=0.865u rfmode=0
M$2980 VDD \$1002 \$1019 VDD sg13_lv_pmos L=0.13u W=0.42u AS=0.204p AD=0.09345p
+ PS=1.835u PD=0.865u rfmode=0
M$2981 VDD \$995 \$1002 VDD sg13_lv_pmos L=0.13u W=0.42u AS=0.204p AD=0.0798p
+ PS=1.835u PD=0.8u rfmode=0
M$2982 VDD \$1001 \$1002 VDD sg13_lv_pmos L=0.13u W=0.42u AS=0.4659p AD=0.0798p
+ PS=3.65u PD=0.8u rfmode=0
M$2983 \$1003 \$1001 VDD VDD sg13_lv_pmos L=0.13u W=1.12u AS=0.3864p AD=0.2128p
+ PS=2.93u PD=1.5u rfmode=0
M$2984 VDD \$1003 \$993 VDD sg13_lv_pmos L=0.13u W=1.12u AS=0.2128p AD=0.3808p
+ PS=1.5u PD=2.92u rfmode=0
M$2985 VDD \$993 \$1020 VDD sg13_lv_pmos L=0.13u W=1.12u AS=0.4032p AD=0.1176p
+ PS=2.96u PD=1.33u rfmode=0
M$2986 \$1020 \$921 \$920 VDD sg13_lv_pmos L=0.13u W=1.12u AS=0.1176p
+ AD=0.3808p PS=1.33u PD=2.92u rfmode=0
M$2995 \$795 \$854 VDD VDD sg13_lv_pmos L=0.13u W=1.12u AS=0.3808p AD=0.3808p
+ PS=2.92u PD=2.92u rfmode=0
M$2996 VDD \$854 \$1021 VDD sg13_lv_pmos L=0.13u W=1.12u AS=0.3808p AD=0.2464p
+ PS=2.92u PD=1.56u rfmode=0
M$2997 \$1021 \$883 \$1022 VDD sg13_lv_pmos L=0.13u W=1.12u AS=0.2464p
+ AD=0.2128p PS=1.56u PD=1.5u rfmode=0
M$2998 \$1022 \$796 \$1004 VDD sg13_lv_pmos L=0.13u W=1.12u AS=0.2128p
+ AD=0.3808p PS=1.5u PD=2.92u rfmode=0
M$2999 VDD \$854 \$1023 VDD sg13_lv_pmos L=0.13u W=1.12u AS=0.3808p AD=0.2464p
+ PS=2.92u PD=1.56u rfmode=0
M$3000 \$1023 \$796 \$1024 VDD sg13_lv_pmos L=0.13u W=1.12u AS=0.2464p
+ AD=0.2128p PS=1.56u PD=1.5u rfmode=0
M$3001 \$1024 \$924 \$1005 VDD sg13_lv_pmos L=0.13u W=1.12u AS=0.2128p
+ AD=0.3808p PS=1.5u PD=2.92u rfmode=0
M$3002 VDD \$924 \$1025 VDD sg13_lv_pmos L=0.13u W=1.12u AS=0.4032p AD=0.1176p
+ PS=2.96u PD=1.33u rfmode=0
M$3003 \$1025 \$621 \$1006 VDD sg13_lv_pmos L=0.13u W=1.12u AS=0.1176p
+ AD=0.3808p PS=1.33u PD=2.92u rfmode=0
M$3008 VDD \$883 \$1026 VDD sg13_lv_pmos L=0.13u W=1.12u AS=0.3808p AD=0.2464p
+ PS=2.92u PD=1.56u rfmode=0
M$3009 \$1026 \$767 \$1027 VDD sg13_lv_pmos L=0.13u W=1.12u AS=0.2464p
+ AD=0.2128p PS=1.56u PD=1.5u rfmode=0
M$3010 \$1027 \$687 \$1007 VDD sg13_lv_pmos L=0.13u W=1.12u AS=0.2128p
+ AD=0.3808p PS=1.5u PD=2.92u rfmode=0
M$3011 VDD \$1004 \$1028 VDD sg13_lv_pmos L=0.15u W=1.12u AS=0.3808p AD=0.2128p
+ PS=2.92u PD=1.5u rfmode=0
M$3012 \$1028 \$350 \$1008 VDD sg13_lv_pmos L=0.15u W=1.12u AS=0.2128p
+ AD=0.2128p PS=1.5u PD=1.5u rfmode=0
M$3013 \$1008 \$1007 VDD VDD sg13_lv_pmos L=0.15u W=1.12u AS=0.2128p AD=0.3808p
+ PS=1.5u PD=2.92u rfmode=0
M$3019 \$967 \$927 VDD VDD sg13_lv_pmos L=0.13u W=0.42u AS=0.147p AD=0.1563p
+ PS=1.54u PD=1.22u rfmode=0
M$3020 VDD \$928 \$986 VDD sg13_lv_pmos L=0.13u W=0.42u AS=0.1563p AD=0.063p
+ PS=1.22u PD=0.72u rfmode=0
M$3021 \$986 \$931 \$967 VDD sg13_lv_pmos L=0.13u W=0.42u AS=0.063p AD=0.0798p
+ PS=0.72u PD=0.8u rfmode=0
M$3022 \$967 \$968 \$930 VDD sg13_lv_pmos L=0.13u W=0.42u AS=0.0798p AD=0.1428p
+ PS=0.8u PD=1.52u rfmode=0
M$3023 \$1009 \$1036 VDD VDD sg13_lv_pmos L=0.13u W=1.12u AS=0.6048p AD=0.2198p
+ PS=3.32u PD=1.52u rfmode=0
M$3024 VDD \$1010 \$1029 VDD sg13_lv_pmos L=0.13u W=1u AS=0.2198p AD=0.2975p
+ PS=1.52u PD=1.595u rfmode=0
M$3025 \$1029 \$687 \$1036 VDD sg13_lv_pmos L=0.13u W=1u AS=0.2975p AD=0.2225p
+ PS=1.595u PD=1.445u rfmode=0
M$3026 \$1036 \$1011 \$1030 VDD sg13_lv_pmos L=0.13u W=1u AS=0.2225p AD=0.3325p
+ PS=1.445u PD=1.665u rfmode=0
M$3027 \$1030 \$921 VDD VDD sg13_lv_pmos L=0.13u W=1u AS=0.3325p AD=0.253p
+ PS=1.665u PD=1.53u rfmode=0
M$3028 VDD \$921 \$1010 VDD sg13_lv_pmos L=0.13u W=0.84u AS=0.253p AD=0.2856p
+ PS=1.53u PD=2.36u rfmode=0
M$3032 VDD \$1005 \$1012 VDD sg13_lv_pmos L=0.13u W=0.84u AS=0.253p AD=0.2856p
+ PS=1.53u PD=2.36u rfmode=0
M$3033 VDD \$1005 \$1031 VDD sg13_lv_pmos L=0.13u W=1u AS=0.253p AD=0.3325p
+ PS=1.53u PD=1.665u rfmode=0
M$3034 \$1031 \$1037 \$1013 VDD sg13_lv_pmos L=0.13u W=1u AS=0.3325p AD=0.2225p
+ PS=1.665u PD=1.445u rfmode=0
M$3035 \$1013 \$687 \$1032 VDD sg13_lv_pmos L=0.13u W=1u AS=0.2225p AD=0.2975p
+ PS=1.445u PD=1.595u rfmode=0
M$3036 VDD \$1012 \$1032 VDD sg13_lv_pmos L=0.13u W=1u AS=0.2198p AD=0.2975p
+ PS=1.52u PD=1.595u rfmode=0
M$3037 VDD \$1013 \$1014 VDD sg13_lv_pmos L=0.13u W=1.12u AS=0.2198p AD=0.6048p
+ PS=1.52u PD=3.32u rfmode=0
M$3038 \$1015 \$669 VDD VDD sg13_lv_pmos L=0.13u W=0.84u AS=0.2856p AD=0.2114p
+ PS=2.36u PD=1.54u rfmode=0
M$3039 VDD \$1015 \$887 VDD sg13_lv_pmos L=0.13u W=1.12u AS=0.2114p AD=0.42p
+ PS=1.54u PD=2.99u rfmode=0
M$3040 \$969 \$872 VDD VDD sg13_lv_pmos L=0.13u W=0.42u AS=0.147p AD=0.1563p
+ PS=1.54u PD=1.22u rfmode=0
M$3041 VDD \$940 \$983 VDD sg13_lv_pmos L=0.13u W=0.42u AS=0.1563p AD=0.063p
+ PS=1.22u PD=0.72u rfmode=0
M$3042 \$983 \$943 \$969 VDD sg13_lv_pmos L=0.13u W=0.42u AS=0.063p AD=0.0798p
+ PS=0.72u PD=0.8u rfmode=0
M$3043 \$969 \$970 \$942 VDD sg13_lv_pmos L=0.13u W=0.42u AS=0.0798p AD=0.1428p
+ PS=0.8u PD=1.52u rfmode=0
M$3064 \$1016 \$938 VDD VDD sg13_lv_pmos L=0.13u W=0.84u AS=0.2856p AD=0.2114p
+ PS=2.36u PD=1.54u rfmode=0
M$3065 VDD \$1016 \$38 VDD sg13_lv_pmos L=0.13u W=1.12u AS=0.2114p AD=0.42p
+ PS=1.54u PD=2.99u rfmode=0
M$3086 VDD \$1056 \$1055 VDD sg13_lv_pmos L=0.13u W=0.42u AS=0.1428p AD=0.0798p
+ PS=1.52u PD=0.8u rfmode=0
M$3087 VDD \$1058 \$1055 VDD sg13_lv_pmos L=0.13u W=0.42u AS=0.3623875p
+ AD=0.0798p PS=2.605u PD=0.8u rfmode=0
M$3088 VDD \$1123 \$1057 VDD sg13_lv_pmos L=0.13u W=1u AS=0.3623875p AD=0.34p
+ PS=2.605u PD=2.68u rfmode=0
M$3089 VDD \$995 \$997 VDD sg13_lv_pmos L=0.13u W=0.42u AS=0.1563p AD=0.147p
+ PS=1.22u PD=1.54u rfmode=0
M$3090 VDD \$998 \$1018 VDD sg13_lv_pmos L=0.13u W=0.42u AS=0.1563p AD=0.063p
+ PS=1.22u PD=0.72u rfmode=0
M$3091 \$1018 \$1000 \$997 VDD sg13_lv_pmos L=0.13u W=0.42u AS=0.063p
+ AD=0.0798p PS=0.72u PD=0.8u rfmode=0
M$3092 \$997 \$999 \$996 VDD sg13_lv_pmos L=0.13u W=0.42u AS=0.0798p AD=0.1428p
+ PS=0.8u PD=1.52u rfmode=0
M$3093 \$1124 \$1060 VDD VDD sg13_lv_pmos L=0.13u W=1.12u AS=0.3864p
+ AD=0.41165p PS=2.93u PD=2.12u rfmode=0
M$3094 VDD \$498 \$1060 VDD sg13_lv_pmos L=0.13u W=1.12u AS=0.41165p AD=0.4088p
+ PS=2.12u PD=2.97u rfmode=0
M$3095 \$1062 \$1124 \$1146 VDD sg13_lv_pmos L=0.13u W=0.42u AS=0.2048p
+ AD=0.09345p PS=1.63u PD=0.865u rfmode=0
M$3096 \$1146 \$1063 VDD VDD sg13_lv_pmos L=0.13u W=0.42u AS=0.09345p AD=0.204p
+ PS=0.865u PD=1.835u rfmode=0
M$3097 VDD \$1058 \$1063 VDD sg13_lv_pmos L=0.13u W=0.42u AS=0.204p AD=0.0798p
+ PS=1.835u PD=0.8u rfmode=0
M$3098 \$1063 \$1062 VDD VDD sg13_lv_pmos L=0.13u W=0.42u AS=0.0798p AD=0.4659p
+ PS=0.8u PD=3.65u rfmode=0
M$3099 \$1057 \$1060 \$1062 VDD sg13_lv_pmos L=0.13u W=1u AS=0.34p AD=0.2048p
+ PS=2.68u PD=1.63u rfmode=0
M$3100 \$1064 \$1062 VDD VDD sg13_lv_pmos L=0.13u W=1.12u AS=0.3864p AD=0.2128p
+ PS=2.93u PD=1.5u rfmode=0
M$3101 VDD \$1064 \$1065 VDD sg13_lv_pmos L=0.13u W=1.12u AS=0.2128p AD=0.3808p
+ PS=1.5u PD=2.92u rfmode=0
M$3102 VDD \$411 \$1233 VDD sg13_lv_pmos L=0.13u W=1.12u AS=0.3808p AD=0.3808p
+ PS=2.92u PD=2.92u rfmode=0
M$3107 VDD \$605 \$1125 VDD sg13_lv_pmos L=0.13u W=0.84u AS=0.253p AD=0.2856p
+ PS=1.53u PD=2.36u rfmode=0
M$3108 VDD \$1125 \$1151 VDD sg13_lv_pmos L=0.13u W=1u AS=0.2198p AD=0.2975p
+ PS=1.52u PD=1.595u rfmode=0
M$3109 \$1151 \$621 \$1067 VDD sg13_lv_pmos L=0.13u W=1u AS=0.2975p AD=0.2225p
+ PS=1.595u PD=1.445u rfmode=0
M$3110 \$1067 \$1068 \$1152 VDD sg13_lv_pmos L=0.13u W=1u AS=0.2225p AD=0.3325p
+ PS=1.445u PD=1.665u rfmode=0
M$3111 \$1152 \$605 VDD VDD sg13_lv_pmos L=0.13u W=1u AS=0.3325p AD=0.253p
+ PS=1.665u PD=1.53u rfmode=0
M$3112 \$1066 \$1067 VDD VDD sg13_lv_pmos L=0.13u W=1.12u AS=0.6048p AD=0.2198p
+ PS=3.32u PD=1.52u rfmode=0
M$3117 VDD \$1069 \$1070 VDD sg13_lv_pmos L=0.13u W=1.12u AS=0.3808p AD=0.3808p
+ PS=2.92u PD=2.92u rfmode=0
M$3118 VDD \$1070 \$1153 VDD sg13_lv_pmos L=0.15u W=1.12u AS=0.3808p AD=0.2128p
+ PS=2.92u PD=1.5u rfmode=0
M$3119 \$1153 \$1005 \$1073 VDD sg13_lv_pmos L=0.15u W=1.12u AS=0.2128p
+ AD=0.2128p PS=1.5u PD=1.5u rfmode=0
M$3120 \$1073 \$1072 VDD VDD sg13_lv_pmos L=0.15u W=1.12u AS=0.2128p AD=0.3808p
+ PS=1.5u PD=2.92u rfmode=0
M$3121 VDD \$1006 \$1072 VDD sg13_lv_pmos L=0.15u W=1.12u AS=0.3808p AD=0.2128p
+ PS=2.92u PD=1.5u rfmode=0
M$3122 \$1072 \$350 \$1150 VDD sg13_lv_pmos L=0.15u W=1.12u AS=0.2128p
+ AD=0.2128p PS=1.5u PD=1.5u rfmode=0
M$3123 \$1150 \$1004 VDD VDD sg13_lv_pmos L=0.15u W=1.12u AS=0.2128p AD=0.3808p
+ PS=1.5u PD=2.92u rfmode=0
M$3127 \$1075 \$1004 VDD VDD sg13_lv_pmos L=0.13u W=0.84u AS=0.2856p AD=0.2618p
+ PS=2.36u PD=1.63u rfmode=0
M$3128 VDD \$1075 \$1148 VDD sg13_lv_pmos L=0.13u W=1.12u AS=0.2618p AD=0.1176p
+ PS=1.63u PD=1.33u rfmode=0
M$3129 \$1148 \$767 \$1126 VDD sg13_lv_pmos L=0.13u W=1.12u AS=0.1176p
+ AD=0.3808p PS=1.33u PD=2.92u rfmode=0
M$3130 VDD \$1127 \$1147 VDD sg13_lv_pmos L=0.15u W=1.12u AS=0.3808p AD=0.2128p
+ PS=2.92u PD=1.5u rfmode=0
M$3131 \$1147 \$1126 \$1077 VDD sg13_lv_pmos L=0.15u W=1.12u AS=0.2128p
+ AD=0.2128p PS=1.5u PD=1.5u rfmode=0
M$3132 \$1077 \$1008 VDD VDD sg13_lv_pmos L=0.15u W=1.12u AS=0.2128p AD=0.3808p
+ PS=1.5u PD=2.92u rfmode=0
M$3133 \$1078 \$342 VDD VDD sg13_lv_pmos L=0.13u W=1.12u AS=0.3808p AD=0.3808p
+ PS=2.92u PD=2.92u rfmode=0
M$3136 VDD \$342 \$1079 VDD sg13_lv_pmos L=0.13u W=1.12u AS=0.3808p AD=0.3808p
+ PS=2.92u PD=2.92u rfmode=0
M$3137 VDD \$1009 \$1080 VDD sg13_lv_pmos L=0.13u W=0.42u AS=0.1428p AD=0.0798p
+ PS=1.52u PD=0.8u rfmode=0
M$3138 VDD \$1079 \$1080 VDD sg13_lv_pmos L=0.13u W=0.42u AS=0.3623875p
+ AD=0.0798p PS=2.605u PD=0.8u rfmode=0
M$3139 VDD \$1128 \$1081 VDD sg13_lv_pmos L=0.13u W=1u AS=0.3623875p AD=0.34p
+ PS=2.605u PD=2.68u rfmode=0
M$3140 \$1129 \$1083 VDD VDD sg13_lv_pmos L=0.13u W=1.12u AS=0.3864p
+ AD=0.41165p PS=2.93u PD=2.12u rfmode=0
M$3141 VDD \$508 \$1083 VDD sg13_lv_pmos L=0.13u W=1.12u AS=0.41165p AD=0.4088p
+ PS=2.12u PD=2.97u rfmode=0
M$3142 \$1085 \$1129 \$1142 VDD sg13_lv_pmos L=0.13u W=0.42u AS=0.2048p
+ AD=0.09345p PS=1.63u PD=0.865u rfmode=0
M$3143 \$1142 \$1086 VDD VDD sg13_lv_pmos L=0.13u W=0.42u AS=0.09345p AD=0.204p
+ PS=0.865u PD=1.835u rfmode=0
M$3144 VDD \$1079 \$1086 VDD sg13_lv_pmos L=0.13u W=0.42u AS=0.204p AD=0.0798p
+ PS=1.835u PD=0.8u rfmode=0
M$3145 \$1086 \$1085 VDD VDD sg13_lv_pmos L=0.13u W=0.42u AS=0.0798p AD=0.4659p
+ PS=0.8u PD=3.65u rfmode=0
M$3146 \$1081 \$1083 \$1085 VDD sg13_lv_pmos L=0.13u W=1u AS=0.34p AD=0.2048p
+ PS=2.68u PD=1.63u rfmode=0
M$3147 \$1087 \$1085 VDD VDD sg13_lv_pmos L=0.13u W=1.12u AS=0.3864p AD=0.2128p
+ PS=2.93u PD=1.5u rfmode=0
M$3148 VDD \$1087 \$1011 VDD sg13_lv_pmos L=0.13u W=1.12u AS=0.2128p AD=0.3808p
+ PS=1.5u PD=2.92u rfmode=0
M$3149 \$1088 \$887 VDD VDD sg13_lv_pmos L=0.13u W=1.12u AS=0.3808p AD=0.3808p
+ PS=2.92u PD=2.92u rfmode=0
M$3150 VDD \$887 \$1089 VDD sg13_lv_pmos L=0.13u W=1.12u AS=0.3808p AD=0.3808p
+ PS=2.92u PD=2.92u rfmode=0
M$3151 VDD \$1014 \$1090 VDD sg13_lv_pmos L=0.13u W=0.42u AS=0.1428p AD=0.0798p
+ PS=1.52u PD=0.8u rfmode=0
M$3152 VDD \$1089 \$1090 VDD sg13_lv_pmos L=0.13u W=0.42u AS=0.3623875p
+ AD=0.0798p PS=2.605u PD=0.8u rfmode=0
M$3153 VDD \$1130 \$1091 VDD sg13_lv_pmos L=0.13u W=1u AS=0.3623875p AD=0.34p
+ PS=2.605u PD=2.68u rfmode=0
M$3154 \$1131 \$1093 VDD VDD sg13_lv_pmos L=0.13u W=1.12u AS=0.3864p
+ AD=0.41165p PS=2.93u PD=2.12u rfmode=0
M$3155 VDD \$1094 \$1093 VDD sg13_lv_pmos L=0.13u W=1.12u AS=0.41165p
+ AD=0.4088p PS=2.12u PD=2.97u rfmode=0
M$3156 \$1096 \$1131 \$1137 VDD sg13_lv_pmos L=0.13u W=0.42u AS=0.2048p
+ AD=0.09345p PS=1.63u PD=0.865u rfmode=0
M$3157 \$1137 \$1097 VDD VDD sg13_lv_pmos L=0.13u W=0.42u AS=0.09345p AD=0.204p
+ PS=0.865u PD=1.835u rfmode=0
M$3158 VDD \$1089 \$1097 VDD sg13_lv_pmos L=0.13u W=0.42u AS=0.204p AD=0.0798p
+ PS=1.835u PD=0.8u rfmode=0
M$3159 \$1097 \$1096 VDD VDD sg13_lv_pmos L=0.13u W=0.42u AS=0.0798p AD=0.4659p
+ PS=0.8u PD=3.65u rfmode=0
M$3160 \$1091 \$1093 \$1096 VDD sg13_lv_pmos L=0.13u W=1u AS=0.34p AD=0.2048p
+ PS=2.68u PD=1.63u rfmode=0
M$3161 \$1098 \$1096 VDD VDD sg13_lv_pmos L=0.13u W=1.12u AS=0.3864p AD=0.2128p
+ PS=2.93u PD=1.5u rfmode=0
M$3162 VDD \$1098 \$1037 VDD sg13_lv_pmos L=0.13u W=1.12u AS=0.2128p AD=0.3808p
+ PS=1.5u PD=2.92u rfmode=0
M$3164 VDD \$887 \$1099 VDD sg13_lv_pmos L=0.13u W=1.12u AS=0.3808p AD=0.3808p
+ PS=2.92u PD=2.92u rfmode=0
M$3165 VDD \$1301 \$1100 VDD sg13_lv_pmos L=0.13u W=0.42u AS=0.1428p AD=0.0798p
+ PS=1.52u PD=0.8u rfmode=0
M$3166 VDD \$1099 \$1100 VDD sg13_lv_pmos L=0.13u W=0.42u AS=0.3623875p
+ AD=0.0798p PS=2.605u PD=0.8u rfmode=0
M$3167 VDD \$1132 \$1101 VDD sg13_lv_pmos L=0.13u W=1u AS=0.3623875p AD=0.34p
+ PS=2.605u PD=2.68u rfmode=0
M$3168 \$1133 \$1103 VDD VDD sg13_lv_pmos L=0.13u W=1.12u AS=0.3864p
+ AD=0.41165p PS=2.93u PD=2.12u rfmode=0
M$3169 VDD \$1094 \$1103 VDD sg13_lv_pmos L=0.13u W=1.12u AS=0.41165p
+ AD=0.4088p PS=2.12u PD=2.97u rfmode=0
M$3170 \$1105 \$1133 \$1135 VDD sg13_lv_pmos L=0.13u W=0.42u AS=0.2048p
+ AD=0.09345p PS=1.63u PD=0.865u rfmode=0
M$3171 \$1135 \$1106 VDD VDD sg13_lv_pmos L=0.13u W=0.42u AS=0.09345p AD=0.204p
+ PS=0.865u PD=1.835u rfmode=0
M$3172 VDD \$1099 \$1106 VDD sg13_lv_pmos L=0.13u W=0.42u AS=0.204p AD=0.0798p
+ PS=1.835u PD=0.8u rfmode=0
M$3173 \$1106 \$1105 VDD VDD sg13_lv_pmos L=0.13u W=0.42u AS=0.0798p AD=0.4659p
+ PS=0.8u PD=3.65u rfmode=0
M$3174 \$1101 \$1103 \$1105 VDD sg13_lv_pmos L=0.13u W=1u AS=0.34p AD=0.2048p
+ PS=2.68u PD=1.63u rfmode=0
M$3175 \$1107 \$1105 VDD VDD sg13_lv_pmos L=0.13u W=1.12u AS=0.3864p AD=0.2128p
+ PS=2.93u PD=1.5u rfmode=0
M$3176 VDD \$1107 \$1108 VDD sg13_lv_pmos L=0.13u W=1.12u AS=0.2128p AD=0.3808p
+ PS=1.5u PD=2.92u rfmode=0
M$3203 VDD \$421 \$1058 VDD sg13_lv_pmos L=0.13u W=1.12u AS=0.3808p AD=0.3808p
+ PS=2.92u PD=2.92u rfmode=0
M$3204 \$1123 \$1058 VDD VDD sg13_lv_pmos L=0.13u W=0.42u AS=0.147p AD=0.1563p
+ PS=1.54u PD=1.22u rfmode=0
M$3205 VDD \$1057 \$1143 VDD sg13_lv_pmos L=0.13u W=0.42u AS=0.1563p AD=0.063p
+ PS=1.22u PD=0.72u rfmode=0
M$3206 \$1143 \$1060 \$1123 VDD sg13_lv_pmos L=0.13u W=0.42u AS=0.063p
+ AD=0.0798p PS=0.72u PD=0.8u rfmode=0
M$3207 \$1123 \$1124 \$1055 VDD sg13_lv_pmos L=0.13u W=0.42u AS=0.0798p
+ AD=0.1428p PS=0.8u PD=1.52u rfmode=0
M$3208 \$1056 \$1232 VDD VDD sg13_lv_pmos L=0.13u W=1.12u AS=0.6048p AD=0.2198p
+ PS=3.32u PD=1.52u rfmode=0
M$3209 VDD \$1155 \$1214 VDD sg13_lv_pmos L=0.13u W=1u AS=0.2198p AD=0.2975p
+ PS=1.52u PD=1.595u rfmode=0
M$3210 \$1214 \$621 \$1232 VDD sg13_lv_pmos L=0.13u W=1u AS=0.2975p AD=0.2225p
+ PS=1.595u PD=1.445u rfmode=0
M$3211 \$1232 \$1065 \$1215 VDD sg13_lv_pmos L=0.13u W=1u AS=0.2225p AD=0.3325p
+ PS=1.445u PD=1.665u rfmode=0
M$3212 \$1215 \$926 VDD VDD sg13_lv_pmos L=0.13u W=1u AS=0.3325p AD=0.253p
+ PS=1.665u PD=1.53u rfmode=0
M$3213 VDD \$926 \$1155 VDD sg13_lv_pmos L=0.13u W=0.84u AS=0.253p AD=0.2856p
+ PS=1.53u PD=2.36u rfmode=0
M$3214 VDD \$1287 \$1156 VDD sg13_lv_pmos L=0.13u W=0.42u AS=0.1428p AD=0.0798p
+ PS=1.52u PD=0.8u rfmode=0
M$3215 VDD \$1233 \$1156 VDD sg13_lv_pmos L=0.13u W=0.42u AS=0.3623875p
+ AD=0.0798p PS=2.605u PD=0.8u rfmode=0
M$3216 VDD \$1158 \$1157 VDD sg13_lv_pmos L=0.13u W=1u AS=0.3623875p AD=0.34p
+ PS=2.605u PD=2.68u rfmode=0
M$3217 VDD \$1233 \$1158 VDD sg13_lv_pmos L=0.13u W=0.42u AS=0.1563p AD=0.147p
+ PS=1.22u PD=1.54u rfmode=0
M$3218 VDD \$1157 \$1216 VDD sg13_lv_pmos L=0.13u W=0.42u AS=0.1563p AD=0.063p
+ PS=1.22u PD=0.72u rfmode=0
M$3219 \$1216 \$1160 \$1158 VDD sg13_lv_pmos L=0.13u W=0.42u AS=0.063p
+ AD=0.0798p PS=0.72u PD=0.8u rfmode=0
M$3220 \$1158 \$1159 \$1156 VDD sg13_lv_pmos L=0.13u W=0.42u AS=0.0798p
+ AD=0.1428p PS=0.8u PD=1.52u rfmode=0
M$3221 VDD \$1160 \$1159 VDD sg13_lv_pmos L=0.13u W=1.12u AS=0.41165p
+ AD=0.3864p PS=2.12u PD=2.93u rfmode=0
M$3222 VDD \$498 \$1160 VDD sg13_lv_pmos L=0.13u W=1.12u AS=0.41165p AD=0.4088p
+ PS=2.12u PD=2.97u rfmode=0
M$3223 \$1157 \$1160 \$1161 VDD sg13_lv_pmos L=0.13u W=1u AS=0.34p AD=0.2048p
+ PS=2.68u PD=1.63u rfmode=0
M$3224 \$1161 \$1159 \$1217 VDD sg13_lv_pmos L=0.13u W=0.42u AS=0.2048p
+ AD=0.09345p PS=1.63u PD=0.865u rfmode=0
M$3225 VDD \$1162 \$1217 VDD sg13_lv_pmos L=0.13u W=0.42u AS=0.204p AD=0.09345p
+ PS=1.835u PD=0.865u rfmode=0
M$3226 VDD \$1233 \$1162 VDD sg13_lv_pmos L=0.13u W=0.42u AS=0.204p AD=0.0798p
+ PS=1.835u PD=0.8u rfmode=0
M$3227 VDD \$1161 \$1162 VDD sg13_lv_pmos L=0.13u W=0.42u AS=0.4659p AD=0.0798p
+ PS=3.65u PD=0.8u rfmode=0
M$3228 \$1163 \$1161 VDD VDD sg13_lv_pmos L=0.13u W=1.12u AS=0.3864p AD=0.2128p
+ PS=2.93u PD=1.5u rfmode=0
M$3229 VDD \$1163 \$1282 VDD sg13_lv_pmos L=0.13u W=1.12u AS=0.2128p AD=0.3808p
+ PS=1.5u PD=2.92u rfmode=0
M$3230 VDD \$1066 \$1164 VDD sg13_lv_pmos L=0.13u W=0.42u AS=0.1428p AD=0.0798p
+ PS=1.52u PD=0.8u rfmode=0
M$3231 VDD \$1167 \$1164 VDD sg13_lv_pmos L=0.13u W=0.42u AS=0.3623875p
+ AD=0.0798p PS=2.605u PD=0.8u rfmode=0
M$3232 VDD \$1166 \$1165 VDD sg13_lv_pmos L=0.13u W=1u AS=0.3623875p AD=0.34p
+ PS=2.605u PD=2.68u rfmode=0
M$3233 VDD \$1167 \$1166 VDD sg13_lv_pmos L=0.13u W=0.42u AS=0.1563p AD=0.147p
+ PS=1.22u PD=1.54u rfmode=0
M$3234 VDD \$1165 \$1218 VDD sg13_lv_pmos L=0.13u W=0.42u AS=0.1563p AD=0.063p
+ PS=1.22u PD=0.72u rfmode=0
M$3235 \$1218 \$1169 \$1166 VDD sg13_lv_pmos L=0.13u W=0.42u AS=0.063p
+ AD=0.0798p PS=0.72u PD=0.8u rfmode=0
M$3236 \$1166 \$1168 \$1164 VDD sg13_lv_pmos L=0.13u W=0.42u AS=0.0798p
+ AD=0.1428p PS=0.8u PD=1.52u rfmode=0
M$3237 VDD \$1169 \$1168 VDD sg13_lv_pmos L=0.13u W=1.12u AS=0.41165p
+ AD=0.3864p PS=2.12u PD=2.93u rfmode=0
M$3238 VDD \$741 \$1169 VDD sg13_lv_pmos L=0.13u W=1.12u AS=0.41165p AD=0.4088p
+ PS=2.12u PD=2.97u rfmode=0
M$3239 \$1165 \$1169 \$1170 VDD sg13_lv_pmos L=0.13u W=1u AS=0.34p AD=0.2048p
+ PS=2.68u PD=1.63u rfmode=0
M$3240 \$1170 \$1168 \$1220 VDD sg13_lv_pmos L=0.13u W=0.42u AS=0.2048p
+ AD=0.09345p PS=1.63u PD=0.865u rfmode=0
M$3241 VDD \$1171 \$1220 VDD sg13_lv_pmos L=0.13u W=0.42u AS=0.204p AD=0.09345p
+ PS=1.835u PD=0.865u rfmode=0
M$3242 VDD \$1167 \$1171 VDD sg13_lv_pmos L=0.13u W=0.42u AS=0.204p AD=0.0798p
+ PS=1.835u PD=0.8u rfmode=0
M$3243 VDD \$1170 \$1171 VDD sg13_lv_pmos L=0.13u W=0.42u AS=0.4659p AD=0.0798p
+ PS=3.65u PD=0.8u rfmode=0
M$3244 \$1172 \$1170 VDD VDD sg13_lv_pmos L=0.13u W=1.12u AS=0.3864p AD=0.2128p
+ PS=2.93u PD=1.5u rfmode=0
M$3245 VDD \$1172 \$1068 VDD sg13_lv_pmos L=0.13u W=1.12u AS=0.2128p AD=0.3808p
+ PS=1.5u PD=2.92u rfmode=0
M$3246 VDD \$1073 \$1173 VDD sg13_lv_pmos L=0.13u W=0.42u AS=0.1428p AD=0.0798p
+ PS=1.52u PD=0.8u rfmode=0
M$3247 VDD \$1176 \$1173 VDD sg13_lv_pmos L=0.13u W=0.42u AS=0.3623875p
+ AD=0.0798p PS=2.605u PD=0.8u rfmode=0
M$3248 VDD \$1175 \$1174 VDD sg13_lv_pmos L=0.13u W=1u AS=0.3623875p AD=0.34p
+ PS=2.605u PD=2.68u rfmode=0
M$3249 VDD \$1176 \$1175 VDD sg13_lv_pmos L=0.13u W=0.42u AS=0.1563p AD=0.147p
+ PS=1.22u PD=1.54u rfmode=0
M$3250 VDD \$1174 \$1221 VDD sg13_lv_pmos L=0.13u W=0.42u AS=0.1563p AD=0.063p
+ PS=1.22u PD=0.72u rfmode=0
M$3251 \$1221 \$1178 \$1175 VDD sg13_lv_pmos L=0.13u W=0.42u AS=0.063p
+ AD=0.0798p PS=0.72u PD=0.8u rfmode=0
M$3252 \$1175 \$1177 \$1173 VDD sg13_lv_pmos L=0.13u W=0.42u AS=0.0798p
+ AD=0.1428p PS=0.8u PD=1.52u rfmode=0
M$3253 VDD \$1178 \$1177 VDD sg13_lv_pmos L=0.13u W=1.12u AS=0.41165p
+ AD=0.3864p PS=2.12u PD=2.93u rfmode=0
M$3254 VDD \$741 \$1178 VDD sg13_lv_pmos L=0.13u W=1.12u AS=0.41165p AD=0.4088p
+ PS=2.12u PD=2.97u rfmode=0
M$3255 \$1174 \$1178 \$1179 VDD sg13_lv_pmos L=0.13u W=1u AS=0.34p AD=0.2048p
+ PS=2.68u PD=1.63u rfmode=0
M$3256 \$1179 \$1177 \$1222 VDD sg13_lv_pmos L=0.13u W=0.42u AS=0.2048p
+ AD=0.09345p PS=1.63u PD=0.865u rfmode=0
M$3257 VDD \$1180 \$1222 VDD sg13_lv_pmos L=0.13u W=0.42u AS=0.204p AD=0.09345p
+ PS=1.835u PD=0.865u rfmode=0
M$3258 VDD \$1176 \$1180 VDD sg13_lv_pmos L=0.13u W=0.42u AS=0.204p AD=0.0798p
+ PS=1.835u PD=0.8u rfmode=0
M$3259 VDD \$1179 \$1180 VDD sg13_lv_pmos L=0.13u W=0.42u AS=0.4659p AD=0.0798p
+ PS=3.65u PD=0.8u rfmode=0
M$3260 \$1181 \$1179 VDD VDD sg13_lv_pmos L=0.13u W=1.12u AS=0.3864p AD=0.2128p
+ PS=2.93u PD=1.5u rfmode=0
M$3261 VDD \$1181 \$1069 VDD sg13_lv_pmos L=0.13u W=1.12u AS=0.2128p AD=0.3808p
+ PS=1.5u PD=2.92u rfmode=0
M$3262 VDD \$1077 \$1182 VDD sg13_lv_pmos L=0.13u W=0.42u AS=0.1428p AD=0.0798p
+ PS=1.52u PD=0.8u rfmode=0
M$3263 VDD \$1078 \$1182 VDD sg13_lv_pmos L=0.13u W=0.42u AS=0.3623875p
+ AD=0.0798p PS=2.605u PD=0.8u rfmode=0
M$3264 VDD \$1184 \$1183 VDD sg13_lv_pmos L=0.13u W=1u AS=0.3623875p AD=0.34p
+ PS=2.605u PD=2.68u rfmode=0
M$3265 VDD \$1078 \$1184 VDD sg13_lv_pmos L=0.13u W=0.42u AS=0.1563p AD=0.147p
+ PS=1.22u PD=1.54u rfmode=0
M$3266 VDD \$1183 \$1224 VDD sg13_lv_pmos L=0.13u W=0.42u AS=0.1563p AD=0.063p
+ PS=1.22u PD=0.72u rfmode=0
M$3267 \$1224 \$1186 \$1184 VDD sg13_lv_pmos L=0.13u W=0.42u AS=0.063p
+ AD=0.0798p PS=0.72u PD=0.8u rfmode=0
M$3268 \$1184 \$1185 \$1182 VDD sg13_lv_pmos L=0.13u W=0.42u AS=0.0798p
+ AD=0.1428p PS=0.8u PD=1.52u rfmode=0
M$3269 VDD \$1186 \$1185 VDD sg13_lv_pmos L=0.13u W=1.12u AS=0.41165p
+ AD=0.3864p PS=2.12u PD=2.93u rfmode=0
M$3270 VDD \$508 \$1186 VDD sg13_lv_pmos L=0.13u W=1.12u AS=0.41165p AD=0.4088p
+ PS=2.12u PD=2.97u rfmode=0
M$3271 \$1183 \$1186 \$1187 VDD sg13_lv_pmos L=0.13u W=1u AS=0.34p AD=0.2048p
+ PS=2.68u PD=1.63u rfmode=0
M$3272 \$1187 \$1185 \$1225 VDD sg13_lv_pmos L=0.13u W=0.42u AS=0.2048p
+ AD=0.09345p PS=1.63u PD=0.865u rfmode=0
M$3273 VDD \$1188 \$1225 VDD sg13_lv_pmos L=0.13u W=0.42u AS=0.204p AD=0.09345p
+ PS=1.835u PD=0.865u rfmode=0
M$3274 VDD \$1078 \$1188 VDD sg13_lv_pmos L=0.13u W=0.42u AS=0.204p AD=0.0798p
+ PS=1.835u PD=0.8u rfmode=0
M$3275 VDD \$1187 \$1188 VDD sg13_lv_pmos L=0.13u W=0.42u AS=0.4659p AD=0.0798p
+ PS=3.65u PD=0.8u rfmode=0
M$3276 \$1189 \$1187 VDD VDD sg13_lv_pmos L=0.13u W=1.12u AS=0.3864p AD=0.2128p
+ PS=2.93u PD=1.5u rfmode=0
M$3277 VDD \$1189 \$1190 VDD sg13_lv_pmos L=0.13u W=1.12u AS=0.2128p AD=0.3808p
+ PS=1.5u PD=2.92u rfmode=0
M$3278 \$1128 \$1079 VDD VDD sg13_lv_pmos L=0.13u W=0.42u AS=0.147p AD=0.1563p
+ PS=1.54u PD=1.22u rfmode=0
M$3279 VDD \$1081 \$1144 VDD sg13_lv_pmos L=0.13u W=0.42u AS=0.1563p AD=0.063p
+ PS=1.22u PD=0.72u rfmode=0
M$3280 \$1144 \$1083 \$1128 VDD sg13_lv_pmos L=0.13u W=0.42u AS=0.063p
+ AD=0.0798p PS=0.72u PD=0.8u rfmode=0
M$3281 \$1128 \$1129 \$1080 VDD sg13_lv_pmos L=0.13u W=0.42u AS=0.0798p
+ AD=0.1428p PS=0.8u PD=1.52u rfmode=0
M$3284 VDD \$1005 \$1191 VDD sg13_lv_pmos L=0.13u W=0.84u AS=0.253p AD=0.2856p
+ PS=1.53u PD=2.36u rfmode=0
M$3285 VDD \$1005 \$1226 VDD sg13_lv_pmos L=0.13u W=1u AS=0.253p AD=0.3325p
+ PS=1.53u PD=1.665u rfmode=0
M$3286 \$1226 \$1202 \$1192 VDD sg13_lv_pmos L=0.13u W=1u AS=0.3325p AD=0.2225p
+ PS=1.665u PD=1.445u rfmode=0
M$3287 \$1192 \$687 \$1227 VDD sg13_lv_pmos L=0.13u W=1u AS=0.2225p AD=0.2975p
+ PS=1.445u PD=1.595u rfmode=0
M$3288 VDD \$1191 \$1227 VDD sg13_lv_pmos L=0.13u W=1u AS=0.2198p AD=0.2975p
+ PS=1.52u PD=1.595u rfmode=0
M$3289 VDD \$1192 \$1193 VDD sg13_lv_pmos L=0.13u W=1.12u AS=0.2198p AD=0.6048p
+ PS=1.52u PD=3.32u rfmode=0
M$3290 VDD \$1193 \$1194 VDD sg13_lv_pmos L=0.13u W=0.42u AS=0.1428p AD=0.0798p
+ PS=1.52u PD=0.8u rfmode=0
M$3291 VDD \$1088 \$1194 VDD sg13_lv_pmos L=0.13u W=0.42u AS=0.3623875p
+ AD=0.0798p PS=2.605u PD=0.8u rfmode=0
M$3292 VDD \$1196 \$1195 VDD sg13_lv_pmos L=0.13u W=1u AS=0.3623875p AD=0.34p
+ PS=2.605u PD=2.68u rfmode=0
M$3293 VDD \$1088 \$1196 VDD sg13_lv_pmos L=0.13u W=0.42u AS=0.1563p AD=0.147p
+ PS=1.22u PD=1.54u rfmode=0
M$3294 VDD \$1195 \$1228 VDD sg13_lv_pmos L=0.13u W=0.42u AS=0.1563p AD=0.063p
+ PS=1.22u PD=0.72u rfmode=0
M$3295 \$1228 \$1198 \$1196 VDD sg13_lv_pmos L=0.13u W=0.42u AS=0.063p
+ AD=0.0798p PS=0.72u PD=0.8u rfmode=0
M$3296 \$1196 \$1197 \$1194 VDD sg13_lv_pmos L=0.13u W=0.42u AS=0.0798p
+ AD=0.1428p PS=0.8u PD=1.52u rfmode=0
M$3297 VDD \$1198 \$1197 VDD sg13_lv_pmos L=0.13u W=1.12u AS=0.41165p
+ AD=0.3864p PS=2.12u PD=2.93u rfmode=0
M$3298 VDD \$1094 \$1198 VDD sg13_lv_pmos L=0.13u W=1.12u AS=0.41165p
+ AD=0.4088p PS=2.12u PD=2.97u rfmode=0
M$3299 \$1130 \$1089 VDD VDD sg13_lv_pmos L=0.13u W=0.42u AS=0.147p AD=0.1563p
+ PS=1.54u PD=1.22u rfmode=0
M$3300 VDD \$1091 \$1138 VDD sg13_lv_pmos L=0.13u W=0.42u AS=0.1563p AD=0.063p
+ PS=1.22u PD=0.72u rfmode=0
M$3301 \$1138 \$1093 \$1130 VDD sg13_lv_pmos L=0.13u W=0.42u AS=0.063p
+ AD=0.0798p PS=0.72u PD=0.8u rfmode=0
M$3302 \$1130 \$1131 \$1090 VDD sg13_lv_pmos L=0.13u W=0.42u AS=0.0798p
+ AD=0.1428p PS=0.8u PD=1.52u rfmode=0
M$3303 \$1195 \$1198 \$1199 VDD sg13_lv_pmos L=0.13u W=1u AS=0.34p AD=0.2048p
+ PS=2.68u PD=1.63u rfmode=0
M$3304 \$1199 \$1197 \$1231 VDD sg13_lv_pmos L=0.13u W=0.42u AS=0.2048p
+ AD=0.09345p PS=1.63u PD=0.865u rfmode=0
M$3305 VDD \$1200 \$1231 VDD sg13_lv_pmos L=0.13u W=0.42u AS=0.204p AD=0.09345p
+ PS=1.835u PD=0.865u rfmode=0
M$3306 VDD \$1088 \$1200 VDD sg13_lv_pmos L=0.13u W=0.42u AS=0.204p AD=0.0798p
+ PS=1.835u PD=0.8u rfmode=0
M$3307 VDD \$1199 \$1200 VDD sg13_lv_pmos L=0.13u W=0.42u AS=0.4659p AD=0.0798p
+ PS=3.65u PD=0.8u rfmode=0
M$3308 \$1201 \$1199 VDD VDD sg13_lv_pmos L=0.13u W=1.12u AS=0.3864p AD=0.2128p
+ PS=2.93u PD=1.5u rfmode=0
M$3309 VDD \$1201 \$1202 VDD sg13_lv_pmos L=0.13u W=1.12u AS=0.2128p AD=0.3808p
+ PS=1.5u PD=2.92u rfmode=0
M$3312 VDD \$1126 \$1203 VDD sg13_lv_pmos L=0.13u W=0.84u AS=0.253p AD=0.2856p
+ PS=1.53u PD=2.36u rfmode=0
M$3313 VDD \$1126 \$1230 VDD sg13_lv_pmos L=0.13u W=1u AS=0.253p AD=0.3325p
+ PS=1.53u PD=1.665u rfmode=0
M$3314 \$1230 \$1234 \$1204 VDD sg13_lv_pmos L=0.13u W=1u AS=0.3325p AD=0.2225p
+ PS=1.665u PD=1.445u rfmode=0
M$3315 \$1204 \$687 \$1229 VDD sg13_lv_pmos L=0.13u W=1u AS=0.2225p AD=0.2975p
+ PS=1.445u PD=1.595u rfmode=0
M$3316 VDD \$1203 \$1229 VDD sg13_lv_pmos L=0.13u W=1u AS=0.2198p AD=0.2975p
+ PS=1.52u PD=1.595u rfmode=0
M$3317 VDD \$1204 \$1205 VDD sg13_lv_pmos L=0.13u W=1.12u AS=0.2198p AD=0.6048p
+ PS=1.52u PD=3.32u rfmode=0
M$3318 VDD \$1205 \$1206 VDD sg13_lv_pmos L=0.13u W=0.42u AS=0.1428p AD=0.0798p
+ PS=1.52u PD=0.8u rfmode=0
M$3319 VDD \$1235 \$1206 VDD sg13_lv_pmos L=0.13u W=0.42u AS=0.3623875p
+ AD=0.0798p PS=2.605u PD=0.8u rfmode=0
M$3320 VDD \$1208 \$1207 VDD sg13_lv_pmos L=0.13u W=1u AS=0.3623875p AD=0.34p
+ PS=2.605u PD=2.68u rfmode=0
M$3321 VDD \$1235 \$1208 VDD sg13_lv_pmos L=0.13u W=0.42u AS=0.1563p AD=0.147p
+ PS=1.22u PD=1.54u rfmode=0
M$3322 VDD \$1207 \$1223 VDD sg13_lv_pmos L=0.13u W=0.42u AS=0.1563p AD=0.063p
+ PS=1.22u PD=0.72u rfmode=0
M$3323 \$1223 \$1210 \$1208 VDD sg13_lv_pmos L=0.13u W=0.42u AS=0.063p
+ AD=0.0798p PS=0.72u PD=0.8u rfmode=0
M$3324 \$1208 \$1209 \$1206 VDD sg13_lv_pmos L=0.13u W=0.42u AS=0.0798p
+ AD=0.1428p PS=0.8u PD=1.52u rfmode=0
M$3325 \$1132 \$1099 VDD VDD sg13_lv_pmos L=0.13u W=0.42u AS=0.147p AD=0.1563p
+ PS=1.54u PD=1.22u rfmode=0
M$3326 VDD \$1101 \$1136 VDD sg13_lv_pmos L=0.13u W=0.42u AS=0.1563p AD=0.063p
+ PS=1.22u PD=0.72u rfmode=0
M$3327 \$1136 \$1103 \$1132 VDD sg13_lv_pmos L=0.13u W=0.42u AS=0.063p
+ AD=0.0798p PS=0.72u PD=0.8u rfmode=0
M$3328 \$1132 \$1133 \$1100 VDD sg13_lv_pmos L=0.13u W=0.42u AS=0.0798p
+ AD=0.1428p PS=0.8u PD=1.52u rfmode=0
M$3329 VDD \$1210 \$1209 VDD sg13_lv_pmos L=0.13u W=1.12u AS=0.41165p
+ AD=0.3864p PS=2.12u PD=2.93u rfmode=0
M$3330 VDD \$1094 \$1210 VDD sg13_lv_pmos L=0.13u W=1.12u AS=0.41165p
+ AD=0.4088p PS=2.12u PD=2.97u rfmode=0
M$3331 \$1207 \$1210 \$1211 VDD sg13_lv_pmos L=0.13u W=1u AS=0.34p AD=0.2048p
+ PS=2.68u PD=1.63u rfmode=0
M$3332 \$1211 \$1209 \$1219 VDD sg13_lv_pmos L=0.13u W=0.42u AS=0.2048p
+ AD=0.09345p PS=1.63u PD=0.865u rfmode=0
M$3333 VDD \$1212 \$1219 VDD sg13_lv_pmos L=0.13u W=0.42u AS=0.204p AD=0.09345p
+ PS=1.835u PD=0.865u rfmode=0
M$3334 VDD \$1235 \$1212 VDD sg13_lv_pmos L=0.13u W=0.42u AS=0.204p AD=0.0798p
+ PS=1.835u PD=0.8u rfmode=0
M$3335 VDD \$1211 \$1212 VDD sg13_lv_pmos L=0.13u W=0.42u AS=0.4659p AD=0.0798p
+ PS=3.65u PD=0.8u rfmode=0
M$3336 \$1213 \$1211 VDD VDD sg13_lv_pmos L=0.13u W=1.12u AS=0.3864p AD=0.2128p
+ PS=2.93u PD=1.5u rfmode=0
M$3337 VDD \$1213 \$1234 VDD sg13_lv_pmos L=0.13u W=1.12u AS=0.2128p AD=0.3808p
+ PS=1.5u PD=2.92u rfmode=0
M$3343 \$30 \$1278 VDD VDD sg13_lv_pmos L=0.13u W=1.12u AS=0.42p AD=0.2114p
+ PS=2.99u PD=1.54u rfmode=0
M$3344 VDD \$1069 \$1278 VDD sg13_lv_pmos L=0.13u W=0.84u AS=0.2114p AD=0.2856p
+ PS=1.54u PD=2.36u rfmode=0
M$3345 \$29 \$1279 VDD VDD sg13_lv_pmos L=0.13u W=1.12u AS=0.42p AD=0.2114p
+ PS=2.99u PD=1.54u rfmode=0
M$3346 VDD \$1190 \$1279 VDD sg13_lv_pmos L=0.13u W=0.84u AS=0.2114p AD=0.2856p
+ PS=1.54u PD=2.36u rfmode=0
M$3349 D0 \$1281 VDD VDD sg13_lv_pmos L=0.13u W=1.12u AS=0.42p AD=0.2114p
+ PS=2.99u PD=1.54u rfmode=0
M$3350 VDD \$1282 \$1281 VDD sg13_lv_pmos L=0.13u W=0.84u AS=0.2114p AD=0.2856p
+ PS=1.54u PD=2.36u rfmode=0
M$3361 D1 \$1284 VDD VDD sg13_lv_pmos L=0.13u W=1.12u AS=0.42p AD=0.2114p
+ PS=2.99u PD=1.54u rfmode=0
M$3362 VDD \$919 \$1284 VDD sg13_lv_pmos L=0.13u W=0.84u AS=0.2114p AD=0.2856p
+ PS=1.54u PD=2.36u rfmode=0
M$3372 D2 \$1286 VDD VDD sg13_lv_pmos L=0.13u W=1.12u AS=0.42p AD=0.2114p
+ PS=2.99u PD=1.54u rfmode=0
M$3373 VDD \$1065 \$1286 VDD sg13_lv_pmos L=0.13u W=0.84u AS=0.2114p AD=0.2856p
+ PS=1.54u PD=2.36u rfmode=0
M$3374 VDD \$793 \$1289 VDD sg13_lv_pmos L=0.13u W=0.84u AS=0.253p AD=0.2856p
+ PS=1.53u PD=2.36u rfmode=0
M$3375 VDD \$1289 \$1317 VDD sg13_lv_pmos L=0.13u W=1u AS=0.2198p AD=0.2975p
+ PS=1.52u PD=1.595u rfmode=0
M$3376 \$1317 \$621 \$1288 VDD sg13_lv_pmos L=0.13u W=1u AS=0.2975p AD=0.2225p
+ PS=1.595u PD=1.445u rfmode=0
M$3377 \$1288 \$1282 \$1318 VDD sg13_lv_pmos L=0.13u W=1u AS=0.2225p AD=0.3325p
+ PS=1.445u PD=1.665u rfmode=0
M$3378 \$1318 \$793 VDD VDD sg13_lv_pmos L=0.13u W=1u AS=0.3325p AD=0.253p
+ PS=1.665u PD=1.53u rfmode=0
M$3379 \$1287 \$1288 VDD VDD sg13_lv_pmos L=0.13u W=1.12u AS=0.6048p AD=0.2198p
+ PS=3.32u PD=1.52u rfmode=0
M$3383 VDD \$421 \$1167 VDD sg13_lv_pmos L=0.13u W=1.12u AS=0.3808p AD=0.3808p
+ PS=2.92u PD=2.92u rfmode=0
M$3387 D3 \$1291 VDD VDD sg13_lv_pmos L=0.13u W=1.12u AS=0.42p AD=0.2114p
+ PS=2.99u PD=1.54u rfmode=0
M$3388 VDD \$1068 \$1291 VDD sg13_lv_pmos L=0.13u W=0.84u AS=0.2114p AD=0.2856p
+ PS=1.54u PD=2.36u rfmode=0
M$3391 VDD \$421 \$1176 VDD sg13_lv_pmos L=0.13u W=1.12u AS=0.3808p AD=0.3808p
+ PS=2.92u PD=2.92u rfmode=0
M$3398 VDD \$1190 \$1127 VDD sg13_lv_pmos L=0.13u W=1.12u AS=0.3808p AD=0.3808p
+ PS=2.92u PD=2.92u rfmode=0
M$3399 D4 \$1293 VDD VDD sg13_lv_pmos L=0.13u W=1.12u AS=0.42p AD=0.2114p
+ PS=2.99u PD=1.54u rfmode=0
M$3400 VDD \$886 \$1293 VDD sg13_lv_pmos L=0.13u W=0.84u AS=0.2114p AD=0.2856p
+ PS=1.54u PD=2.36u rfmode=0
M$3411 D5 \$1295 VDD VDD sg13_lv_pmos L=0.13u W=1.12u AS=0.42p AD=0.2114p
+ PS=2.99u PD=1.54u rfmode=0
M$3412 VDD \$1011 \$1295 VDD sg13_lv_pmos L=0.13u W=0.84u AS=0.2114p AD=0.2856p
+ PS=1.54u PD=2.36u rfmode=0
M$3416 \$1094 \$1296 VDD VDD sg13_lv_pmos L=0.13u W=1.12u AS=0.42p AD=0.2114p
+ PS=2.99u PD=1.54u rfmode=0
M$3417 VDD \$343 \$1296 VDD sg13_lv_pmos L=0.13u W=0.84u AS=0.2114p AD=0.2856p
+ PS=1.54u PD=2.36u rfmode=0
M$3422 VDD \$1202 \$1297 VDD sg13_lv_pmos L=0.13u W=0.84u AS=0.2114p AD=0.2856p
+ PS=1.54u PD=2.36u rfmode=0
M$3423 VDD \$1297 D6 VDD sg13_lv_pmos L=0.13u W=1.12u AS=0.2114p AD=0.42p
+ PS=1.54u PD=2.99u rfmode=0
M$3424 \$1299 \$1126 VDD VDD sg13_lv_pmos L=0.13u W=0.84u AS=0.2856p AD=0.253p
+ PS=2.36u PD=1.53u rfmode=0
M$3425 VDD \$1126 \$1313 VDD sg13_lv_pmos L=0.13u W=1u AS=0.253p AD=0.3325p
+ PS=1.53u PD=1.665u rfmode=0
M$3426 \$1313 \$1108 \$1300 VDD sg13_lv_pmos L=0.13u W=1u AS=0.3325p AD=0.2225p
+ PS=1.665u PD=1.445u rfmode=0
M$3427 \$1300 \$687 \$1312 VDD sg13_lv_pmos L=0.13u W=1u AS=0.2225p AD=0.2975p
+ PS=1.445u PD=1.595u rfmode=0
M$3428 \$1312 \$1299 VDD VDD sg13_lv_pmos L=0.13u W=1u AS=0.2975p AD=0.2198p
+ PS=1.595u PD=1.52u rfmode=0
M$3429 VDD \$1300 \$1301 VDD sg13_lv_pmos L=0.13u W=1.12u AS=0.2198p AD=0.6048p
+ PS=1.52u PD=3.32u rfmode=0
M$3430 VDD \$887 \$1235 VDD sg13_lv_pmos L=0.13u W=1.12u AS=0.3808p AD=0.3808p
+ PS=2.92u PD=2.92u rfmode=0
M$3439 D7 \$1303 VDD VDD sg13_lv_pmos L=0.13u W=1.12u AS=0.42p AD=0.2114p
+ PS=2.99u PD=1.54u rfmode=0
M$3440 VDD \$1234 \$1303 VDD sg13_lv_pmos L=0.13u W=0.84u AS=0.2114p AD=0.2856p
+ PS=1.54u PD=2.36u rfmode=0
M$3441 VDD \$1108 \$1304 VDD sg13_lv_pmos L=0.13u W=0.84u AS=0.2114p AD=0.2856p
+ PS=1.54u PD=2.36u rfmode=0
M$3442 VDD \$1304 \$40 VDD sg13_lv_pmos L=0.13u W=1.12u AS=0.2114p AD=0.42p
+ PS=1.54u PD=2.99u rfmode=0
M$3443 VDD \$1037 \$1305 VDD sg13_lv_pmos L=0.13u W=0.84u AS=0.2114p AD=0.2856p
+ PS=1.54u PD=2.36u rfmode=0
M$3444 VDD \$1305 \$39 VDD sg13_lv_pmos L=0.13u W=1.12u AS=0.2114p AD=0.42p
+ PS=1.54u PD=2.99u rfmode=0
C$3445 \$5 \$3 cap_cmim w=5.71u l=5.71u A=32.6041p P=22.84u m=40
C$3457 \$6 \$4 cap_cmim w=5.71u l=5.71u A=32.6041p P=22.84u m=40
C$3470 \$8 \$7 cap_cmim w=5.71u l=5.71u A=32.6041p P=22.84u m=64
C$3483 \$10 \$9 cap_cmim w=5.71u l=5.71u A=32.6041p P=22.84u m=64
C$3505 \$11 \$8 cap_cmim w=1.49u l=1.49u A=2.2201p P=5.96u m=1
C$3506 \$12 \$10 cap_cmim w=1.49u l=1.49u A=2.2201p P=5.96u m=1
C$3523 \$8 \$17 cap_cmim w=5.71u l=5.71u A=32.6041p P=22.84u m=32
C$3531 \$10 \$28 cap_cmim w=5.71u l=5.71u A=32.6041p P=22.84u m=32
C$3550 \$8 \$18 cap_cmim w=5.71u l=5.71u A=32.6041p P=22.84u m=16
C$3554 \$8 VDD cap_cmim w=5.71u l=5.71u A=32.6041p P=22.84u m=1
C$3555 \$10 VDD cap_cmim w=5.71u l=5.71u A=32.6041p P=22.84u m=1
C$3556 \$10 \$19 cap_cmim w=5.71u l=5.71u A=32.6041p P=22.84u m=16
C$3575 \$8 \$20 cap_cmim w=5.71u l=5.71u A=32.6041p P=22.84u m=8
C$3578 \$8 \$21 cap_cmim w=5.71u l=5.71u A=32.6041p P=22.84u m=1
C$3579 \$10 \$22 cap_cmim w=5.71u l=5.71u A=32.6041p P=22.84u m=1
C$3581 \$10 \$23 cap_cmim w=5.71u l=5.71u A=32.6041p P=22.84u m=8
C$3600 \$8 \$24 cap_cmim w=5.71u l=5.71u A=32.6041p P=22.84u m=4
C$3601 \$8 \$25 cap_cmim w=5.71u l=5.71u A=32.6041p P=22.84u m=2
C$3603 \$10 \$26 cap_cmim w=5.71u l=5.71u A=32.6041p P=22.84u m=2
C$3605 \$10 \$27 cap_cmim w=5.71u l=5.71u A=32.6041p P=22.84u m=4
C$3783 \$280 \$227 cap_cmim w=9.39u l=6.99u A=65.6361p P=32.76u m=1
C$3784 \$297 \$221 cap_cmim w=4.665u l=6.99u A=32.60835p P=23.31u m=1
C$3785 \$295 \$225 cap_cmim w=4.665u l=6.99u A=32.60835p P=23.31u m=1
C$3786 \$302 VSS cap_cmim w=3.59u l=3.59u A=12.8881p P=14.36u m=1
C$3787 \$296 \$226 cap_cmim w=4.665u l=6.99u A=32.60835p P=23.31u m=1
C$3788 \$298 \$224 cap_cmim w=4.665u l=6.99u A=32.60835p P=23.31u m=1
C$3789 \$256 \$228 cap_cmim w=9.39u l=6.99u A=65.6361p P=32.76u m=1
R$3790 VDD \$199 ntap1 A=15.376p P=99.2u
.ENDS SAR_ADC

.SUBCKT CS_DAC_10b VDD VSS VBIAS X10 CLK X8 X9 OUTP OUTN X4 X3 X5 X6 X7 X2 X1
M$1 VSS \$167 \$7 VSS sg13_lv_nmos L=0.13u W=0.55u AS=0.187p AD=0.1045p
+ PS=1.78u PD=0.93u rfmode=0
M$2 \$7 \$321 VSS VSS sg13_lv_nmos L=0.13u W=0.55u AS=0.1045p AD=0.146425p
+ PS=0.93u PD=1.155u rfmode=0
M$3 VSS \$7 \$8 VSS sg13_lv_nmos L=0.13u W=1.48u AS=0.312925p AD=0.4477p
+ PS=2.345u PD=3.43u rfmode=0
M$5 VSS \$171 \$11 VSS sg13_lv_nmos L=0.13u W=0.55u AS=0.187p AD=0.1045p
+ PS=1.78u PD=0.93u rfmode=0
M$6 \$11 \$321 VSS VSS sg13_lv_nmos L=0.13u W=0.55u AS=0.1045p AD=0.146425p
+ PS=0.93u PD=1.155u rfmode=0
M$7 VSS \$11 \$12 VSS sg13_lv_nmos L=0.13u W=1.48u AS=0.312925p AD=0.4477p
+ PS=2.345u PD=3.43u rfmode=0
M$9 VSS \$174 \$15 VSS sg13_lv_nmos L=0.13u W=0.55u AS=0.187p AD=0.1045p
+ PS=1.78u PD=0.93u rfmode=0
M$10 \$15 \$321 VSS VSS sg13_lv_nmos L=0.13u W=0.55u AS=0.1045p AD=0.146425p
+ PS=0.93u PD=1.155u rfmode=0
M$11 VSS \$15 \$16 VSS sg13_lv_nmos L=0.13u W=1.48u AS=0.312925p AD=0.4477p
+ PS=2.345u PD=3.43u rfmode=0
M$13 VSS \$177 \$19 VSS sg13_lv_nmos L=0.13u W=0.55u AS=0.187p AD=0.1045p
+ PS=1.78u PD=0.93u rfmode=0
M$14 \$19 \$321 VSS VSS sg13_lv_nmos L=0.13u W=0.55u AS=0.1045p AD=0.146425p
+ PS=0.93u PD=1.155u rfmode=0
M$15 VSS \$19 \$20 VSS sg13_lv_nmos L=0.13u W=1.48u AS=0.312925p AD=0.4477p
+ PS=2.345u PD=3.43u rfmode=0
M$17 VSS \$180 \$23 VSS sg13_lv_nmos L=0.13u W=0.55u AS=0.187p AD=0.1045p
+ PS=1.78u PD=0.93u rfmode=0
M$18 \$23 \$321 VSS VSS sg13_lv_nmos L=0.13u W=0.55u AS=0.1045p AD=0.146425p
+ PS=0.93u PD=1.155u rfmode=0
M$19 VSS \$23 \$24 VSS sg13_lv_nmos L=0.13u W=1.48u AS=0.312925p AD=0.4477p
+ PS=2.345u PD=3.43u rfmode=0
M$21 VSS \$183 \$27 VSS sg13_lv_nmos L=0.13u W=0.55u AS=0.187p AD=0.1045p
+ PS=1.78u PD=0.93u rfmode=0
M$22 \$27 \$321 VSS VSS sg13_lv_nmos L=0.13u W=0.55u AS=0.1045p AD=0.146425p
+ PS=0.93u PD=1.155u rfmode=0
M$23 VSS \$27 \$28 VSS sg13_lv_nmos L=0.13u W=1.48u AS=0.312925p AD=0.4477p
+ PS=2.345u PD=3.43u rfmode=0
M$25 VSS \$186 \$31 VSS sg13_lv_nmos L=0.13u W=0.55u AS=0.187p AD=0.1045p
+ PS=1.78u PD=0.93u rfmode=0
M$26 \$31 \$321 VSS VSS sg13_lv_nmos L=0.13u W=0.55u AS=0.1045p AD=0.146425p
+ PS=0.93u PD=1.155u rfmode=0
M$27 VSS \$31 \$32 VSS sg13_lv_nmos L=0.13u W=1.48u AS=0.312925p AD=0.4477p
+ PS=2.345u PD=3.43u rfmode=0
M$29 VSS VSS \$35 VSS sg13_lv_nmos L=0.13u W=0.55u AS=0.187p AD=0.1045p
+ PS=1.78u PD=0.93u rfmode=0
M$30 \$35 \$321 VSS VSS sg13_lv_nmos L=0.13u W=0.55u AS=0.1045p AD=0.146425p
+ PS=0.93u PD=1.155u rfmode=0
M$31 VSS \$35 \$36 VSS sg13_lv_nmos L=0.13u W=1.48u AS=0.312925p AD=0.4477p
+ PS=2.345u PD=3.43u rfmode=0
M$33 \$4 X10 VSS VSS sg13_lv_nmos L=0.13u W=0.64u AS=0.2176p AD=0.1371p
+ PS=1.96u PD=1.12u rfmode=0
M$34 VSS \$4 \$5 VSS sg13_lv_nmos L=0.13u W=1.48u AS=0.2777p AD=0.3922p
+ PS=2.24u PD=3.28u rfmode=0
M$36 \$41 \$40 \$120 VSS sg13_lv_nmos L=0.13u W=0.42u AS=0.1428p AD=0.0609p
+ PS=1.52u PD=0.71u rfmode=0
M$37 \$120 VDD VSS VSS sg13_lv_nmos L=0.13u W=0.42u AS=0.0609p AD=0.1626p
+ PS=0.71u PD=1.415u rfmode=0
M$38 VSS \$168 \$9 VSS sg13_lv_nmos L=0.13u W=0.74u AS=0.1626p AD=0.2516p
+ PS=1.415u PD=2.16u rfmode=0
M$39 \$43 \$170 VSS VSS sg13_lv_nmos L=0.13u W=0.42u AS=0.1428p AD=0.0798p
+ PS=1.52u PD=0.8u rfmode=0
M$40 VSS VDD \$122 VSS sg13_lv_nmos L=0.13u W=0.42u AS=0.0798p AD=0.0378p
+ PS=0.8u PD=0.6u rfmode=0
M$41 \$122 \$44 \$170 VSS sg13_lv_nmos L=0.13u W=0.42u AS=0.0378p AD=0.1428p
+ PS=0.6u PD=1.52u rfmode=0
M$42 VSS \$44 \$46 VSS sg13_lv_nmos L=0.13u W=0.64u AS=0.1331p AD=0.2176p
+ PS=1.12u PD=1.96u rfmode=0
M$43 VSS \$44 \$45 VSS sg13_lv_nmos L=0.13u W=1.48u AS=0.3922p AD=0.2737p
+ PS=3.28u PD=2.24u rfmode=0
M$45 VSS \$46 \$47 VSS sg13_lv_nmos L=0.13u W=1.48u AS=0.3922p AD=0.3922p
+ PS=3.28u PD=3.28u rfmode=0
M$47 \$51 \$50 \$131 VSS sg13_lv_nmos L=0.13u W=0.42u AS=0.1428p AD=0.0609p
+ PS=1.52u PD=0.71u rfmode=0
M$48 \$131 VDD VSS VSS sg13_lv_nmos L=0.13u W=0.42u AS=0.0609p AD=0.1626p
+ PS=0.71u PD=1.415u rfmode=0
M$49 VSS \$172 \$13 VSS sg13_lv_nmos L=0.13u W=0.74u AS=0.1626p AD=0.2516p
+ PS=1.415u PD=2.16u rfmode=0
M$50 \$53 \$173 VSS VSS sg13_lv_nmos L=0.13u W=0.42u AS=0.1428p AD=0.0798p
+ PS=1.52u PD=0.8u rfmode=0
M$51 VSS VDD \$134 VSS sg13_lv_nmos L=0.13u W=0.42u AS=0.0798p AD=0.0378p
+ PS=0.8u PD=0.6u rfmode=0
M$52 \$134 \$54 \$173 VSS sg13_lv_nmos L=0.13u W=0.42u AS=0.0378p AD=0.1428p
+ PS=0.6u PD=1.52u rfmode=0
M$53 VSS \$54 \$56 VSS sg13_lv_nmos L=0.13u W=0.64u AS=0.1331p AD=0.2176p
+ PS=1.12u PD=1.96u rfmode=0
M$54 VSS \$54 \$55 VSS sg13_lv_nmos L=0.13u W=1.48u AS=0.3922p AD=0.2737p
+ PS=3.28u PD=2.24u rfmode=0
M$56 VSS \$56 \$57 VSS sg13_lv_nmos L=0.13u W=1.48u AS=0.3922p AD=0.3922p
+ PS=3.28u PD=3.28u rfmode=0
M$58 \$61 \$60 \$141 VSS sg13_lv_nmos L=0.13u W=0.42u AS=0.1428p AD=0.0609p
+ PS=1.52u PD=0.71u rfmode=0
M$59 \$141 VDD VSS VSS sg13_lv_nmos L=0.13u W=0.42u AS=0.0609p AD=0.1626p
+ PS=0.71u PD=1.415u rfmode=0
M$60 VSS \$175 \$17 VSS sg13_lv_nmos L=0.13u W=0.74u AS=0.1626p AD=0.2516p
+ PS=1.415u PD=2.16u rfmode=0
M$61 \$63 \$176 VSS VSS sg13_lv_nmos L=0.13u W=0.42u AS=0.1428p AD=0.0798p
+ PS=1.52u PD=0.8u rfmode=0
M$62 VSS VDD \$145 VSS sg13_lv_nmos L=0.13u W=0.42u AS=0.0798p AD=0.0378p
+ PS=0.8u PD=0.6u rfmode=0
M$63 \$145 \$64 \$176 VSS sg13_lv_nmos L=0.13u W=0.42u AS=0.0378p AD=0.1428p
+ PS=0.6u PD=1.52u rfmode=0
M$64 VSS \$64 \$66 VSS sg13_lv_nmos L=0.13u W=0.64u AS=0.1331p AD=0.2176p
+ PS=1.12u PD=1.96u rfmode=0
M$65 VSS \$64 \$65 VSS sg13_lv_nmos L=0.13u W=1.48u AS=0.3922p AD=0.2737p
+ PS=3.28u PD=2.24u rfmode=0
M$67 VSS \$66 \$67 VSS sg13_lv_nmos L=0.13u W=1.48u AS=0.3922p AD=0.3922p
+ PS=3.28u PD=3.28u rfmode=0
M$69 \$71 \$70 \$152 VSS sg13_lv_nmos L=0.13u W=0.42u AS=0.1428p AD=0.0609p
+ PS=1.52u PD=0.71u rfmode=0
M$70 \$152 VDD VSS VSS sg13_lv_nmos L=0.13u W=0.42u AS=0.0609p AD=0.1626p
+ PS=0.71u PD=1.415u rfmode=0
M$71 VSS \$178 \$21 VSS sg13_lv_nmos L=0.13u W=0.74u AS=0.1626p AD=0.2516p
+ PS=1.415u PD=2.16u rfmode=0
M$72 \$73 \$179 VSS VSS sg13_lv_nmos L=0.13u W=0.42u AS=0.1428p AD=0.0798p
+ PS=1.52u PD=0.8u rfmode=0
M$73 VSS VDD \$155 VSS sg13_lv_nmos L=0.13u W=0.42u AS=0.0798p AD=0.0378p
+ PS=0.8u PD=0.6u rfmode=0
M$74 \$155 \$74 \$179 VSS sg13_lv_nmos L=0.13u W=0.42u AS=0.0378p AD=0.1428p
+ PS=0.6u PD=1.52u rfmode=0
M$75 VSS \$74 \$76 VSS sg13_lv_nmos L=0.13u W=0.64u AS=0.1331p AD=0.2176p
+ PS=1.12u PD=1.96u rfmode=0
M$76 VSS \$74 \$75 VSS sg13_lv_nmos L=0.13u W=1.48u AS=0.3922p AD=0.2737p
+ PS=3.28u PD=2.24u rfmode=0
M$78 VSS \$76 \$77 VSS sg13_lv_nmos L=0.13u W=1.48u AS=0.3922p AD=0.3922p
+ PS=3.28u PD=3.28u rfmode=0
M$80 \$81 \$80 \$162 VSS sg13_lv_nmos L=0.13u W=0.42u AS=0.1428p AD=0.0609p
+ PS=1.52u PD=0.71u rfmode=0
M$81 \$162 VDD VSS VSS sg13_lv_nmos L=0.13u W=0.42u AS=0.0609p AD=0.1626p
+ PS=0.71u PD=1.415u rfmode=0
M$82 VSS \$181 \$25 VSS sg13_lv_nmos L=0.13u W=0.74u AS=0.1626p AD=0.2516p
+ PS=1.415u PD=2.16u rfmode=0
M$83 \$83 \$182 VSS VSS sg13_lv_nmos L=0.13u W=0.42u AS=0.1428p AD=0.0798p
+ PS=1.52u PD=0.8u rfmode=0
M$84 VSS VDD \$166 VSS sg13_lv_nmos L=0.13u W=0.42u AS=0.0798p AD=0.0378p
+ PS=0.8u PD=0.6u rfmode=0
M$85 \$166 \$84 \$182 VSS sg13_lv_nmos L=0.13u W=0.42u AS=0.0378p AD=0.1428p
+ PS=0.6u PD=1.52u rfmode=0
M$86 VSS \$84 \$86 VSS sg13_lv_nmos L=0.13u W=0.64u AS=0.1331p AD=0.2176p
+ PS=1.12u PD=1.96u rfmode=0
M$87 VSS \$84 \$85 VSS sg13_lv_nmos L=0.13u W=1.48u AS=0.3922p AD=0.2737p
+ PS=3.28u PD=2.24u rfmode=0
M$89 VSS \$86 \$87 VSS sg13_lv_nmos L=0.13u W=1.48u AS=0.3922p AD=0.3922p
+ PS=3.28u PD=3.28u rfmode=0
M$91 \$91 \$90 \$158 VSS sg13_lv_nmos L=0.13u W=0.42u AS=0.1428p AD=0.0609p
+ PS=1.52u PD=0.71u rfmode=0
M$92 \$158 VDD VSS VSS sg13_lv_nmos L=0.13u W=0.42u AS=0.0609p AD=0.1626p
+ PS=0.71u PD=1.415u rfmode=0
M$93 VSS \$184 \$29 VSS sg13_lv_nmos L=0.13u W=0.74u AS=0.1626p AD=0.2516p
+ PS=1.415u PD=2.16u rfmode=0
M$94 \$93 \$185 VSS VSS sg13_lv_nmos L=0.13u W=0.42u AS=0.1428p AD=0.0798p
+ PS=1.52u PD=0.8u rfmode=0
M$95 VSS VDD \$154 VSS sg13_lv_nmos L=0.13u W=0.42u AS=0.0798p AD=0.0378p
+ PS=0.8u PD=0.6u rfmode=0
M$96 \$154 \$94 \$185 VSS sg13_lv_nmos L=0.13u W=0.42u AS=0.0378p AD=0.1428p
+ PS=0.6u PD=1.52u rfmode=0
M$97 VSS \$94 \$96 VSS sg13_lv_nmos L=0.13u W=0.64u AS=0.1331p AD=0.2176p
+ PS=1.12u PD=1.96u rfmode=0
M$98 VSS \$94 \$95 VSS sg13_lv_nmos L=0.13u W=1.48u AS=0.3922p AD=0.2737p
+ PS=3.28u PD=2.24u rfmode=0
M$100 VSS \$96 \$97 VSS sg13_lv_nmos L=0.13u W=1.48u AS=0.3922p AD=0.3922p
+ PS=3.28u PD=3.28u rfmode=0
M$102 \$101 \$100 \$144 VSS sg13_lv_nmos L=0.13u W=0.42u AS=0.1428p AD=0.0609p
+ PS=1.52u PD=0.71u rfmode=0
M$103 \$144 VDD VSS VSS sg13_lv_nmos L=0.13u W=0.42u AS=0.0609p AD=0.1626p
+ PS=0.71u PD=1.415u rfmode=0
M$104 VSS \$187 \$33 VSS sg13_lv_nmos L=0.13u W=0.74u AS=0.1626p AD=0.2516p
+ PS=1.415u PD=2.16u rfmode=0
M$105 \$103 \$188 VSS VSS sg13_lv_nmos L=0.13u W=0.42u AS=0.1428p AD=0.0798p
+ PS=1.52u PD=0.8u rfmode=0
M$106 VSS VDD \$140 VSS sg13_lv_nmos L=0.13u W=0.42u AS=0.0798p AD=0.0378p
+ PS=0.8u PD=0.6u rfmode=0
M$107 \$140 \$104 \$188 VSS sg13_lv_nmos L=0.13u W=0.42u AS=0.0378p AD=0.1428p
+ PS=0.6u PD=1.52u rfmode=0
M$108 VSS \$104 \$106 VSS sg13_lv_nmos L=0.13u W=0.64u AS=0.1331p AD=0.2176p
+ PS=1.12u PD=1.96u rfmode=0
M$109 VSS \$104 \$105 VSS sg13_lv_nmos L=0.13u W=1.48u AS=0.3922p AD=0.2737p
+ PS=3.28u PD=2.24u rfmode=0
M$111 VSS \$106 \$107 VSS sg13_lv_nmos L=0.13u W=1.48u AS=0.3922p AD=0.3922p
+ PS=3.28u PD=3.28u rfmode=0
M$113 \$111 \$110 \$130 VSS sg13_lv_nmos L=0.13u W=0.42u AS=0.1428p AD=0.0609p
+ PS=1.52u PD=0.71u rfmode=0
M$114 \$130 VDD VSS VSS sg13_lv_nmos L=0.13u W=0.42u AS=0.0609p AD=0.1626p
+ PS=0.71u PD=1.415u rfmode=0
M$115 VSS \$189 \$37 VSS sg13_lv_nmos L=0.13u W=0.74u AS=0.1626p AD=0.2516p
+ PS=1.415u PD=2.16u rfmode=0
M$116 \$113 \$190 VSS VSS sg13_lv_nmos L=0.13u W=0.42u AS=0.1428p AD=0.0798p
+ PS=1.52u PD=0.8u rfmode=0
M$117 VSS VDD \$127 VSS sg13_lv_nmos L=0.13u W=0.42u AS=0.0798p AD=0.0378p
+ PS=0.8u PD=0.6u rfmode=0
M$118 \$127 \$114 \$190 VSS sg13_lv_nmos L=0.13u W=0.42u AS=0.0378p AD=0.1428p
+ PS=0.6u PD=1.52u rfmode=0
M$119 VSS \$114 \$116 VSS sg13_lv_nmos L=0.13u W=0.64u AS=0.1331p AD=0.2176p
+ PS=1.12u PD=1.96u rfmode=0
M$120 VSS \$114 \$115 VSS sg13_lv_nmos L=0.13u W=1.48u AS=0.3922p AD=0.2737p
+ PS=3.28u PD=2.24u rfmode=0
M$122 VSS \$116 \$117 VSS sg13_lv_nmos L=0.13u W=1.48u AS=0.3922p AD=0.3922p
+ PS=3.28u PD=3.28u rfmode=0
M$124 \$39 \$8 VSS VSS sg13_lv_nmos L=0.13u W=1.44u AS=0.4068p AD=0.2772p
+ PS=3.29u PD=2.21u rfmode=0
M$126 \$39 VDD \$40 VSS sg13_lv_nmos L=0.13u W=1.44u AS=0.2772p AD=0.3816p
+ PS=2.21u PD=3.22u rfmode=0
M$128 VSS VDD \$121 VSS sg13_lv_nmos L=0.13u W=0.42u AS=0.1701p AD=0.03885p
+ PS=1.65u PD=0.605u rfmode=0
M$129 \$121 \$9 \$42 VSS sg13_lv_nmos L=0.13u W=0.42u AS=0.03885p AD=0.1596p
+ PS=0.605u PD=1.6u rfmode=0
M$130 \$41 \$10 \$168 VSS sg13_lv_nmos L=0.13u W=0.42u AS=0.1296p AD=0.081p
+ PS=1.52u PD=0.81u rfmode=0
M$131 \$168 \$196 \$42 VSS sg13_lv_nmos L=0.13u W=0.42u AS=0.081p AD=0.2163p
+ PS=0.81u PD=1.87u rfmode=0
M$132 VSS \$10 \$196 VSS sg13_lv_nmos L=0.13u W=0.74u AS=0.43315p AD=0.2516p
+ PS=2.205u PD=2.16u rfmode=0
M$133 VSS CLK \$10 VSS sg13_lv_nmos L=0.13u W=0.74u AS=0.43315p AD=0.2516p
+ PS=2.205u PD=2.16u rfmode=0
M$134 \$44 \$10 \$43 VSS sg13_lv_nmos L=0.13u W=0.42u AS=0.12665p AD=0.1428p
+ PS=1.145u PD=1.52u rfmode=0
M$135 \$9 \$196 \$44 VSS sg13_lv_nmos L=0.13u W=0.74u AS=0.3473p AD=0.12665p
+ PS=2.71u PD=1.145u rfmode=0
M$136 \$49 \$12 VSS VSS sg13_lv_nmos L=0.13u W=1.44u AS=0.4068p AD=0.2772p
+ PS=3.29u PD=2.21u rfmode=0
M$138 \$49 VDD \$50 VSS sg13_lv_nmos L=0.13u W=1.44u AS=0.2772p AD=0.3816p
+ PS=2.21u PD=3.22u rfmode=0
M$140 VSS VDD \$132 VSS sg13_lv_nmos L=0.13u W=0.42u AS=0.1701p AD=0.03885p
+ PS=1.65u PD=0.605u rfmode=0
M$141 \$132 \$13 \$52 VSS sg13_lv_nmos L=0.13u W=0.42u AS=0.03885p AD=0.1596p
+ PS=0.605u PD=1.6u rfmode=0
M$142 \$51 \$14 \$172 VSS sg13_lv_nmos L=0.13u W=0.42u AS=0.1296p AD=0.081p
+ PS=1.52u PD=0.81u rfmode=0
M$143 \$172 \$198 \$52 VSS sg13_lv_nmos L=0.13u W=0.42u AS=0.081p AD=0.2163p
+ PS=0.81u PD=1.87u rfmode=0
M$144 VSS \$14 \$198 VSS sg13_lv_nmos L=0.13u W=0.74u AS=0.43315p AD=0.2516p
+ PS=2.205u PD=2.16u rfmode=0
M$145 VSS CLK \$14 VSS sg13_lv_nmos L=0.13u W=0.74u AS=0.43315p AD=0.2516p
+ PS=2.205u PD=2.16u rfmode=0
M$146 \$54 \$14 \$53 VSS sg13_lv_nmos L=0.13u W=0.42u AS=0.12665p AD=0.1428p
+ PS=1.145u PD=1.52u rfmode=0
M$147 \$13 \$198 \$54 VSS sg13_lv_nmos L=0.13u W=0.74u AS=0.3473p AD=0.12665p
+ PS=2.71u PD=1.145u rfmode=0
M$148 \$59 \$16 VSS VSS sg13_lv_nmos L=0.13u W=1.44u AS=0.4068p AD=0.2772p
+ PS=3.29u PD=2.21u rfmode=0
M$150 \$59 VDD \$60 VSS sg13_lv_nmos L=0.13u W=1.44u AS=0.2772p AD=0.3816p
+ PS=2.21u PD=3.22u rfmode=0
M$152 VSS VDD \$143 VSS sg13_lv_nmos L=0.13u W=0.42u AS=0.1701p AD=0.03885p
+ PS=1.65u PD=0.605u rfmode=0
M$153 \$143 \$17 \$62 VSS sg13_lv_nmos L=0.13u W=0.42u AS=0.03885p AD=0.1596p
+ PS=0.605u PD=1.6u rfmode=0
M$154 \$61 \$18 \$175 VSS sg13_lv_nmos L=0.13u W=0.42u AS=0.1296p AD=0.081p
+ PS=1.52u PD=0.81u rfmode=0
M$155 \$175 \$200 \$62 VSS sg13_lv_nmos L=0.13u W=0.42u AS=0.081p AD=0.2163p
+ PS=0.81u PD=1.87u rfmode=0
M$156 VSS \$18 \$200 VSS sg13_lv_nmos L=0.13u W=0.74u AS=0.43315p AD=0.2516p
+ PS=2.205u PD=2.16u rfmode=0
M$157 VSS CLK \$18 VSS sg13_lv_nmos L=0.13u W=0.74u AS=0.43315p AD=0.2516p
+ PS=2.205u PD=2.16u rfmode=0
M$158 \$64 \$18 \$63 VSS sg13_lv_nmos L=0.13u W=0.42u AS=0.12665p AD=0.1428p
+ PS=1.145u PD=1.52u rfmode=0
M$159 \$17 \$200 \$64 VSS sg13_lv_nmos L=0.13u W=0.74u AS=0.3473p AD=0.12665p
+ PS=2.71u PD=1.145u rfmode=0
M$160 \$69 \$20 VSS VSS sg13_lv_nmos L=0.13u W=1.44u AS=0.4068p AD=0.2772p
+ PS=3.29u PD=2.21u rfmode=0
M$162 \$69 VDD \$70 VSS sg13_lv_nmos L=0.13u W=1.44u AS=0.2772p AD=0.3816p
+ PS=2.21u PD=3.22u rfmode=0
M$164 VSS VDD \$153 VSS sg13_lv_nmos L=0.13u W=0.42u AS=0.1701p AD=0.03885p
+ PS=1.65u PD=0.605u rfmode=0
M$165 \$153 \$21 \$72 VSS sg13_lv_nmos L=0.13u W=0.42u AS=0.03885p AD=0.1596p
+ PS=0.605u PD=1.6u rfmode=0
M$166 \$71 \$22 \$178 VSS sg13_lv_nmos L=0.13u W=0.42u AS=0.1296p AD=0.081p
+ PS=1.52u PD=0.81u rfmode=0
M$167 \$178 \$202 \$72 VSS sg13_lv_nmos L=0.13u W=0.42u AS=0.081p AD=0.2163p
+ PS=0.81u PD=1.87u rfmode=0
M$168 VSS \$22 \$202 VSS sg13_lv_nmos L=0.13u W=0.74u AS=0.43315p AD=0.2516p
+ PS=2.205u PD=2.16u rfmode=0
M$169 VSS CLK \$22 VSS sg13_lv_nmos L=0.13u W=0.74u AS=0.43315p AD=0.2516p
+ PS=2.205u PD=2.16u rfmode=0
M$170 \$74 \$22 \$73 VSS sg13_lv_nmos L=0.13u W=0.42u AS=0.12665p AD=0.1428p
+ PS=1.145u PD=1.52u rfmode=0
M$171 \$21 \$202 \$74 VSS sg13_lv_nmos L=0.13u W=0.74u AS=0.3473p AD=0.12665p
+ PS=2.71u PD=1.145u rfmode=0
M$172 \$79 \$24 VSS VSS sg13_lv_nmos L=0.13u W=1.44u AS=0.4068p AD=0.2772p
+ PS=3.29u PD=2.21u rfmode=0
M$174 \$79 VDD \$80 VSS sg13_lv_nmos L=0.13u W=1.44u AS=0.2772p AD=0.3816p
+ PS=2.21u PD=3.22u rfmode=0
M$176 VSS VDD \$163 VSS sg13_lv_nmos L=0.13u W=0.42u AS=0.1701p AD=0.03885p
+ PS=1.65u PD=0.605u rfmode=0
M$177 \$163 \$25 \$82 VSS sg13_lv_nmos L=0.13u W=0.42u AS=0.03885p AD=0.1596p
+ PS=0.605u PD=1.6u rfmode=0
M$178 \$81 \$26 \$181 VSS sg13_lv_nmos L=0.13u W=0.42u AS=0.1296p AD=0.081p
+ PS=1.52u PD=0.81u rfmode=0
M$179 \$181 \$204 \$82 VSS sg13_lv_nmos L=0.13u W=0.42u AS=0.081p AD=0.2163p
+ PS=0.81u PD=1.87u rfmode=0
M$180 VSS \$26 \$204 VSS sg13_lv_nmos L=0.13u W=0.74u AS=0.43315p AD=0.2516p
+ PS=2.205u PD=2.16u rfmode=0
M$181 VSS CLK \$26 VSS sg13_lv_nmos L=0.13u W=0.74u AS=0.43315p AD=0.2516p
+ PS=2.205u PD=2.16u rfmode=0
M$182 \$84 \$26 \$83 VSS sg13_lv_nmos L=0.13u W=0.42u AS=0.12665p AD=0.1428p
+ PS=1.145u PD=1.52u rfmode=0
M$183 \$25 \$204 \$84 VSS sg13_lv_nmos L=0.13u W=0.74u AS=0.3473p AD=0.12665p
+ PS=2.71u PD=1.145u rfmode=0
M$184 \$89 \$28 VSS VSS sg13_lv_nmos L=0.13u W=1.44u AS=0.4068p AD=0.2772p
+ PS=3.29u PD=2.21u rfmode=0
M$186 \$89 VDD \$90 VSS sg13_lv_nmos L=0.13u W=1.44u AS=0.2772p AD=0.3816p
+ PS=2.21u PD=3.22u rfmode=0
M$188 VSS VDD \$156 VSS sg13_lv_nmos L=0.13u W=0.42u AS=0.1701p AD=0.03885p
+ PS=1.65u PD=0.605u rfmode=0
M$189 \$156 \$29 \$92 VSS sg13_lv_nmos L=0.13u W=0.42u AS=0.03885p AD=0.1596p
+ PS=0.605u PD=1.6u rfmode=0
M$190 \$91 \$30 \$184 VSS sg13_lv_nmos L=0.13u W=0.42u AS=0.1296p AD=0.081p
+ PS=1.52u PD=0.81u rfmode=0
M$191 \$184 \$206 \$92 VSS sg13_lv_nmos L=0.13u W=0.42u AS=0.081p AD=0.2163p
+ PS=0.81u PD=1.87u rfmode=0
M$192 VSS \$30 \$206 VSS sg13_lv_nmos L=0.13u W=0.74u AS=0.43315p AD=0.2516p
+ PS=2.205u PD=2.16u rfmode=0
M$193 VSS CLK \$30 VSS sg13_lv_nmos L=0.13u W=0.74u AS=0.43315p AD=0.2516p
+ PS=2.205u PD=2.16u rfmode=0
M$194 \$94 \$30 \$93 VSS sg13_lv_nmos L=0.13u W=0.42u AS=0.12665p AD=0.1428p
+ PS=1.145u PD=1.52u rfmode=0
M$195 \$29 \$206 \$94 VSS sg13_lv_nmos L=0.13u W=0.74u AS=0.3473p AD=0.12665p
+ PS=2.71u PD=1.145u rfmode=0
M$196 \$99 \$32 VSS VSS sg13_lv_nmos L=0.13u W=1.44u AS=0.4068p AD=0.2772p
+ PS=3.29u PD=2.21u rfmode=0
M$198 \$99 VDD \$100 VSS sg13_lv_nmos L=0.13u W=1.44u AS=0.2772p AD=0.3816p
+ PS=2.21u PD=3.22u rfmode=0
M$200 VSS VDD \$142 VSS sg13_lv_nmos L=0.13u W=0.42u AS=0.1701p AD=0.03885p
+ PS=1.65u PD=0.605u rfmode=0
M$201 \$142 \$33 \$102 VSS sg13_lv_nmos L=0.13u W=0.42u AS=0.03885p AD=0.1596p
+ PS=0.605u PD=1.6u rfmode=0
M$202 \$101 \$34 \$187 VSS sg13_lv_nmos L=0.13u W=0.42u AS=0.1296p AD=0.081p
+ PS=1.52u PD=0.81u rfmode=0
M$203 \$187 \$208 \$102 VSS sg13_lv_nmos L=0.13u W=0.42u AS=0.081p AD=0.2163p
+ PS=0.81u PD=1.87u rfmode=0
M$204 VSS \$34 \$208 VSS sg13_lv_nmos L=0.13u W=0.74u AS=0.43315p AD=0.2516p
+ PS=2.205u PD=2.16u rfmode=0
M$205 VSS CLK \$34 VSS sg13_lv_nmos L=0.13u W=0.74u AS=0.43315p AD=0.2516p
+ PS=2.205u PD=2.16u rfmode=0
M$206 \$104 \$34 \$103 VSS sg13_lv_nmos L=0.13u W=0.42u AS=0.12665p AD=0.1428p
+ PS=1.145u PD=1.52u rfmode=0
M$207 \$33 \$208 \$104 VSS sg13_lv_nmos L=0.13u W=0.74u AS=0.3473p AD=0.12665p
+ PS=2.71u PD=1.145u rfmode=0
M$208 \$109 \$36 VSS VSS sg13_lv_nmos L=0.13u W=1.44u AS=0.4068p AD=0.2772p
+ PS=3.29u PD=2.21u rfmode=0
M$210 \$109 VDD \$110 VSS sg13_lv_nmos L=0.13u W=1.44u AS=0.2772p AD=0.3816p
+ PS=2.21u PD=3.22u rfmode=0
M$212 VSS VDD \$128 VSS sg13_lv_nmos L=0.13u W=0.42u AS=0.1701p AD=0.03885p
+ PS=1.65u PD=0.605u rfmode=0
M$213 \$128 \$37 \$112 VSS sg13_lv_nmos L=0.13u W=0.42u AS=0.03885p AD=0.1596p
+ PS=0.605u PD=1.6u rfmode=0
M$214 \$111 \$38 \$189 VSS sg13_lv_nmos L=0.13u W=0.42u AS=0.1296p AD=0.081p
+ PS=1.52u PD=0.81u rfmode=0
M$215 \$189 \$210 \$112 VSS sg13_lv_nmos L=0.13u W=0.42u AS=0.081p AD=0.2163p
+ PS=0.81u PD=1.87u rfmode=0
M$216 VSS \$38 \$210 VSS sg13_lv_nmos L=0.13u W=0.74u AS=0.43315p AD=0.2516p
+ PS=2.205u PD=2.16u rfmode=0
M$217 VSS CLK \$38 VSS sg13_lv_nmos L=0.13u W=0.74u AS=0.43315p AD=0.2516p
+ PS=2.205u PD=2.16u rfmode=0
M$218 \$114 \$38 \$113 VSS sg13_lv_nmos L=0.13u W=0.42u AS=0.12665p AD=0.1428p
+ PS=1.145u PD=1.52u rfmode=0
M$219 \$37 \$210 \$114 VSS sg13_lv_nmos L=0.13u W=0.74u AS=0.3473p AD=0.12665p
+ PS=2.71u PD=1.145u rfmode=0
M$220 \$192 X8 \$254 VSS sg13_lv_nmos L=0.13u W=0.64u AS=0.2176p AD=0.1216p
+ PS=1.96u PD=1.02u rfmode=0
M$221 VSS X9 \$254 VSS sg13_lv_nmos L=0.13u W=0.64u AS=0.1331p AD=0.1216p
+ PS=1.12u PD=1.02u rfmode=0
M$222 VSS \$192 \$193 VSS sg13_lv_nmos L=0.13u W=1.48u AS=0.2737p AD=0.4218p
+ PS=2.24u PD=3.36u rfmode=0
M$224 VSS X10 \$194 VSS sg13_lv_nmos L=0.13u W=0.55u AS=0.187p AD=0.1045p
+ PS=1.78u PD=0.93u rfmode=0
M$225 \$194 \$193 VSS VSS sg13_lv_nmos L=0.13u W=0.55u AS=0.1045p AD=0.146425p
+ PS=0.93u PD=1.155u rfmode=0
M$226 VSS \$194 \$195 VSS sg13_lv_nmos L=0.13u W=1.48u AS=0.312925p AD=0.4477p
+ PS=2.345u PD=3.43u rfmode=0
M$228 VSS VSS \$197 VSS sg13_lv_nmos L=0.13u W=1u AS=0.265p AD=0.265p PS=2.56u
+ PD=2.56u rfmode=0
M$229 \$197 \$45 OUTP VSS sg13_lv_nmos L=0.13u W=2u AS=0.38p AD=0.38p PS=3.52u
+ PD=3.52u rfmode=0
M$231 \$197 \$47 OUTN VSS sg13_lv_nmos L=0.13u W=2u AS=0.38p AD=0.38p PS=3.52u
+ PD=3.52u rfmode=0
M$238 VSS VSS \$199 VSS sg13_lv_nmos L=0.13u W=1u AS=0.265p AD=0.265p PS=2.56u
+ PD=2.56u rfmode=0
M$239 \$199 \$55 OUTP VSS sg13_lv_nmos L=0.13u W=2u AS=0.38p AD=0.38p PS=3.52u
+ PD=3.52u rfmode=0
M$241 \$199 \$57 OUTN VSS sg13_lv_nmos L=0.13u W=2u AS=0.38p AD=0.38p PS=3.52u
+ PD=3.52u rfmode=0
M$248 VSS VSS \$201 VSS sg13_lv_nmos L=0.13u W=1u AS=0.265p AD=0.265p PS=2.56u
+ PD=2.56u rfmode=0
M$249 \$201 \$65 OUTP VSS sg13_lv_nmos L=0.13u W=2u AS=0.38p AD=0.38p PS=3.52u
+ PD=3.52u rfmode=0
M$251 \$201 \$67 OUTN VSS sg13_lv_nmos L=0.13u W=2u AS=0.38p AD=0.38p PS=3.52u
+ PD=3.52u rfmode=0
M$258 VSS VSS \$203 VSS sg13_lv_nmos L=0.13u W=1u AS=0.265p AD=0.265p PS=2.56u
+ PD=2.56u rfmode=0
M$259 \$203 \$75 OUTP VSS sg13_lv_nmos L=0.13u W=2u AS=0.38p AD=0.38p PS=3.52u
+ PD=3.52u rfmode=0
M$261 \$203 \$77 OUTN VSS sg13_lv_nmos L=0.13u W=2u AS=0.38p AD=0.38p PS=3.52u
+ PD=3.52u rfmode=0
M$268 VSS VSS \$205 VSS sg13_lv_nmos L=0.13u W=1u AS=0.265p AD=0.265p PS=2.56u
+ PD=2.56u rfmode=0
M$269 \$205 \$85 OUTP VSS sg13_lv_nmos L=0.13u W=2u AS=0.38p AD=0.38p PS=3.52u
+ PD=3.52u rfmode=0
M$271 \$205 \$87 OUTN VSS sg13_lv_nmos L=0.13u W=2u AS=0.38p AD=0.38p PS=3.52u
+ PD=3.52u rfmode=0
M$278 VSS VSS \$207 VSS sg13_lv_nmos L=0.13u W=1u AS=0.265p AD=0.265p PS=2.56u
+ PD=2.56u rfmode=0
M$279 \$207 \$95 OUTP VSS sg13_lv_nmos L=0.13u W=2u AS=0.38p AD=0.38p PS=3.52u
+ PD=3.52u rfmode=0
M$281 \$207 \$97 OUTN VSS sg13_lv_nmos L=0.13u W=2u AS=0.38p AD=0.38p PS=3.52u
+ PD=3.52u rfmode=0
M$288 VSS VSS \$209 VSS sg13_lv_nmos L=0.13u W=1u AS=0.265p AD=0.265p PS=2.56u
+ PD=2.56u rfmode=0
M$289 \$209 \$105 OUTP VSS sg13_lv_nmos L=0.13u W=2u AS=0.38p AD=0.38p PS=3.52u
+ PD=3.52u rfmode=0
M$291 \$209 \$107 OUTN VSS sg13_lv_nmos L=0.13u W=2u AS=0.38p AD=0.38p PS=3.52u
+ PD=3.52u rfmode=0
M$298 VSS VSS \$211 VSS sg13_lv_nmos L=0.13u W=1u AS=0.265p AD=0.265p PS=2.56u
+ PD=2.56u rfmode=0
M$299 \$211 \$115 OUTP VSS sg13_lv_nmos L=0.13u W=2u AS=0.38p AD=0.38p PS=3.52u
+ PD=3.52u rfmode=0
M$301 \$211 \$117 OUTN VSS sg13_lv_nmos L=0.13u W=2u AS=0.38p AD=0.38p PS=3.52u
+ PD=3.52u rfmode=0
M$308 VSS X9 \$313 VSS sg13_lv_nmos L=0.13u W=0.55u AS=0.187p AD=0.1045p
+ PS=1.78u PD=0.93u rfmode=0
M$309 VSS X8 \$313 VSS sg13_lv_nmos L=0.13u W=0.55u AS=0.146425p AD=0.1045p
+ PS=1.155u PD=0.93u rfmode=0
M$310 VSS \$313 \$314 VSS sg13_lv_nmos L=0.13u W=1.48u AS=0.312925p AD=0.4477p
+ PS=2.345u PD=3.43u rfmode=0
M$312 VSS X9 \$318 VSS sg13_lv_nmos L=0.13u W=0.55u AS=0.187p AD=0.1045p
+ PS=1.78u PD=0.93u rfmode=0
M$313 \$318 X10 VSS VSS sg13_lv_nmos L=0.13u W=0.55u AS=0.1045p AD=0.146425p
+ PS=0.93u PD=1.155u rfmode=0
M$314 VSS \$318 \$319 VSS sg13_lv_nmos L=0.13u W=1.48u AS=0.312925p AD=0.4477p
+ PS=2.345u PD=3.43u rfmode=0
M$316 VSS X8 \$320 VSS sg13_lv_nmos L=0.13u W=0.55u AS=0.187p AD=0.1045p
+ PS=1.78u PD=0.93u rfmode=0
M$317 \$320 \$319 VSS VSS sg13_lv_nmos L=0.13u W=0.55u AS=0.1045p AD=0.146425p
+ PS=0.93u PD=1.155u rfmode=0
M$318 VSS \$320 \$321 VSS sg13_lv_nmos L=0.13u W=1.48u AS=0.312925p AD=0.4477p
+ PS=2.345u PD=3.43u rfmode=0
M$320 \$315 X10 \$322 VSS sg13_lv_nmos L=0.13u W=0.64u AS=0.2176p AD=0.1216p
+ PS=1.96u PD=1.02u rfmode=0
M$321 \$322 \$314 VSS VSS sg13_lv_nmos L=0.13u W=0.64u AS=0.1216p AD=0.1331p
+ PS=1.02u PD=1.12u rfmode=0
M$322 VSS \$315 \$316 VSS sg13_lv_nmos L=0.13u W=1.48u AS=0.2737p AD=0.4218p
+ PS=2.24u PD=3.36u rfmode=0
M$324 VSS \$167 \$327 VSS sg13_lv_nmos L=0.13u W=0.55u AS=0.187p AD=0.1045p
+ PS=1.78u PD=0.93u rfmode=0
M$325 \$327 \$319 VSS VSS sg13_lv_nmos L=0.13u W=0.55u AS=0.1045p AD=0.146425p
+ PS=0.93u PD=1.155u rfmode=0
M$326 VSS \$327 \$328 VSS sg13_lv_nmos L=0.13u W=1.48u AS=0.312925p AD=0.4477p
+ PS=2.345u PD=3.43u rfmode=0
M$328 \$361 \$360 \$440 VSS sg13_lv_nmos L=0.13u W=0.42u AS=0.1428p AD=0.0609p
+ PS=1.52u PD=0.71u rfmode=0
M$329 \$440 VDD VSS VSS sg13_lv_nmos L=0.13u W=0.42u AS=0.0609p AD=0.1626p
+ PS=0.71u PD=1.415u rfmode=0
M$330 VSS \$487 \$329 VSS sg13_lv_nmos L=0.13u W=0.74u AS=0.1626p AD=0.2516p
+ PS=1.415u PD=2.16u rfmode=0
M$331 \$363 \$488 VSS VSS sg13_lv_nmos L=0.13u W=0.42u AS=0.1428p AD=0.0798p
+ PS=1.52u PD=0.8u rfmode=0
M$332 VSS VDD \$442 VSS sg13_lv_nmos L=0.13u W=0.42u AS=0.0798p AD=0.0378p
+ PS=0.8u PD=0.6u rfmode=0
M$333 \$442 \$364 \$488 VSS sg13_lv_nmos L=0.13u W=0.42u AS=0.0378p AD=0.1428p
+ PS=0.6u PD=1.52u rfmode=0
M$334 VSS \$364 \$366 VSS sg13_lv_nmos L=0.13u W=0.64u AS=0.1331p AD=0.2176p
+ PS=1.12u PD=1.96u rfmode=0
M$335 VSS \$364 \$365 VSS sg13_lv_nmos L=0.13u W=1.48u AS=0.3922p AD=0.2737p
+ PS=3.28u PD=2.24u rfmode=0
M$337 VSS \$366 \$367 VSS sg13_lv_nmos L=0.13u W=1.48u AS=0.3922p AD=0.3922p
+ PS=3.28u PD=3.28u rfmode=0
M$339 VSS \$171 \$331 VSS sg13_lv_nmos L=0.13u W=0.55u AS=0.187p AD=0.1045p
+ PS=1.78u PD=0.93u rfmode=0
M$340 \$331 \$319 VSS VSS sg13_lv_nmos L=0.13u W=0.55u AS=0.1045p AD=0.146425p
+ PS=0.93u PD=1.155u rfmode=0
M$341 VSS \$331 \$332 VSS sg13_lv_nmos L=0.13u W=1.48u AS=0.312925p AD=0.4477p
+ PS=2.345u PD=3.43u rfmode=0
M$343 \$371 \$370 \$451 VSS sg13_lv_nmos L=0.13u W=0.42u AS=0.1428p AD=0.0609p
+ PS=1.52u PD=0.71u rfmode=0
M$344 \$451 VDD VSS VSS sg13_lv_nmos L=0.13u W=0.42u AS=0.0609p AD=0.1626p
+ PS=0.71u PD=1.415u rfmode=0
M$345 VSS \$489 \$333 VSS sg13_lv_nmos L=0.13u W=0.74u AS=0.1626p AD=0.2516p
+ PS=1.415u PD=2.16u rfmode=0
M$346 \$373 \$490 VSS VSS sg13_lv_nmos L=0.13u W=0.42u AS=0.1428p AD=0.0798p
+ PS=1.52u PD=0.8u rfmode=0
M$347 VSS VDD \$453 VSS sg13_lv_nmos L=0.13u W=0.42u AS=0.0798p AD=0.0378p
+ PS=0.8u PD=0.6u rfmode=0
M$348 \$453 \$374 \$490 VSS sg13_lv_nmos L=0.13u W=0.42u AS=0.0378p AD=0.1428p
+ PS=0.6u PD=1.52u rfmode=0
M$349 VSS \$374 \$376 VSS sg13_lv_nmos L=0.13u W=0.64u AS=0.1331p AD=0.2176p
+ PS=1.12u PD=1.96u rfmode=0
M$350 VSS \$374 \$375 VSS sg13_lv_nmos L=0.13u W=1.48u AS=0.3922p AD=0.2737p
+ PS=3.28u PD=2.24u rfmode=0
M$352 VSS \$376 \$377 VSS sg13_lv_nmos L=0.13u W=1.48u AS=0.3922p AD=0.3922p
+ PS=3.28u PD=3.28u rfmode=0
M$354 VSS \$174 \$335 VSS sg13_lv_nmos L=0.13u W=0.55u AS=0.187p AD=0.1045p
+ PS=1.78u PD=0.93u rfmode=0
M$355 \$335 \$319 VSS VSS sg13_lv_nmos L=0.13u W=0.55u AS=0.1045p AD=0.146425p
+ PS=0.93u PD=1.155u rfmode=0
M$356 VSS \$335 \$336 VSS sg13_lv_nmos L=0.13u W=1.48u AS=0.312925p AD=0.4477p
+ PS=2.345u PD=3.43u rfmode=0
M$358 \$381 \$380 \$459 VSS sg13_lv_nmos L=0.13u W=0.42u AS=0.1428p AD=0.0609p
+ PS=1.52u PD=0.71u rfmode=0
M$359 \$459 VDD VSS VSS sg13_lv_nmos L=0.13u W=0.42u AS=0.0609p AD=0.1626p
+ PS=0.71u PD=1.415u rfmode=0
M$360 VSS \$491 \$337 VSS sg13_lv_nmos L=0.13u W=0.74u AS=0.1626p AD=0.2516p
+ PS=1.415u PD=2.16u rfmode=0
M$361 \$383 \$492 VSS VSS sg13_lv_nmos L=0.13u W=0.42u AS=0.1428p AD=0.0798p
+ PS=1.52u PD=0.8u rfmode=0
M$362 VSS VDD \$462 VSS sg13_lv_nmos L=0.13u W=0.42u AS=0.0798p AD=0.0378p
+ PS=0.8u PD=0.6u rfmode=0
M$363 \$462 \$384 \$492 VSS sg13_lv_nmos L=0.13u W=0.42u AS=0.0378p AD=0.1428p
+ PS=0.6u PD=1.52u rfmode=0
M$364 VSS \$384 \$386 VSS sg13_lv_nmos L=0.13u W=0.64u AS=0.1331p AD=0.2176p
+ PS=1.12u PD=1.96u rfmode=0
M$365 VSS \$384 \$385 VSS sg13_lv_nmos L=0.13u W=1.48u AS=0.3922p AD=0.2737p
+ PS=3.28u PD=2.24u rfmode=0
M$367 VSS \$386 \$387 VSS sg13_lv_nmos L=0.13u W=1.48u AS=0.3922p AD=0.3922p
+ PS=3.28u PD=3.28u rfmode=0
M$369 VSS \$177 \$339 VSS sg13_lv_nmos L=0.13u W=0.55u AS=0.187p AD=0.1045p
+ PS=1.78u PD=0.93u rfmode=0
M$370 \$339 \$319 VSS VSS sg13_lv_nmos L=0.13u W=0.55u AS=0.1045p AD=0.146425p
+ PS=0.93u PD=1.155u rfmode=0
M$371 VSS \$339 \$340 VSS sg13_lv_nmos L=0.13u W=1.48u AS=0.312925p AD=0.4477p
+ PS=2.345u PD=3.43u rfmode=0
M$373 \$391 \$390 \$470 VSS sg13_lv_nmos L=0.13u W=0.42u AS=0.1428p AD=0.0609p
+ PS=1.52u PD=0.71u rfmode=0
M$374 \$470 VDD VSS VSS sg13_lv_nmos L=0.13u W=0.42u AS=0.0609p AD=0.1626p
+ PS=0.71u PD=1.415u rfmode=0
M$375 VSS \$493 \$341 VSS sg13_lv_nmos L=0.13u W=0.74u AS=0.1626p AD=0.2516p
+ PS=1.415u PD=2.16u rfmode=0
M$376 \$393 \$494 VSS VSS sg13_lv_nmos L=0.13u W=0.42u AS=0.1428p AD=0.0798p
+ PS=1.52u PD=0.8u rfmode=0
M$377 VSS VDD \$472 VSS sg13_lv_nmos L=0.13u W=0.42u AS=0.0798p AD=0.0378p
+ PS=0.8u PD=0.6u rfmode=0
M$378 \$472 \$394 \$494 VSS sg13_lv_nmos L=0.13u W=0.42u AS=0.0378p AD=0.1428p
+ PS=0.6u PD=1.52u rfmode=0
M$379 VSS \$394 \$396 VSS sg13_lv_nmos L=0.13u W=0.64u AS=0.1331p AD=0.2176p
+ PS=1.12u PD=1.96u rfmode=0
M$380 VSS \$394 \$395 VSS sg13_lv_nmos L=0.13u W=1.48u AS=0.3922p AD=0.2737p
+ PS=3.28u PD=2.24u rfmode=0
M$382 VSS \$396 \$397 VSS sg13_lv_nmos L=0.13u W=1.48u AS=0.3922p AD=0.3922p
+ PS=3.28u PD=3.28u rfmode=0
M$384 VSS \$180 \$343 VSS sg13_lv_nmos L=0.13u W=0.55u AS=0.187p AD=0.1045p
+ PS=1.78u PD=0.93u rfmode=0
M$385 \$343 \$319 VSS VSS sg13_lv_nmos L=0.13u W=0.55u AS=0.1045p AD=0.146425p
+ PS=0.93u PD=1.155u rfmode=0
M$386 VSS \$343 \$344 VSS sg13_lv_nmos L=0.13u W=1.48u AS=0.312925p AD=0.4477p
+ PS=2.345u PD=3.43u rfmode=0
M$388 \$401 \$400 \$479 VSS sg13_lv_nmos L=0.13u W=0.42u AS=0.1428p AD=0.0609p
+ PS=1.52u PD=0.71u rfmode=0
M$389 \$479 VDD VSS VSS sg13_lv_nmos L=0.13u W=0.42u AS=0.0609p AD=0.1626p
+ PS=0.71u PD=1.415u rfmode=0
M$390 VSS \$495 \$345 VSS sg13_lv_nmos L=0.13u W=0.74u AS=0.1626p AD=0.2516p
+ PS=1.415u PD=2.16u rfmode=0
M$391 \$403 \$496 VSS VSS sg13_lv_nmos L=0.13u W=0.42u AS=0.1428p AD=0.0798p
+ PS=1.52u PD=0.8u rfmode=0
M$392 VSS VDD \$483 VSS sg13_lv_nmos L=0.13u W=0.42u AS=0.0798p AD=0.0378p
+ PS=0.8u PD=0.6u rfmode=0
M$393 \$483 \$404 \$496 VSS sg13_lv_nmos L=0.13u W=0.42u AS=0.0378p AD=0.1428p
+ PS=0.6u PD=1.52u rfmode=0
M$394 VSS \$404 \$406 VSS sg13_lv_nmos L=0.13u W=0.64u AS=0.1331p AD=0.2176p
+ PS=1.12u PD=1.96u rfmode=0
M$395 VSS \$404 \$405 VSS sg13_lv_nmos L=0.13u W=1.48u AS=0.3922p AD=0.2737p
+ PS=3.28u PD=2.24u rfmode=0
M$397 VSS \$406 \$407 VSS sg13_lv_nmos L=0.13u W=1.48u AS=0.3922p AD=0.3922p
+ PS=3.28u PD=3.28u rfmode=0
M$399 VSS \$183 \$347 VSS sg13_lv_nmos L=0.13u W=0.55u AS=0.187p AD=0.1045p
+ PS=1.78u PD=0.93u rfmode=0
M$400 \$347 \$319 VSS VSS sg13_lv_nmos L=0.13u W=0.55u AS=0.1045p AD=0.146425p
+ PS=0.93u PD=1.155u rfmode=0
M$401 VSS \$347 \$348 VSS sg13_lv_nmos L=0.13u W=1.48u AS=0.312925p AD=0.4477p
+ PS=2.345u PD=3.43u rfmode=0
M$403 \$411 \$410 \$482 VSS sg13_lv_nmos L=0.13u W=0.42u AS=0.1428p AD=0.0609p
+ PS=1.52u PD=0.71u rfmode=0
M$404 \$482 VDD VSS VSS sg13_lv_nmos L=0.13u W=0.42u AS=0.0609p AD=0.1626p
+ PS=0.71u PD=1.415u rfmode=0
M$405 VSS \$497 \$349 VSS sg13_lv_nmos L=0.13u W=0.74u AS=0.1626p AD=0.2516p
+ PS=1.415u PD=2.16u rfmode=0
M$406 \$413 \$498 VSS VSS sg13_lv_nmos L=0.13u W=0.42u AS=0.1428p AD=0.0798p
+ PS=1.52u PD=0.8u rfmode=0
M$407 VSS VDD \$478 VSS sg13_lv_nmos L=0.13u W=0.42u AS=0.0798p AD=0.0378p
+ PS=0.8u PD=0.6u rfmode=0
M$408 \$478 \$414 \$498 VSS sg13_lv_nmos L=0.13u W=0.42u AS=0.0378p AD=0.1428p
+ PS=0.6u PD=1.52u rfmode=0
M$409 VSS \$414 \$416 VSS sg13_lv_nmos L=0.13u W=0.64u AS=0.1331p AD=0.2176p
+ PS=1.12u PD=1.96u rfmode=0
M$410 VSS \$414 \$415 VSS sg13_lv_nmos L=0.13u W=1.48u AS=0.3922p AD=0.2737p
+ PS=3.28u PD=2.24u rfmode=0
M$412 VSS \$416 \$417 VSS sg13_lv_nmos L=0.13u W=1.48u AS=0.3922p AD=0.3922p
+ PS=3.28u PD=3.28u rfmode=0
M$414 VSS \$186 \$351 VSS sg13_lv_nmos L=0.13u W=0.55u AS=0.187p AD=0.1045p
+ PS=1.78u PD=0.93u rfmode=0
M$415 \$351 \$319 VSS VSS sg13_lv_nmos L=0.13u W=0.55u AS=0.1045p AD=0.146425p
+ PS=0.93u PD=1.155u rfmode=0
M$416 VSS \$351 \$352 VSS sg13_lv_nmos L=0.13u W=1.48u AS=0.312925p AD=0.4477p
+ PS=2.345u PD=3.43u rfmode=0
M$418 \$421 \$420 \$467 VSS sg13_lv_nmos L=0.13u W=0.42u AS=0.1428p AD=0.0609p
+ PS=1.52u PD=0.71u rfmode=0
M$419 \$467 VDD VSS VSS sg13_lv_nmos L=0.13u W=0.42u AS=0.0609p AD=0.1626p
+ PS=0.71u PD=1.415u rfmode=0
M$420 VSS \$499 \$353 VSS sg13_lv_nmos L=0.13u W=0.74u AS=0.1626p AD=0.2516p
+ PS=1.415u PD=2.16u rfmode=0
M$421 \$423 \$500 VSS VSS sg13_lv_nmos L=0.13u W=0.42u AS=0.1428p AD=0.0798p
+ PS=1.52u PD=0.8u rfmode=0
M$422 VSS VDD \$463 VSS sg13_lv_nmos L=0.13u W=0.42u AS=0.0798p AD=0.0378p
+ PS=0.8u PD=0.6u rfmode=0
M$423 \$463 \$424 \$500 VSS sg13_lv_nmos L=0.13u W=0.42u AS=0.0378p AD=0.1428p
+ PS=0.6u PD=1.52u rfmode=0
M$424 VSS \$424 \$426 VSS sg13_lv_nmos L=0.13u W=0.64u AS=0.1331p AD=0.2176p
+ PS=1.12u PD=1.96u rfmode=0
M$425 VSS \$424 \$425 VSS sg13_lv_nmos L=0.13u W=1.48u AS=0.3922p AD=0.2737p
+ PS=3.28u PD=2.24u rfmode=0
M$427 VSS \$426 \$427 VSS sg13_lv_nmos L=0.13u W=1.48u AS=0.3922p AD=0.3922p
+ PS=3.28u PD=3.28u rfmode=0
M$429 VSS VSS \$355 VSS sg13_lv_nmos L=0.13u W=0.55u AS=0.187p AD=0.1045p
+ PS=1.78u PD=0.93u rfmode=0
M$430 \$355 \$319 VSS VSS sg13_lv_nmos L=0.13u W=0.55u AS=0.1045p AD=0.146425p
+ PS=0.93u PD=1.155u rfmode=0
M$431 VSS \$355 \$356 VSS sg13_lv_nmos L=0.13u W=1.48u AS=0.312925p AD=0.4477p
+ PS=2.345u PD=3.43u rfmode=0
M$433 \$431 \$430 \$450 VSS sg13_lv_nmos L=0.13u W=0.42u AS=0.1428p AD=0.0609p
+ PS=1.52u PD=0.71u rfmode=0
M$434 \$450 VDD VSS VSS sg13_lv_nmos L=0.13u W=0.42u AS=0.0609p AD=0.1626p
+ PS=0.71u PD=1.415u rfmode=0
M$435 VSS \$501 \$357 VSS sg13_lv_nmos L=0.13u W=0.74u AS=0.1626p AD=0.2516p
+ PS=1.415u PD=2.16u rfmode=0
M$436 \$433 \$502 VSS VSS sg13_lv_nmos L=0.13u W=0.42u AS=0.1428p AD=0.0798p
+ PS=1.52u PD=0.8u rfmode=0
M$437 VSS VDD \$447 VSS sg13_lv_nmos L=0.13u W=0.42u AS=0.0798p AD=0.0378p
+ PS=0.8u PD=0.6u rfmode=0
M$438 \$447 \$434 \$502 VSS sg13_lv_nmos L=0.13u W=0.42u AS=0.0378p AD=0.1428p
+ PS=0.6u PD=1.52u rfmode=0
M$439 VSS \$434 \$436 VSS sg13_lv_nmos L=0.13u W=0.64u AS=0.1331p AD=0.2176p
+ PS=1.12u PD=1.96u rfmode=0
M$440 VSS \$434 \$435 VSS sg13_lv_nmos L=0.13u W=1.48u AS=0.3922p AD=0.2737p
+ PS=3.28u PD=2.24u rfmode=0
M$442 VSS \$436 \$437 VSS sg13_lv_nmos L=0.13u W=1.48u AS=0.3922p AD=0.3922p
+ PS=3.28u PD=3.28u rfmode=0
M$444 \$359 \$328 VSS VSS sg13_lv_nmos L=0.13u W=1.44u AS=0.4068p AD=0.2772p
+ PS=3.29u PD=2.21u rfmode=0
M$446 \$359 \$321 \$360 VSS sg13_lv_nmos L=0.13u W=1.44u AS=0.2772p AD=0.3816p
+ PS=2.21u PD=3.22u rfmode=0
M$448 VSS VDD \$441 VSS sg13_lv_nmos L=0.13u W=0.42u AS=0.1701p AD=0.03885p
+ PS=1.65u PD=0.605u rfmode=0
M$449 \$441 \$329 \$362 VSS sg13_lv_nmos L=0.13u W=0.42u AS=0.03885p AD=0.1596p
+ PS=0.605u PD=1.6u rfmode=0
M$450 VSS \$330 \$503 VSS sg13_lv_nmos L=0.13u W=0.74u AS=0.43315p AD=0.2516p
+ PS=2.205u PD=2.16u rfmode=0
M$451 VSS CLK \$330 VSS sg13_lv_nmos L=0.13u W=0.74u AS=0.43315p AD=0.2516p
+ PS=2.205u PD=2.16u rfmode=0
M$452 \$364 \$330 \$363 VSS sg13_lv_nmos L=0.13u W=0.42u AS=0.12665p AD=0.1428p
+ PS=1.145u PD=1.52u rfmode=0
M$453 \$329 \$503 \$364 VSS sg13_lv_nmos L=0.13u W=0.74u AS=0.3473p AD=0.12665p
+ PS=2.71u PD=1.145u rfmode=0
M$454 \$369 \$332 VSS VSS sg13_lv_nmos L=0.13u W=1.44u AS=0.4068p AD=0.2772p
+ PS=3.29u PD=2.21u rfmode=0
M$456 \$369 \$321 \$370 VSS sg13_lv_nmos L=0.13u W=1.44u AS=0.2772p AD=0.3816p
+ PS=2.21u PD=3.22u rfmode=0
M$458 VSS VDD \$452 VSS sg13_lv_nmos L=0.13u W=0.42u AS=0.1701p AD=0.03885p
+ PS=1.65u PD=0.605u rfmode=0
M$459 \$452 \$333 \$372 VSS sg13_lv_nmos L=0.13u W=0.42u AS=0.03885p AD=0.1596p
+ PS=0.605u PD=1.6u rfmode=0
M$460 VSS \$334 \$505 VSS sg13_lv_nmos L=0.13u W=0.74u AS=0.43315p AD=0.2516p
+ PS=2.205u PD=2.16u rfmode=0
M$461 VSS CLK \$334 VSS sg13_lv_nmos L=0.13u W=0.74u AS=0.43315p AD=0.2516p
+ PS=2.205u PD=2.16u rfmode=0
M$462 \$374 \$334 \$373 VSS sg13_lv_nmos L=0.13u W=0.42u AS=0.12665p AD=0.1428p
+ PS=1.145u PD=1.52u rfmode=0
M$463 \$333 \$505 \$374 VSS sg13_lv_nmos L=0.13u W=0.74u AS=0.3473p AD=0.12665p
+ PS=2.71u PD=1.145u rfmode=0
M$464 \$379 \$336 VSS VSS sg13_lv_nmos L=0.13u W=1.44u AS=0.4068p AD=0.2772p
+ PS=3.29u PD=2.21u rfmode=0
M$466 \$379 \$321 \$380 VSS sg13_lv_nmos L=0.13u W=1.44u AS=0.2772p AD=0.3816p
+ PS=2.21u PD=3.22u rfmode=0
M$468 VSS VDD \$461 VSS sg13_lv_nmos L=0.13u W=0.42u AS=0.1701p AD=0.03885p
+ PS=1.65u PD=0.605u rfmode=0
M$469 \$461 \$337 \$382 VSS sg13_lv_nmos L=0.13u W=0.42u AS=0.03885p AD=0.1596p
+ PS=0.605u PD=1.6u rfmode=0
M$470 VSS \$338 \$507 VSS sg13_lv_nmos L=0.13u W=0.74u AS=0.43315p AD=0.2516p
+ PS=2.205u PD=2.16u rfmode=0
M$471 VSS CLK \$338 VSS sg13_lv_nmos L=0.13u W=0.74u AS=0.43315p AD=0.2516p
+ PS=2.205u PD=2.16u rfmode=0
M$472 \$384 \$338 \$383 VSS sg13_lv_nmos L=0.13u W=0.42u AS=0.12665p AD=0.1428p
+ PS=1.145u PD=1.52u rfmode=0
M$473 \$337 \$507 \$384 VSS sg13_lv_nmos L=0.13u W=0.74u AS=0.3473p AD=0.12665p
+ PS=2.71u PD=1.145u rfmode=0
M$474 \$389 \$340 VSS VSS sg13_lv_nmos L=0.13u W=1.44u AS=0.4068p AD=0.2772p
+ PS=3.29u PD=2.21u rfmode=0
M$476 \$389 \$321 \$390 VSS sg13_lv_nmos L=0.13u W=1.44u AS=0.2772p AD=0.3816p
+ PS=2.21u PD=3.22u rfmode=0
M$478 VSS VDD \$471 VSS sg13_lv_nmos L=0.13u W=0.42u AS=0.1701p AD=0.03885p
+ PS=1.65u PD=0.605u rfmode=0
M$479 \$471 \$341 \$392 VSS sg13_lv_nmos L=0.13u W=0.42u AS=0.03885p AD=0.1596p
+ PS=0.605u PD=1.6u rfmode=0
M$480 VSS \$342 \$509 VSS sg13_lv_nmos L=0.13u W=0.74u AS=0.43315p AD=0.2516p
+ PS=2.205u PD=2.16u rfmode=0
M$481 VSS CLK \$342 VSS sg13_lv_nmos L=0.13u W=0.74u AS=0.43315p AD=0.2516p
+ PS=2.205u PD=2.16u rfmode=0
M$482 \$394 \$342 \$393 VSS sg13_lv_nmos L=0.13u W=0.42u AS=0.12665p AD=0.1428p
+ PS=1.145u PD=1.52u rfmode=0
M$483 \$341 \$509 \$394 VSS sg13_lv_nmos L=0.13u W=0.74u AS=0.3473p AD=0.12665p
+ PS=2.71u PD=1.145u rfmode=0
M$484 \$399 \$344 VSS VSS sg13_lv_nmos L=0.13u W=1.44u AS=0.4068p AD=0.2772p
+ PS=3.29u PD=2.21u rfmode=0
M$486 \$399 \$321 \$400 VSS sg13_lv_nmos L=0.13u W=1.44u AS=0.2772p AD=0.3816p
+ PS=2.21u PD=3.22u rfmode=0
M$488 VSS VDD \$480 VSS sg13_lv_nmos L=0.13u W=0.42u AS=0.1701p AD=0.03885p
+ PS=1.65u PD=0.605u rfmode=0
M$489 \$480 \$345 \$402 VSS sg13_lv_nmos L=0.13u W=0.42u AS=0.03885p AD=0.1596p
+ PS=0.605u PD=1.6u rfmode=0
M$490 VSS \$346 \$511 VSS sg13_lv_nmos L=0.13u W=0.74u AS=0.43315p AD=0.2516p
+ PS=2.205u PD=2.16u rfmode=0
M$491 VSS CLK \$346 VSS sg13_lv_nmos L=0.13u W=0.74u AS=0.43315p AD=0.2516p
+ PS=2.205u PD=2.16u rfmode=0
M$492 \$404 \$346 \$403 VSS sg13_lv_nmos L=0.13u W=0.42u AS=0.12665p AD=0.1428p
+ PS=1.145u PD=1.52u rfmode=0
M$493 \$345 \$511 \$404 VSS sg13_lv_nmos L=0.13u W=0.74u AS=0.3473p AD=0.12665p
+ PS=2.71u PD=1.145u rfmode=0
M$494 \$409 \$348 VSS VSS sg13_lv_nmos L=0.13u W=1.44u AS=0.4068p AD=0.2772p
+ PS=3.29u PD=2.21u rfmode=0
M$496 \$409 \$321 \$410 VSS sg13_lv_nmos L=0.13u W=1.44u AS=0.2772p AD=0.3816p
+ PS=2.21u PD=3.22u rfmode=0
M$498 VSS VDD \$481 VSS sg13_lv_nmos L=0.13u W=0.42u AS=0.1701p AD=0.03885p
+ PS=1.65u PD=0.605u rfmode=0
M$499 \$481 \$349 \$412 VSS sg13_lv_nmos L=0.13u W=0.42u AS=0.03885p AD=0.1596p
+ PS=0.605u PD=1.6u rfmode=0
M$500 VSS \$350 \$513 VSS sg13_lv_nmos L=0.13u W=0.74u AS=0.43315p AD=0.2516p
+ PS=2.205u PD=2.16u rfmode=0
M$501 VSS CLK \$350 VSS sg13_lv_nmos L=0.13u W=0.74u AS=0.43315p AD=0.2516p
+ PS=2.205u PD=2.16u rfmode=0
M$502 \$414 \$350 \$413 VSS sg13_lv_nmos L=0.13u W=0.42u AS=0.12665p AD=0.1428p
+ PS=1.145u PD=1.52u rfmode=0
M$503 \$349 \$513 \$414 VSS sg13_lv_nmos L=0.13u W=0.74u AS=0.3473p AD=0.12665p
+ PS=2.71u PD=1.145u rfmode=0
M$504 \$419 \$352 VSS VSS sg13_lv_nmos L=0.13u W=1.44u AS=0.4068p AD=0.2772p
+ PS=3.29u PD=2.21u rfmode=0
M$506 \$419 \$321 \$420 VSS sg13_lv_nmos L=0.13u W=1.44u AS=0.2772p AD=0.3816p
+ PS=2.21u PD=3.22u rfmode=0
M$508 VSS VDD \$466 VSS sg13_lv_nmos L=0.13u W=0.42u AS=0.1701p AD=0.03885p
+ PS=1.65u PD=0.605u rfmode=0
M$509 \$466 \$353 \$422 VSS sg13_lv_nmos L=0.13u W=0.42u AS=0.03885p AD=0.1596p
+ PS=0.605u PD=1.6u rfmode=0
M$510 VSS \$354 \$515 VSS sg13_lv_nmos L=0.13u W=0.74u AS=0.43315p AD=0.2516p
+ PS=2.205u PD=2.16u rfmode=0
M$511 VSS CLK \$354 VSS sg13_lv_nmos L=0.13u W=0.74u AS=0.43315p AD=0.2516p
+ PS=2.205u PD=2.16u rfmode=0
M$512 \$424 \$354 \$423 VSS sg13_lv_nmos L=0.13u W=0.42u AS=0.12665p AD=0.1428p
+ PS=1.145u PD=1.52u rfmode=0
M$513 \$353 \$515 \$424 VSS sg13_lv_nmos L=0.13u W=0.74u AS=0.3473p AD=0.12665p
+ PS=2.71u PD=1.145u rfmode=0
M$514 \$429 \$356 VSS VSS sg13_lv_nmos L=0.13u W=1.44u AS=0.4068p AD=0.2772p
+ PS=3.29u PD=2.21u rfmode=0
M$516 \$429 \$321 \$430 VSS sg13_lv_nmos L=0.13u W=1.44u AS=0.2772p AD=0.3816p
+ PS=2.21u PD=3.22u rfmode=0
M$518 VSS VDD \$449 VSS sg13_lv_nmos L=0.13u W=0.42u AS=0.1701p AD=0.03885p
+ PS=1.65u PD=0.605u rfmode=0
M$519 \$449 \$357 \$432 VSS sg13_lv_nmos L=0.13u W=0.42u AS=0.03885p AD=0.1596p
+ PS=0.605u PD=1.6u rfmode=0
M$520 VSS \$358 \$517 VSS sg13_lv_nmos L=0.13u W=0.74u AS=0.43315p AD=0.2516p
+ PS=2.205u PD=2.16u rfmode=0
M$521 VSS CLK \$358 VSS sg13_lv_nmos L=0.13u W=0.74u AS=0.43315p AD=0.2516p
+ PS=2.205u PD=2.16u rfmode=0
M$522 \$434 \$358 \$433 VSS sg13_lv_nmos L=0.13u W=0.42u AS=0.12665p AD=0.1428p
+ PS=1.145u PD=1.52u rfmode=0
M$523 \$357 \$517 \$434 VSS sg13_lv_nmos L=0.13u W=0.74u AS=0.3473p AD=0.12665p
+ PS=2.71u PD=1.145u rfmode=0
M$524 \$323 X9 \$520 VSS sg13_lv_nmos L=0.13u W=0.64u AS=0.2176p AD=0.1216p
+ PS=1.96u PD=1.02u rfmode=0
M$525 \$520 X10 VSS VSS sg13_lv_nmos L=0.13u W=0.64u AS=0.1216p AD=0.1331p
+ PS=1.02u PD=1.12u rfmode=0
M$526 VSS \$323 \$324 VSS sg13_lv_nmos L=0.13u W=1.48u AS=0.2737p AD=0.4218p
+ PS=2.24u PD=3.36u rfmode=0
M$528 \$560 X8 \$572 VSS sg13_lv_nmos L=0.13u W=0.64u AS=0.2176p AD=0.1216p
+ PS=1.96u PD=1.02u rfmode=0
M$529 VSS X9 \$572 VSS sg13_lv_nmos L=0.13u W=0.64u AS=0.1331p AD=0.1216p
+ PS=1.12u PD=1.02u rfmode=0
M$530 VSS \$560 \$561 VSS sg13_lv_nmos L=0.13u W=1.48u AS=0.2737p AD=0.4218p
+ PS=2.24u PD=3.36u rfmode=0
M$532 \$562 X10 \$573 VSS sg13_lv_nmos L=0.13u W=0.64u AS=0.2176p AD=0.1216p
+ PS=1.96u PD=1.02u rfmode=0
M$533 VSS \$561 \$573 VSS sg13_lv_nmos L=0.13u W=0.64u AS=0.1331p AD=0.1216p
+ PS=1.12u PD=1.02u rfmode=0
M$534 VSS \$562 \$563 VSS sg13_lv_nmos L=0.13u W=1.48u AS=0.2737p AD=0.4218p
+ PS=2.24u PD=3.36u rfmode=0
M$536 VSS \$167 \$622 VSS sg13_lv_nmos L=0.13u W=0.55u AS=0.187p AD=0.1045p
+ PS=1.78u PD=0.93u rfmode=0
M$537 \$622 \$195 VSS VSS sg13_lv_nmos L=0.13u W=0.55u AS=0.1045p AD=0.146425p
+ PS=0.93u PD=1.155u rfmode=0
M$538 VSS \$622 \$623 VSS sg13_lv_nmos L=0.13u W=1.48u AS=0.312925p AD=0.4477p
+ PS=2.345u PD=3.43u rfmode=0
M$540 \$656 \$655 \$732 VSS sg13_lv_nmos L=0.13u W=0.42u AS=0.1428p AD=0.0609p
+ PS=1.52u PD=0.71u rfmode=0
M$541 \$732 VDD VSS VSS sg13_lv_nmos L=0.13u W=0.42u AS=0.0609p AD=0.1626p
+ PS=0.71u PD=1.415u rfmode=0
M$542 VSS \$779 \$624 VSS sg13_lv_nmos L=0.13u W=0.74u AS=0.1626p AD=0.2516p
+ PS=1.415u PD=2.16u rfmode=0
M$543 \$361 \$330 \$487 VSS sg13_lv_nmos L=0.13u W=0.42u AS=0.1296p AD=0.081p
+ PS=1.52u PD=0.81u rfmode=0
M$544 \$487 \$503 \$362 VSS sg13_lv_nmos L=0.13u W=0.42u AS=0.081p AD=0.2163p
+ PS=0.81u PD=1.87u rfmode=0
M$545 \$658 \$780 VSS VSS sg13_lv_nmos L=0.13u W=0.42u AS=0.1428p AD=0.0798p
+ PS=1.52u PD=0.8u rfmode=0
M$546 VSS VDD \$734 VSS sg13_lv_nmos L=0.13u W=0.42u AS=0.0798p AD=0.0378p
+ PS=0.8u PD=0.6u rfmode=0
M$547 \$734 \$659 \$780 VSS sg13_lv_nmos L=0.13u W=0.42u AS=0.0378p AD=0.1428p
+ PS=0.6u PD=1.52u rfmode=0
M$548 VSS \$659 \$661 VSS sg13_lv_nmos L=0.13u W=0.64u AS=0.1331p AD=0.2176p
+ PS=1.12u PD=1.96u rfmode=0
M$549 VSS \$659 \$660 VSS sg13_lv_nmos L=0.13u W=1.48u AS=0.3922p AD=0.2737p
+ PS=3.28u PD=2.24u rfmode=0
M$551 VSS \$661 \$662 VSS sg13_lv_nmos L=0.13u W=1.48u AS=0.3922p AD=0.3922p
+ PS=3.28u PD=3.28u rfmode=0
M$553 VSS VSS \$504 VSS sg13_lv_nmos L=0.13u W=1u AS=0.265p AD=0.265p PS=2.56u
+ PD=2.56u rfmode=0
M$554 \$504 \$365 OUTP VSS sg13_lv_nmos L=0.13u W=2u AS=0.38p AD=0.38p PS=3.52u
+ PD=3.52u rfmode=0
M$556 \$504 \$367 OUTN VSS sg13_lv_nmos L=0.13u W=2u AS=0.38p AD=0.38p PS=3.52u
+ PD=3.52u rfmode=0
M$563 VSS \$171 \$626 VSS sg13_lv_nmos L=0.13u W=0.55u AS=0.187p AD=0.1045p
+ PS=1.78u PD=0.93u rfmode=0
M$564 \$626 \$195 VSS VSS sg13_lv_nmos L=0.13u W=0.55u AS=0.1045p AD=0.146425p
+ PS=0.93u PD=1.155u rfmode=0
M$565 VSS \$626 \$627 VSS sg13_lv_nmos L=0.13u W=1.48u AS=0.312925p AD=0.4477p
+ PS=2.345u PD=3.43u rfmode=0
M$567 \$666 \$665 \$743 VSS sg13_lv_nmos L=0.13u W=0.42u AS=0.1428p AD=0.0609p
+ PS=1.52u PD=0.71u rfmode=0
M$568 \$743 VDD VSS VSS sg13_lv_nmos L=0.13u W=0.42u AS=0.0609p AD=0.1626p
+ PS=0.71u PD=1.415u rfmode=0
M$569 VSS \$781 \$628 VSS sg13_lv_nmos L=0.13u W=0.74u AS=0.1626p AD=0.2516p
+ PS=1.415u PD=2.16u rfmode=0
M$570 \$371 \$334 \$489 VSS sg13_lv_nmos L=0.13u W=0.42u AS=0.1296p AD=0.081p
+ PS=1.52u PD=0.81u rfmode=0
M$571 \$489 \$505 \$372 VSS sg13_lv_nmos L=0.13u W=0.42u AS=0.081p AD=0.2163p
+ PS=0.81u PD=1.87u rfmode=0
M$572 \$668 \$782 VSS VSS sg13_lv_nmos L=0.13u W=0.42u AS=0.1428p AD=0.0798p
+ PS=1.52u PD=0.8u rfmode=0
M$573 VSS VDD \$746 VSS sg13_lv_nmos L=0.13u W=0.42u AS=0.0798p AD=0.0378p
+ PS=0.8u PD=0.6u rfmode=0
M$574 \$746 \$669 \$782 VSS sg13_lv_nmos L=0.13u W=0.42u AS=0.0378p AD=0.1428p
+ PS=0.6u PD=1.52u rfmode=0
M$575 VSS \$669 \$671 VSS sg13_lv_nmos L=0.13u W=0.64u AS=0.1331p AD=0.2176p
+ PS=1.12u PD=1.96u rfmode=0
M$576 VSS \$669 \$670 VSS sg13_lv_nmos L=0.13u W=1.48u AS=0.3922p AD=0.2737p
+ PS=3.28u PD=2.24u rfmode=0
M$578 VSS \$671 \$672 VSS sg13_lv_nmos L=0.13u W=1.48u AS=0.3922p AD=0.3922p
+ PS=3.28u PD=3.28u rfmode=0
M$580 VSS VSS \$506 VSS sg13_lv_nmos L=0.13u W=1u AS=0.265p AD=0.265p PS=2.56u
+ PD=2.56u rfmode=0
M$581 \$506 \$375 OUTP VSS sg13_lv_nmos L=0.13u W=2u AS=0.38p AD=0.38p PS=3.52u
+ PD=3.52u rfmode=0
M$583 \$506 \$377 OUTN VSS sg13_lv_nmos L=0.13u W=2u AS=0.38p AD=0.38p PS=3.52u
+ PD=3.52u rfmode=0
M$590 VSS \$174 \$630 VSS sg13_lv_nmos L=0.13u W=0.55u AS=0.187p AD=0.1045p
+ PS=1.78u PD=0.93u rfmode=0
M$591 \$630 \$195 VSS VSS sg13_lv_nmos L=0.13u W=0.55u AS=0.1045p AD=0.146425p
+ PS=0.93u PD=1.155u rfmode=0
M$592 VSS \$630 \$631 VSS sg13_lv_nmos L=0.13u W=1.48u AS=0.312925p AD=0.4477p
+ PS=2.345u PD=3.43u rfmode=0
M$594 \$676 \$675 \$753 VSS sg13_lv_nmos L=0.13u W=0.42u AS=0.1428p AD=0.0609p
+ PS=1.52u PD=0.71u rfmode=0
M$595 \$753 VDD VSS VSS sg13_lv_nmos L=0.13u W=0.42u AS=0.0609p AD=0.1626p
+ PS=0.71u PD=1.415u rfmode=0
M$596 VSS \$783 \$632 VSS sg13_lv_nmos L=0.13u W=0.74u AS=0.1626p AD=0.2516p
+ PS=1.415u PD=2.16u rfmode=0
M$597 \$381 \$338 \$491 VSS sg13_lv_nmos L=0.13u W=0.42u AS=0.1296p AD=0.081p
+ PS=1.52u PD=0.81u rfmode=0
M$598 \$491 \$507 \$382 VSS sg13_lv_nmos L=0.13u W=0.42u AS=0.081p AD=0.2163p
+ PS=0.81u PD=1.87u rfmode=0
M$599 \$678 \$784 VSS VSS sg13_lv_nmos L=0.13u W=0.42u AS=0.1428p AD=0.0798p
+ PS=1.52u PD=0.8u rfmode=0
M$600 VSS VDD \$757 VSS sg13_lv_nmos L=0.13u W=0.42u AS=0.0798p AD=0.0378p
+ PS=0.8u PD=0.6u rfmode=0
M$601 \$757 \$679 \$784 VSS sg13_lv_nmos L=0.13u W=0.42u AS=0.0378p AD=0.1428p
+ PS=0.6u PD=1.52u rfmode=0
M$602 VSS \$679 \$681 VSS sg13_lv_nmos L=0.13u W=0.64u AS=0.1331p AD=0.2176p
+ PS=1.12u PD=1.96u rfmode=0
M$603 VSS \$679 \$680 VSS sg13_lv_nmos L=0.13u W=1.48u AS=0.3922p AD=0.2737p
+ PS=3.28u PD=2.24u rfmode=0
M$605 VSS \$681 \$682 VSS sg13_lv_nmos L=0.13u W=1.48u AS=0.3922p AD=0.3922p
+ PS=3.28u PD=3.28u rfmode=0
M$607 VSS VSS \$508 VSS sg13_lv_nmos L=0.13u W=1u AS=0.265p AD=0.265p PS=2.56u
+ PD=2.56u rfmode=0
M$608 \$508 \$385 OUTP VSS sg13_lv_nmos L=0.13u W=2u AS=0.38p AD=0.38p PS=3.52u
+ PD=3.52u rfmode=0
M$610 \$508 \$387 OUTN VSS sg13_lv_nmos L=0.13u W=2u AS=0.38p AD=0.38p PS=3.52u
+ PD=3.52u rfmode=0
M$617 VSS \$177 \$634 VSS sg13_lv_nmos L=0.13u W=0.55u AS=0.187p AD=0.1045p
+ PS=1.78u PD=0.93u rfmode=0
M$618 \$634 \$195 VSS VSS sg13_lv_nmos L=0.13u W=0.55u AS=0.1045p AD=0.146425p
+ PS=0.93u PD=1.155u rfmode=0
M$619 VSS \$634 \$635 VSS sg13_lv_nmos L=0.13u W=1.48u AS=0.312925p AD=0.4477p
+ PS=2.345u PD=3.43u rfmode=0
M$621 \$686 \$685 \$764 VSS sg13_lv_nmos L=0.13u W=0.42u AS=0.1428p AD=0.0609p
+ PS=1.52u PD=0.71u rfmode=0
M$622 \$764 VDD VSS VSS sg13_lv_nmos L=0.13u W=0.42u AS=0.0609p AD=0.1626p
+ PS=0.71u PD=1.415u rfmode=0
M$623 VSS \$785 \$636 VSS sg13_lv_nmos L=0.13u W=0.74u AS=0.1626p AD=0.2516p
+ PS=1.415u PD=2.16u rfmode=0
M$624 \$391 \$342 \$493 VSS sg13_lv_nmos L=0.13u W=0.42u AS=0.1296p AD=0.081p
+ PS=1.52u PD=0.81u rfmode=0
M$625 \$493 \$509 \$392 VSS sg13_lv_nmos L=0.13u W=0.42u AS=0.081p AD=0.2163p
+ PS=0.81u PD=1.87u rfmode=0
M$626 \$688 \$786 VSS VSS sg13_lv_nmos L=0.13u W=0.42u AS=0.1428p AD=0.0798p
+ PS=1.52u PD=0.8u rfmode=0
M$627 VSS VDD \$767 VSS sg13_lv_nmos L=0.13u W=0.42u AS=0.0798p AD=0.0378p
+ PS=0.8u PD=0.6u rfmode=0
M$628 \$767 \$689 \$786 VSS sg13_lv_nmos L=0.13u W=0.42u AS=0.0378p AD=0.1428p
+ PS=0.6u PD=1.52u rfmode=0
M$629 VSS \$689 \$691 VSS sg13_lv_nmos L=0.13u W=0.64u AS=0.1331p AD=0.2176p
+ PS=1.12u PD=1.96u rfmode=0
M$630 VSS \$689 \$690 VSS sg13_lv_nmos L=0.13u W=1.48u AS=0.3922p AD=0.2737p
+ PS=3.28u PD=2.24u rfmode=0
M$632 VSS \$691 \$692 VSS sg13_lv_nmos L=0.13u W=1.48u AS=0.3922p AD=0.3922p
+ PS=3.28u PD=3.28u rfmode=0
M$634 VSS VSS \$510 VSS sg13_lv_nmos L=0.13u W=1u AS=0.265p AD=0.265p PS=2.56u
+ PD=2.56u rfmode=0
M$635 \$510 \$395 OUTP VSS sg13_lv_nmos L=0.13u W=2u AS=0.38p AD=0.38p PS=3.52u
+ PD=3.52u rfmode=0
M$637 \$510 \$397 OUTN VSS sg13_lv_nmos L=0.13u W=2u AS=0.38p AD=0.38p PS=3.52u
+ PD=3.52u rfmode=0
M$644 VSS \$180 \$638 VSS sg13_lv_nmos L=0.13u W=0.55u AS=0.187p AD=0.1045p
+ PS=1.78u PD=0.93u rfmode=0
M$645 \$638 \$195 VSS VSS sg13_lv_nmos L=0.13u W=0.55u AS=0.1045p AD=0.146425p
+ PS=0.93u PD=1.155u rfmode=0
M$646 VSS \$638 \$639 VSS sg13_lv_nmos L=0.13u W=1.48u AS=0.312925p AD=0.4477p
+ PS=2.345u PD=3.43u rfmode=0
M$648 \$696 \$695 \$774 VSS sg13_lv_nmos L=0.13u W=0.42u AS=0.1428p AD=0.0609p
+ PS=1.52u PD=0.71u rfmode=0
M$649 \$774 VDD VSS VSS sg13_lv_nmos L=0.13u W=0.42u AS=0.0609p AD=0.1626p
+ PS=0.71u PD=1.415u rfmode=0
M$650 VSS \$787 \$640 VSS sg13_lv_nmos L=0.13u W=0.74u AS=0.1626p AD=0.2516p
+ PS=1.415u PD=2.16u rfmode=0
M$651 \$401 \$346 \$495 VSS sg13_lv_nmos L=0.13u W=0.42u AS=0.1296p AD=0.081p
+ PS=1.52u PD=0.81u rfmode=0
M$652 \$495 \$511 \$402 VSS sg13_lv_nmos L=0.13u W=0.42u AS=0.081p AD=0.2163p
+ PS=0.81u PD=1.87u rfmode=0
M$653 \$698 \$788 VSS VSS sg13_lv_nmos L=0.13u W=0.42u AS=0.1428p AD=0.0798p
+ PS=1.52u PD=0.8u rfmode=0
M$654 VSS VDD \$776 VSS sg13_lv_nmos L=0.13u W=0.42u AS=0.0798p AD=0.0378p
+ PS=0.8u PD=0.6u rfmode=0
M$655 \$776 \$699 \$788 VSS sg13_lv_nmos L=0.13u W=0.42u AS=0.0378p AD=0.1428p
+ PS=0.6u PD=1.52u rfmode=0
M$656 VSS \$699 \$701 VSS sg13_lv_nmos L=0.13u W=0.64u AS=0.1331p AD=0.2176p
+ PS=1.12u PD=1.96u rfmode=0
M$657 VSS \$699 \$700 VSS sg13_lv_nmos L=0.13u W=1.48u AS=0.3922p AD=0.2737p
+ PS=3.28u PD=2.24u rfmode=0
M$659 VSS \$701 \$702 VSS sg13_lv_nmos L=0.13u W=1.48u AS=0.3922p AD=0.3922p
+ PS=3.28u PD=3.28u rfmode=0
M$661 VSS VSS \$512 VSS sg13_lv_nmos L=0.13u W=1u AS=0.265p AD=0.265p PS=2.56u
+ PD=2.56u rfmode=0
M$662 \$512 \$405 OUTP VSS sg13_lv_nmos L=0.13u W=2u AS=0.38p AD=0.38p PS=3.52u
+ PD=3.52u rfmode=0
M$664 \$512 \$407 OUTN VSS sg13_lv_nmos L=0.13u W=2u AS=0.38p AD=0.38p PS=3.52u
+ PD=3.52u rfmode=0
M$671 VSS \$183 \$642 VSS sg13_lv_nmos L=0.13u W=0.55u AS=0.187p AD=0.1045p
+ PS=1.78u PD=0.93u rfmode=0
M$672 \$642 \$195 VSS VSS sg13_lv_nmos L=0.13u W=0.55u AS=0.1045p AD=0.146425p
+ PS=0.93u PD=1.155u rfmode=0
M$673 VSS \$642 \$643 VSS sg13_lv_nmos L=0.13u W=1.48u AS=0.312925p AD=0.4477p
+ PS=2.345u PD=3.43u rfmode=0
M$675 \$805 \$705 \$771 VSS sg13_lv_nmos L=0.13u W=0.42u AS=0.1428p AD=0.0609p
+ PS=1.52u PD=0.71u rfmode=0
M$676 \$771 VDD VSS VSS sg13_lv_nmos L=0.13u W=0.42u AS=0.0609p AD=0.1626p
+ PS=0.71u PD=1.415u rfmode=0
M$677 VSS \$789 \$644 VSS sg13_lv_nmos L=0.13u W=0.74u AS=0.1626p AD=0.2516p
+ PS=1.415u PD=2.16u rfmode=0
M$678 \$411 \$350 \$497 VSS sg13_lv_nmos L=0.13u W=0.42u AS=0.1296p AD=0.081p
+ PS=1.52u PD=0.81u rfmode=0
M$679 \$497 \$513 \$412 VSS sg13_lv_nmos L=0.13u W=0.42u AS=0.081p AD=0.2163p
+ PS=0.81u PD=1.87u rfmode=0
M$680 \$707 \$790 VSS VSS sg13_lv_nmos L=0.13u W=0.42u AS=0.1428p AD=0.0798p
+ PS=1.52u PD=0.8u rfmode=0
M$681 VSS VDD \$766 VSS sg13_lv_nmos L=0.13u W=0.42u AS=0.0798p AD=0.0378p
+ PS=0.8u PD=0.6u rfmode=0
M$682 \$766 \$708 \$790 VSS sg13_lv_nmos L=0.13u W=0.42u AS=0.0378p AD=0.1428p
+ PS=0.6u PD=1.52u rfmode=0
M$683 VSS \$708 \$710 VSS sg13_lv_nmos L=0.13u W=0.64u AS=0.1331p AD=0.2176p
+ PS=1.12u PD=1.96u rfmode=0
M$684 VSS \$708 \$709 VSS sg13_lv_nmos L=0.13u W=1.48u AS=0.3922p AD=0.2737p
+ PS=3.28u PD=2.24u rfmode=0
M$686 VSS \$710 \$711 VSS sg13_lv_nmos L=0.13u W=1.48u AS=0.3922p AD=0.3922p
+ PS=3.28u PD=3.28u rfmode=0
M$688 VSS VSS \$514 VSS sg13_lv_nmos L=0.13u W=1u AS=0.265p AD=0.265p PS=2.56u
+ PD=2.56u rfmode=0
M$689 \$514 \$415 OUTP VSS sg13_lv_nmos L=0.13u W=2u AS=0.38p AD=0.38p PS=3.52u
+ PD=3.52u rfmode=0
M$691 \$514 \$417 OUTN VSS sg13_lv_nmos L=0.13u W=2u AS=0.38p AD=0.38p PS=3.52u
+ PD=3.52u rfmode=0
M$698 VSS \$186 \$646 VSS sg13_lv_nmos L=0.13u W=0.55u AS=0.187p AD=0.1045p
+ PS=1.78u PD=0.93u rfmode=0
M$699 \$646 \$195 VSS VSS sg13_lv_nmos L=0.13u W=0.55u AS=0.1045p AD=0.146425p
+ PS=0.93u PD=1.155u rfmode=0
M$700 VSS \$646 \$647 VSS sg13_lv_nmos L=0.13u W=1.48u AS=0.312925p AD=0.4477p
+ PS=2.345u PD=3.43u rfmode=0
M$702 \$808 \$714 \$756 VSS sg13_lv_nmos L=0.13u W=0.42u AS=0.1428p AD=0.0609p
+ PS=1.52u PD=0.71u rfmode=0
M$703 \$756 VDD VSS VSS sg13_lv_nmos L=0.13u W=0.42u AS=0.0609p AD=0.1626p
+ PS=0.71u PD=1.415u rfmode=0
M$704 VSS \$791 \$648 VSS sg13_lv_nmos L=0.13u W=0.74u AS=0.1626p AD=0.2516p
+ PS=1.415u PD=2.16u rfmode=0
M$705 \$421 \$354 \$499 VSS sg13_lv_nmos L=0.13u W=0.42u AS=0.1296p AD=0.081p
+ PS=1.52u PD=0.81u rfmode=0
M$706 \$499 \$515 \$422 VSS sg13_lv_nmos L=0.13u W=0.42u AS=0.081p AD=0.2163p
+ PS=0.81u PD=1.87u rfmode=0
M$707 \$716 \$792 VSS VSS sg13_lv_nmos L=0.13u W=0.42u AS=0.1428p AD=0.0798p
+ PS=1.52u PD=0.8u rfmode=0
M$708 VSS VDD \$752 VSS sg13_lv_nmos L=0.13u W=0.42u AS=0.0798p AD=0.0378p
+ PS=0.8u PD=0.6u rfmode=0
M$709 \$752 \$717 \$792 VSS sg13_lv_nmos L=0.13u W=0.42u AS=0.0378p AD=0.1428p
+ PS=0.6u PD=1.52u rfmode=0
M$710 VSS \$717 \$719 VSS sg13_lv_nmos L=0.13u W=0.64u AS=0.1331p AD=0.2176p
+ PS=1.12u PD=1.96u rfmode=0
M$711 VSS \$717 \$718 VSS sg13_lv_nmos L=0.13u W=1.48u AS=0.3922p AD=0.2737p
+ PS=3.28u PD=2.24u rfmode=0
M$713 VSS \$719 \$720 VSS sg13_lv_nmos L=0.13u W=1.48u AS=0.3922p AD=0.3922p
+ PS=3.28u PD=3.28u rfmode=0
M$715 VSS VSS \$516 VSS sg13_lv_nmos L=0.13u W=1u AS=0.265p AD=0.265p PS=2.56u
+ PD=2.56u rfmode=0
M$716 \$516 \$425 OUTP VSS sg13_lv_nmos L=0.13u W=2u AS=0.38p AD=0.38p PS=3.52u
+ PD=3.52u rfmode=0
M$718 \$516 \$427 OUTN VSS sg13_lv_nmos L=0.13u W=2u AS=0.38p AD=0.38p PS=3.52u
+ PD=3.52u rfmode=0
M$725 VSS VSS \$650 VSS sg13_lv_nmos L=0.13u W=0.55u AS=0.187p AD=0.1045p
+ PS=1.78u PD=0.93u rfmode=0
M$726 \$650 \$195 VSS VSS sg13_lv_nmos L=0.13u W=0.55u AS=0.1045p AD=0.146425p
+ PS=0.93u PD=1.155u rfmode=0
M$727 VSS \$650 \$651 VSS sg13_lv_nmos L=0.13u W=1.48u AS=0.312925p AD=0.4477p
+ PS=2.345u PD=3.43u rfmode=0
M$729 \$811 \$723 \$742 VSS sg13_lv_nmos L=0.13u W=0.42u AS=0.1428p AD=0.0609p
+ PS=1.52u PD=0.71u rfmode=0
M$730 \$742 VDD VSS VSS sg13_lv_nmos L=0.13u W=0.42u AS=0.0609p AD=0.1626p
+ PS=0.71u PD=1.415u rfmode=0
M$731 VSS \$793 \$652 VSS sg13_lv_nmos L=0.13u W=0.74u AS=0.1626p AD=0.2516p
+ PS=1.415u PD=2.16u rfmode=0
M$732 \$431 \$358 \$501 VSS sg13_lv_nmos L=0.13u W=0.42u AS=0.1296p AD=0.081p
+ PS=1.52u PD=0.81u rfmode=0
M$733 \$501 \$517 \$432 VSS sg13_lv_nmos L=0.13u W=0.42u AS=0.081p AD=0.2163p
+ PS=0.81u PD=1.87u rfmode=0
M$734 \$725 \$794 VSS VSS sg13_lv_nmos L=0.13u W=0.42u AS=0.1428p AD=0.0798p
+ PS=1.52u PD=0.8u rfmode=0
M$735 VSS VDD \$739 VSS sg13_lv_nmos L=0.13u W=0.42u AS=0.0798p AD=0.0378p
+ PS=0.8u PD=0.6u rfmode=0
M$736 \$739 \$726 \$794 VSS sg13_lv_nmos L=0.13u W=0.42u AS=0.0378p AD=0.1428p
+ PS=0.6u PD=1.52u rfmode=0
M$737 VSS \$726 \$728 VSS sg13_lv_nmos L=0.13u W=0.64u AS=0.1331p AD=0.2176p
+ PS=1.12u PD=1.96u rfmode=0
M$738 VSS \$726 \$727 VSS sg13_lv_nmos L=0.13u W=1.48u AS=0.3922p AD=0.2737p
+ PS=3.28u PD=2.24u rfmode=0
M$740 VSS \$728 \$729 VSS sg13_lv_nmos L=0.13u W=1.48u AS=0.3922p AD=0.3922p
+ PS=3.28u PD=3.28u rfmode=0
M$742 VSS VSS \$518 VSS sg13_lv_nmos L=0.13u W=1u AS=0.265p AD=0.265p PS=2.56u
+ PD=2.56u rfmode=0
M$743 \$518 \$435 OUTP VSS sg13_lv_nmos L=0.13u W=2u AS=0.38p AD=0.38p PS=3.52u
+ PD=3.52u rfmode=0
M$745 \$518 \$437 OUTN VSS sg13_lv_nmos L=0.13u W=2u AS=0.38p AD=0.38p PS=3.52u
+ PD=3.52u rfmode=0
M$752 \$654 \$623 VSS VSS sg13_lv_nmos L=0.13u W=1.44u AS=0.4068p AD=0.2772p
+ PS=3.29u PD=2.21u rfmode=0
M$754 \$654 \$319 \$655 VSS sg13_lv_nmos L=0.13u W=1.44u AS=0.2772p AD=0.3816p
+ PS=2.21u PD=3.22u rfmode=0
M$756 VSS VDD \$733 VSS sg13_lv_nmos L=0.13u W=0.42u AS=0.1701p AD=0.03885p
+ PS=1.65u PD=0.605u rfmode=0
M$757 \$733 \$624 \$657 VSS sg13_lv_nmos L=0.13u W=0.42u AS=0.03885p AD=0.1596p
+ PS=0.605u PD=1.6u rfmode=0
M$758 VSS \$625 \$795 VSS sg13_lv_nmos L=0.13u W=0.74u AS=0.43315p AD=0.2516p
+ PS=2.205u PD=2.16u rfmode=0
M$759 VSS CLK \$625 VSS sg13_lv_nmos L=0.13u W=0.74u AS=0.43315p AD=0.2516p
+ PS=2.205u PD=2.16u rfmode=0
M$760 \$659 \$625 \$658 VSS sg13_lv_nmos L=0.13u W=0.42u AS=0.12665p AD=0.1428p
+ PS=1.145u PD=1.52u rfmode=0
M$761 \$624 \$795 \$659 VSS sg13_lv_nmos L=0.13u W=0.74u AS=0.3473p AD=0.12665p
+ PS=2.71u PD=1.145u rfmode=0
M$762 \$664 \$627 VSS VSS sg13_lv_nmos L=0.13u W=1.44u AS=0.4068p AD=0.2772p
+ PS=3.29u PD=2.21u rfmode=0
M$764 \$664 \$319 \$665 VSS sg13_lv_nmos L=0.13u W=1.44u AS=0.2772p AD=0.3816p
+ PS=2.21u PD=3.22u rfmode=0
M$766 VSS VDD \$744 VSS sg13_lv_nmos L=0.13u W=0.42u AS=0.1701p AD=0.03885p
+ PS=1.65u PD=0.605u rfmode=0
M$767 \$744 \$628 \$667 VSS sg13_lv_nmos L=0.13u W=0.42u AS=0.03885p AD=0.1596p
+ PS=0.605u PD=1.6u rfmode=0
M$768 VSS \$629 \$797 VSS sg13_lv_nmos L=0.13u W=0.74u AS=0.43315p AD=0.2516p
+ PS=2.205u PD=2.16u rfmode=0
M$769 VSS CLK \$629 VSS sg13_lv_nmos L=0.13u W=0.74u AS=0.43315p AD=0.2516p
+ PS=2.205u PD=2.16u rfmode=0
M$770 \$669 \$629 \$668 VSS sg13_lv_nmos L=0.13u W=0.42u AS=0.12665p AD=0.1428p
+ PS=1.145u PD=1.52u rfmode=0
M$771 \$628 \$797 \$669 VSS sg13_lv_nmos L=0.13u W=0.74u AS=0.3473p AD=0.12665p
+ PS=2.71u PD=1.145u rfmode=0
M$772 \$674 \$631 VSS VSS sg13_lv_nmos L=0.13u W=1.44u AS=0.4068p AD=0.2772p
+ PS=3.29u PD=2.21u rfmode=0
M$774 \$674 \$319 \$675 VSS sg13_lv_nmos L=0.13u W=1.44u AS=0.2772p AD=0.3816p
+ PS=2.21u PD=3.22u rfmode=0
M$776 VSS VDD \$755 VSS sg13_lv_nmos L=0.13u W=0.42u AS=0.1701p AD=0.03885p
+ PS=1.65u PD=0.605u rfmode=0
M$777 \$755 \$632 \$677 VSS sg13_lv_nmos L=0.13u W=0.42u AS=0.03885p AD=0.1596p
+ PS=0.605u PD=1.6u rfmode=0
M$778 VSS \$633 \$799 VSS sg13_lv_nmos L=0.13u W=0.74u AS=0.43315p AD=0.2516p
+ PS=2.205u PD=2.16u rfmode=0
M$779 VSS CLK \$633 VSS sg13_lv_nmos L=0.13u W=0.74u AS=0.43315p AD=0.2516p
+ PS=2.205u PD=2.16u rfmode=0
M$780 \$679 \$633 \$678 VSS sg13_lv_nmos L=0.13u W=0.42u AS=0.12665p AD=0.1428p
+ PS=1.145u PD=1.52u rfmode=0
M$781 \$632 \$799 \$679 VSS sg13_lv_nmos L=0.13u W=0.74u AS=0.3473p AD=0.12665p
+ PS=2.71u PD=1.145u rfmode=0
M$782 \$684 \$635 VSS VSS sg13_lv_nmos L=0.13u W=1.44u AS=0.4068p AD=0.2772p
+ PS=3.29u PD=2.21u rfmode=0
M$784 \$684 \$319 \$685 VSS sg13_lv_nmos L=0.13u W=1.44u AS=0.2772p AD=0.3816p
+ PS=2.21u PD=3.22u rfmode=0
M$786 VSS VDD \$765 VSS sg13_lv_nmos L=0.13u W=0.42u AS=0.1701p AD=0.03885p
+ PS=1.65u PD=0.605u rfmode=0
M$787 \$765 \$636 \$687 VSS sg13_lv_nmos L=0.13u W=0.42u AS=0.03885p AD=0.1596p
+ PS=0.605u PD=1.6u rfmode=0
M$788 VSS \$637 \$801 VSS sg13_lv_nmos L=0.13u W=0.74u AS=0.43315p AD=0.2516p
+ PS=2.205u PD=2.16u rfmode=0
M$789 VSS CLK \$637 VSS sg13_lv_nmos L=0.13u W=0.74u AS=0.43315p AD=0.2516p
+ PS=2.205u PD=2.16u rfmode=0
M$790 \$689 \$637 \$688 VSS sg13_lv_nmos L=0.13u W=0.42u AS=0.12665p AD=0.1428p
+ PS=1.145u PD=1.52u rfmode=0
M$791 \$636 \$801 \$689 VSS sg13_lv_nmos L=0.13u W=0.74u AS=0.3473p AD=0.12665p
+ PS=2.71u PD=1.145u rfmode=0
M$792 \$694 \$639 VSS VSS sg13_lv_nmos L=0.13u W=1.44u AS=0.4068p AD=0.2772p
+ PS=3.29u PD=2.21u rfmode=0
M$794 \$694 \$319 \$695 VSS sg13_lv_nmos L=0.13u W=1.44u AS=0.2772p AD=0.3816p
+ PS=2.21u PD=3.22u rfmode=0
M$796 VSS VDD \$775 VSS sg13_lv_nmos L=0.13u W=0.42u AS=0.1701p AD=0.03885p
+ PS=1.65u PD=0.605u rfmode=0
M$797 \$775 \$640 \$697 VSS sg13_lv_nmos L=0.13u W=0.42u AS=0.03885p AD=0.1596p
+ PS=0.605u PD=1.6u rfmode=0
M$798 VSS \$641 \$803 VSS sg13_lv_nmos L=0.13u W=0.74u AS=0.43315p AD=0.2516p
+ PS=2.205u PD=2.16u rfmode=0
M$799 VSS CLK \$641 VSS sg13_lv_nmos L=0.13u W=0.74u AS=0.43315p AD=0.2516p
+ PS=2.205u PD=2.16u rfmode=0
M$800 \$699 \$641 \$698 VSS sg13_lv_nmos L=0.13u W=0.42u AS=0.12665p AD=0.1428p
+ PS=1.145u PD=1.52u rfmode=0
M$801 \$640 \$803 \$699 VSS sg13_lv_nmos L=0.13u W=0.74u AS=0.3473p AD=0.12665p
+ PS=2.71u PD=1.145u rfmode=0
M$802 \$704 \$643 VSS VSS sg13_lv_nmos L=0.13u W=1.44u AS=0.4068p AD=0.2772p
+ PS=3.29u PD=2.21u rfmode=0
M$804 \$704 \$319 \$705 VSS sg13_lv_nmos L=0.13u W=1.44u AS=0.2772p AD=0.3816p
+ PS=2.21u PD=3.22u rfmode=0
M$806 VSS VDD \$769 VSS sg13_lv_nmos L=0.13u W=0.42u AS=0.1701p AD=0.03885p
+ PS=1.65u PD=0.605u rfmode=0
M$807 \$769 \$644 \$706 VSS sg13_lv_nmos L=0.13u W=0.42u AS=0.03885p AD=0.1596p
+ PS=0.605u PD=1.6u rfmode=0
M$808 VSS \$645 \$806 VSS sg13_lv_nmos L=0.13u W=0.74u AS=0.43315p AD=0.2516p
+ PS=2.205u PD=2.16u rfmode=0
M$809 VSS CLK \$645 VSS sg13_lv_nmos L=0.13u W=0.74u AS=0.43315p AD=0.2516p
+ PS=2.205u PD=2.16u rfmode=0
M$810 \$708 \$645 \$707 VSS sg13_lv_nmos L=0.13u W=0.42u AS=0.12665p AD=0.1428p
+ PS=1.145u PD=1.52u rfmode=0
M$811 \$644 \$806 \$708 VSS sg13_lv_nmos L=0.13u W=0.74u AS=0.3473p AD=0.12665p
+ PS=2.71u PD=1.145u rfmode=0
M$812 \$713 \$647 VSS VSS sg13_lv_nmos L=0.13u W=1.44u AS=0.4068p AD=0.2772p
+ PS=3.29u PD=2.21u rfmode=0
M$814 \$713 \$319 \$714 VSS sg13_lv_nmos L=0.13u W=1.44u AS=0.2772p AD=0.3816p
+ PS=2.21u PD=3.22u rfmode=0
M$816 VSS VDD \$754 VSS sg13_lv_nmos L=0.13u W=0.42u AS=0.1701p AD=0.03885p
+ PS=1.65u PD=0.605u rfmode=0
M$817 \$754 \$648 \$715 VSS sg13_lv_nmos L=0.13u W=0.42u AS=0.03885p AD=0.1596p
+ PS=0.605u PD=1.6u rfmode=0
M$818 VSS \$649 \$809 VSS sg13_lv_nmos L=0.13u W=0.74u AS=0.43315p AD=0.2516p
+ PS=2.205u PD=2.16u rfmode=0
M$819 VSS CLK \$649 VSS sg13_lv_nmos L=0.13u W=0.74u AS=0.43315p AD=0.2516p
+ PS=2.205u PD=2.16u rfmode=0
M$820 \$717 \$649 \$716 VSS sg13_lv_nmos L=0.13u W=0.42u AS=0.12665p AD=0.1428p
+ PS=1.145u PD=1.52u rfmode=0
M$821 \$648 \$809 \$717 VSS sg13_lv_nmos L=0.13u W=0.74u AS=0.3473p AD=0.12665p
+ PS=2.71u PD=1.145u rfmode=0
M$822 \$722 \$651 VSS VSS sg13_lv_nmos L=0.13u W=1.44u AS=0.4068p AD=0.2772p
+ PS=3.29u PD=2.21u rfmode=0
M$824 \$722 \$319 \$723 VSS sg13_lv_nmos L=0.13u W=1.44u AS=0.2772p AD=0.3816p
+ PS=2.21u PD=3.22u rfmode=0
M$826 VSS VDD \$741 VSS sg13_lv_nmos L=0.13u W=0.42u AS=0.1701p AD=0.03885p
+ PS=1.65u PD=0.605u rfmode=0
M$827 \$741 \$652 \$724 VSS sg13_lv_nmos L=0.13u W=0.42u AS=0.03885p AD=0.1596p
+ PS=0.605u PD=1.6u rfmode=0
M$828 VSS \$653 \$812 VSS sg13_lv_nmos L=0.13u W=0.74u AS=0.43315p AD=0.2516p
+ PS=2.205u PD=2.16u rfmode=0
M$829 VSS CLK \$653 VSS sg13_lv_nmos L=0.13u W=0.74u AS=0.43315p AD=0.2516p
+ PS=2.205u PD=2.16u rfmode=0
M$830 \$726 \$653 \$725 VSS sg13_lv_nmos L=0.13u W=0.42u AS=0.12665p AD=0.1428p
+ PS=1.145u PD=1.52u rfmode=0
M$831 \$652 \$812 \$726 VSS sg13_lv_nmos L=0.13u W=0.74u AS=0.3473p AD=0.12665p
+ PS=2.71u PD=1.145u rfmode=0
M$832 VSS \$167 \$910 VSS sg13_lv_nmos L=0.13u W=0.55u AS=0.187p AD=0.1045p
+ PS=1.78u PD=0.93u rfmode=0
M$833 \$910 \$5 VSS VSS sg13_lv_nmos L=0.13u W=0.55u AS=0.1045p AD=0.146425p
+ PS=0.93u PD=1.155u rfmode=0
M$834 VSS \$910 \$911 VSS sg13_lv_nmos L=0.13u W=1.48u AS=0.312925p AD=0.4477p
+ PS=2.345u PD=3.43u rfmode=0
M$836 \$944 \$943 \$1022 VSS sg13_lv_nmos L=0.13u W=0.42u AS=0.1428p AD=0.0609p
+ PS=1.52u PD=0.71u rfmode=0
M$837 \$1022 VDD VSS VSS sg13_lv_nmos L=0.13u W=0.42u AS=0.0609p AD=0.1626p
+ PS=0.71u PD=1.415u rfmode=0
M$838 VSS \$1069 \$912 VSS sg13_lv_nmos L=0.13u W=0.74u AS=0.1626p AD=0.2516p
+ PS=1.415u PD=2.16u rfmode=0
M$839 \$656 \$625 \$779 VSS sg13_lv_nmos L=0.13u W=0.42u AS=0.1296p AD=0.081p
+ PS=1.52u PD=0.81u rfmode=0
M$840 \$779 \$795 \$657 VSS sg13_lv_nmos L=0.13u W=0.42u AS=0.081p AD=0.2163p
+ PS=0.81u PD=1.87u rfmode=0
M$841 \$946 \$1070 VSS VSS sg13_lv_nmos L=0.13u W=0.42u AS=0.1428p AD=0.0798p
+ PS=1.52u PD=0.8u rfmode=0
M$842 VSS VDD \$1024 VSS sg13_lv_nmos L=0.13u W=0.42u AS=0.0798p AD=0.0378p
+ PS=0.8u PD=0.6u rfmode=0
M$843 \$1024 \$947 \$1070 VSS sg13_lv_nmos L=0.13u W=0.42u AS=0.0378p
+ AD=0.1428p PS=0.6u PD=1.52u rfmode=0
M$844 VSS \$947 \$949 VSS sg13_lv_nmos L=0.13u W=0.64u AS=0.1331p AD=0.2176p
+ PS=1.12u PD=1.96u rfmode=0
M$845 VSS \$947 \$948 VSS sg13_lv_nmos L=0.13u W=1.48u AS=0.3922p AD=0.2737p
+ PS=3.28u PD=2.24u rfmode=0
M$847 VSS \$949 \$950 VSS sg13_lv_nmos L=0.13u W=1.48u AS=0.3922p AD=0.3922p
+ PS=3.28u PD=3.28u rfmode=0
M$849 VSS VSS \$796 VSS sg13_lv_nmos L=0.13u W=1u AS=0.265p AD=0.265p PS=2.56u
+ PD=2.56u rfmode=0
M$850 \$796 \$660 OUTP VSS sg13_lv_nmos L=0.13u W=2u AS=0.38p AD=0.38p PS=3.52u
+ PD=3.52u rfmode=0
M$852 \$796 \$662 OUTN VSS sg13_lv_nmos L=0.13u W=2u AS=0.38p AD=0.38p PS=3.52u
+ PD=3.52u rfmode=0
M$859 VSS \$171 \$914 VSS sg13_lv_nmos L=0.13u W=0.55u AS=0.187p AD=0.1045p
+ PS=1.78u PD=0.93u rfmode=0
M$860 \$914 \$5 VSS VSS sg13_lv_nmos L=0.13u W=0.55u AS=0.1045p AD=0.146425p
+ PS=0.93u PD=1.155u rfmode=0
M$861 VSS \$914 \$915 VSS sg13_lv_nmos L=0.13u W=1.48u AS=0.312925p AD=0.4477p
+ PS=2.345u PD=3.43u rfmode=0
M$863 \$1087 \$953 \$1033 VSS sg13_lv_nmos L=0.13u W=0.42u AS=0.1428p
+ AD=0.0609p PS=1.52u PD=0.71u rfmode=0
M$864 \$1033 VDD VSS VSS sg13_lv_nmos L=0.13u W=0.42u AS=0.0609p AD=0.1626p
+ PS=0.71u PD=1.415u rfmode=0
M$865 VSS \$1071 \$916 VSS sg13_lv_nmos L=0.13u W=0.74u AS=0.1626p AD=0.2516p
+ PS=1.415u PD=2.16u rfmode=0
M$866 \$666 \$629 \$781 VSS sg13_lv_nmos L=0.13u W=0.42u AS=0.1296p AD=0.081p
+ PS=1.52u PD=0.81u rfmode=0
M$867 \$781 \$797 \$667 VSS sg13_lv_nmos L=0.13u W=0.42u AS=0.081p AD=0.2163p
+ PS=0.81u PD=1.87u rfmode=0
M$868 \$955 \$1072 VSS VSS sg13_lv_nmos L=0.13u W=0.42u AS=0.1428p AD=0.0798p
+ PS=1.52u PD=0.8u rfmode=0
M$869 VSS VDD \$1036 VSS sg13_lv_nmos L=0.13u W=0.42u AS=0.0798p AD=0.0378p
+ PS=0.8u PD=0.6u rfmode=0
M$870 \$1036 \$956 \$1072 VSS sg13_lv_nmos L=0.13u W=0.42u AS=0.0378p
+ AD=0.1428p PS=0.6u PD=1.52u rfmode=0
M$871 VSS \$956 \$958 VSS sg13_lv_nmos L=0.13u W=0.64u AS=0.1331p AD=0.2176p
+ PS=1.12u PD=1.96u rfmode=0
M$872 VSS \$956 \$957 VSS sg13_lv_nmos L=0.13u W=1.48u AS=0.3922p AD=0.2737p
+ PS=3.28u PD=2.24u rfmode=0
M$874 VSS \$958 \$959 VSS sg13_lv_nmos L=0.13u W=1.48u AS=0.3922p AD=0.3922p
+ PS=3.28u PD=3.28u rfmode=0
M$876 VSS VSS \$798 VSS sg13_lv_nmos L=0.13u W=1u AS=0.265p AD=0.265p PS=2.56u
+ PD=2.56u rfmode=0
M$877 \$798 \$670 OUTP VSS sg13_lv_nmos L=0.13u W=2u AS=0.38p AD=0.38p PS=3.52u
+ PD=3.52u rfmode=0
M$879 \$798 \$672 OUTN VSS sg13_lv_nmos L=0.13u W=2u AS=0.38p AD=0.38p PS=3.52u
+ PD=3.52u rfmode=0
M$886 VSS \$174 \$918 VSS sg13_lv_nmos L=0.13u W=0.55u AS=0.187p AD=0.1045p
+ PS=1.78u PD=0.93u rfmode=0
M$887 \$918 \$5 VSS VSS sg13_lv_nmos L=0.13u W=0.55u AS=0.1045p AD=0.146425p
+ PS=0.93u PD=1.155u rfmode=0
M$888 VSS \$918 \$919 VSS sg13_lv_nmos L=0.13u W=1.48u AS=0.312925p AD=0.4477p
+ PS=2.345u PD=3.43u rfmode=0
M$890 \$963 \$962 \$1043 VSS sg13_lv_nmos L=0.13u W=0.42u AS=0.1428p AD=0.0609p
+ PS=1.52u PD=0.71u rfmode=0
M$891 \$1043 VDD VSS VSS sg13_lv_nmos L=0.13u W=0.42u AS=0.0609p AD=0.1626p
+ PS=0.71u PD=1.415u rfmode=0
M$892 VSS \$1073 \$920 VSS sg13_lv_nmos L=0.13u W=0.74u AS=0.1626p AD=0.2516p
+ PS=1.415u PD=2.16u rfmode=0
M$893 \$676 \$633 \$783 VSS sg13_lv_nmos L=0.13u W=0.42u AS=0.1296p AD=0.081p
+ PS=1.52u PD=0.81u rfmode=0
M$894 \$783 \$799 \$677 VSS sg13_lv_nmos L=0.13u W=0.42u AS=0.081p AD=0.2163p
+ PS=0.81u PD=1.87u rfmode=0
M$895 \$965 \$1074 VSS VSS sg13_lv_nmos L=0.13u W=0.42u AS=0.1428p AD=0.0798p
+ PS=1.52u PD=0.8u rfmode=0
M$896 VSS VDD \$1047 VSS sg13_lv_nmos L=0.13u W=0.42u AS=0.0798p AD=0.0378p
+ PS=0.8u PD=0.6u rfmode=0
M$897 \$1047 \$966 \$1074 VSS sg13_lv_nmos L=0.13u W=0.42u AS=0.0378p
+ AD=0.1428p PS=0.6u PD=1.52u rfmode=0
M$898 VSS \$966 \$968 VSS sg13_lv_nmos L=0.13u W=0.64u AS=0.1331p AD=0.2176p
+ PS=1.12u PD=1.96u rfmode=0
M$899 VSS \$966 \$967 VSS sg13_lv_nmos L=0.13u W=1.48u AS=0.3922p AD=0.2737p
+ PS=3.28u PD=2.24u rfmode=0
M$901 VSS \$968 \$969 VSS sg13_lv_nmos L=0.13u W=1.48u AS=0.3922p AD=0.3922p
+ PS=3.28u PD=3.28u rfmode=0
M$903 VSS VSS \$800 VSS sg13_lv_nmos L=0.13u W=1u AS=0.265p AD=0.265p PS=2.56u
+ PD=2.56u rfmode=0
M$904 \$800 \$680 OUTP VSS sg13_lv_nmos L=0.13u W=2u AS=0.38p AD=0.38p PS=3.52u
+ PD=3.52u rfmode=0
M$906 \$800 \$682 OUTN VSS sg13_lv_nmos L=0.13u W=2u AS=0.38p AD=0.38p PS=3.52u
+ PD=3.52u rfmode=0
M$913 VSS \$177 \$922 VSS sg13_lv_nmos L=0.13u W=0.55u AS=0.187p AD=0.1045p
+ PS=1.78u PD=0.93u rfmode=0
M$914 \$922 \$5 VSS VSS sg13_lv_nmos L=0.13u W=0.55u AS=0.1045p AD=0.146425p
+ PS=0.93u PD=1.155u rfmode=0
M$915 VSS \$922 \$923 VSS sg13_lv_nmos L=0.13u W=1.48u AS=0.312925p AD=0.4477p
+ PS=2.345u PD=3.43u rfmode=0
M$917 \$973 \$972 \$1054 VSS sg13_lv_nmos L=0.13u W=0.42u AS=0.1428p AD=0.0609p
+ PS=1.52u PD=0.71u rfmode=0
M$918 \$1054 VDD VSS VSS sg13_lv_nmos L=0.13u W=0.42u AS=0.0609p AD=0.1626p
+ PS=0.71u PD=1.415u rfmode=0
M$919 VSS \$1075 \$924 VSS sg13_lv_nmos L=0.13u W=0.74u AS=0.1626p AD=0.2516p
+ PS=1.415u PD=2.16u rfmode=0
M$920 \$686 \$637 \$785 VSS sg13_lv_nmos L=0.13u W=0.42u AS=0.1296p AD=0.081p
+ PS=1.52u PD=0.81u rfmode=0
M$921 \$785 \$801 \$687 VSS sg13_lv_nmos L=0.13u W=0.42u AS=0.081p AD=0.2163p
+ PS=0.81u PD=1.87u rfmode=0
M$922 \$975 \$1076 VSS VSS sg13_lv_nmos L=0.13u W=0.42u AS=0.1428p AD=0.0798p
+ PS=1.52u PD=0.8u rfmode=0
M$923 VSS VDD \$1057 VSS sg13_lv_nmos L=0.13u W=0.42u AS=0.0798p AD=0.0378p
+ PS=0.8u PD=0.6u rfmode=0
M$924 \$1057 \$976 \$1076 VSS sg13_lv_nmos L=0.13u W=0.42u AS=0.0378p
+ AD=0.1428p PS=0.6u PD=1.52u rfmode=0
M$925 VSS \$976 \$978 VSS sg13_lv_nmos L=0.13u W=0.64u AS=0.1331p AD=0.2176p
+ PS=1.12u PD=1.96u rfmode=0
M$926 VSS \$976 \$977 VSS sg13_lv_nmos L=0.13u W=1.48u AS=0.3922p AD=0.2737p
+ PS=3.28u PD=2.24u rfmode=0
M$928 VSS \$978 \$979 VSS sg13_lv_nmos L=0.13u W=1.48u AS=0.3922p AD=0.3922p
+ PS=3.28u PD=3.28u rfmode=0
M$930 VSS VSS \$802 VSS sg13_lv_nmos L=0.13u W=1u AS=0.265p AD=0.265p PS=2.56u
+ PD=2.56u rfmode=0
M$931 \$802 \$690 OUTP VSS sg13_lv_nmos L=0.13u W=2u AS=0.38p AD=0.38p PS=3.52u
+ PD=3.52u rfmode=0
M$933 \$802 \$692 OUTN VSS sg13_lv_nmos L=0.13u W=2u AS=0.38p AD=0.38p PS=3.52u
+ PD=3.52u rfmode=0
M$940 VSS \$180 \$926 VSS sg13_lv_nmos L=0.13u W=0.55u AS=0.187p AD=0.1045p
+ PS=1.78u PD=0.93u rfmode=0
M$941 \$926 \$5 VSS VSS sg13_lv_nmos L=0.13u W=0.55u AS=0.1045p AD=0.146425p
+ PS=0.93u PD=1.155u rfmode=0
M$942 VSS \$926 \$927 VSS sg13_lv_nmos L=0.13u W=1.48u AS=0.312925p AD=0.4477p
+ PS=2.345u PD=3.43u rfmode=0
M$944 \$983 \$982 \$1064 VSS sg13_lv_nmos L=0.13u W=0.42u AS=0.1428p AD=0.0609p
+ PS=1.52u PD=0.71u rfmode=0
M$945 \$1064 VDD VSS VSS sg13_lv_nmos L=0.13u W=0.42u AS=0.0609p AD=0.1626p
+ PS=0.71u PD=1.415u rfmode=0
M$946 VSS \$1077 \$928 VSS sg13_lv_nmos L=0.13u W=0.74u AS=0.1626p AD=0.2516p
+ PS=1.415u PD=2.16u rfmode=0
M$947 \$696 \$641 \$787 VSS sg13_lv_nmos L=0.13u W=0.42u AS=0.1296p AD=0.081p
+ PS=1.52u PD=0.81u rfmode=0
M$948 \$787 \$803 \$697 VSS sg13_lv_nmos L=0.13u W=0.42u AS=0.081p AD=0.2163p
+ PS=0.81u PD=1.87u rfmode=0
M$949 \$985 \$1078 VSS VSS sg13_lv_nmos L=0.13u W=0.42u AS=0.1428p AD=0.0798p
+ PS=1.52u PD=0.8u rfmode=0
M$950 VSS VDD \$1066 VSS sg13_lv_nmos L=0.13u W=0.42u AS=0.0798p AD=0.0378p
+ PS=0.8u PD=0.6u rfmode=0
M$951 \$1066 \$986 \$1078 VSS sg13_lv_nmos L=0.13u W=0.42u AS=0.0378p
+ AD=0.1428p PS=0.6u PD=1.52u rfmode=0
M$952 VSS \$986 \$988 VSS sg13_lv_nmos L=0.13u W=0.64u AS=0.1331p AD=0.2176p
+ PS=1.12u PD=1.96u rfmode=0
M$953 VSS \$986 \$987 VSS sg13_lv_nmos L=0.13u W=1.48u AS=0.3922p AD=0.2737p
+ PS=3.28u PD=2.24u rfmode=0
M$955 VSS \$988 \$989 VSS sg13_lv_nmos L=0.13u W=1.48u AS=0.3922p AD=0.3922p
+ PS=3.28u PD=3.28u rfmode=0
M$957 VSS VSS \$804 VSS sg13_lv_nmos L=0.13u W=1u AS=0.265p AD=0.265p PS=2.56u
+ PD=2.56u rfmode=0
M$958 \$804 \$700 OUTP VSS sg13_lv_nmos L=0.13u W=2u AS=0.38p AD=0.38p PS=3.52u
+ PD=3.52u rfmode=0
M$960 \$804 \$702 OUTN VSS sg13_lv_nmos L=0.13u W=2u AS=0.38p AD=0.38p PS=3.52u
+ PD=3.52u rfmode=0
M$967 VSS \$183 \$930 VSS sg13_lv_nmos L=0.13u W=0.55u AS=0.187p AD=0.1045p
+ PS=1.78u PD=0.93u rfmode=0
M$968 \$930 \$5 VSS VSS sg13_lv_nmos L=0.13u W=0.55u AS=0.1045p AD=0.146425p
+ PS=0.93u PD=1.155u rfmode=0
M$969 VSS \$930 \$931 VSS sg13_lv_nmos L=0.13u W=1.48u AS=0.312925p AD=0.4477p
+ PS=2.345u PD=3.43u rfmode=0
M$971 \$993 \$992 \$1061 VSS sg13_lv_nmos L=0.13u W=0.42u AS=0.1428p AD=0.0609p
+ PS=1.52u PD=0.71u rfmode=0
M$972 \$1061 VDD VSS VSS sg13_lv_nmos L=0.13u W=0.42u AS=0.0609p AD=0.1626p
+ PS=0.71u PD=1.415u rfmode=0
M$973 VSS \$1079 \$932 VSS sg13_lv_nmos L=0.13u W=0.74u AS=0.1626p AD=0.2516p
+ PS=1.415u PD=2.16u rfmode=0
M$974 \$805 \$645 \$789 VSS sg13_lv_nmos L=0.13u W=0.42u AS=0.1296p AD=0.081p
+ PS=1.52u PD=0.81u rfmode=0
M$975 \$789 \$806 \$706 VSS sg13_lv_nmos L=0.13u W=0.42u AS=0.081p AD=0.2163p
+ PS=0.81u PD=1.87u rfmode=0
M$976 \$995 \$1080 VSS VSS sg13_lv_nmos L=0.13u W=0.42u AS=0.1428p AD=0.0798p
+ PS=1.52u PD=0.8u rfmode=0
M$977 VSS VDD \$1056 VSS sg13_lv_nmos L=0.13u W=0.42u AS=0.0798p AD=0.0378p
+ PS=0.8u PD=0.6u rfmode=0
M$978 \$1056 \$996 \$1080 VSS sg13_lv_nmos L=0.13u W=0.42u AS=0.0378p
+ AD=0.1428p PS=0.6u PD=1.52u rfmode=0
M$979 VSS \$996 \$998 VSS sg13_lv_nmos L=0.13u W=0.64u AS=0.1331p AD=0.2176p
+ PS=1.12u PD=1.96u rfmode=0
M$980 VSS \$996 \$997 VSS sg13_lv_nmos L=0.13u W=1.48u AS=0.3922p AD=0.2737p
+ PS=3.28u PD=2.24u rfmode=0
M$982 VSS \$998 \$999 VSS sg13_lv_nmos L=0.13u W=1.48u AS=0.3922p AD=0.3922p
+ PS=3.28u PD=3.28u rfmode=0
M$984 VSS VSS \$807 VSS sg13_lv_nmos L=0.13u W=1u AS=0.265p AD=0.265p PS=2.56u
+ PD=2.56u rfmode=0
M$985 \$807 \$709 OUTP VSS sg13_lv_nmos L=0.13u W=2u AS=0.38p AD=0.38p PS=3.52u
+ PD=3.52u rfmode=0
M$987 \$807 \$711 OUTN VSS sg13_lv_nmos L=0.13u W=2u AS=0.38p AD=0.38p PS=3.52u
+ PD=3.52u rfmode=0
M$994 VSS \$186 \$934 VSS sg13_lv_nmos L=0.13u W=0.55u AS=0.187p AD=0.1045p
+ PS=1.78u PD=0.93u rfmode=0
M$995 \$934 \$5 VSS VSS sg13_lv_nmos L=0.13u W=0.55u AS=0.1045p AD=0.146425p
+ PS=0.93u PD=1.155u rfmode=0
M$996 VSS \$934 \$935 VSS sg13_lv_nmos L=0.13u W=1.48u AS=0.312925p AD=0.4477p
+ PS=2.345u PD=3.43u rfmode=0
M$998 \$1003 \$1002 \$1046 VSS sg13_lv_nmos L=0.13u W=0.42u AS=0.1428p
+ AD=0.0609p PS=1.52u PD=0.71u rfmode=0
M$999 \$1046 VDD VSS VSS sg13_lv_nmos L=0.13u W=0.42u AS=0.0609p AD=0.1626p
+ PS=0.71u PD=1.415u rfmode=0
M$1000 VSS \$1081 \$936 VSS sg13_lv_nmos L=0.13u W=0.74u AS=0.1626p AD=0.2516p
+ PS=1.415u PD=2.16u rfmode=0
M$1001 \$808 \$649 \$791 VSS sg13_lv_nmos L=0.13u W=0.42u AS=0.1296p AD=0.081p
+ PS=1.52u PD=0.81u rfmode=0
M$1002 \$791 \$809 \$715 VSS sg13_lv_nmos L=0.13u W=0.42u AS=0.081p AD=0.2163p
+ PS=0.81u PD=1.87u rfmode=0
M$1003 \$1005 \$1082 VSS VSS sg13_lv_nmos L=0.13u W=0.42u AS=0.1428p AD=0.0798p
+ PS=1.52u PD=0.8u rfmode=0
M$1004 VSS VDD \$1042 VSS sg13_lv_nmos L=0.13u W=0.42u AS=0.0798p AD=0.0378p
+ PS=0.8u PD=0.6u rfmode=0
M$1005 \$1042 \$1006 \$1082 VSS sg13_lv_nmos L=0.13u W=0.42u AS=0.0378p
+ AD=0.1428p PS=0.6u PD=1.52u rfmode=0
M$1006 VSS \$1006 \$1008 VSS sg13_lv_nmos L=0.13u W=0.64u AS=0.1331p AD=0.2176p
+ PS=1.12u PD=1.96u rfmode=0
M$1007 VSS \$1006 \$1007 VSS sg13_lv_nmos L=0.13u W=1.48u AS=0.3922p AD=0.2737p
+ PS=3.28u PD=2.24u rfmode=0
M$1009 VSS \$1008 \$1009 VSS sg13_lv_nmos L=0.13u W=1.48u AS=0.3922p AD=0.3922p
+ PS=3.28u PD=3.28u rfmode=0
M$1011 VSS VSS \$810 VSS sg13_lv_nmos L=0.13u W=1u AS=0.265p AD=0.265p PS=2.56u
+ PD=2.56u rfmode=0
M$1012 \$810 \$718 OUTP VSS sg13_lv_nmos L=0.13u W=2u AS=0.38p AD=0.38p
+ PS=3.52u PD=3.52u rfmode=0
M$1014 \$810 \$720 OUTN VSS sg13_lv_nmos L=0.13u W=2u AS=0.38p AD=0.38p
+ PS=3.52u PD=3.52u rfmode=0
M$1021 VSS VSS \$938 VSS sg13_lv_nmos L=0.13u W=0.55u AS=0.187p AD=0.1045p
+ PS=1.78u PD=0.93u rfmode=0
M$1022 \$938 \$5 VSS VSS sg13_lv_nmos L=0.13u W=0.55u AS=0.1045p AD=0.146425p
+ PS=0.93u PD=1.155u rfmode=0
M$1023 VSS \$938 \$939 VSS sg13_lv_nmos L=0.13u W=1.48u AS=0.312925p AD=0.4477p
+ PS=2.345u PD=3.43u rfmode=0
M$1025 \$1013 \$1012 \$1032 VSS sg13_lv_nmos L=0.13u W=0.42u AS=0.1428p
+ AD=0.0609p PS=1.52u PD=0.71u rfmode=0
M$1026 \$1032 VDD VSS VSS sg13_lv_nmos L=0.13u W=0.42u AS=0.0609p AD=0.1626p
+ PS=0.71u PD=1.415u rfmode=0
M$1027 VSS \$1083 \$940 VSS sg13_lv_nmos L=0.13u W=0.74u AS=0.1626p AD=0.2516p
+ PS=1.415u PD=2.16u rfmode=0
M$1028 \$811 \$653 \$793 VSS sg13_lv_nmos L=0.13u W=0.42u AS=0.1296p AD=0.081p
+ PS=1.52u PD=0.81u rfmode=0
M$1029 \$793 \$812 \$724 VSS sg13_lv_nmos L=0.13u W=0.42u AS=0.081p AD=0.2163p
+ PS=0.81u PD=1.87u rfmode=0
M$1030 \$1015 \$1084 VSS VSS sg13_lv_nmos L=0.13u W=0.42u AS=0.1428p AD=0.0798p
+ PS=1.52u PD=0.8u rfmode=0
M$1031 VSS VDD \$1029 VSS sg13_lv_nmos L=0.13u W=0.42u AS=0.0798p AD=0.0378p
+ PS=0.8u PD=0.6u rfmode=0
M$1032 \$1029 \$1016 \$1084 VSS sg13_lv_nmos L=0.13u W=0.42u AS=0.0378p
+ AD=0.1428p PS=0.6u PD=1.52u rfmode=0
M$1033 VSS \$1016 \$1018 VSS sg13_lv_nmos L=0.13u W=0.64u AS=0.1331p AD=0.2176p
+ PS=1.12u PD=1.96u rfmode=0
M$1034 VSS \$1016 \$1017 VSS sg13_lv_nmos L=0.13u W=1.48u AS=0.3922p AD=0.2737p
+ PS=3.28u PD=2.24u rfmode=0
M$1036 VSS \$1018 \$1019 VSS sg13_lv_nmos L=0.13u W=1.48u AS=0.3922p AD=0.3922p
+ PS=3.28u PD=3.28u rfmode=0
M$1038 VSS VSS \$813 VSS sg13_lv_nmos L=0.13u W=1u AS=0.265p AD=0.265p PS=2.56u
+ PD=2.56u rfmode=0
M$1039 \$813 \$727 OUTP VSS sg13_lv_nmos L=0.13u W=2u AS=0.38p AD=0.38p
+ PS=3.52u PD=3.52u rfmode=0
M$1041 \$813 \$729 OUTN VSS sg13_lv_nmos L=0.13u W=2u AS=0.38p AD=0.38p
+ PS=3.52u PD=3.52u rfmode=0
M$1048 \$942 \$911 VSS VSS sg13_lv_nmos L=0.13u W=1.44u AS=0.4068p AD=0.2772p
+ PS=3.29u PD=2.21u rfmode=0
M$1050 \$942 \$195 \$943 VSS sg13_lv_nmos L=0.13u W=1.44u AS=0.2772p AD=0.3816p
+ PS=2.21u PD=3.22u rfmode=0
M$1052 VSS VDD \$1023 VSS sg13_lv_nmos L=0.13u W=0.42u AS=0.1701p AD=0.03885p
+ PS=1.65u PD=0.605u rfmode=0
M$1053 \$1023 \$912 \$945 VSS sg13_lv_nmos L=0.13u W=0.42u AS=0.03885p
+ AD=0.1596p PS=0.605u PD=1.6u rfmode=0
M$1054 VSS \$913 \$1085 VSS sg13_lv_nmos L=0.13u W=0.74u AS=0.43315p AD=0.2516p
+ PS=2.205u PD=2.16u rfmode=0
M$1055 VSS CLK \$913 VSS sg13_lv_nmos L=0.13u W=0.74u AS=0.43315p AD=0.2516p
+ PS=2.205u PD=2.16u rfmode=0
M$1056 \$947 \$913 \$946 VSS sg13_lv_nmos L=0.13u W=0.42u AS=0.12665p
+ AD=0.1428p PS=1.145u PD=1.52u rfmode=0
M$1057 \$912 \$1085 \$947 VSS sg13_lv_nmos L=0.13u W=0.74u AS=0.3473p
+ AD=0.12665p PS=2.71u PD=1.145u rfmode=0
M$1058 \$952 \$915 VSS VSS sg13_lv_nmos L=0.13u W=1.44u AS=0.4068p AD=0.2772p
+ PS=3.29u PD=2.21u rfmode=0
M$1060 \$952 \$195 \$953 VSS sg13_lv_nmos L=0.13u W=1.44u AS=0.2772p AD=0.3816p
+ PS=2.21u PD=3.22u rfmode=0
M$1062 VSS VDD \$1034 VSS sg13_lv_nmos L=0.13u W=0.42u AS=0.1701p AD=0.03885p
+ PS=1.65u PD=0.605u rfmode=0
M$1063 \$1034 \$916 \$954 VSS sg13_lv_nmos L=0.13u W=0.42u AS=0.03885p
+ AD=0.1596p PS=0.605u PD=1.6u rfmode=0
M$1064 VSS \$917 \$1088 VSS sg13_lv_nmos L=0.13u W=0.74u AS=0.43315p AD=0.2516p
+ PS=2.205u PD=2.16u rfmode=0
M$1065 VSS CLK \$917 VSS sg13_lv_nmos L=0.13u W=0.74u AS=0.43315p AD=0.2516p
+ PS=2.205u PD=2.16u rfmode=0
M$1066 \$956 \$917 \$955 VSS sg13_lv_nmos L=0.13u W=0.42u AS=0.12665p
+ AD=0.1428p PS=1.145u PD=1.52u rfmode=0
M$1067 \$916 \$1088 \$956 VSS sg13_lv_nmos L=0.13u W=0.74u AS=0.3473p
+ AD=0.12665p PS=2.71u PD=1.145u rfmode=0
M$1068 \$961 \$919 VSS VSS sg13_lv_nmos L=0.13u W=1.44u AS=0.4068p AD=0.2772p
+ PS=3.29u PD=2.21u rfmode=0
M$1070 \$961 \$195 \$962 VSS sg13_lv_nmos L=0.13u W=1.44u AS=0.2772p AD=0.3816p
+ PS=2.21u PD=3.22u rfmode=0
M$1072 VSS VDD \$1044 VSS sg13_lv_nmos L=0.13u W=0.42u AS=0.1701p AD=0.03885p
+ PS=1.65u PD=0.605u rfmode=0
M$1073 \$1044 \$920 \$964 VSS sg13_lv_nmos L=0.13u W=0.42u AS=0.03885p
+ AD=0.1596p PS=0.605u PD=1.6u rfmode=0
M$1074 VSS \$921 \$1090 VSS sg13_lv_nmos L=0.13u W=0.74u AS=0.43315p AD=0.2516p
+ PS=2.205u PD=2.16u rfmode=0
M$1075 VSS CLK \$921 VSS sg13_lv_nmos L=0.13u W=0.74u AS=0.43315p AD=0.2516p
+ PS=2.205u PD=2.16u rfmode=0
M$1076 \$966 \$921 \$965 VSS sg13_lv_nmos L=0.13u W=0.42u AS=0.12665p
+ AD=0.1428p PS=1.145u PD=1.52u rfmode=0
M$1077 \$920 \$1090 \$966 VSS sg13_lv_nmos L=0.13u W=0.74u AS=0.3473p
+ AD=0.12665p PS=2.71u PD=1.145u rfmode=0
M$1078 \$971 \$923 VSS VSS sg13_lv_nmos L=0.13u W=1.44u AS=0.4068p AD=0.2772p
+ PS=3.29u PD=2.21u rfmode=0
M$1080 \$971 \$195 \$972 VSS sg13_lv_nmos L=0.13u W=1.44u AS=0.2772p AD=0.3816p
+ PS=2.21u PD=3.22u rfmode=0
M$1082 VSS VDD \$1055 VSS sg13_lv_nmos L=0.13u W=0.42u AS=0.1701p AD=0.03885p
+ PS=1.65u PD=0.605u rfmode=0
M$1083 \$1055 \$924 \$974 VSS sg13_lv_nmos L=0.13u W=0.42u AS=0.03885p
+ AD=0.1596p PS=0.605u PD=1.6u rfmode=0
M$1084 VSS \$925 \$1092 VSS sg13_lv_nmos L=0.13u W=0.74u AS=0.43315p AD=0.2516p
+ PS=2.205u PD=2.16u rfmode=0
M$1085 VSS CLK \$925 VSS sg13_lv_nmos L=0.13u W=0.74u AS=0.43315p AD=0.2516p
+ PS=2.205u PD=2.16u rfmode=0
M$1086 \$976 \$925 \$975 VSS sg13_lv_nmos L=0.13u W=0.42u AS=0.12665p
+ AD=0.1428p PS=1.145u PD=1.52u rfmode=0
M$1087 \$924 \$1092 \$976 VSS sg13_lv_nmos L=0.13u W=0.74u AS=0.3473p
+ AD=0.12665p PS=2.71u PD=1.145u rfmode=0
M$1088 \$981 \$927 VSS VSS sg13_lv_nmos L=0.13u W=1.44u AS=0.4068p AD=0.2772p
+ PS=3.29u PD=2.21u rfmode=0
M$1090 \$981 \$195 \$982 VSS sg13_lv_nmos L=0.13u W=1.44u AS=0.2772p AD=0.3816p
+ PS=2.21u PD=3.22u rfmode=0
M$1092 VSS VDD \$1065 VSS sg13_lv_nmos L=0.13u W=0.42u AS=0.1701p AD=0.03885p
+ PS=1.65u PD=0.605u rfmode=0
M$1093 \$1065 \$928 \$984 VSS sg13_lv_nmos L=0.13u W=0.42u AS=0.03885p
+ AD=0.1596p PS=0.605u PD=1.6u rfmode=0
M$1094 VSS \$929 \$1094 VSS sg13_lv_nmos L=0.13u W=0.74u AS=0.43315p AD=0.2516p
+ PS=2.205u PD=2.16u rfmode=0
M$1095 VSS CLK \$929 VSS sg13_lv_nmos L=0.13u W=0.74u AS=0.43315p AD=0.2516p
+ PS=2.205u PD=2.16u rfmode=0
M$1096 \$986 \$929 \$985 VSS sg13_lv_nmos L=0.13u W=0.42u AS=0.12665p
+ AD=0.1428p PS=1.145u PD=1.52u rfmode=0
M$1097 \$928 \$1094 \$986 VSS sg13_lv_nmos L=0.13u W=0.74u AS=0.3473p
+ AD=0.12665p PS=2.71u PD=1.145u rfmode=0
M$1098 \$991 \$931 VSS VSS sg13_lv_nmos L=0.13u W=1.44u AS=0.4068p AD=0.2772p
+ PS=3.29u PD=2.21u rfmode=0
M$1100 \$991 \$195 \$992 VSS sg13_lv_nmos L=0.13u W=1.44u AS=0.2772p AD=0.3816p
+ PS=2.21u PD=3.22u rfmode=0
M$1102 VSS VDD \$1059 VSS sg13_lv_nmos L=0.13u W=0.42u AS=0.1701p AD=0.03885p
+ PS=1.65u PD=0.605u rfmode=0
M$1103 \$1059 \$932 \$994 VSS sg13_lv_nmos L=0.13u W=0.42u AS=0.03885p
+ AD=0.1596p PS=0.605u PD=1.6u rfmode=0
M$1104 VSS \$933 \$1096 VSS sg13_lv_nmos L=0.13u W=0.74u AS=0.43315p AD=0.2516p
+ PS=2.205u PD=2.16u rfmode=0
M$1105 VSS CLK \$933 VSS sg13_lv_nmos L=0.13u W=0.74u AS=0.43315p AD=0.2516p
+ PS=2.205u PD=2.16u rfmode=0
M$1106 \$996 \$933 \$995 VSS sg13_lv_nmos L=0.13u W=0.42u AS=0.12665p
+ AD=0.1428p PS=1.145u PD=1.52u rfmode=0
M$1107 \$932 \$1096 \$996 VSS sg13_lv_nmos L=0.13u W=0.74u AS=0.3473p
+ AD=0.12665p PS=2.71u PD=1.145u rfmode=0
M$1108 \$1001 \$935 VSS VSS sg13_lv_nmos L=0.13u W=1.44u AS=0.4068p AD=0.2772p
+ PS=3.29u PD=2.21u rfmode=0
M$1110 \$1001 \$195 \$1002 VSS sg13_lv_nmos L=0.13u W=1.44u AS=0.2772p
+ AD=0.3816p PS=2.21u PD=3.22u rfmode=0
M$1112 VSS VDD \$1045 VSS sg13_lv_nmos L=0.13u W=0.42u AS=0.1701p AD=0.03885p
+ PS=1.65u PD=0.605u rfmode=0
M$1113 \$1045 \$936 \$1004 VSS sg13_lv_nmos L=0.13u W=0.42u AS=0.03885p
+ AD=0.1596p PS=0.605u PD=1.6u rfmode=0
M$1114 VSS \$937 \$1098 VSS sg13_lv_nmos L=0.13u W=0.74u AS=0.43315p AD=0.2516p
+ PS=2.205u PD=2.16u rfmode=0
M$1115 VSS CLK \$937 VSS sg13_lv_nmos L=0.13u W=0.74u AS=0.43315p AD=0.2516p
+ PS=2.205u PD=2.16u rfmode=0
M$1116 \$1006 \$937 \$1005 VSS sg13_lv_nmos L=0.13u W=0.42u AS=0.12665p
+ AD=0.1428p PS=1.145u PD=1.52u rfmode=0
M$1117 \$936 \$1098 \$1006 VSS sg13_lv_nmos L=0.13u W=0.74u AS=0.3473p
+ AD=0.12665p PS=2.71u PD=1.145u rfmode=0
M$1118 \$1011 \$939 VSS VSS sg13_lv_nmos L=0.13u W=1.44u AS=0.4068p AD=0.2772p
+ PS=3.29u PD=2.21u rfmode=0
M$1120 \$1011 \$195 \$1012 VSS sg13_lv_nmos L=0.13u W=1.44u AS=0.2772p
+ AD=0.3816p PS=2.21u PD=3.22u rfmode=0
M$1122 VSS VDD \$1031 VSS sg13_lv_nmos L=0.13u W=0.42u AS=0.1701p AD=0.03885p
+ PS=1.65u PD=0.605u rfmode=0
M$1123 \$1031 \$940 \$1014 VSS sg13_lv_nmos L=0.13u W=0.42u AS=0.03885p
+ AD=0.1596p PS=0.605u PD=1.6u rfmode=0
M$1124 VSS \$941 \$1100 VSS sg13_lv_nmos L=0.13u W=0.74u AS=0.43315p AD=0.2516p
+ PS=2.205u PD=2.16u rfmode=0
M$1125 VSS CLK \$941 VSS sg13_lv_nmos L=0.13u W=0.74u AS=0.43315p AD=0.2516p
+ PS=2.205u PD=2.16u rfmode=0
M$1126 \$1016 \$941 \$1015 VSS sg13_lv_nmos L=0.13u W=0.42u AS=0.12665p
+ AD=0.1428p PS=1.145u PD=1.52u rfmode=0
M$1127 \$940 \$1100 \$1016 VSS sg13_lv_nmos L=0.13u W=0.74u AS=0.3473p
+ AD=0.12665p PS=2.71u PD=1.145u rfmode=0
M$1128 VSS \$167 \$1198 VSS sg13_lv_nmos L=0.13u W=0.55u AS=0.187p AD=0.1045p
+ PS=1.78u PD=0.93u rfmode=0
M$1129 \$1198 \$316 VSS VSS sg13_lv_nmos L=0.13u W=0.55u AS=0.1045p
+ AD=0.146425p PS=0.93u PD=1.155u rfmode=0
M$1130 VSS \$1198 \$1199 VSS sg13_lv_nmos L=0.13u W=1.48u AS=0.312925p
+ AD=0.4477p PS=2.345u PD=3.43u rfmode=0
M$1132 \$1232 \$1231 \$1307 VSS sg13_lv_nmos L=0.13u W=0.42u AS=0.1428p
+ AD=0.0609p PS=1.52u PD=0.71u rfmode=0
M$1133 \$1307 VDD VSS VSS sg13_lv_nmos L=0.13u W=0.42u AS=0.0609p AD=0.1626p
+ PS=0.71u PD=1.415u rfmode=0
M$1134 VSS \$1354 \$1200 VSS sg13_lv_nmos L=0.13u W=0.74u AS=0.1626p AD=0.2516p
+ PS=1.415u PD=2.16u rfmode=0
M$1135 \$944 \$913 \$1069 VSS sg13_lv_nmos L=0.13u W=0.42u AS=0.1296p AD=0.081p
+ PS=1.52u PD=0.81u rfmode=0
M$1136 \$1069 \$1085 \$945 VSS sg13_lv_nmos L=0.13u W=0.42u AS=0.081p
+ AD=0.2163p PS=0.81u PD=1.87u rfmode=0
M$1137 \$1234 \$1355 VSS VSS sg13_lv_nmos L=0.13u W=0.42u AS=0.1428p AD=0.0798p
+ PS=1.52u PD=0.8u rfmode=0
M$1138 VSS VDD \$1309 VSS sg13_lv_nmos L=0.13u W=0.42u AS=0.0798p AD=0.0378p
+ PS=0.8u PD=0.6u rfmode=0
M$1139 \$1309 \$1235 \$1355 VSS sg13_lv_nmos L=0.13u W=0.42u AS=0.0378p
+ AD=0.1428p PS=0.6u PD=1.52u rfmode=0
M$1140 VSS \$1235 \$1237 VSS sg13_lv_nmos L=0.13u W=0.64u AS=0.1331p AD=0.2176p
+ PS=1.12u PD=1.96u rfmode=0
M$1141 VSS \$1235 \$1236 VSS sg13_lv_nmos L=0.13u W=1.48u AS=0.3922p AD=0.2737p
+ PS=3.28u PD=2.24u rfmode=0
M$1143 VSS \$1237 \$1238 VSS sg13_lv_nmos L=0.13u W=1.48u AS=0.3922p AD=0.3922p
+ PS=3.28u PD=3.28u rfmode=0
M$1145 VSS VSS \$1086 VSS sg13_lv_nmos L=0.13u W=1u AS=0.265p AD=0.265p
+ PS=2.56u PD=2.56u rfmode=0
M$1146 \$1086 \$948 OUTP VSS sg13_lv_nmos L=0.13u W=2u AS=0.38p AD=0.38p
+ PS=3.52u PD=3.52u rfmode=0
M$1148 \$1086 \$950 OUTN VSS sg13_lv_nmos L=0.13u W=2u AS=0.38p AD=0.38p
+ PS=3.52u PD=3.52u rfmode=0
M$1155 VSS \$171 \$1202 VSS sg13_lv_nmos L=0.13u W=0.55u AS=0.187p AD=0.1045p
+ PS=1.78u PD=0.93u rfmode=0
M$1156 \$1202 \$316 VSS VSS sg13_lv_nmos L=0.13u W=0.55u AS=0.1045p
+ AD=0.146425p PS=0.93u PD=1.155u rfmode=0
M$1157 VSS \$1202 \$1203 VSS sg13_lv_nmos L=0.13u W=1.48u AS=0.312925p
+ AD=0.4477p PS=2.345u PD=3.43u rfmode=0
M$1159 \$1372 \$1241 \$1318 VSS sg13_lv_nmos L=0.13u W=0.42u AS=0.1428p
+ AD=0.0609p PS=1.52u PD=0.71u rfmode=0
M$1160 \$1318 VDD VSS VSS sg13_lv_nmos L=0.13u W=0.42u AS=0.0609p AD=0.1626p
+ PS=0.71u PD=1.415u rfmode=0
M$1161 VSS \$1356 \$1204 VSS sg13_lv_nmos L=0.13u W=0.74u AS=0.1626p AD=0.2516p
+ PS=1.415u PD=2.16u rfmode=0
M$1162 \$1087 \$917 \$1071 VSS sg13_lv_nmos L=0.13u W=0.42u AS=0.1296p
+ AD=0.081p PS=1.52u PD=0.81u rfmode=0
M$1163 \$1071 \$1088 \$954 VSS sg13_lv_nmos L=0.13u W=0.42u AS=0.081p
+ AD=0.2163p PS=0.81u PD=1.87u rfmode=0
M$1164 \$1243 \$1357 VSS VSS sg13_lv_nmos L=0.13u W=0.42u AS=0.1428p AD=0.0798p
+ PS=1.52u PD=0.8u rfmode=0
M$1165 VSS VDD \$1321 VSS sg13_lv_nmos L=0.13u W=0.42u AS=0.0798p AD=0.0378p
+ PS=0.8u PD=0.6u rfmode=0
M$1166 \$1321 \$1244 \$1357 VSS sg13_lv_nmos L=0.13u W=0.42u AS=0.0378p
+ AD=0.1428p PS=0.6u PD=1.52u rfmode=0
M$1167 VSS \$1244 \$1246 VSS sg13_lv_nmos L=0.13u W=0.64u AS=0.1331p AD=0.2176p
+ PS=1.12u PD=1.96u rfmode=0
M$1168 VSS \$1244 \$1245 VSS sg13_lv_nmos L=0.13u W=1.48u AS=0.3922p AD=0.2737p
+ PS=3.28u PD=2.24u rfmode=0
M$1170 VSS \$1246 \$1247 VSS sg13_lv_nmos L=0.13u W=1.48u AS=0.3922p AD=0.3922p
+ PS=3.28u PD=3.28u rfmode=0
M$1172 VSS VSS \$1089 VSS sg13_lv_nmos L=0.13u W=1u AS=0.265p AD=0.265p
+ PS=2.56u PD=2.56u rfmode=0
M$1173 \$1089 \$957 OUTP VSS sg13_lv_nmos L=0.13u W=2u AS=0.38p AD=0.38p
+ PS=3.52u PD=3.52u rfmode=0
M$1175 \$1089 \$959 OUTN VSS sg13_lv_nmos L=0.13u W=2u AS=0.38p AD=0.38p
+ PS=3.52u PD=3.52u rfmode=0
M$1182 VSS \$174 \$1206 VSS sg13_lv_nmos L=0.13u W=0.55u AS=0.187p AD=0.1045p
+ PS=1.78u PD=0.93u rfmode=0
M$1183 \$1206 \$316 VSS VSS sg13_lv_nmos L=0.13u W=0.55u AS=0.1045p
+ AD=0.146425p PS=0.93u PD=1.155u rfmode=0
M$1184 VSS \$1206 \$1207 VSS sg13_lv_nmos L=0.13u W=1.48u AS=0.312925p
+ AD=0.4477p PS=2.345u PD=3.43u rfmode=0
M$1186 \$1251 \$1250 \$1328 VSS sg13_lv_nmos L=0.13u W=0.42u AS=0.1428p
+ AD=0.0609p PS=1.52u PD=0.71u rfmode=0
M$1187 \$1328 VDD VSS VSS sg13_lv_nmos L=0.13u W=0.42u AS=0.0609p AD=0.1626p
+ PS=0.71u PD=1.415u rfmode=0
M$1188 VSS \$1358 \$1208 VSS sg13_lv_nmos L=0.13u W=0.74u AS=0.1626p AD=0.2516p
+ PS=1.415u PD=2.16u rfmode=0
M$1189 \$963 \$921 \$1073 VSS sg13_lv_nmos L=0.13u W=0.42u AS=0.1296p AD=0.081p
+ PS=1.52u PD=0.81u rfmode=0
M$1190 \$1073 \$1090 \$964 VSS sg13_lv_nmos L=0.13u W=0.42u AS=0.081p
+ AD=0.2163p PS=0.81u PD=1.87u rfmode=0
M$1191 \$1253 \$1359 VSS VSS sg13_lv_nmos L=0.13u W=0.42u AS=0.1428p AD=0.0798p
+ PS=1.52u PD=0.8u rfmode=0
M$1192 VSS VDD \$1332 VSS sg13_lv_nmos L=0.13u W=0.42u AS=0.0798p AD=0.0378p
+ PS=0.8u PD=0.6u rfmode=0
M$1193 \$1332 \$1254 \$1359 VSS sg13_lv_nmos L=0.13u W=0.42u AS=0.0378p
+ AD=0.1428p PS=0.6u PD=1.52u rfmode=0
M$1194 VSS \$1254 \$1256 VSS sg13_lv_nmos L=0.13u W=0.64u AS=0.1331p AD=0.2176p
+ PS=1.12u PD=1.96u rfmode=0
M$1195 VSS \$1254 \$1255 VSS sg13_lv_nmos L=0.13u W=1.48u AS=0.3922p AD=0.2737p
+ PS=3.28u PD=2.24u rfmode=0
M$1197 VSS \$1256 \$1257 VSS sg13_lv_nmos L=0.13u W=1.48u AS=0.3922p AD=0.3922p
+ PS=3.28u PD=3.28u rfmode=0
M$1199 VSS VSS \$1091 VSS sg13_lv_nmos L=0.13u W=1u AS=0.265p AD=0.265p
+ PS=2.56u PD=2.56u rfmode=0
M$1200 \$1091 \$967 OUTP VSS sg13_lv_nmos L=0.13u W=2u AS=0.38p AD=0.38p
+ PS=3.52u PD=3.52u rfmode=0
M$1202 \$1091 \$969 OUTN VSS sg13_lv_nmos L=0.13u W=2u AS=0.38p AD=0.38p
+ PS=3.52u PD=3.52u rfmode=0
M$1209 VSS \$177 \$1210 VSS sg13_lv_nmos L=0.13u W=0.55u AS=0.187p AD=0.1045p
+ PS=1.78u PD=0.93u rfmode=0
M$1210 \$1210 \$316 VSS VSS sg13_lv_nmos L=0.13u W=0.55u AS=0.1045p
+ AD=0.146425p PS=0.93u PD=1.155u rfmode=0
M$1211 VSS \$1210 \$1211 VSS sg13_lv_nmos L=0.13u W=1.48u AS=0.312925p
+ AD=0.4477p PS=2.345u PD=3.43u rfmode=0
M$1213 \$1377 \$1260 \$1339 VSS sg13_lv_nmos L=0.13u W=0.42u AS=0.1428p
+ AD=0.0609p PS=1.52u PD=0.71u rfmode=0
M$1214 \$1339 VDD VSS VSS sg13_lv_nmos L=0.13u W=0.42u AS=0.0609p AD=0.1626p
+ PS=0.71u PD=1.415u rfmode=0
M$1215 VSS \$1360 \$1212 VSS sg13_lv_nmos L=0.13u W=0.74u AS=0.1626p AD=0.2516p
+ PS=1.415u PD=2.16u rfmode=0
M$1216 \$973 \$925 \$1075 VSS sg13_lv_nmos L=0.13u W=0.42u AS=0.1296p AD=0.081p
+ PS=1.52u PD=0.81u rfmode=0
M$1217 \$1075 \$1092 \$974 VSS sg13_lv_nmos L=0.13u W=0.42u AS=0.081p
+ AD=0.2163p PS=0.81u PD=1.87u rfmode=0
M$1218 \$1262 \$1361 VSS VSS sg13_lv_nmos L=0.13u W=0.42u AS=0.1428p AD=0.0798p
+ PS=1.52u PD=0.8u rfmode=0
M$1219 VSS VDD \$1342 VSS sg13_lv_nmos L=0.13u W=0.42u AS=0.0798p AD=0.0378p
+ PS=0.8u PD=0.6u rfmode=0
M$1220 \$1342 \$1263 \$1361 VSS sg13_lv_nmos L=0.13u W=0.42u AS=0.0378p
+ AD=0.1428p PS=0.6u PD=1.52u rfmode=0
M$1221 VSS \$1263 \$1265 VSS sg13_lv_nmos L=0.13u W=0.64u AS=0.1331p AD=0.2176p
+ PS=1.12u PD=1.96u rfmode=0
M$1222 VSS \$1263 \$1264 VSS sg13_lv_nmos L=0.13u W=1.48u AS=0.3922p AD=0.2737p
+ PS=3.28u PD=2.24u rfmode=0
M$1224 VSS \$1265 \$1266 VSS sg13_lv_nmos L=0.13u W=1.48u AS=0.3922p AD=0.3922p
+ PS=3.28u PD=3.28u rfmode=0
M$1226 VSS VSS \$1093 VSS sg13_lv_nmos L=0.13u W=1u AS=0.265p AD=0.265p
+ PS=2.56u PD=2.56u rfmode=0
M$1227 \$1093 \$977 OUTP VSS sg13_lv_nmos L=0.13u W=2u AS=0.38p AD=0.38p
+ PS=3.52u PD=3.52u rfmode=0
M$1229 \$1093 \$979 OUTN VSS sg13_lv_nmos L=0.13u W=2u AS=0.38p AD=0.38p
+ PS=3.52u PD=3.52u rfmode=0
M$1236 VSS \$180 \$1214 VSS sg13_lv_nmos L=0.13u W=0.55u AS=0.187p AD=0.1045p
+ PS=1.78u PD=0.93u rfmode=0
M$1237 \$1214 \$316 VSS VSS sg13_lv_nmos L=0.13u W=0.55u AS=0.1045p
+ AD=0.146425p PS=0.93u PD=1.155u rfmode=0
M$1238 VSS \$1214 \$1215 VSS sg13_lv_nmos L=0.13u W=1.48u AS=0.312925p
+ AD=0.4477p PS=2.345u PD=3.43u rfmode=0
M$1240 \$1380 \$1269 \$1349 VSS sg13_lv_nmos L=0.13u W=0.42u AS=0.1428p
+ AD=0.0609p PS=1.52u PD=0.71u rfmode=0
M$1241 \$1349 VDD VSS VSS sg13_lv_nmos L=0.13u W=0.42u AS=0.0609p AD=0.1626p
+ PS=0.71u PD=1.415u rfmode=0
M$1242 VSS \$1362 \$1216 VSS sg13_lv_nmos L=0.13u W=0.74u AS=0.1626p AD=0.2516p
+ PS=1.415u PD=2.16u rfmode=0
M$1243 \$983 \$929 \$1077 VSS sg13_lv_nmos L=0.13u W=0.42u AS=0.1296p AD=0.081p
+ PS=1.52u PD=0.81u rfmode=0
M$1244 \$1077 \$1094 \$984 VSS sg13_lv_nmos L=0.13u W=0.42u AS=0.081p
+ AD=0.2163p PS=0.81u PD=1.87u rfmode=0
M$1245 \$1271 \$1363 VSS VSS sg13_lv_nmos L=0.13u W=0.42u AS=0.1428p AD=0.0798p
+ PS=1.52u PD=0.8u rfmode=0
M$1246 VSS VDD \$1351 VSS sg13_lv_nmos L=0.13u W=0.42u AS=0.0798p AD=0.0378p
+ PS=0.8u PD=0.6u rfmode=0
M$1247 \$1351 \$1272 \$1363 VSS sg13_lv_nmos L=0.13u W=0.42u AS=0.0378p
+ AD=0.1428p PS=0.6u PD=1.52u rfmode=0
M$1248 VSS \$1272 \$1274 VSS sg13_lv_nmos L=0.13u W=0.64u AS=0.1331p AD=0.2176p
+ PS=1.12u PD=1.96u rfmode=0
M$1249 VSS \$1272 \$1273 VSS sg13_lv_nmos L=0.13u W=1.48u AS=0.3922p AD=0.2737p
+ PS=3.28u PD=2.24u rfmode=0
M$1251 VSS \$1274 \$1275 VSS sg13_lv_nmos L=0.13u W=1.48u AS=0.3922p AD=0.3922p
+ PS=3.28u PD=3.28u rfmode=0
M$1253 VSS VSS \$1095 VSS sg13_lv_nmos L=0.13u W=1u AS=0.265p AD=0.265p
+ PS=2.56u PD=2.56u rfmode=0
M$1254 \$1095 \$987 OUTP VSS sg13_lv_nmos L=0.13u W=2u AS=0.38p AD=0.38p
+ PS=3.52u PD=3.52u rfmode=0
M$1256 \$1095 \$989 OUTN VSS sg13_lv_nmos L=0.13u W=2u AS=0.38p AD=0.38p
+ PS=3.52u PD=3.52u rfmode=0
M$1263 VSS \$183 \$1218 VSS sg13_lv_nmos L=0.13u W=0.55u AS=0.187p AD=0.1045p
+ PS=1.78u PD=0.93u rfmode=0
M$1264 \$1218 \$316 VSS VSS sg13_lv_nmos L=0.13u W=0.55u AS=0.1045p
+ AD=0.146425p PS=0.93u PD=1.155u rfmode=0
M$1265 VSS \$1218 \$1219 VSS sg13_lv_nmos L=0.13u W=1.48u AS=0.312925p
+ AD=0.4477p PS=2.345u PD=3.43u rfmode=0
M$1267 \$1279 \$1278 \$1346 VSS sg13_lv_nmos L=0.13u W=0.42u AS=0.1428p
+ AD=0.0609p PS=1.52u PD=0.71u rfmode=0
M$1268 \$1346 VDD VSS VSS sg13_lv_nmos L=0.13u W=0.42u AS=0.0609p AD=0.1626p
+ PS=0.71u PD=1.415u rfmode=0
M$1269 VSS \$1364 \$1220 VSS sg13_lv_nmos L=0.13u W=0.74u AS=0.1626p AD=0.2516p
+ PS=1.415u PD=2.16u rfmode=0
M$1270 \$993 \$933 \$1079 VSS sg13_lv_nmos L=0.13u W=0.42u AS=0.1296p AD=0.081p
+ PS=1.52u PD=0.81u rfmode=0
M$1271 \$1079 \$1096 \$994 VSS sg13_lv_nmos L=0.13u W=0.42u AS=0.081p
+ AD=0.2163p PS=0.81u PD=1.87u rfmode=0
M$1272 \$1281 \$1365 VSS VSS sg13_lv_nmos L=0.13u W=0.42u AS=0.1428p AD=0.0798p
+ PS=1.52u PD=0.8u rfmode=0
M$1273 VSS VDD \$1341 VSS sg13_lv_nmos L=0.13u W=0.42u AS=0.0798p AD=0.0378p
+ PS=0.8u PD=0.6u rfmode=0
M$1274 \$1341 \$1282 \$1365 VSS sg13_lv_nmos L=0.13u W=0.42u AS=0.0378p
+ AD=0.1428p PS=0.6u PD=1.52u rfmode=0
M$1275 VSS \$1282 \$1284 VSS sg13_lv_nmos L=0.13u W=0.64u AS=0.1331p AD=0.2176p
+ PS=1.12u PD=1.96u rfmode=0
M$1276 VSS \$1282 \$1283 VSS sg13_lv_nmos L=0.13u W=1.48u AS=0.3922p AD=0.2737p
+ PS=3.28u PD=2.24u rfmode=0
M$1278 VSS \$1284 \$1285 VSS sg13_lv_nmos L=0.13u W=1.48u AS=0.3922p AD=0.3922p
+ PS=3.28u PD=3.28u rfmode=0
M$1280 VSS VSS \$1097 VSS sg13_lv_nmos L=0.13u W=1u AS=0.265p AD=0.265p
+ PS=2.56u PD=2.56u rfmode=0
M$1281 \$1097 \$997 OUTP VSS sg13_lv_nmos L=0.13u W=2u AS=0.38p AD=0.38p
+ PS=3.52u PD=3.52u rfmode=0
M$1283 \$1097 \$999 OUTN VSS sg13_lv_nmos L=0.13u W=2u AS=0.38p AD=0.38p
+ PS=3.52u PD=3.52u rfmode=0
M$1290 VSS \$186 \$1222 VSS sg13_lv_nmos L=0.13u W=0.55u AS=0.187p AD=0.1045p
+ PS=1.78u PD=0.93u rfmode=0
M$1291 \$1222 \$316 VSS VSS sg13_lv_nmos L=0.13u W=0.55u AS=0.1045p
+ AD=0.146425p PS=0.93u PD=1.155u rfmode=0
M$1292 VSS \$1222 \$1223 VSS sg13_lv_nmos L=0.13u W=1.48u AS=0.312925p
+ AD=0.4477p PS=2.345u PD=3.43u rfmode=0
M$1294 \$1385 \$1288 \$1331 VSS sg13_lv_nmos L=0.13u W=0.42u AS=0.1428p
+ AD=0.0609p PS=1.52u PD=0.71u rfmode=0
M$1295 \$1331 VDD VSS VSS sg13_lv_nmos L=0.13u W=0.42u AS=0.0609p AD=0.1626p
+ PS=0.71u PD=1.415u rfmode=0
M$1296 VSS \$1366 \$1224 VSS sg13_lv_nmos L=0.13u W=0.74u AS=0.1626p AD=0.2516p
+ PS=1.415u PD=2.16u rfmode=0
M$1297 \$1003 \$937 \$1081 VSS sg13_lv_nmos L=0.13u W=0.42u AS=0.1296p
+ AD=0.081p PS=1.52u PD=0.81u rfmode=0
M$1298 \$1081 \$1098 \$1004 VSS sg13_lv_nmos L=0.13u W=0.42u AS=0.081p
+ AD=0.2163p PS=0.81u PD=1.87u rfmode=0
M$1299 \$1290 \$1367 VSS VSS sg13_lv_nmos L=0.13u W=0.42u AS=0.1428p AD=0.0798p
+ PS=1.52u PD=0.8u rfmode=0
M$1300 VSS VDD \$1327 VSS sg13_lv_nmos L=0.13u W=0.42u AS=0.0798p AD=0.0378p
+ PS=0.8u PD=0.6u rfmode=0
M$1301 \$1327 \$1291 \$1367 VSS sg13_lv_nmos L=0.13u W=0.42u AS=0.0378p
+ AD=0.1428p PS=0.6u PD=1.52u rfmode=0
M$1302 VSS \$1291 \$1293 VSS sg13_lv_nmos L=0.13u W=0.64u AS=0.1331p AD=0.2176p
+ PS=1.12u PD=1.96u rfmode=0
M$1303 VSS \$1291 \$1292 VSS sg13_lv_nmos L=0.13u W=1.48u AS=0.3922p AD=0.2737p
+ PS=3.28u PD=2.24u rfmode=0
M$1305 VSS \$1293 \$1294 VSS sg13_lv_nmos L=0.13u W=1.48u AS=0.3922p AD=0.3922p
+ PS=3.28u PD=3.28u rfmode=0
M$1307 VSS VSS \$1099 VSS sg13_lv_nmos L=0.13u W=1u AS=0.265p AD=0.265p
+ PS=2.56u PD=2.56u rfmode=0
M$1308 \$1099 \$1007 OUTP VSS sg13_lv_nmos L=0.13u W=2u AS=0.38p AD=0.38p
+ PS=3.52u PD=3.52u rfmode=0
M$1310 \$1099 \$1009 OUTN VSS sg13_lv_nmos L=0.13u W=2u AS=0.38p AD=0.38p
+ PS=3.52u PD=3.52u rfmode=0
M$1317 VSS VSS \$1226 VSS sg13_lv_nmos L=0.13u W=0.55u AS=0.187p AD=0.1045p
+ PS=1.78u PD=0.93u rfmode=0
M$1318 \$1226 \$316 VSS VSS sg13_lv_nmos L=0.13u W=0.55u AS=0.1045p
+ AD=0.146425p PS=0.93u PD=1.155u rfmode=0
M$1319 VSS \$1226 \$1227 VSS sg13_lv_nmos L=0.13u W=1.48u AS=0.312925p
+ AD=0.4477p PS=2.345u PD=3.43u rfmode=0
M$1321 \$1298 \$1297 \$1317 VSS sg13_lv_nmos L=0.13u W=0.42u AS=0.1428p
+ AD=0.0609p PS=1.52u PD=0.71u rfmode=0
M$1322 \$1317 VDD VSS VSS sg13_lv_nmos L=0.13u W=0.42u AS=0.0609p AD=0.1626p
+ PS=0.71u PD=1.415u rfmode=0
M$1323 VSS \$1368 \$1228 VSS sg13_lv_nmos L=0.13u W=0.74u AS=0.1626p AD=0.2516p
+ PS=1.415u PD=2.16u rfmode=0
M$1324 \$1013 \$941 \$1083 VSS sg13_lv_nmos L=0.13u W=0.42u AS=0.1296p
+ AD=0.081p PS=1.52u PD=0.81u rfmode=0
M$1325 \$1083 \$1100 \$1014 VSS sg13_lv_nmos L=0.13u W=0.42u AS=0.081p
+ AD=0.2163p PS=0.81u PD=1.87u rfmode=0
M$1326 \$1300 \$1369 VSS VSS sg13_lv_nmos L=0.13u W=0.42u AS=0.1428p AD=0.0798p
+ PS=1.52u PD=0.8u rfmode=0
M$1327 VSS VDD \$1314 VSS sg13_lv_nmos L=0.13u W=0.42u AS=0.0798p AD=0.0378p
+ PS=0.8u PD=0.6u rfmode=0
M$1328 \$1314 \$1301 \$1369 VSS sg13_lv_nmos L=0.13u W=0.42u AS=0.0378p
+ AD=0.1428p PS=0.6u PD=1.52u rfmode=0
M$1329 VSS \$1301 \$1303 VSS sg13_lv_nmos L=0.13u W=0.64u AS=0.1331p AD=0.2176p
+ PS=1.12u PD=1.96u rfmode=0
M$1330 VSS \$1301 \$1302 VSS sg13_lv_nmos L=0.13u W=1.48u AS=0.3922p AD=0.2737p
+ PS=3.28u PD=2.24u rfmode=0
M$1332 VSS \$1303 \$1304 VSS sg13_lv_nmos L=0.13u W=1.48u AS=0.3922p AD=0.3922p
+ PS=3.28u PD=3.28u rfmode=0
M$1334 VSS VSS \$1101 VSS sg13_lv_nmos L=0.13u W=1u AS=0.265p AD=0.265p
+ PS=2.56u PD=2.56u rfmode=0
M$1335 \$1101 \$1017 OUTP VSS sg13_lv_nmos L=0.13u W=2u AS=0.38p AD=0.38p
+ PS=3.52u PD=3.52u rfmode=0
M$1337 \$1101 \$1019 OUTN VSS sg13_lv_nmos L=0.13u W=2u AS=0.38p AD=0.38p
+ PS=3.52u PD=3.52u rfmode=0
M$1344 \$1230 \$1199 VSS VSS sg13_lv_nmos L=0.13u W=1.44u AS=0.4068p AD=0.2772p
+ PS=3.29u PD=2.21u rfmode=0
M$1346 \$1230 \$5 \$1231 VSS sg13_lv_nmos L=0.13u W=1.44u AS=0.2772p AD=0.3816p
+ PS=2.21u PD=3.22u rfmode=0
M$1348 VSS VDD \$1308 VSS sg13_lv_nmos L=0.13u W=0.42u AS=0.1701p AD=0.03885p
+ PS=1.65u PD=0.605u rfmode=0
M$1349 \$1308 \$1200 \$1233 VSS sg13_lv_nmos L=0.13u W=0.42u AS=0.03885p
+ AD=0.1596p PS=0.605u PD=1.6u rfmode=0
M$1350 VSS \$1201 \$1370 VSS sg13_lv_nmos L=0.13u W=0.74u AS=0.43315p
+ AD=0.2516p PS=2.205u PD=2.16u rfmode=0
M$1351 VSS CLK \$1201 VSS sg13_lv_nmos L=0.13u W=0.74u AS=0.43315p AD=0.2516p
+ PS=2.205u PD=2.16u rfmode=0
M$1352 \$1235 \$1201 \$1234 VSS sg13_lv_nmos L=0.13u W=0.42u AS=0.12665p
+ AD=0.1428p PS=1.145u PD=1.52u rfmode=0
M$1353 \$1200 \$1370 \$1235 VSS sg13_lv_nmos L=0.13u W=0.74u AS=0.3473p
+ AD=0.12665p PS=2.71u PD=1.145u rfmode=0
M$1354 \$1240 \$1203 VSS VSS sg13_lv_nmos L=0.13u W=1.44u AS=0.4068p AD=0.2772p
+ PS=3.29u PD=2.21u rfmode=0
M$1356 \$1240 \$5 \$1241 VSS sg13_lv_nmos L=0.13u W=1.44u AS=0.2772p AD=0.3816p
+ PS=2.21u PD=3.22u rfmode=0
M$1358 VSS VDD \$1319 VSS sg13_lv_nmos L=0.13u W=0.42u AS=0.1701p AD=0.03885p
+ PS=1.65u PD=0.605u rfmode=0
M$1359 \$1319 \$1204 \$1242 VSS sg13_lv_nmos L=0.13u W=0.42u AS=0.03885p
+ AD=0.1596p PS=0.605u PD=1.6u rfmode=0
M$1360 VSS \$1205 \$1373 VSS sg13_lv_nmos L=0.13u W=0.74u AS=0.43315p
+ AD=0.2516p PS=2.205u PD=2.16u rfmode=0
M$1361 VSS CLK \$1205 VSS sg13_lv_nmos L=0.13u W=0.74u AS=0.43315p AD=0.2516p
+ PS=2.205u PD=2.16u rfmode=0
M$1362 \$1244 \$1205 \$1243 VSS sg13_lv_nmos L=0.13u W=0.42u AS=0.12665p
+ AD=0.1428p PS=1.145u PD=1.52u rfmode=0
M$1363 \$1204 \$1373 \$1244 VSS sg13_lv_nmos L=0.13u W=0.74u AS=0.3473p
+ AD=0.12665p PS=2.71u PD=1.145u rfmode=0
M$1364 \$1249 \$1207 VSS VSS sg13_lv_nmos L=0.13u W=1.44u AS=0.4068p AD=0.2772p
+ PS=3.29u PD=2.21u rfmode=0
M$1366 \$1249 \$5 \$1250 VSS sg13_lv_nmos L=0.13u W=1.44u AS=0.2772p AD=0.3816p
+ PS=2.21u PD=3.22u rfmode=0
M$1368 VSS VDD \$1329 VSS sg13_lv_nmos L=0.13u W=0.42u AS=0.1701p AD=0.03885p
+ PS=1.65u PD=0.605u rfmode=0
M$1369 \$1329 \$1208 \$1252 VSS sg13_lv_nmos L=0.13u W=0.42u AS=0.03885p
+ AD=0.1596p PS=0.605u PD=1.6u rfmode=0
M$1370 VSS \$1209 \$1375 VSS sg13_lv_nmos L=0.13u W=0.74u AS=0.43315p
+ AD=0.2516p PS=2.205u PD=2.16u rfmode=0
M$1371 VSS CLK \$1209 VSS sg13_lv_nmos L=0.13u W=0.74u AS=0.43315p AD=0.2516p
+ PS=2.205u PD=2.16u rfmode=0
M$1372 \$1254 \$1209 \$1253 VSS sg13_lv_nmos L=0.13u W=0.42u AS=0.12665p
+ AD=0.1428p PS=1.145u PD=1.52u rfmode=0
M$1373 \$1208 \$1375 \$1254 VSS sg13_lv_nmos L=0.13u W=0.74u AS=0.3473p
+ AD=0.12665p PS=2.71u PD=1.145u rfmode=0
M$1374 \$1259 \$1211 VSS VSS sg13_lv_nmos L=0.13u W=1.44u AS=0.4068p AD=0.2772p
+ PS=3.29u PD=2.21u rfmode=0
M$1376 \$1259 \$5 \$1260 VSS sg13_lv_nmos L=0.13u W=1.44u AS=0.2772p AD=0.3816p
+ PS=2.21u PD=3.22u rfmode=0
M$1378 VSS VDD \$1340 VSS sg13_lv_nmos L=0.13u W=0.42u AS=0.1701p AD=0.03885p
+ PS=1.65u PD=0.605u rfmode=0
M$1379 \$1340 \$1212 \$1261 VSS sg13_lv_nmos L=0.13u W=0.42u AS=0.03885p
+ AD=0.1596p PS=0.605u PD=1.6u rfmode=0
M$1380 VSS \$1213 \$1378 VSS sg13_lv_nmos L=0.13u W=0.74u AS=0.43315p
+ AD=0.2516p PS=2.205u PD=2.16u rfmode=0
M$1381 VSS CLK \$1213 VSS sg13_lv_nmos L=0.13u W=0.74u AS=0.43315p AD=0.2516p
+ PS=2.205u PD=2.16u rfmode=0
M$1382 \$1263 \$1213 \$1262 VSS sg13_lv_nmos L=0.13u W=0.42u AS=0.12665p
+ AD=0.1428p PS=1.145u PD=1.52u rfmode=0
M$1383 \$1212 \$1378 \$1263 VSS sg13_lv_nmos L=0.13u W=0.74u AS=0.3473p
+ AD=0.12665p PS=2.71u PD=1.145u rfmode=0
M$1384 \$1268 \$1215 VSS VSS sg13_lv_nmos L=0.13u W=1.44u AS=0.4068p AD=0.2772p
+ PS=3.29u PD=2.21u rfmode=0
M$1386 \$1268 \$5 \$1269 VSS sg13_lv_nmos L=0.13u W=1.44u AS=0.2772p AD=0.3816p
+ PS=2.21u PD=3.22u rfmode=0
M$1388 VSS VDD \$1350 VSS sg13_lv_nmos L=0.13u W=0.42u AS=0.1701p AD=0.03885p
+ PS=1.65u PD=0.605u rfmode=0
M$1389 \$1350 \$1216 \$1270 VSS sg13_lv_nmos L=0.13u W=0.42u AS=0.03885p
+ AD=0.1596p PS=0.605u PD=1.6u rfmode=0
M$1390 VSS \$1217 \$1381 VSS sg13_lv_nmos L=0.13u W=0.74u AS=0.43315p
+ AD=0.2516p PS=2.205u PD=2.16u rfmode=0
M$1391 VSS CLK \$1217 VSS sg13_lv_nmos L=0.13u W=0.74u AS=0.43315p AD=0.2516p
+ PS=2.205u PD=2.16u rfmode=0
M$1392 \$1272 \$1217 \$1271 VSS sg13_lv_nmos L=0.13u W=0.42u AS=0.12665p
+ AD=0.1428p PS=1.145u PD=1.52u rfmode=0
M$1393 \$1216 \$1381 \$1272 VSS sg13_lv_nmos L=0.13u W=0.74u AS=0.3473p
+ AD=0.12665p PS=2.71u PD=1.145u rfmode=0
M$1394 \$1277 \$1219 VSS VSS sg13_lv_nmos L=0.13u W=1.44u AS=0.4068p AD=0.2772p
+ PS=3.29u PD=2.21u rfmode=0
M$1396 \$1277 \$5 \$1278 VSS sg13_lv_nmos L=0.13u W=1.44u AS=0.2772p AD=0.3816p
+ PS=2.21u PD=3.22u rfmode=0
M$1398 VSS VDD \$1344 VSS sg13_lv_nmos L=0.13u W=0.42u AS=0.1701p AD=0.03885p
+ PS=1.65u PD=0.605u rfmode=0
M$1399 \$1344 \$1220 \$1280 VSS sg13_lv_nmos L=0.13u W=0.42u AS=0.03885p
+ AD=0.1596p PS=0.605u PD=1.6u rfmode=0
M$1400 VSS \$1221 \$1383 VSS sg13_lv_nmos L=0.13u W=0.74u AS=0.43315p
+ AD=0.2516p PS=2.205u PD=2.16u rfmode=0
M$1401 VSS CLK \$1221 VSS sg13_lv_nmos L=0.13u W=0.74u AS=0.43315p AD=0.2516p
+ PS=2.205u PD=2.16u rfmode=0
M$1402 \$1282 \$1221 \$1281 VSS sg13_lv_nmos L=0.13u W=0.42u AS=0.12665p
+ AD=0.1428p PS=1.145u PD=1.52u rfmode=0
M$1403 \$1220 \$1383 \$1282 VSS sg13_lv_nmos L=0.13u W=0.74u AS=0.3473p
+ AD=0.12665p PS=2.71u PD=1.145u rfmode=0
M$1404 \$1287 \$1223 VSS VSS sg13_lv_nmos L=0.13u W=1.44u AS=0.4068p AD=0.2772p
+ PS=3.29u PD=2.21u rfmode=0
M$1406 \$1287 \$5 \$1288 VSS sg13_lv_nmos L=0.13u W=1.44u AS=0.2772p AD=0.3816p
+ PS=2.21u PD=3.22u rfmode=0
M$1408 VSS VDD \$1330 VSS sg13_lv_nmos L=0.13u W=0.42u AS=0.1701p AD=0.03885p
+ PS=1.65u PD=0.605u rfmode=0
M$1409 \$1330 \$1224 \$1289 VSS sg13_lv_nmos L=0.13u W=0.42u AS=0.03885p
+ AD=0.1596p PS=0.605u PD=1.6u rfmode=0
M$1410 VSS \$1225 \$1386 VSS sg13_lv_nmos L=0.13u W=0.74u AS=0.43315p
+ AD=0.2516p PS=2.205u PD=2.16u rfmode=0
M$1411 VSS CLK \$1225 VSS sg13_lv_nmos L=0.13u W=0.74u AS=0.43315p AD=0.2516p
+ PS=2.205u PD=2.16u rfmode=0
M$1412 \$1291 \$1225 \$1290 VSS sg13_lv_nmos L=0.13u W=0.42u AS=0.12665p
+ AD=0.1428p PS=1.145u PD=1.52u rfmode=0
M$1413 \$1224 \$1386 \$1291 VSS sg13_lv_nmos L=0.13u W=0.74u AS=0.3473p
+ AD=0.12665p PS=2.71u PD=1.145u rfmode=0
M$1414 \$1296 \$1227 VSS VSS sg13_lv_nmos L=0.13u W=1.44u AS=0.4068p AD=0.2772p
+ PS=3.29u PD=2.21u rfmode=0
M$1416 \$1296 \$5 \$1297 VSS sg13_lv_nmos L=0.13u W=1.44u AS=0.2772p AD=0.3816p
+ PS=2.21u PD=3.22u rfmode=0
M$1418 VSS VDD \$1316 VSS sg13_lv_nmos L=0.13u W=0.42u AS=0.1701p AD=0.03885p
+ PS=1.65u PD=0.605u rfmode=0
M$1419 \$1316 \$1228 \$1299 VSS sg13_lv_nmos L=0.13u W=0.42u AS=0.03885p
+ AD=0.1596p PS=0.605u PD=1.6u rfmode=0
M$1420 VSS \$1229 \$1388 VSS sg13_lv_nmos L=0.13u W=0.74u AS=0.43315p
+ AD=0.2516p PS=2.205u PD=2.16u rfmode=0
M$1421 VSS CLK \$1229 VSS sg13_lv_nmos L=0.13u W=0.74u AS=0.43315p AD=0.2516p
+ PS=2.205u PD=2.16u rfmode=0
M$1422 \$1301 \$1229 \$1300 VSS sg13_lv_nmos L=0.13u W=0.42u AS=0.12665p
+ AD=0.1428p PS=1.145u PD=1.52u rfmode=0
M$1423 \$1228 \$1388 \$1301 VSS sg13_lv_nmos L=0.13u W=0.74u AS=0.3473p
+ AD=0.12665p PS=2.71u PD=1.145u rfmode=0
M$1424 VSS \$167 \$1486 VSS sg13_lv_nmos L=0.13u W=0.55u AS=0.187p AD=0.1045p
+ PS=1.78u PD=0.93u rfmode=0
M$1425 \$1486 \$324 VSS VSS sg13_lv_nmos L=0.13u W=0.55u AS=0.1045p
+ AD=0.146425p PS=0.93u PD=1.155u rfmode=0
M$1426 VSS \$1486 \$1487 VSS sg13_lv_nmos L=0.13u W=1.48u AS=0.312925p
+ AD=0.4477p PS=2.345u PD=3.43u rfmode=0
M$1428 \$1520 \$1519 \$1599 VSS sg13_lv_nmos L=0.13u W=0.42u AS=0.1428p
+ AD=0.0609p PS=1.52u PD=0.71u rfmode=0
M$1429 \$1599 VDD VSS VSS sg13_lv_nmos L=0.13u W=0.42u AS=0.0609p AD=0.1626p
+ PS=0.71u PD=1.415u rfmode=0
M$1430 VSS \$1646 \$1488 VSS sg13_lv_nmos L=0.13u W=0.74u AS=0.1626p AD=0.2516p
+ PS=1.415u PD=2.16u rfmode=0
M$1431 \$1232 \$1201 \$1354 VSS sg13_lv_nmos L=0.13u W=0.42u AS=0.1296p
+ AD=0.081p PS=1.52u PD=0.81u rfmode=0
M$1432 \$1354 \$1370 \$1233 VSS sg13_lv_nmos L=0.13u W=0.42u AS=0.081p
+ AD=0.2163p PS=0.81u PD=1.87u rfmode=0
M$1433 \$1522 \$1647 VSS VSS sg13_lv_nmos L=0.13u W=0.42u AS=0.1428p AD=0.0798p
+ PS=1.52u PD=0.8u rfmode=0
M$1434 VSS VDD \$1601 VSS sg13_lv_nmos L=0.13u W=0.42u AS=0.0798p AD=0.0378p
+ PS=0.8u PD=0.6u rfmode=0
M$1435 \$1601 \$1523 \$1647 VSS sg13_lv_nmos L=0.13u W=0.42u AS=0.0378p
+ AD=0.1428p PS=0.6u PD=1.52u rfmode=0
M$1436 VSS \$1523 \$1525 VSS sg13_lv_nmos L=0.13u W=0.64u AS=0.1331p AD=0.2176p
+ PS=1.12u PD=1.96u rfmode=0
M$1437 VSS \$1523 \$1524 VSS sg13_lv_nmos L=0.13u W=1.48u AS=0.3922p AD=0.2737p
+ PS=3.28u PD=2.24u rfmode=0
M$1439 VSS \$1525 \$1526 VSS sg13_lv_nmos L=0.13u W=1.48u AS=0.3922p AD=0.3922p
+ PS=3.28u PD=3.28u rfmode=0
M$1441 VSS VSS \$1371 VSS sg13_lv_nmos L=0.13u W=1u AS=0.265p AD=0.265p
+ PS=2.56u PD=2.56u rfmode=0
M$1442 \$1371 \$1236 OUTP VSS sg13_lv_nmos L=0.13u W=2u AS=0.38p AD=0.38p
+ PS=3.52u PD=3.52u rfmode=0
M$1444 \$1371 \$1238 OUTN VSS sg13_lv_nmos L=0.13u W=2u AS=0.38p AD=0.38p
+ PS=3.52u PD=3.52u rfmode=0
M$1451 VSS \$171 \$1490 VSS sg13_lv_nmos L=0.13u W=0.55u AS=0.187p AD=0.1045p
+ PS=1.78u PD=0.93u rfmode=0
M$1452 \$1490 \$324 VSS VSS sg13_lv_nmos L=0.13u W=0.55u AS=0.1045p
+ AD=0.146425p PS=0.93u PD=1.155u rfmode=0
M$1453 VSS \$1490 \$1491 VSS sg13_lv_nmos L=0.13u W=1.48u AS=0.312925p
+ AD=0.4477p PS=2.345u PD=3.43u rfmode=0
M$1455 \$1530 \$1529 \$1610 VSS sg13_lv_nmos L=0.13u W=0.42u AS=0.1428p
+ AD=0.0609p PS=1.52u PD=0.71u rfmode=0
M$1456 \$1610 VDD VSS VSS sg13_lv_nmos L=0.13u W=0.42u AS=0.0609p AD=0.1626p
+ PS=0.71u PD=1.415u rfmode=0
M$1457 VSS \$1648 \$1492 VSS sg13_lv_nmos L=0.13u W=0.74u AS=0.1626p AD=0.2516p
+ PS=1.415u PD=2.16u rfmode=0
M$1458 \$1372 \$1205 \$1356 VSS sg13_lv_nmos L=0.13u W=0.42u AS=0.1296p
+ AD=0.081p PS=1.52u PD=0.81u rfmode=0
M$1459 \$1356 \$1373 \$1242 VSS sg13_lv_nmos L=0.13u W=0.42u AS=0.081p
+ AD=0.2163p PS=0.81u PD=1.87u rfmode=0
M$1460 \$1532 \$1649 VSS VSS sg13_lv_nmos L=0.13u W=0.42u AS=0.1428p AD=0.0798p
+ PS=1.52u PD=0.8u rfmode=0
M$1461 VSS VDD \$1612 VSS sg13_lv_nmos L=0.13u W=0.42u AS=0.0798p AD=0.0378p
+ PS=0.8u PD=0.6u rfmode=0
M$1462 \$1612 \$1533 \$1649 VSS sg13_lv_nmos L=0.13u W=0.42u AS=0.0378p
+ AD=0.1428p PS=0.6u PD=1.52u rfmode=0
M$1463 VSS \$1533 \$1535 VSS sg13_lv_nmos L=0.13u W=0.64u AS=0.1331p AD=0.2176p
+ PS=1.12u PD=1.96u rfmode=0
M$1464 VSS \$1533 \$1534 VSS sg13_lv_nmos L=0.13u W=1.48u AS=0.3922p AD=0.2737p
+ PS=3.28u PD=2.24u rfmode=0
M$1466 VSS \$1535 \$1536 VSS sg13_lv_nmos L=0.13u W=1.48u AS=0.3922p AD=0.3922p
+ PS=3.28u PD=3.28u rfmode=0
M$1468 VSS VSS \$1374 VSS sg13_lv_nmos L=0.13u W=1u AS=0.265p AD=0.265p
+ PS=2.56u PD=2.56u rfmode=0
M$1469 \$1374 \$1245 OUTP VSS sg13_lv_nmos L=0.13u W=2u AS=0.38p AD=0.38p
+ PS=3.52u PD=3.52u rfmode=0
M$1471 \$1374 \$1247 OUTN VSS sg13_lv_nmos L=0.13u W=2u AS=0.38p AD=0.38p
+ PS=3.52u PD=3.52u rfmode=0
M$1478 VSS \$174 \$1494 VSS sg13_lv_nmos L=0.13u W=0.55u AS=0.187p AD=0.1045p
+ PS=1.78u PD=0.93u rfmode=0
M$1479 \$1494 \$324 VSS VSS sg13_lv_nmos L=0.13u W=0.55u AS=0.1045p
+ AD=0.146425p PS=0.93u PD=1.155u rfmode=0
M$1480 VSS \$1494 \$1495 VSS sg13_lv_nmos L=0.13u W=1.48u AS=0.312925p
+ AD=0.4477p PS=2.345u PD=3.43u rfmode=0
M$1482 \$1540 \$1539 \$1619 VSS sg13_lv_nmos L=0.13u W=0.42u AS=0.1428p
+ AD=0.0609p PS=1.52u PD=0.71u rfmode=0
M$1483 \$1619 VDD VSS VSS sg13_lv_nmos L=0.13u W=0.42u AS=0.0609p AD=0.1626p
+ PS=0.71u PD=1.415u rfmode=0
M$1484 VSS \$1650 \$1496 VSS sg13_lv_nmos L=0.13u W=0.74u AS=0.1626p AD=0.2516p
+ PS=1.415u PD=2.16u rfmode=0
M$1485 \$1251 \$1209 \$1358 VSS sg13_lv_nmos L=0.13u W=0.42u AS=0.1296p
+ AD=0.081p PS=1.52u PD=0.81u rfmode=0
M$1486 \$1358 \$1375 \$1252 VSS sg13_lv_nmos L=0.13u W=0.42u AS=0.081p
+ AD=0.2163p PS=0.81u PD=1.87u rfmode=0
M$1487 \$1542 \$1651 VSS VSS sg13_lv_nmos L=0.13u W=0.42u AS=0.1428p AD=0.0798p
+ PS=1.52u PD=0.8u rfmode=0
M$1488 VSS VDD \$1622 VSS sg13_lv_nmos L=0.13u W=0.42u AS=0.0798p AD=0.0378p
+ PS=0.8u PD=0.6u rfmode=0
M$1489 \$1622 \$1543 \$1651 VSS sg13_lv_nmos L=0.13u W=0.42u AS=0.0378p
+ AD=0.1428p PS=0.6u PD=1.52u rfmode=0
M$1490 VSS \$1543 \$1545 VSS sg13_lv_nmos L=0.13u W=0.64u AS=0.1331p AD=0.2176p
+ PS=1.12u PD=1.96u rfmode=0
M$1491 VSS \$1543 \$1544 VSS sg13_lv_nmos L=0.13u W=1.48u AS=0.3922p AD=0.2737p
+ PS=3.28u PD=2.24u rfmode=0
M$1493 VSS \$1545 \$1546 VSS sg13_lv_nmos L=0.13u W=1.48u AS=0.3922p AD=0.3922p
+ PS=3.28u PD=3.28u rfmode=0
M$1495 VSS VSS \$1376 VSS sg13_lv_nmos L=0.13u W=1u AS=0.265p AD=0.265p
+ PS=2.56u PD=2.56u rfmode=0
M$1496 \$1376 \$1255 OUTP VSS sg13_lv_nmos L=0.13u W=2u AS=0.38p AD=0.38p
+ PS=3.52u PD=3.52u rfmode=0
M$1498 \$1376 \$1257 OUTN VSS sg13_lv_nmos L=0.13u W=2u AS=0.38p AD=0.38p
+ PS=3.52u PD=3.52u rfmode=0
M$1505 VSS \$177 \$1498 VSS sg13_lv_nmos L=0.13u W=0.55u AS=0.187p AD=0.1045p
+ PS=1.78u PD=0.93u rfmode=0
M$1506 \$1498 \$324 VSS VSS sg13_lv_nmos L=0.13u W=0.55u AS=0.1045p
+ AD=0.146425p PS=0.93u PD=1.155u rfmode=0
M$1507 VSS \$1498 \$1499 VSS sg13_lv_nmos L=0.13u W=1.48u AS=0.312925p
+ AD=0.4477p PS=2.345u PD=3.43u rfmode=0
M$1509 \$1550 \$1549 \$1629 VSS sg13_lv_nmos L=0.13u W=0.42u AS=0.1428p
+ AD=0.0609p PS=1.52u PD=0.71u rfmode=0
M$1510 \$1629 VDD VSS VSS sg13_lv_nmos L=0.13u W=0.42u AS=0.0609p AD=0.1626p
+ PS=0.71u PD=1.415u rfmode=0
M$1511 VSS \$1652 \$1500 VSS sg13_lv_nmos L=0.13u W=0.74u AS=0.1626p AD=0.2516p
+ PS=1.415u PD=2.16u rfmode=0
M$1512 \$1377 \$1213 \$1360 VSS sg13_lv_nmos L=0.13u W=0.42u AS=0.1296p
+ AD=0.081p PS=1.52u PD=0.81u rfmode=0
M$1513 \$1360 \$1378 \$1261 VSS sg13_lv_nmos L=0.13u W=0.42u AS=0.081p
+ AD=0.2163p PS=0.81u PD=1.87u rfmode=0
M$1514 \$1552 \$1653 VSS VSS sg13_lv_nmos L=0.13u W=0.42u AS=0.1428p AD=0.0798p
+ PS=1.52u PD=0.8u rfmode=0
M$1515 VSS VDD \$1633 VSS sg13_lv_nmos L=0.13u W=0.42u AS=0.0798p AD=0.0378p
+ PS=0.8u PD=0.6u rfmode=0
M$1516 \$1633 \$1553 \$1653 VSS sg13_lv_nmos L=0.13u W=0.42u AS=0.0378p
+ AD=0.1428p PS=0.6u PD=1.52u rfmode=0
M$1517 VSS \$1553 \$1555 VSS sg13_lv_nmos L=0.13u W=0.64u AS=0.1331p AD=0.2176p
+ PS=1.12u PD=1.96u rfmode=0
M$1518 VSS \$1553 \$1554 VSS sg13_lv_nmos L=0.13u W=1.48u AS=0.3922p AD=0.2737p
+ PS=3.28u PD=2.24u rfmode=0
M$1520 VSS \$1555 \$1556 VSS sg13_lv_nmos L=0.13u W=1.48u AS=0.3922p AD=0.3922p
+ PS=3.28u PD=3.28u rfmode=0
M$1522 VSS VSS \$1379 VSS sg13_lv_nmos L=0.13u W=1u AS=0.265p AD=0.265p
+ PS=2.56u PD=2.56u rfmode=0
M$1523 \$1379 \$1264 OUTP VSS sg13_lv_nmos L=0.13u W=2u AS=0.38p AD=0.38p
+ PS=3.52u PD=3.52u rfmode=0
M$1525 \$1379 \$1266 OUTN VSS sg13_lv_nmos L=0.13u W=2u AS=0.38p AD=0.38p
+ PS=3.52u PD=3.52u rfmode=0
M$1532 VSS \$180 \$1502 VSS sg13_lv_nmos L=0.13u W=0.55u AS=0.187p AD=0.1045p
+ PS=1.78u PD=0.93u rfmode=0
M$1533 \$1502 \$324 VSS VSS sg13_lv_nmos L=0.13u W=0.55u AS=0.1045p
+ AD=0.146425p PS=0.93u PD=1.155u rfmode=0
M$1534 VSS \$1502 \$1503 VSS sg13_lv_nmos L=0.13u W=1.48u AS=0.312925p
+ AD=0.4477p PS=2.345u PD=3.43u rfmode=0
M$1536 \$1560 \$1559 \$1641 VSS sg13_lv_nmos L=0.13u W=0.42u AS=0.1428p
+ AD=0.0609p PS=1.52u PD=0.71u rfmode=0
M$1537 \$1641 VDD VSS VSS sg13_lv_nmos L=0.13u W=0.42u AS=0.0609p AD=0.1626p
+ PS=0.71u PD=1.415u rfmode=0
M$1538 VSS \$1654 \$1504 VSS sg13_lv_nmos L=0.13u W=0.74u AS=0.1626p AD=0.2516p
+ PS=1.415u PD=2.16u rfmode=0
M$1539 \$1380 \$1217 \$1362 VSS sg13_lv_nmos L=0.13u W=0.42u AS=0.1296p
+ AD=0.081p PS=1.52u PD=0.81u rfmode=0
M$1540 \$1362 \$1381 \$1270 VSS sg13_lv_nmos L=0.13u W=0.42u AS=0.081p
+ AD=0.2163p PS=0.81u PD=1.87u rfmode=0
M$1541 \$1562 \$1655 VSS VSS sg13_lv_nmos L=0.13u W=0.42u AS=0.1428p AD=0.0798p
+ PS=1.52u PD=0.8u rfmode=0
M$1542 VSS VDD \$1643 VSS sg13_lv_nmos L=0.13u W=0.42u AS=0.0798p AD=0.0378p
+ PS=0.8u PD=0.6u rfmode=0
M$1543 \$1643 \$1563 \$1655 VSS sg13_lv_nmos L=0.13u W=0.42u AS=0.0378p
+ AD=0.1428p PS=0.6u PD=1.52u rfmode=0
M$1544 VSS \$1563 \$1565 VSS sg13_lv_nmos L=0.13u W=0.64u AS=0.1331p AD=0.2176p
+ PS=1.12u PD=1.96u rfmode=0
M$1545 VSS \$1563 \$1564 VSS sg13_lv_nmos L=0.13u W=1.48u AS=0.3922p AD=0.2737p
+ PS=3.28u PD=2.24u rfmode=0
M$1547 VSS \$1565 \$1566 VSS sg13_lv_nmos L=0.13u W=1.48u AS=0.3922p AD=0.3922p
+ PS=3.28u PD=3.28u rfmode=0
M$1549 VSS VSS \$1382 VSS sg13_lv_nmos L=0.13u W=1u AS=0.265p AD=0.265p
+ PS=2.56u PD=2.56u rfmode=0
M$1550 \$1382 \$1273 OUTP VSS sg13_lv_nmos L=0.13u W=2u AS=0.38p AD=0.38p
+ PS=3.52u PD=3.52u rfmode=0
M$1552 \$1382 \$1275 OUTN VSS sg13_lv_nmos L=0.13u W=2u AS=0.38p AD=0.38p
+ PS=3.52u PD=3.52u rfmode=0
M$1559 VSS \$183 \$1506 VSS sg13_lv_nmos L=0.13u W=0.55u AS=0.187p AD=0.1045p
+ PS=1.78u PD=0.93u rfmode=0
M$1560 \$1506 \$324 VSS VSS sg13_lv_nmos L=0.13u W=0.55u AS=0.1045p
+ AD=0.146425p PS=0.93u PD=1.155u rfmode=0
M$1561 VSS \$1506 \$1507 VSS sg13_lv_nmos L=0.13u W=1.48u AS=0.312925p
+ AD=0.4477p PS=2.345u PD=3.43u rfmode=0
M$1563 \$1570 \$1569 \$1638 VSS sg13_lv_nmos L=0.13u W=0.42u AS=0.1428p
+ AD=0.0609p PS=1.52u PD=0.71u rfmode=0
M$1564 \$1638 VDD VSS VSS sg13_lv_nmos L=0.13u W=0.42u AS=0.0609p AD=0.1626p
+ PS=0.71u PD=1.415u rfmode=0
M$1565 VSS \$1656 \$1508 VSS sg13_lv_nmos L=0.13u W=0.74u AS=0.1626p AD=0.2516p
+ PS=1.415u PD=2.16u rfmode=0
M$1566 \$1279 \$1221 \$1364 VSS sg13_lv_nmos L=0.13u W=0.42u AS=0.1296p
+ AD=0.081p PS=1.52u PD=0.81u rfmode=0
M$1567 \$1364 \$1383 \$1280 VSS sg13_lv_nmos L=0.13u W=0.42u AS=0.081p
+ AD=0.2163p PS=0.81u PD=1.87u rfmode=0
M$1568 \$1572 \$1657 VSS VSS sg13_lv_nmos L=0.13u W=0.42u AS=0.1428p AD=0.0798p
+ PS=1.52u PD=0.8u rfmode=0
M$1569 VSS VDD \$1636 VSS sg13_lv_nmos L=0.13u W=0.42u AS=0.0798p AD=0.0378p
+ PS=0.8u PD=0.6u rfmode=0
M$1570 \$1636 \$1573 \$1657 VSS sg13_lv_nmos L=0.13u W=0.42u AS=0.0378p
+ AD=0.1428p PS=0.6u PD=1.52u rfmode=0
M$1571 VSS \$1573 \$1575 VSS sg13_lv_nmos L=0.13u W=0.64u AS=0.1331p AD=0.2176p
+ PS=1.12u PD=1.96u rfmode=0
M$1572 VSS \$1573 \$1574 VSS sg13_lv_nmos L=0.13u W=1.48u AS=0.3922p AD=0.2737p
+ PS=3.28u PD=2.24u rfmode=0
M$1574 VSS \$1575 \$1576 VSS sg13_lv_nmos L=0.13u W=1.48u AS=0.3922p AD=0.3922p
+ PS=3.28u PD=3.28u rfmode=0
M$1576 VSS VSS \$1384 VSS sg13_lv_nmos L=0.13u W=1u AS=0.265p AD=0.265p
+ PS=2.56u PD=2.56u rfmode=0
M$1577 \$1384 \$1283 OUTP VSS sg13_lv_nmos L=0.13u W=2u AS=0.38p AD=0.38p
+ PS=3.52u PD=3.52u rfmode=0
M$1579 \$1384 \$1285 OUTN VSS sg13_lv_nmos L=0.13u W=2u AS=0.38p AD=0.38p
+ PS=3.52u PD=3.52u rfmode=0
M$1586 VSS \$186 \$1510 VSS sg13_lv_nmos L=0.13u W=0.55u AS=0.187p AD=0.1045p
+ PS=1.78u PD=0.93u rfmode=0
M$1587 \$1510 \$324 VSS VSS sg13_lv_nmos L=0.13u W=0.55u AS=0.1045p
+ AD=0.146425p PS=0.93u PD=1.155u rfmode=0
M$1588 VSS \$1510 \$1511 VSS sg13_lv_nmos L=0.13u W=1.48u AS=0.312925p
+ AD=0.4477p PS=2.345u PD=3.43u rfmode=0
M$1590 \$1580 \$1579 \$1624 VSS sg13_lv_nmos L=0.13u W=0.42u AS=0.1428p
+ AD=0.0609p PS=1.52u PD=0.71u rfmode=0
M$1591 \$1624 VDD VSS VSS sg13_lv_nmos L=0.13u W=0.42u AS=0.0609p AD=0.1626p
+ PS=0.71u PD=1.415u rfmode=0
M$1592 VSS \$1658 \$1512 VSS sg13_lv_nmos L=0.13u W=0.74u AS=0.1626p AD=0.2516p
+ PS=1.415u PD=2.16u rfmode=0
M$1593 \$1385 \$1225 \$1366 VSS sg13_lv_nmos L=0.13u W=0.42u AS=0.1296p
+ AD=0.081p PS=1.52u PD=0.81u rfmode=0
M$1594 \$1366 \$1386 \$1289 VSS sg13_lv_nmos L=0.13u W=0.42u AS=0.081p
+ AD=0.2163p PS=0.81u PD=1.87u rfmode=0
M$1595 \$1582 \$1659 VSS VSS sg13_lv_nmos L=0.13u W=0.42u AS=0.1428p AD=0.0798p
+ PS=1.52u PD=0.8u rfmode=0
M$1596 VSS VDD \$1621 VSS sg13_lv_nmos L=0.13u W=0.42u AS=0.0798p AD=0.0378p
+ PS=0.8u PD=0.6u rfmode=0
M$1597 \$1621 \$1583 \$1659 VSS sg13_lv_nmos L=0.13u W=0.42u AS=0.0378p
+ AD=0.1428p PS=0.6u PD=1.52u rfmode=0
M$1598 VSS \$1583 \$1585 VSS sg13_lv_nmos L=0.13u W=0.64u AS=0.1331p AD=0.2176p
+ PS=1.12u PD=1.96u rfmode=0
M$1599 VSS \$1583 \$1584 VSS sg13_lv_nmos L=0.13u W=1.48u AS=0.3922p AD=0.2737p
+ PS=3.28u PD=2.24u rfmode=0
M$1601 VSS \$1585 \$1586 VSS sg13_lv_nmos L=0.13u W=1.48u AS=0.3922p AD=0.3922p
+ PS=3.28u PD=3.28u rfmode=0
M$1603 VSS VSS \$1387 VSS sg13_lv_nmos L=0.13u W=1u AS=0.265p AD=0.265p
+ PS=2.56u PD=2.56u rfmode=0
M$1604 \$1387 \$1292 OUTP VSS sg13_lv_nmos L=0.13u W=2u AS=0.38p AD=0.38p
+ PS=3.52u PD=3.52u rfmode=0
M$1606 \$1387 \$1294 OUTN VSS sg13_lv_nmos L=0.13u W=2u AS=0.38p AD=0.38p
+ PS=3.52u PD=3.52u rfmode=0
M$1613 VSS VSS \$1514 VSS sg13_lv_nmos L=0.13u W=0.55u AS=0.187p AD=0.1045p
+ PS=1.78u PD=0.93u rfmode=0
M$1614 \$1514 \$324 VSS VSS sg13_lv_nmos L=0.13u W=0.55u AS=0.1045p
+ AD=0.146425p PS=0.93u PD=1.155u rfmode=0
M$1615 VSS \$1514 \$1515 VSS sg13_lv_nmos L=0.13u W=1.48u AS=0.312925p
+ AD=0.4477p PS=2.345u PD=3.43u rfmode=0
M$1617 \$1590 \$1589 \$1609 VSS sg13_lv_nmos L=0.13u W=0.42u AS=0.1428p
+ AD=0.0609p PS=1.52u PD=0.71u rfmode=0
M$1618 \$1609 VDD VSS VSS sg13_lv_nmos L=0.13u W=0.42u AS=0.0609p AD=0.1626p
+ PS=0.71u PD=1.415u rfmode=0
M$1619 VSS \$1660 \$1516 VSS sg13_lv_nmos L=0.13u W=0.74u AS=0.1626p AD=0.2516p
+ PS=1.415u PD=2.16u rfmode=0
M$1620 \$1298 \$1229 \$1368 VSS sg13_lv_nmos L=0.13u W=0.42u AS=0.1296p
+ AD=0.081p PS=1.52u PD=0.81u rfmode=0
M$1621 \$1368 \$1388 \$1299 VSS sg13_lv_nmos L=0.13u W=0.42u AS=0.081p
+ AD=0.2163p PS=0.81u PD=1.87u rfmode=0
M$1622 \$1592 \$1661 VSS VSS sg13_lv_nmos L=0.13u W=0.42u AS=0.1428p AD=0.0798p
+ PS=1.52u PD=0.8u rfmode=0
M$1623 VSS VDD \$1606 VSS sg13_lv_nmos L=0.13u W=0.42u AS=0.0798p AD=0.0378p
+ PS=0.8u PD=0.6u rfmode=0
M$1624 \$1606 \$1593 \$1661 VSS sg13_lv_nmos L=0.13u W=0.42u AS=0.0378p
+ AD=0.1428p PS=0.6u PD=1.52u rfmode=0
M$1625 VSS \$1593 \$1595 VSS sg13_lv_nmos L=0.13u W=0.64u AS=0.1331p AD=0.2176p
+ PS=1.12u PD=1.96u rfmode=0
M$1626 VSS \$1593 \$1594 VSS sg13_lv_nmos L=0.13u W=1.48u AS=0.3922p AD=0.2737p
+ PS=3.28u PD=2.24u rfmode=0
M$1628 VSS \$1595 \$1596 VSS sg13_lv_nmos L=0.13u W=1.48u AS=0.3922p AD=0.3922p
+ PS=3.28u PD=3.28u rfmode=0
M$1630 VSS VSS \$1389 VSS sg13_lv_nmos L=0.13u W=1u AS=0.265p AD=0.265p
+ PS=2.56u PD=2.56u rfmode=0
M$1631 \$1389 \$1302 OUTP VSS sg13_lv_nmos L=0.13u W=2u AS=0.38p AD=0.38p
+ PS=3.52u PD=3.52u rfmode=0
M$1633 \$1389 \$1304 OUTN VSS sg13_lv_nmos L=0.13u W=2u AS=0.38p AD=0.38p
+ PS=3.52u PD=3.52u rfmode=0
M$1640 \$1518 \$1487 VSS VSS sg13_lv_nmos L=0.13u W=1.44u AS=0.4068p AD=0.2772p
+ PS=3.29u PD=2.21u rfmode=0
M$1642 \$1518 \$316 \$1519 VSS sg13_lv_nmos L=0.13u W=1.44u AS=0.2772p
+ AD=0.3816p PS=2.21u PD=3.22u rfmode=0
M$1644 VSS VDD \$1600 VSS sg13_lv_nmos L=0.13u W=0.42u AS=0.1701p AD=0.03885p
+ PS=1.65u PD=0.605u rfmode=0
M$1645 \$1600 \$1488 \$1521 VSS sg13_lv_nmos L=0.13u W=0.42u AS=0.03885p
+ AD=0.1596p PS=0.605u PD=1.6u rfmode=0
M$1646 VSS \$1489 \$1662 VSS sg13_lv_nmos L=0.13u W=0.74u AS=0.43315p
+ AD=0.2516p PS=2.205u PD=2.16u rfmode=0
M$1647 VSS CLK \$1489 VSS sg13_lv_nmos L=0.13u W=0.74u AS=0.43315p AD=0.2516p
+ PS=2.205u PD=2.16u rfmode=0
M$1648 \$1523 \$1489 \$1522 VSS sg13_lv_nmos L=0.13u W=0.42u AS=0.12665p
+ AD=0.1428p PS=1.145u PD=1.52u rfmode=0
M$1649 \$1488 \$1662 \$1523 VSS sg13_lv_nmos L=0.13u W=0.74u AS=0.3473p
+ AD=0.12665p PS=2.71u PD=1.145u rfmode=0
M$1650 \$1528 \$1491 VSS VSS sg13_lv_nmos L=0.13u W=1.44u AS=0.4068p AD=0.2772p
+ PS=3.29u PD=2.21u rfmode=0
M$1652 \$1528 \$316 \$1529 VSS sg13_lv_nmos L=0.13u W=1.44u AS=0.2772p
+ AD=0.3816p PS=2.21u PD=3.22u rfmode=0
M$1654 VSS VDD \$1611 VSS sg13_lv_nmos L=0.13u W=0.42u AS=0.1701p AD=0.03885p
+ PS=1.65u PD=0.605u rfmode=0
M$1655 \$1611 \$1492 \$1531 VSS sg13_lv_nmos L=0.13u W=0.42u AS=0.03885p
+ AD=0.1596p PS=0.605u PD=1.6u rfmode=0
M$1656 VSS \$1493 \$1664 VSS sg13_lv_nmos L=0.13u W=0.74u AS=0.43315p
+ AD=0.2516p PS=2.205u PD=2.16u rfmode=0
M$1657 VSS CLK \$1493 VSS sg13_lv_nmos L=0.13u W=0.74u AS=0.43315p AD=0.2516p
+ PS=2.205u PD=2.16u rfmode=0
M$1658 \$1533 \$1493 \$1532 VSS sg13_lv_nmos L=0.13u W=0.42u AS=0.12665p
+ AD=0.1428p PS=1.145u PD=1.52u rfmode=0
M$1659 \$1492 \$1664 \$1533 VSS sg13_lv_nmos L=0.13u W=0.74u AS=0.3473p
+ AD=0.12665p PS=2.71u PD=1.145u rfmode=0
M$1660 \$1538 \$1495 VSS VSS sg13_lv_nmos L=0.13u W=1.44u AS=0.4068p AD=0.2772p
+ PS=3.29u PD=2.21u rfmode=0
M$1662 \$1538 \$316 \$1539 VSS sg13_lv_nmos L=0.13u W=1.44u AS=0.2772p
+ AD=0.3816p PS=2.21u PD=3.22u rfmode=0
M$1664 VSS VDD \$1620 VSS sg13_lv_nmos L=0.13u W=0.42u AS=0.1701p AD=0.03885p
+ PS=1.65u PD=0.605u rfmode=0
M$1665 \$1620 \$1496 \$1541 VSS sg13_lv_nmos L=0.13u W=0.42u AS=0.03885p
+ AD=0.1596p PS=0.605u PD=1.6u rfmode=0
M$1666 VSS \$1497 \$1666 VSS sg13_lv_nmos L=0.13u W=0.74u AS=0.43315p
+ AD=0.2516p PS=2.205u PD=2.16u rfmode=0
M$1667 VSS CLK \$1497 VSS sg13_lv_nmos L=0.13u W=0.74u AS=0.43315p AD=0.2516p
+ PS=2.205u PD=2.16u rfmode=0
M$1668 \$1543 \$1497 \$1542 VSS sg13_lv_nmos L=0.13u W=0.42u AS=0.12665p
+ AD=0.1428p PS=1.145u PD=1.52u rfmode=0
M$1669 \$1496 \$1666 \$1543 VSS sg13_lv_nmos L=0.13u W=0.74u AS=0.3473p
+ AD=0.12665p PS=2.71u PD=1.145u rfmode=0
M$1670 \$1548 \$1499 VSS VSS sg13_lv_nmos L=0.13u W=1.44u AS=0.4068p AD=0.2772p
+ PS=3.29u PD=2.21u rfmode=0
M$1672 \$1548 \$316 \$1549 VSS sg13_lv_nmos L=0.13u W=1.44u AS=0.2772p
+ AD=0.3816p PS=2.21u PD=3.22u rfmode=0
M$1674 VSS VDD \$1630 VSS sg13_lv_nmos L=0.13u W=0.42u AS=0.1701p AD=0.03885p
+ PS=1.65u PD=0.605u rfmode=0
M$1675 \$1630 \$1500 \$1551 VSS sg13_lv_nmos L=0.13u W=0.42u AS=0.03885p
+ AD=0.1596p PS=0.605u PD=1.6u rfmode=0
M$1676 VSS \$1501 \$1668 VSS sg13_lv_nmos L=0.13u W=0.74u AS=0.43315p
+ AD=0.2516p PS=2.205u PD=2.16u rfmode=0
M$1677 VSS CLK \$1501 VSS sg13_lv_nmos L=0.13u W=0.74u AS=0.43315p AD=0.2516p
+ PS=2.205u PD=2.16u rfmode=0
M$1678 \$1553 \$1501 \$1552 VSS sg13_lv_nmos L=0.13u W=0.42u AS=0.12665p
+ AD=0.1428p PS=1.145u PD=1.52u rfmode=0
M$1679 \$1500 \$1668 \$1553 VSS sg13_lv_nmos L=0.13u W=0.74u AS=0.3473p
+ AD=0.12665p PS=2.71u PD=1.145u rfmode=0
M$1680 \$1558 \$1503 VSS VSS sg13_lv_nmos L=0.13u W=1.44u AS=0.4068p AD=0.2772p
+ PS=3.29u PD=2.21u rfmode=0
M$1682 \$1558 \$316 \$1559 VSS sg13_lv_nmos L=0.13u W=1.44u AS=0.2772p
+ AD=0.3816p PS=2.21u PD=3.22u rfmode=0
M$1684 VSS VDD \$1642 VSS sg13_lv_nmos L=0.13u W=0.42u AS=0.1701p AD=0.03885p
+ PS=1.65u PD=0.605u rfmode=0
M$1685 \$1642 \$1504 \$1561 VSS sg13_lv_nmos L=0.13u W=0.42u AS=0.03885p
+ AD=0.1596p PS=0.605u PD=1.6u rfmode=0
M$1686 VSS \$1505 \$1670 VSS sg13_lv_nmos L=0.13u W=0.74u AS=0.43315p
+ AD=0.2516p PS=2.205u PD=2.16u rfmode=0
M$1687 VSS CLK \$1505 VSS sg13_lv_nmos L=0.13u W=0.74u AS=0.43315p AD=0.2516p
+ PS=2.205u PD=2.16u rfmode=0
M$1688 \$1563 \$1505 \$1562 VSS sg13_lv_nmos L=0.13u W=0.42u AS=0.12665p
+ AD=0.1428p PS=1.145u PD=1.52u rfmode=0
M$1689 \$1504 \$1670 \$1563 VSS sg13_lv_nmos L=0.13u W=0.74u AS=0.3473p
+ AD=0.12665p PS=2.71u PD=1.145u rfmode=0
M$1690 \$1568 \$1507 VSS VSS sg13_lv_nmos L=0.13u W=1.44u AS=0.4068p AD=0.2772p
+ PS=3.29u PD=2.21u rfmode=0
M$1692 \$1568 \$316 \$1569 VSS sg13_lv_nmos L=0.13u W=1.44u AS=0.2772p
+ AD=0.3816p PS=2.21u PD=3.22u rfmode=0
M$1694 VSS VDD \$1637 VSS sg13_lv_nmos L=0.13u W=0.42u AS=0.1701p AD=0.03885p
+ PS=1.65u PD=0.605u rfmode=0
M$1695 \$1637 \$1508 \$1571 VSS sg13_lv_nmos L=0.13u W=0.42u AS=0.03885p
+ AD=0.1596p PS=0.605u PD=1.6u rfmode=0
M$1696 VSS \$1509 \$1672 VSS sg13_lv_nmos L=0.13u W=0.74u AS=0.43315p
+ AD=0.2516p PS=2.205u PD=2.16u rfmode=0
M$1697 VSS CLK \$1509 VSS sg13_lv_nmos L=0.13u W=0.74u AS=0.43315p AD=0.2516p
+ PS=2.205u PD=2.16u rfmode=0
M$1698 \$1573 \$1509 \$1572 VSS sg13_lv_nmos L=0.13u W=0.42u AS=0.12665p
+ AD=0.1428p PS=1.145u PD=1.52u rfmode=0
M$1699 \$1508 \$1672 \$1573 VSS sg13_lv_nmos L=0.13u W=0.74u AS=0.3473p
+ AD=0.12665p PS=2.71u PD=1.145u rfmode=0
M$1700 \$1578 \$1511 VSS VSS sg13_lv_nmos L=0.13u W=1.44u AS=0.4068p AD=0.2772p
+ PS=3.29u PD=2.21u rfmode=0
M$1702 \$1578 \$316 \$1579 VSS sg13_lv_nmos L=0.13u W=1.44u AS=0.2772p
+ AD=0.3816p PS=2.21u PD=3.22u rfmode=0
M$1704 VSS VDD \$1623 VSS sg13_lv_nmos L=0.13u W=0.42u AS=0.1701p AD=0.03885p
+ PS=1.65u PD=0.605u rfmode=0
M$1705 \$1623 \$1512 \$1581 VSS sg13_lv_nmos L=0.13u W=0.42u AS=0.03885p
+ AD=0.1596p PS=0.605u PD=1.6u rfmode=0
M$1706 VSS \$1513 \$1674 VSS sg13_lv_nmos L=0.13u W=0.74u AS=0.43315p
+ AD=0.2516p PS=2.205u PD=2.16u rfmode=0
M$1707 VSS CLK \$1513 VSS sg13_lv_nmos L=0.13u W=0.74u AS=0.43315p AD=0.2516p
+ PS=2.205u PD=2.16u rfmode=0
M$1708 \$1583 \$1513 \$1582 VSS sg13_lv_nmos L=0.13u W=0.42u AS=0.12665p
+ AD=0.1428p PS=1.145u PD=1.52u rfmode=0
M$1709 \$1512 \$1674 \$1583 VSS sg13_lv_nmos L=0.13u W=0.74u AS=0.3473p
+ AD=0.12665p PS=2.71u PD=1.145u rfmode=0
M$1710 \$1588 \$1515 VSS VSS sg13_lv_nmos L=0.13u W=1.44u AS=0.4068p AD=0.2772p
+ PS=3.29u PD=2.21u rfmode=0
M$1712 \$1588 \$316 \$1589 VSS sg13_lv_nmos L=0.13u W=1.44u AS=0.2772p
+ AD=0.3816p PS=2.21u PD=3.22u rfmode=0
M$1714 VSS VDD \$1608 VSS sg13_lv_nmos L=0.13u W=0.42u AS=0.1701p AD=0.03885p
+ PS=1.65u PD=0.605u rfmode=0
M$1715 \$1608 \$1516 \$1591 VSS sg13_lv_nmos L=0.13u W=0.42u AS=0.03885p
+ AD=0.1596p PS=0.605u PD=1.6u rfmode=0
M$1716 VSS \$1517 \$1676 VSS sg13_lv_nmos L=0.13u W=0.74u AS=0.43315p
+ AD=0.2516p PS=2.205u PD=2.16u rfmode=0
M$1717 VSS CLK \$1517 VSS sg13_lv_nmos L=0.13u W=0.74u AS=0.43315p AD=0.2516p
+ PS=2.205u PD=2.16u rfmode=0
M$1718 \$1593 \$1517 \$1592 VSS sg13_lv_nmos L=0.13u W=0.42u AS=0.12665p
+ AD=0.1428p PS=1.145u PD=1.52u rfmode=0
M$1719 \$1516 \$1676 \$1593 VSS sg13_lv_nmos L=0.13u W=0.74u AS=0.3473p
+ AD=0.12665p PS=2.71u PD=1.145u rfmode=0
M$1720 VSS \$167 \$1774 VSS sg13_lv_nmos L=0.13u W=0.55u AS=0.187p AD=0.1045p
+ PS=1.78u PD=0.93u rfmode=0
M$1721 \$1774 \$563 VSS VSS sg13_lv_nmos L=0.13u W=0.55u AS=0.1045p
+ AD=0.146425p PS=0.93u PD=1.155u rfmode=0
M$1722 VSS \$1774 \$1775 VSS sg13_lv_nmos L=0.13u W=1.48u AS=0.312925p
+ AD=0.4477p PS=2.345u PD=3.43u rfmode=0
M$1724 \$1808 \$1807 \$1884 VSS sg13_lv_nmos L=0.13u W=0.42u AS=0.1428p
+ AD=0.0609p PS=1.52u PD=0.71u rfmode=0
M$1725 \$1884 VDD VSS VSS sg13_lv_nmos L=0.13u W=0.42u AS=0.0609p AD=0.1626p
+ PS=0.71u PD=1.415u rfmode=0
M$1726 VSS \$1931 \$1776 VSS sg13_lv_nmos L=0.13u W=0.74u AS=0.1626p AD=0.2516p
+ PS=1.415u PD=2.16u rfmode=0
M$1727 \$1520 \$1489 \$1646 VSS sg13_lv_nmos L=0.13u W=0.42u AS=0.1296p
+ AD=0.081p PS=1.52u PD=0.81u rfmode=0
M$1728 \$1646 \$1662 \$1521 VSS sg13_lv_nmos L=0.13u W=0.42u AS=0.081p
+ AD=0.2163p PS=0.81u PD=1.87u rfmode=0
M$1729 \$1810 \$1932 VSS VSS sg13_lv_nmos L=0.13u W=0.42u AS=0.1428p AD=0.0798p
+ PS=1.52u PD=0.8u rfmode=0
M$1730 VSS VDD \$1886 VSS sg13_lv_nmos L=0.13u W=0.42u AS=0.0798p AD=0.0378p
+ PS=0.8u PD=0.6u rfmode=0
M$1731 \$1886 \$1811 \$1932 VSS sg13_lv_nmos L=0.13u W=0.42u AS=0.0378p
+ AD=0.1428p PS=0.6u PD=1.52u rfmode=0
M$1732 VSS \$1811 \$1813 VSS sg13_lv_nmos L=0.13u W=0.64u AS=0.1331p AD=0.2176p
+ PS=1.12u PD=1.96u rfmode=0
M$1733 VSS \$1811 \$1812 VSS sg13_lv_nmos L=0.13u W=1.48u AS=0.3922p AD=0.2737p
+ PS=3.28u PD=2.24u rfmode=0
M$1735 VSS \$1813 \$1814 VSS sg13_lv_nmos L=0.13u W=1.48u AS=0.3922p AD=0.3922p
+ PS=3.28u PD=3.28u rfmode=0
M$1737 VSS VSS \$1663 VSS sg13_lv_nmos L=0.13u W=1u AS=0.265p AD=0.265p
+ PS=2.56u PD=2.56u rfmode=0
M$1738 \$1663 \$1524 OUTP VSS sg13_lv_nmos L=0.13u W=2u AS=0.38p AD=0.38p
+ PS=3.52u PD=3.52u rfmode=0
M$1740 \$1663 \$1526 OUTN VSS sg13_lv_nmos L=0.13u W=2u AS=0.38p AD=0.38p
+ PS=3.52u PD=3.52u rfmode=0
M$1747 VSS \$171 \$1778 VSS sg13_lv_nmos L=0.13u W=0.55u AS=0.187p AD=0.1045p
+ PS=1.78u PD=0.93u rfmode=0
M$1748 \$1778 \$563 VSS VSS sg13_lv_nmos L=0.13u W=0.55u AS=0.1045p
+ AD=0.146425p PS=0.93u PD=1.155u rfmode=0
M$1749 VSS \$1778 \$1779 VSS sg13_lv_nmos L=0.13u W=1.48u AS=0.312925p
+ AD=0.4477p PS=2.345u PD=3.43u rfmode=0
M$1751 \$1949 \$1817 \$1895 VSS sg13_lv_nmos L=0.13u W=0.42u AS=0.1428p
+ AD=0.0609p PS=1.52u PD=0.71u rfmode=0
M$1752 \$1895 VDD VSS VSS sg13_lv_nmos L=0.13u W=0.42u AS=0.0609p AD=0.1626p
+ PS=0.71u PD=1.415u rfmode=0
M$1753 VSS \$1933 \$1780 VSS sg13_lv_nmos L=0.13u W=0.74u AS=0.1626p AD=0.2516p
+ PS=1.415u PD=2.16u rfmode=0
M$1754 \$1530 \$1493 \$1648 VSS sg13_lv_nmos L=0.13u W=0.42u AS=0.1296p
+ AD=0.081p PS=1.52u PD=0.81u rfmode=0
M$1755 \$1648 \$1664 \$1531 VSS sg13_lv_nmos L=0.13u W=0.42u AS=0.081p
+ AD=0.2163p PS=0.81u PD=1.87u rfmode=0
M$1756 \$1819 \$1934 VSS VSS sg13_lv_nmos L=0.13u W=0.42u AS=0.1428p AD=0.0798p
+ PS=1.52u PD=0.8u rfmode=0
M$1757 VSS VDD \$1898 VSS sg13_lv_nmos L=0.13u W=0.42u AS=0.0798p AD=0.0378p
+ PS=0.8u PD=0.6u rfmode=0
M$1758 \$1898 \$1820 \$1934 VSS sg13_lv_nmos L=0.13u W=0.42u AS=0.0378p
+ AD=0.1428p PS=0.6u PD=1.52u rfmode=0
M$1759 VSS \$1820 \$1822 VSS sg13_lv_nmos L=0.13u W=0.64u AS=0.1331p AD=0.2176p
+ PS=1.12u PD=1.96u rfmode=0
M$1760 VSS \$1820 \$1821 VSS sg13_lv_nmos L=0.13u W=1.48u AS=0.3922p AD=0.2737p
+ PS=3.28u PD=2.24u rfmode=0
M$1762 VSS \$1822 \$1823 VSS sg13_lv_nmos L=0.13u W=1.48u AS=0.3922p AD=0.3922p
+ PS=3.28u PD=3.28u rfmode=0
M$1764 VSS VSS \$1665 VSS sg13_lv_nmos L=0.13u W=1u AS=0.265p AD=0.265p
+ PS=2.56u PD=2.56u rfmode=0
M$1765 \$1665 \$1534 OUTP VSS sg13_lv_nmos L=0.13u W=2u AS=0.38p AD=0.38p
+ PS=3.52u PD=3.52u rfmode=0
M$1767 \$1665 \$1536 OUTN VSS sg13_lv_nmos L=0.13u W=2u AS=0.38p AD=0.38p
+ PS=3.52u PD=3.52u rfmode=0
M$1774 VSS \$174 \$1782 VSS sg13_lv_nmos L=0.13u W=0.55u AS=0.187p AD=0.1045p
+ PS=1.78u PD=0.93u rfmode=0
M$1775 \$1782 \$563 VSS VSS sg13_lv_nmos L=0.13u W=0.55u AS=0.1045p
+ AD=0.146425p PS=0.93u PD=1.155u rfmode=0
M$1776 VSS \$1782 \$1783 VSS sg13_lv_nmos L=0.13u W=1.48u AS=0.312925p
+ AD=0.4477p PS=2.345u PD=3.43u rfmode=0
M$1778 \$1827 \$1826 \$1905 VSS sg13_lv_nmos L=0.13u W=0.42u AS=0.1428p
+ AD=0.0609p PS=1.52u PD=0.71u rfmode=0
M$1779 \$1905 VDD VSS VSS sg13_lv_nmos L=0.13u W=0.42u AS=0.0609p AD=0.1626p
+ PS=0.71u PD=1.415u rfmode=0
M$1780 VSS \$1935 \$1784 VSS sg13_lv_nmos L=0.13u W=0.74u AS=0.1626p AD=0.2516p
+ PS=1.415u PD=2.16u rfmode=0
M$1781 \$1540 \$1497 \$1650 VSS sg13_lv_nmos L=0.13u W=0.42u AS=0.1296p
+ AD=0.081p PS=1.52u PD=0.81u rfmode=0
M$1782 \$1650 \$1666 \$1541 VSS sg13_lv_nmos L=0.13u W=0.42u AS=0.081p
+ AD=0.2163p PS=0.81u PD=1.87u rfmode=0
M$1783 \$1829 \$1936 VSS VSS sg13_lv_nmos L=0.13u W=0.42u AS=0.1428p AD=0.0798p
+ PS=1.52u PD=0.8u rfmode=0
M$1784 VSS VDD \$1909 VSS sg13_lv_nmos L=0.13u W=0.42u AS=0.0798p AD=0.0378p
+ PS=0.8u PD=0.6u rfmode=0
M$1785 \$1909 \$1830 \$1936 VSS sg13_lv_nmos L=0.13u W=0.42u AS=0.0378p
+ AD=0.1428p PS=0.6u PD=1.52u rfmode=0
M$1786 VSS \$1830 \$1832 VSS sg13_lv_nmos L=0.13u W=0.64u AS=0.1331p AD=0.2176p
+ PS=1.12u PD=1.96u rfmode=0
M$1787 VSS \$1830 \$1831 VSS sg13_lv_nmos L=0.13u W=1.48u AS=0.3922p AD=0.2737p
+ PS=3.28u PD=2.24u rfmode=0
M$1789 VSS \$1832 \$1833 VSS sg13_lv_nmos L=0.13u W=1.48u AS=0.3922p AD=0.3922p
+ PS=3.28u PD=3.28u rfmode=0
M$1791 VSS VSS \$1667 VSS sg13_lv_nmos L=0.13u W=1u AS=0.265p AD=0.265p
+ PS=2.56u PD=2.56u rfmode=0
M$1792 \$1667 \$1544 OUTP VSS sg13_lv_nmos L=0.13u W=2u AS=0.38p AD=0.38p
+ PS=3.52u PD=3.52u rfmode=0
M$1794 \$1667 \$1546 OUTN VSS sg13_lv_nmos L=0.13u W=2u AS=0.38p AD=0.38p
+ PS=3.52u PD=3.52u rfmode=0
M$1801 VSS \$177 \$1786 VSS sg13_lv_nmos L=0.13u W=0.55u AS=0.187p AD=0.1045p
+ PS=1.78u PD=0.93u rfmode=0
M$1802 \$1786 \$563 VSS VSS sg13_lv_nmos L=0.13u W=0.55u AS=0.1045p
+ AD=0.146425p PS=0.93u PD=1.155u rfmode=0
M$1803 VSS \$1786 \$1787 VSS sg13_lv_nmos L=0.13u W=1.48u AS=0.312925p
+ AD=0.4477p PS=2.345u PD=3.43u rfmode=0
M$1805 \$1837 \$1836 \$1915 VSS sg13_lv_nmos L=0.13u W=0.42u AS=0.1428p
+ AD=0.0609p PS=1.52u PD=0.71u rfmode=0
M$1806 \$1915 VDD VSS VSS sg13_lv_nmos L=0.13u W=0.42u AS=0.0609p AD=0.1626p
+ PS=0.71u PD=1.415u rfmode=0
M$1807 VSS \$1937 \$1788 VSS sg13_lv_nmos L=0.13u W=0.74u AS=0.1626p AD=0.2516p
+ PS=1.415u PD=2.16u rfmode=0
M$1808 \$1550 \$1501 \$1652 VSS sg13_lv_nmos L=0.13u W=0.42u AS=0.1296p
+ AD=0.081p PS=1.52u PD=0.81u rfmode=0
M$1809 \$1652 \$1668 \$1551 VSS sg13_lv_nmos L=0.13u W=0.42u AS=0.081p
+ AD=0.2163p PS=0.81u PD=1.87u rfmode=0
M$1810 \$1839 \$1938 VSS VSS sg13_lv_nmos L=0.13u W=0.42u AS=0.1428p AD=0.0798p
+ PS=1.52u PD=0.8u rfmode=0
M$1811 VSS VDD \$1918 VSS sg13_lv_nmos L=0.13u W=0.42u AS=0.0798p AD=0.0378p
+ PS=0.8u PD=0.6u rfmode=0
M$1812 \$1918 \$1840 \$1938 VSS sg13_lv_nmos L=0.13u W=0.42u AS=0.0378p
+ AD=0.1428p PS=0.6u PD=1.52u rfmode=0
M$1813 VSS \$1840 \$1842 VSS sg13_lv_nmos L=0.13u W=0.64u AS=0.1331p AD=0.2176p
+ PS=1.12u PD=1.96u rfmode=0
M$1814 VSS \$1840 \$1841 VSS sg13_lv_nmos L=0.13u W=1.48u AS=0.3922p AD=0.2737p
+ PS=3.28u PD=2.24u rfmode=0
M$1816 VSS \$1842 \$1843 VSS sg13_lv_nmos L=0.13u W=1.48u AS=0.3922p AD=0.3922p
+ PS=3.28u PD=3.28u rfmode=0
M$1818 VSS VSS \$1669 VSS sg13_lv_nmos L=0.13u W=1u AS=0.265p AD=0.265p
+ PS=2.56u PD=2.56u rfmode=0
M$1819 \$1669 \$1554 OUTP VSS sg13_lv_nmos L=0.13u W=2u AS=0.38p AD=0.38p
+ PS=3.52u PD=3.52u rfmode=0
M$1821 \$1669 \$1556 OUTN VSS sg13_lv_nmos L=0.13u W=2u AS=0.38p AD=0.38p
+ PS=3.52u PD=3.52u rfmode=0
M$1828 VSS \$180 \$1790 VSS sg13_lv_nmos L=0.13u W=0.55u AS=0.187p AD=0.1045p
+ PS=1.78u PD=0.93u rfmode=0
M$1829 \$1790 \$563 VSS VSS sg13_lv_nmos L=0.13u W=0.55u AS=0.1045p
+ AD=0.146425p PS=0.93u PD=1.155u rfmode=0
M$1830 VSS \$1790 \$1791 VSS sg13_lv_nmos L=0.13u W=1.48u AS=0.312925p
+ AD=0.4477p PS=2.345u PD=3.43u rfmode=0
M$1832 \$1847 \$1846 \$1926 VSS sg13_lv_nmos L=0.13u W=0.42u AS=0.1428p
+ AD=0.0609p PS=1.52u PD=0.71u rfmode=0
M$1833 \$1926 VDD VSS VSS sg13_lv_nmos L=0.13u W=0.42u AS=0.0609p AD=0.1626p
+ PS=0.71u PD=1.415u rfmode=0
M$1834 VSS \$1939 \$1792 VSS sg13_lv_nmos L=0.13u W=0.74u AS=0.1626p AD=0.2516p
+ PS=1.415u PD=2.16u rfmode=0
M$1835 \$1560 \$1505 \$1654 VSS sg13_lv_nmos L=0.13u W=0.42u AS=0.1296p
+ AD=0.081p PS=1.52u PD=0.81u rfmode=0
M$1836 \$1654 \$1670 \$1561 VSS sg13_lv_nmos L=0.13u W=0.42u AS=0.081p
+ AD=0.2163p PS=0.81u PD=1.87u rfmode=0
M$1837 \$1849 \$1940 VSS VSS sg13_lv_nmos L=0.13u W=0.42u AS=0.1428p AD=0.0798p
+ PS=1.52u PD=0.8u rfmode=0
M$1838 VSS VDD \$1928 VSS sg13_lv_nmos L=0.13u W=0.42u AS=0.0798p AD=0.0378p
+ PS=0.8u PD=0.6u rfmode=0
M$1839 \$1928 \$1850 \$1940 VSS sg13_lv_nmos L=0.13u W=0.42u AS=0.0378p
+ AD=0.1428p PS=0.6u PD=1.52u rfmode=0
M$1840 VSS \$1850 \$1852 VSS sg13_lv_nmos L=0.13u W=0.64u AS=0.1331p AD=0.2176p
+ PS=1.12u PD=1.96u rfmode=0
M$1841 VSS \$1850 \$1851 VSS sg13_lv_nmos L=0.13u W=1.48u AS=0.3922p AD=0.2737p
+ PS=3.28u PD=2.24u rfmode=0
M$1843 VSS \$1852 \$1853 VSS sg13_lv_nmos L=0.13u W=1.48u AS=0.3922p AD=0.3922p
+ PS=3.28u PD=3.28u rfmode=0
M$1845 VSS VSS \$1671 VSS sg13_lv_nmos L=0.13u W=1u AS=0.265p AD=0.265p
+ PS=2.56u PD=2.56u rfmode=0
M$1846 \$1671 \$1564 OUTP VSS sg13_lv_nmos L=0.13u W=2u AS=0.38p AD=0.38p
+ PS=3.52u PD=3.52u rfmode=0
M$1848 \$1671 \$1566 OUTN VSS sg13_lv_nmos L=0.13u W=2u AS=0.38p AD=0.38p
+ PS=3.52u PD=3.52u rfmode=0
M$1855 VSS \$183 \$1794 VSS sg13_lv_nmos L=0.13u W=0.55u AS=0.187p AD=0.1045p
+ PS=1.78u PD=0.93u rfmode=0
M$1856 \$1794 \$563 VSS VSS sg13_lv_nmos L=0.13u W=0.55u AS=0.1045p
+ AD=0.146425p PS=0.93u PD=1.155u rfmode=0
M$1857 VSS \$1794 \$1795 VSS sg13_lv_nmos L=0.13u W=1.48u AS=0.312925p
+ AD=0.4477p PS=2.345u PD=3.43u rfmode=0
M$1859 \$1857 \$1856 \$1923 VSS sg13_lv_nmos L=0.13u W=0.42u AS=0.1428p
+ AD=0.0609p PS=1.52u PD=0.71u rfmode=0
M$1860 \$1923 VDD VSS VSS sg13_lv_nmos L=0.13u W=0.42u AS=0.0609p AD=0.1626p
+ PS=0.71u PD=1.415u rfmode=0
M$1861 VSS \$1941 \$1796 VSS sg13_lv_nmos L=0.13u W=0.74u AS=0.1626p AD=0.2516p
+ PS=1.415u PD=2.16u rfmode=0
M$1862 \$1570 \$1509 \$1656 VSS sg13_lv_nmos L=0.13u W=0.42u AS=0.1296p
+ AD=0.081p PS=1.52u PD=0.81u rfmode=0
M$1863 \$1656 \$1672 \$1571 VSS sg13_lv_nmos L=0.13u W=0.42u AS=0.081p
+ AD=0.2163p PS=0.81u PD=1.87u rfmode=0
M$1864 \$1859 \$1942 VSS VSS sg13_lv_nmos L=0.13u W=0.42u AS=0.1428p AD=0.0798p
+ PS=1.52u PD=0.8u rfmode=0
M$1865 VSS VDD \$1919 VSS sg13_lv_nmos L=0.13u W=0.42u AS=0.0798p AD=0.0378p
+ PS=0.8u PD=0.6u rfmode=0
M$1866 \$1919 \$1860 \$1942 VSS sg13_lv_nmos L=0.13u W=0.42u AS=0.0378p
+ AD=0.1428p PS=0.6u PD=1.52u rfmode=0
M$1867 VSS \$1860 \$1862 VSS sg13_lv_nmos L=0.13u W=0.64u AS=0.1331p AD=0.2176p
+ PS=1.12u PD=1.96u rfmode=0
M$1868 VSS \$1860 \$1861 VSS sg13_lv_nmos L=0.13u W=1.48u AS=0.3922p AD=0.2737p
+ PS=3.28u PD=2.24u rfmode=0
M$1870 VSS \$1862 \$1863 VSS sg13_lv_nmos L=0.13u W=1.48u AS=0.3922p AD=0.3922p
+ PS=3.28u PD=3.28u rfmode=0
M$1872 VSS VSS \$1673 VSS sg13_lv_nmos L=0.13u W=1u AS=0.265p AD=0.265p
+ PS=2.56u PD=2.56u rfmode=0
M$1873 \$1673 \$1574 OUTP VSS sg13_lv_nmos L=0.13u W=2u AS=0.38p AD=0.38p
+ PS=3.52u PD=3.52u rfmode=0
M$1875 \$1673 \$1576 OUTN VSS sg13_lv_nmos L=0.13u W=2u AS=0.38p AD=0.38p
+ PS=3.52u PD=3.52u rfmode=0
M$1882 VSS \$186 \$1798 VSS sg13_lv_nmos L=0.13u W=0.55u AS=0.187p AD=0.1045p
+ PS=1.78u PD=0.93u rfmode=0
M$1883 \$1798 \$563 VSS VSS sg13_lv_nmos L=0.13u W=0.55u AS=0.1045p
+ AD=0.146425p PS=0.93u PD=1.155u rfmode=0
M$1884 VSS \$1798 \$1799 VSS sg13_lv_nmos L=0.13u W=1.48u AS=0.312925p
+ AD=0.4477p PS=2.345u PD=3.43u rfmode=0
M$1886 \$1960 \$1866 \$1908 VSS sg13_lv_nmos L=0.13u W=0.42u AS=0.1428p
+ AD=0.0609p PS=1.52u PD=0.71u rfmode=0
M$1887 \$1908 VDD VSS VSS sg13_lv_nmos L=0.13u W=0.42u AS=0.0609p AD=0.1626p
+ PS=0.71u PD=1.415u rfmode=0
M$1888 VSS \$1943 \$1800 VSS sg13_lv_nmos L=0.13u W=0.74u AS=0.1626p AD=0.2516p
+ PS=1.415u PD=2.16u rfmode=0
M$1889 \$1580 \$1513 \$1658 VSS sg13_lv_nmos L=0.13u W=0.42u AS=0.1296p
+ AD=0.081p PS=1.52u PD=0.81u rfmode=0
M$1890 \$1658 \$1674 \$1581 VSS sg13_lv_nmos L=0.13u W=0.42u AS=0.081p
+ AD=0.2163p PS=0.81u PD=1.87u rfmode=0
M$1891 \$1868 \$1944 VSS VSS sg13_lv_nmos L=0.13u W=0.42u AS=0.1428p AD=0.0798p
+ PS=1.52u PD=0.8u rfmode=0
M$1892 VSS VDD \$1904 VSS sg13_lv_nmos L=0.13u W=0.42u AS=0.0798p AD=0.0378p
+ PS=0.8u PD=0.6u rfmode=0
M$1893 \$1904 \$1869 \$1944 VSS sg13_lv_nmos L=0.13u W=0.42u AS=0.0378p
+ AD=0.1428p PS=0.6u PD=1.52u rfmode=0
M$1894 VSS \$1869 \$1871 VSS sg13_lv_nmos L=0.13u W=0.64u AS=0.1331p AD=0.2176p
+ PS=1.12u PD=1.96u rfmode=0
M$1895 VSS \$1869 \$1870 VSS sg13_lv_nmos L=0.13u W=1.48u AS=0.3922p AD=0.2737p
+ PS=3.28u PD=2.24u rfmode=0
M$1897 VSS \$1871 \$1872 VSS sg13_lv_nmos L=0.13u W=1.48u AS=0.3922p AD=0.3922p
+ PS=3.28u PD=3.28u rfmode=0
M$1899 VSS VSS \$1675 VSS sg13_lv_nmos L=0.13u W=1u AS=0.265p AD=0.265p
+ PS=2.56u PD=2.56u rfmode=0
M$1900 \$1675 \$1584 OUTP VSS sg13_lv_nmos L=0.13u W=2u AS=0.38p AD=0.38p
+ PS=3.52u PD=3.52u rfmode=0
M$1902 \$1675 \$1586 OUTN VSS sg13_lv_nmos L=0.13u W=2u AS=0.38p AD=0.38p
+ PS=3.52u PD=3.52u rfmode=0
M$1909 VSS VSS \$1802 VSS sg13_lv_nmos L=0.13u W=0.55u AS=0.187p AD=0.1045p
+ PS=1.78u PD=0.93u rfmode=0
M$1910 \$1802 \$563 VSS VSS sg13_lv_nmos L=0.13u W=0.55u AS=0.1045p
+ AD=0.146425p PS=0.93u PD=1.155u rfmode=0
M$1911 VSS \$1802 \$1803 VSS sg13_lv_nmos L=0.13u W=1.48u AS=0.312925p
+ AD=0.4477p PS=2.345u PD=3.43u rfmode=0
M$1913 \$1963 \$1875 \$1894 VSS sg13_lv_nmos L=0.13u W=0.42u AS=0.1428p
+ AD=0.0609p PS=1.52u PD=0.71u rfmode=0
M$1914 \$1894 VDD VSS VSS sg13_lv_nmos L=0.13u W=0.42u AS=0.0609p AD=0.1626p
+ PS=0.71u PD=1.415u rfmode=0
M$1915 VSS \$1945 \$1804 VSS sg13_lv_nmos L=0.13u W=0.74u AS=0.1626p AD=0.2516p
+ PS=1.415u PD=2.16u rfmode=0
M$1916 \$1590 \$1517 \$1660 VSS sg13_lv_nmos L=0.13u W=0.42u AS=0.1296p
+ AD=0.081p PS=1.52u PD=0.81u rfmode=0
M$1917 \$1660 \$1676 \$1591 VSS sg13_lv_nmos L=0.13u W=0.42u AS=0.081p
+ AD=0.2163p PS=0.81u PD=1.87u rfmode=0
M$1918 \$1877 \$1946 VSS VSS sg13_lv_nmos L=0.13u W=0.42u AS=0.1428p AD=0.0798p
+ PS=1.52u PD=0.8u rfmode=0
M$1919 VSS VDD \$1891 VSS sg13_lv_nmos L=0.13u W=0.42u AS=0.0798p AD=0.0378p
+ PS=0.8u PD=0.6u rfmode=0
M$1920 \$1891 \$1878 \$1946 VSS sg13_lv_nmos L=0.13u W=0.42u AS=0.0378p
+ AD=0.1428p PS=0.6u PD=1.52u rfmode=0
M$1921 VSS \$1878 \$1880 VSS sg13_lv_nmos L=0.13u W=0.64u AS=0.1331p AD=0.2176p
+ PS=1.12u PD=1.96u rfmode=0
M$1922 VSS \$1878 \$1879 VSS sg13_lv_nmos L=0.13u W=1.48u AS=0.3922p AD=0.2737p
+ PS=3.28u PD=2.24u rfmode=0
M$1924 VSS \$1880 \$1881 VSS sg13_lv_nmos L=0.13u W=1.48u AS=0.3922p AD=0.3922p
+ PS=3.28u PD=3.28u rfmode=0
M$1926 VSS VSS \$1677 VSS sg13_lv_nmos L=0.13u W=1u AS=0.265p AD=0.265p
+ PS=2.56u PD=2.56u rfmode=0
M$1927 \$1677 \$1594 OUTP VSS sg13_lv_nmos L=0.13u W=2u AS=0.38p AD=0.38p
+ PS=3.52u PD=3.52u rfmode=0
M$1929 \$1677 \$1596 OUTN VSS sg13_lv_nmos L=0.13u W=2u AS=0.38p AD=0.38p
+ PS=3.52u PD=3.52u rfmode=0
M$1936 \$1806 \$1775 VSS VSS sg13_lv_nmos L=0.13u W=1.44u AS=0.4068p AD=0.2772p
+ PS=3.29u PD=2.21u rfmode=0
M$1938 \$1806 \$324 \$1807 VSS sg13_lv_nmos L=0.13u W=1.44u AS=0.2772p
+ AD=0.3816p PS=2.21u PD=3.22u rfmode=0
M$1940 VSS VDD \$1885 VSS sg13_lv_nmos L=0.13u W=0.42u AS=0.1701p AD=0.03885p
+ PS=1.65u PD=0.605u rfmode=0
M$1941 \$1885 \$1776 \$1809 VSS sg13_lv_nmos L=0.13u W=0.42u AS=0.03885p
+ AD=0.1596p PS=0.605u PD=1.6u rfmode=0
M$1942 VSS \$1777 \$1947 VSS sg13_lv_nmos L=0.13u W=0.74u AS=0.43315p
+ AD=0.2516p PS=2.205u PD=2.16u rfmode=0
M$1943 VSS CLK \$1777 VSS sg13_lv_nmos L=0.13u W=0.74u AS=0.43315p AD=0.2516p
+ PS=2.205u PD=2.16u rfmode=0
M$1944 \$1811 \$1777 \$1810 VSS sg13_lv_nmos L=0.13u W=0.42u AS=0.12665p
+ AD=0.1428p PS=1.145u PD=1.52u rfmode=0
M$1945 \$1776 \$1947 \$1811 VSS sg13_lv_nmos L=0.13u W=0.74u AS=0.3473p
+ AD=0.12665p PS=2.71u PD=1.145u rfmode=0
M$1946 \$1816 \$1779 VSS VSS sg13_lv_nmos L=0.13u W=1.44u AS=0.4068p AD=0.2772p
+ PS=3.29u PD=2.21u rfmode=0
M$1948 \$1816 \$324 \$1817 VSS sg13_lv_nmos L=0.13u W=1.44u AS=0.2772p
+ AD=0.3816p PS=2.21u PD=3.22u rfmode=0
M$1950 VSS VDD \$1896 VSS sg13_lv_nmos L=0.13u W=0.42u AS=0.1701p AD=0.03885p
+ PS=1.65u PD=0.605u rfmode=0
M$1951 \$1896 \$1780 \$1818 VSS sg13_lv_nmos L=0.13u W=0.42u AS=0.03885p
+ AD=0.1596p PS=0.605u PD=1.6u rfmode=0
M$1952 VSS \$1781 \$1950 VSS sg13_lv_nmos L=0.13u W=0.74u AS=0.43315p
+ AD=0.2516p PS=2.205u PD=2.16u rfmode=0
M$1953 VSS CLK \$1781 VSS sg13_lv_nmos L=0.13u W=0.74u AS=0.43315p AD=0.2516p
+ PS=2.205u PD=2.16u rfmode=0
M$1954 \$1820 \$1781 \$1819 VSS sg13_lv_nmos L=0.13u W=0.42u AS=0.12665p
+ AD=0.1428p PS=1.145u PD=1.52u rfmode=0
M$1955 \$1780 \$1950 \$1820 VSS sg13_lv_nmos L=0.13u W=0.74u AS=0.3473p
+ AD=0.12665p PS=2.71u PD=1.145u rfmode=0
M$1956 \$1825 \$1783 VSS VSS sg13_lv_nmos L=0.13u W=1.44u AS=0.4068p AD=0.2772p
+ PS=3.29u PD=2.21u rfmode=0
M$1958 \$1825 \$324 \$1826 VSS sg13_lv_nmos L=0.13u W=1.44u AS=0.2772p
+ AD=0.3816p PS=2.21u PD=3.22u rfmode=0
M$1960 VSS VDD \$1906 VSS sg13_lv_nmos L=0.13u W=0.42u AS=0.1701p AD=0.03885p
+ PS=1.65u PD=0.605u rfmode=0
M$1961 \$1906 \$1784 \$1828 VSS sg13_lv_nmos L=0.13u W=0.42u AS=0.03885p
+ AD=0.1596p PS=0.605u PD=1.6u rfmode=0
M$1962 VSS \$1785 \$1952 VSS sg13_lv_nmos L=0.13u W=0.74u AS=0.43315p
+ AD=0.2516p PS=2.205u PD=2.16u rfmode=0
M$1963 VSS CLK \$1785 VSS sg13_lv_nmos L=0.13u W=0.74u AS=0.43315p AD=0.2516p
+ PS=2.205u PD=2.16u rfmode=0
M$1964 \$1830 \$1785 \$1829 VSS sg13_lv_nmos L=0.13u W=0.42u AS=0.12665p
+ AD=0.1428p PS=1.145u PD=1.52u rfmode=0
M$1965 \$1784 \$1952 \$1830 VSS sg13_lv_nmos L=0.13u W=0.74u AS=0.3473p
+ AD=0.12665p PS=2.71u PD=1.145u rfmode=0
M$1966 \$1835 \$1787 VSS VSS sg13_lv_nmos L=0.13u W=1.44u AS=0.4068p AD=0.2772p
+ PS=3.29u PD=2.21u rfmode=0
M$1968 \$1835 \$324 \$1836 VSS sg13_lv_nmos L=0.13u W=1.44u AS=0.2772p
+ AD=0.3816p PS=2.21u PD=3.22u rfmode=0
M$1970 VSS VDD \$1917 VSS sg13_lv_nmos L=0.13u W=0.42u AS=0.1701p AD=0.03885p
+ PS=1.65u PD=0.605u rfmode=0
M$1971 \$1917 \$1788 \$1838 VSS sg13_lv_nmos L=0.13u W=0.42u AS=0.03885p
+ AD=0.1596p PS=0.605u PD=1.6u rfmode=0
M$1972 VSS \$1789 \$1954 VSS sg13_lv_nmos L=0.13u W=0.74u AS=0.43315p
+ AD=0.2516p PS=2.205u PD=2.16u rfmode=0
M$1973 VSS CLK \$1789 VSS sg13_lv_nmos L=0.13u W=0.74u AS=0.43315p AD=0.2516p
+ PS=2.205u PD=2.16u rfmode=0
M$1974 \$1840 \$1789 \$1839 VSS sg13_lv_nmos L=0.13u W=0.42u AS=0.12665p
+ AD=0.1428p PS=1.145u PD=1.52u rfmode=0
M$1975 \$1788 \$1954 \$1840 VSS sg13_lv_nmos L=0.13u W=0.74u AS=0.3473p
+ AD=0.12665p PS=2.71u PD=1.145u rfmode=0
M$1976 \$1845 \$1791 VSS VSS sg13_lv_nmos L=0.13u W=1.44u AS=0.4068p AD=0.2772p
+ PS=3.29u PD=2.21u rfmode=0
M$1978 \$1845 \$324 \$1846 VSS sg13_lv_nmos L=0.13u W=1.44u AS=0.2772p
+ AD=0.3816p PS=2.21u PD=3.22u rfmode=0
M$1980 VSS VDD \$1927 VSS sg13_lv_nmos L=0.13u W=0.42u AS=0.1701p AD=0.03885p
+ PS=1.65u PD=0.605u rfmode=0
M$1981 \$1927 \$1792 \$1848 VSS sg13_lv_nmos L=0.13u W=0.42u AS=0.03885p
+ AD=0.1596p PS=0.605u PD=1.6u rfmode=0
M$1982 VSS \$1793 \$1956 VSS sg13_lv_nmos L=0.13u W=0.74u AS=0.43315p
+ AD=0.2516p PS=2.205u PD=2.16u rfmode=0
M$1983 VSS CLK \$1793 VSS sg13_lv_nmos L=0.13u W=0.74u AS=0.43315p AD=0.2516p
+ PS=2.205u PD=2.16u rfmode=0
M$1984 \$1850 \$1793 \$1849 VSS sg13_lv_nmos L=0.13u W=0.42u AS=0.12665p
+ AD=0.1428p PS=1.145u PD=1.52u rfmode=0
M$1985 \$1792 \$1956 \$1850 VSS sg13_lv_nmos L=0.13u W=0.74u AS=0.3473p
+ AD=0.12665p PS=2.71u PD=1.145u rfmode=0
M$1986 \$1855 \$1795 VSS VSS sg13_lv_nmos L=0.13u W=1.44u AS=0.4068p AD=0.2772p
+ PS=3.29u PD=2.21u rfmode=0
M$1988 \$1855 \$324 \$1856 VSS sg13_lv_nmos L=0.13u W=1.44u AS=0.2772p
+ AD=0.3816p PS=2.21u PD=3.22u rfmode=0
M$1990 VSS VDD \$1922 VSS sg13_lv_nmos L=0.13u W=0.42u AS=0.1701p AD=0.03885p
+ PS=1.65u PD=0.605u rfmode=0
M$1991 \$1922 \$1796 \$1858 VSS sg13_lv_nmos L=0.13u W=0.42u AS=0.03885p
+ AD=0.1596p PS=0.605u PD=1.6u rfmode=0
M$1992 VSS \$1797 \$1958 VSS sg13_lv_nmos L=0.13u W=0.74u AS=0.43315p
+ AD=0.2516p PS=2.205u PD=2.16u rfmode=0
M$1993 VSS CLK \$1797 VSS sg13_lv_nmos L=0.13u W=0.74u AS=0.43315p AD=0.2516p
+ PS=2.205u PD=2.16u rfmode=0
M$1994 \$1860 \$1797 \$1859 VSS sg13_lv_nmos L=0.13u W=0.42u AS=0.12665p
+ AD=0.1428p PS=1.145u PD=1.52u rfmode=0
M$1995 \$1796 \$1958 \$1860 VSS sg13_lv_nmos L=0.13u W=0.74u AS=0.3473p
+ AD=0.12665p PS=2.71u PD=1.145u rfmode=0
M$1996 \$1865 \$1799 VSS VSS sg13_lv_nmos L=0.13u W=1.44u AS=0.4068p AD=0.2772p
+ PS=3.29u PD=2.21u rfmode=0
M$1998 \$1865 \$324 \$1866 VSS sg13_lv_nmos L=0.13u W=1.44u AS=0.2772p
+ AD=0.3816p PS=2.21u PD=3.22u rfmode=0
M$2000 VSS VDD \$1907 VSS sg13_lv_nmos L=0.13u W=0.42u AS=0.1701p AD=0.03885p
+ PS=1.65u PD=0.605u rfmode=0
M$2001 \$1907 \$1800 \$1867 VSS sg13_lv_nmos L=0.13u W=0.42u AS=0.03885p
+ AD=0.1596p PS=0.605u PD=1.6u rfmode=0
M$2002 VSS \$1801 \$1961 VSS sg13_lv_nmos L=0.13u W=0.74u AS=0.43315p
+ AD=0.2516p PS=2.205u PD=2.16u rfmode=0
M$2003 VSS CLK \$1801 VSS sg13_lv_nmos L=0.13u W=0.74u AS=0.43315p AD=0.2516p
+ PS=2.205u PD=2.16u rfmode=0
M$2004 \$1869 \$1801 \$1868 VSS sg13_lv_nmos L=0.13u W=0.42u AS=0.12665p
+ AD=0.1428p PS=1.145u PD=1.52u rfmode=0
M$2005 \$1800 \$1961 \$1869 VSS sg13_lv_nmos L=0.13u W=0.74u AS=0.3473p
+ AD=0.12665p PS=2.71u PD=1.145u rfmode=0
M$2006 \$1874 \$1803 VSS VSS sg13_lv_nmos L=0.13u W=1.44u AS=0.4068p AD=0.2772p
+ PS=3.29u PD=2.21u rfmode=0
M$2008 \$1874 \$324 \$1875 VSS sg13_lv_nmos L=0.13u W=1.44u AS=0.2772p
+ AD=0.3816p PS=2.21u PD=3.22u rfmode=0
M$2010 VSS VDD \$1893 VSS sg13_lv_nmos L=0.13u W=0.42u AS=0.1701p AD=0.03885p
+ PS=1.65u PD=0.605u rfmode=0
M$2011 \$1893 \$1804 \$1876 VSS sg13_lv_nmos L=0.13u W=0.42u AS=0.03885p
+ AD=0.1596p PS=0.605u PD=1.6u rfmode=0
M$2012 VSS \$1805 \$1964 VSS sg13_lv_nmos L=0.13u W=0.74u AS=0.43315p
+ AD=0.2516p PS=2.205u PD=2.16u rfmode=0
M$2013 VSS CLK \$1805 VSS sg13_lv_nmos L=0.13u W=0.74u AS=0.43315p AD=0.2516p
+ PS=2.205u PD=2.16u rfmode=0
M$2014 \$1878 \$1805 \$1877 VSS sg13_lv_nmos L=0.13u W=0.42u AS=0.12665p
+ AD=0.1428p PS=1.145u PD=1.52u rfmode=0
M$2015 \$1804 \$1964 \$1878 VSS sg13_lv_nmos L=0.13u W=0.74u AS=0.3473p
+ AD=0.12665p PS=2.71u PD=1.145u rfmode=0
M$2016 VSS \$167 \$2062 VSS sg13_lv_nmos L=0.13u W=0.55u AS=0.187p AD=0.1045p
+ PS=1.78u PD=0.93u rfmode=0
M$2017 \$2062 VSS VSS VSS sg13_lv_nmos L=0.13u W=0.55u AS=0.1045p AD=0.146425p
+ PS=0.93u PD=1.155u rfmode=0
M$2018 VSS \$2062 \$2063 VSS sg13_lv_nmos L=0.13u W=1.48u AS=0.312925p
+ AD=0.4477p PS=2.345u PD=3.43u rfmode=0
M$2020 \$2090 \$2063 VSS VSS sg13_lv_nmos L=0.13u W=1.44u AS=0.4068p AD=0.2772p
+ PS=3.29u PD=2.21u rfmode=0
M$2022 \$2090 \$563 \$2091 VSS sg13_lv_nmos L=0.13u W=1.44u AS=0.2772p
+ AD=0.3816p PS=2.21u PD=3.22u rfmode=0
M$2024 \$2092 \$2091 \$2158 VSS sg13_lv_nmos L=0.13u W=0.42u AS=0.1428p
+ AD=0.0609p PS=1.52u PD=0.71u rfmode=0
M$2025 \$2158 VDD VSS VSS sg13_lv_nmos L=0.13u W=0.42u AS=0.0609p AD=0.1626p
+ PS=0.71u PD=1.415u rfmode=0
M$2026 VSS \$2199 \$2064 VSS sg13_lv_nmos L=0.13u W=0.74u AS=0.1626p AD=0.2516p
+ PS=1.415u PD=2.16u rfmode=0
M$2027 \$1808 \$1777 \$1931 VSS sg13_lv_nmos L=0.13u W=0.42u AS=0.1296p
+ AD=0.081p PS=1.52u PD=0.81u rfmode=0
M$2028 \$1931 \$1947 \$1809 VSS sg13_lv_nmos L=0.13u W=0.42u AS=0.081p
+ AD=0.2163p PS=0.81u PD=1.87u rfmode=0
M$2029 \$2094 \$2200 VSS VSS sg13_lv_nmos L=0.13u W=0.42u AS=0.1428p AD=0.0798p
+ PS=1.52u PD=0.8u rfmode=0
M$2030 VSS VDD \$2160 VSS sg13_lv_nmos L=0.13u W=0.42u AS=0.0798p AD=0.0378p
+ PS=0.8u PD=0.6u rfmode=0
M$2031 \$2160 \$2095 \$2200 VSS sg13_lv_nmos L=0.13u W=0.42u AS=0.0378p
+ AD=0.1428p PS=0.6u PD=1.52u rfmode=0
M$2032 VSS \$2095 \$2097 VSS sg13_lv_nmos L=0.13u W=0.64u AS=0.1331p AD=0.2176p
+ PS=1.12u PD=1.96u rfmode=0
M$2033 VSS \$2095 \$2096 VSS sg13_lv_nmos L=0.13u W=1.48u AS=0.3922p AD=0.2737p
+ PS=3.28u PD=2.24u rfmode=0
M$2035 VSS \$2097 \$2098 VSS sg13_lv_nmos L=0.13u W=1.48u AS=0.3922p AD=0.3922p
+ PS=3.28u PD=3.28u rfmode=0
M$2037 VSS VSS \$1948 VSS sg13_lv_nmos L=0.13u W=1u AS=0.265p AD=0.265p
+ PS=2.56u PD=2.56u rfmode=0
M$2038 \$1948 \$1812 OUTP VSS sg13_lv_nmos L=0.13u W=2u AS=0.38p AD=0.38p
+ PS=3.52u PD=3.52u rfmode=0
M$2040 \$1948 \$1814 OUTN VSS sg13_lv_nmos L=0.13u W=2u AS=0.38p AD=0.38p
+ PS=3.52u PD=3.52u rfmode=0
M$2047 VSS \$171 \$2066 VSS sg13_lv_nmos L=0.13u W=0.55u AS=0.187p AD=0.1045p
+ PS=1.78u PD=0.93u rfmode=0
M$2048 \$2066 VSS VSS VSS sg13_lv_nmos L=0.13u W=0.55u AS=0.1045p AD=0.146425p
+ PS=0.93u PD=1.155u rfmode=0
M$2049 VSS \$2066 \$2067 VSS sg13_lv_nmos L=0.13u W=1.48u AS=0.312925p
+ AD=0.4477p PS=2.345u PD=3.43u rfmode=0
M$2051 \$2100 \$2067 VSS VSS sg13_lv_nmos L=0.13u W=1.44u AS=0.4068p AD=0.2772p
+ PS=3.29u PD=2.21u rfmode=0
M$2053 \$2100 \$563 \$2101 VSS sg13_lv_nmos L=0.13u W=1.44u AS=0.2772p
+ AD=0.3816p PS=2.21u PD=3.22u rfmode=0
M$2055 \$2102 \$2101 \$2169 VSS sg13_lv_nmos L=0.13u W=0.42u AS=0.1428p
+ AD=0.0609p PS=1.52u PD=0.71u rfmode=0
M$2056 \$2169 VDD VSS VSS sg13_lv_nmos L=0.13u W=0.42u AS=0.0609p AD=0.1626p
+ PS=0.71u PD=1.415u rfmode=0
M$2057 VSS \$2201 \$2068 VSS sg13_lv_nmos L=0.13u W=0.74u AS=0.1626p AD=0.2516p
+ PS=1.415u PD=2.16u rfmode=0
M$2058 \$1949 \$1781 \$1933 VSS sg13_lv_nmos L=0.13u W=0.42u AS=0.1296p
+ AD=0.081p PS=1.52u PD=0.81u rfmode=0
M$2059 \$1933 \$1950 \$1818 VSS sg13_lv_nmos L=0.13u W=0.42u AS=0.081p
+ AD=0.2163p PS=0.81u PD=1.87u rfmode=0
M$2060 \$2104 \$2202 VSS VSS sg13_lv_nmos L=0.13u W=0.42u AS=0.1428p AD=0.0798p
+ PS=1.52u PD=0.8u rfmode=0
M$2061 VSS VDD \$2172 VSS sg13_lv_nmos L=0.13u W=0.42u AS=0.0798p AD=0.0378p
+ PS=0.8u PD=0.6u rfmode=0
M$2062 \$2172 \$2105 \$2202 VSS sg13_lv_nmos L=0.13u W=0.42u AS=0.0378p
+ AD=0.1428p PS=0.6u PD=1.52u rfmode=0
M$2063 VSS \$2105 \$2107 VSS sg13_lv_nmos L=0.13u W=0.64u AS=0.1331p AD=0.2176p
+ PS=1.12u PD=1.96u rfmode=0
M$2064 VSS \$2105 \$2106 VSS sg13_lv_nmos L=0.13u W=1.48u AS=0.3922p AD=0.2737p
+ PS=3.28u PD=2.24u rfmode=0
M$2066 VSS \$2107 \$2108 VSS sg13_lv_nmos L=0.13u W=1.48u AS=0.3922p AD=0.3922p
+ PS=3.28u PD=3.28u rfmode=0
M$2068 VSS VSS \$1951 VSS sg13_lv_nmos L=0.13u W=1u AS=0.265p AD=0.265p
+ PS=2.56u PD=2.56u rfmode=0
M$2069 \$1951 \$1821 OUTP VSS sg13_lv_nmos L=0.13u W=2u AS=0.38p AD=0.38p
+ PS=3.52u PD=3.52u rfmode=0
M$2071 \$1951 \$1823 OUTN VSS sg13_lv_nmos L=0.13u W=2u AS=0.38p AD=0.38p
+ PS=3.52u PD=3.52u rfmode=0
M$2078 VSS \$174 \$2070 VSS sg13_lv_nmos L=0.13u W=0.55u AS=0.187p AD=0.1045p
+ PS=1.78u PD=0.93u rfmode=0
M$2079 \$2070 VSS VSS VSS sg13_lv_nmos L=0.13u W=0.55u AS=0.1045p AD=0.146425p
+ PS=0.93u PD=1.155u rfmode=0
M$2080 VSS \$2070 \$2071 VSS sg13_lv_nmos L=0.13u W=1.48u AS=0.312925p
+ AD=0.4477p PS=2.345u PD=3.43u rfmode=0
M$2082 \$2110 \$2071 VSS VSS sg13_lv_nmos L=0.13u W=1.44u AS=0.4068p AD=0.2772p
+ PS=3.29u PD=2.21u rfmode=0
M$2084 \$2110 \$563 \$2111 VSS sg13_lv_nmos L=0.13u W=1.44u AS=0.2772p
+ AD=0.3816p PS=2.21u PD=3.22u rfmode=0
M$2086 \$2217 \$2111 \$2179 VSS sg13_lv_nmos L=0.13u W=0.42u AS=0.1428p
+ AD=0.0609p PS=1.52u PD=0.71u rfmode=0
M$2087 \$2179 VDD VSS VSS sg13_lv_nmos L=0.13u W=0.42u AS=0.0609p AD=0.1626p
+ PS=0.71u PD=1.415u rfmode=0
M$2088 VSS \$2203 \$2072 VSS sg13_lv_nmos L=0.13u W=0.74u AS=0.1626p AD=0.2516p
+ PS=1.415u PD=2.16u rfmode=0
M$2089 \$1827 \$1785 \$1935 VSS sg13_lv_nmos L=0.13u W=0.42u AS=0.1296p
+ AD=0.081p PS=1.52u PD=0.81u rfmode=0
M$2090 \$1935 \$1952 \$1828 VSS sg13_lv_nmos L=0.13u W=0.42u AS=0.081p
+ AD=0.2163p PS=0.81u PD=1.87u rfmode=0
M$2091 \$2113 \$2204 VSS VSS sg13_lv_nmos L=0.13u W=0.42u AS=0.1428p AD=0.0798p
+ PS=1.52u PD=0.8u rfmode=0
M$2092 VSS VDD \$2183 VSS sg13_lv_nmos L=0.13u W=0.42u AS=0.0798p AD=0.0378p
+ PS=0.8u PD=0.6u rfmode=0
M$2093 \$2183 \$2114 \$2204 VSS sg13_lv_nmos L=0.13u W=0.42u AS=0.0378p
+ AD=0.1428p PS=0.6u PD=1.52u rfmode=0
M$2094 VSS \$2114 \$2116 VSS sg13_lv_nmos L=0.13u W=0.64u AS=0.1331p AD=0.2176p
+ PS=1.12u PD=1.96u rfmode=0
M$2095 VSS \$2114 \$2115 VSS sg13_lv_nmos L=0.13u W=1.48u AS=0.3922p AD=0.2737p
+ PS=3.28u PD=2.24u rfmode=0
M$2097 VSS \$2116 \$2117 VSS sg13_lv_nmos L=0.13u W=1.48u AS=0.3922p AD=0.3922p
+ PS=3.28u PD=3.28u rfmode=0
M$2099 VSS VSS \$1953 VSS sg13_lv_nmos L=0.13u W=1u AS=0.265p AD=0.265p
+ PS=2.56u PD=2.56u rfmode=0
M$2100 \$1953 \$1831 OUTP VSS sg13_lv_nmos L=0.13u W=2u AS=0.38p AD=0.38p
+ PS=3.52u PD=3.52u rfmode=0
M$2102 \$1953 \$1833 OUTN VSS sg13_lv_nmos L=0.13u W=2u AS=0.38p AD=0.38p
+ PS=3.52u PD=3.52u rfmode=0
M$2109 VSS \$177 \$2074 VSS sg13_lv_nmos L=0.13u W=0.55u AS=0.187p AD=0.1045p
+ PS=1.78u PD=0.93u rfmode=0
M$2110 \$2074 VSS VSS VSS sg13_lv_nmos L=0.13u W=0.55u AS=0.1045p AD=0.146425p
+ PS=0.93u PD=1.155u rfmode=0
M$2111 VSS \$2074 \$2075 VSS sg13_lv_nmos L=0.13u W=1.48u AS=0.312925p
+ AD=0.4477p PS=2.345u PD=3.43u rfmode=0
M$2113 \$2119 \$2075 VSS VSS sg13_lv_nmos L=0.13u W=1.44u AS=0.4068p AD=0.2772p
+ PS=3.29u PD=2.21u rfmode=0
M$2115 \$2119 \$563 \$2120 VSS sg13_lv_nmos L=0.13u W=1.44u AS=0.2772p
+ AD=0.3816p PS=2.21u PD=3.22u rfmode=0
M$2117 \$2121 \$2120 \$2189 VSS sg13_lv_nmos L=0.13u W=0.42u AS=0.1428p
+ AD=0.0609p PS=1.52u PD=0.71u rfmode=0
M$2118 \$2189 VDD VSS VSS sg13_lv_nmos L=0.13u W=0.42u AS=0.0609p AD=0.1626p
+ PS=0.71u PD=1.415u rfmode=0
M$2119 VSS \$2205 \$2076 VSS sg13_lv_nmos L=0.13u W=0.74u AS=0.1626p AD=0.2516p
+ PS=1.415u PD=2.16u rfmode=0
M$2120 \$1837 \$1789 \$1937 VSS sg13_lv_nmos L=0.13u W=0.42u AS=0.1296p
+ AD=0.081p PS=1.52u PD=0.81u rfmode=0
M$2121 \$1937 \$1954 \$1838 VSS sg13_lv_nmos L=0.13u W=0.42u AS=0.081p
+ AD=0.2163p PS=0.81u PD=1.87u rfmode=0
M$2122 \$2123 \$2206 VSS VSS sg13_lv_nmos L=0.13u W=0.42u AS=0.1428p AD=0.0798p
+ PS=1.52u PD=0.8u rfmode=0
M$2123 VSS VDD \$2192 VSS sg13_lv_nmos L=0.13u W=0.42u AS=0.0798p AD=0.0378p
+ PS=0.8u PD=0.6u rfmode=0
M$2124 \$2192 \$2124 \$2206 VSS sg13_lv_nmos L=0.13u W=0.42u AS=0.0378p
+ AD=0.1428p PS=0.6u PD=1.52u rfmode=0
M$2125 VSS \$2124 \$2126 VSS sg13_lv_nmos L=0.13u W=0.64u AS=0.1331p AD=0.2176p
+ PS=1.12u PD=1.96u rfmode=0
M$2126 VSS \$2124 \$2125 VSS sg13_lv_nmos L=0.13u W=1.48u AS=0.3922p AD=0.2737p
+ PS=3.28u PD=2.24u rfmode=0
M$2128 VSS \$2126 \$2127 VSS sg13_lv_nmos L=0.13u W=1.48u AS=0.3922p AD=0.3922p
+ PS=3.28u PD=3.28u rfmode=0
M$2130 VSS VSS \$1955 VSS sg13_lv_nmos L=0.13u W=1u AS=0.265p AD=0.265p
+ PS=2.56u PD=2.56u rfmode=0
M$2131 \$1955 \$1841 OUTP VSS sg13_lv_nmos L=0.13u W=2u AS=0.38p AD=0.38p
+ PS=3.52u PD=3.52u rfmode=0
M$2133 \$1955 \$1843 OUTN VSS sg13_lv_nmos L=0.13u W=2u AS=0.38p AD=0.38p
+ PS=3.52u PD=3.52u rfmode=0
M$2140 VSS \$180 \$2078 VSS sg13_lv_nmos L=0.13u W=0.55u AS=0.187p AD=0.1045p
+ PS=1.78u PD=0.93u rfmode=0
M$2141 \$2078 VSS VSS VSS sg13_lv_nmos L=0.13u W=0.55u AS=0.1045p AD=0.146425p
+ PS=0.93u PD=1.155u rfmode=0
M$2142 VSS \$2078 \$2079 VSS sg13_lv_nmos L=0.13u W=1.48u AS=0.312925p
+ AD=0.4477p PS=2.345u PD=3.43u rfmode=0
M$2144 \$2129 \$2079 VSS VSS sg13_lv_nmos L=0.13u W=1.44u AS=0.4068p AD=0.2772p
+ PS=3.29u PD=2.21u rfmode=0
M$2146 \$2129 \$563 \$2130 VSS sg13_lv_nmos L=0.13u W=1.44u AS=0.2772p
+ AD=0.3816p PS=2.21u PD=3.22u rfmode=0
M$2148 \$2131 \$2130 \$2197 VSS sg13_lv_nmos L=0.13u W=0.42u AS=0.1428p
+ AD=0.0609p PS=1.52u PD=0.71u rfmode=0
M$2149 \$2197 VDD VSS VSS sg13_lv_nmos L=0.13u W=0.42u AS=0.0609p AD=0.1626p
+ PS=0.71u PD=1.415u rfmode=0
M$2150 VSS \$2207 \$2080 VSS sg13_lv_nmos L=0.13u W=0.74u AS=0.1626p AD=0.2516p
+ PS=1.415u PD=2.16u rfmode=0
M$2151 \$1847 \$1793 \$1939 VSS sg13_lv_nmos L=0.13u W=0.42u AS=0.1296p
+ AD=0.081p PS=1.52u PD=0.81u rfmode=0
M$2152 \$1939 \$1956 \$1848 VSS sg13_lv_nmos L=0.13u W=0.42u AS=0.081p
+ AD=0.2163p PS=0.81u PD=1.87u rfmode=0
M$2153 \$2133 \$2208 VSS VSS sg13_lv_nmos L=0.13u W=0.42u AS=0.1428p AD=0.0798p
+ PS=1.52u PD=0.8u rfmode=0
M$2154 VSS VDD \$2193 VSS sg13_lv_nmos L=0.13u W=0.42u AS=0.0798p AD=0.0378p
+ PS=0.8u PD=0.6u rfmode=0
M$2155 \$2193 \$2134 \$2208 VSS sg13_lv_nmos L=0.13u W=0.42u AS=0.0378p
+ AD=0.1428p PS=0.6u PD=1.52u rfmode=0
M$2156 VSS \$2134 \$2136 VSS sg13_lv_nmos L=0.13u W=0.64u AS=0.1331p AD=0.2176p
+ PS=1.12u PD=1.96u rfmode=0
M$2157 VSS \$2134 \$2135 VSS sg13_lv_nmos L=0.13u W=1.48u AS=0.3922p AD=0.2737p
+ PS=3.28u PD=2.24u rfmode=0
M$2159 VSS \$2136 \$2137 VSS sg13_lv_nmos L=0.13u W=1.48u AS=0.3922p AD=0.3922p
+ PS=3.28u PD=3.28u rfmode=0
M$2161 VSS VSS \$1957 VSS sg13_lv_nmos L=0.13u W=1u AS=0.265p AD=0.265p
+ PS=2.56u PD=2.56u rfmode=0
M$2162 \$1957 \$1851 OUTP VSS sg13_lv_nmos L=0.13u W=2u AS=0.38p AD=0.38p
+ PS=3.52u PD=3.52u rfmode=0
M$2164 \$1957 \$1853 OUTN VSS sg13_lv_nmos L=0.13u W=2u AS=0.38p AD=0.38p
+ PS=3.52u PD=3.52u rfmode=0
M$2171 VSS \$183 \$2082 VSS sg13_lv_nmos L=0.13u W=0.55u AS=0.187p AD=0.1045p
+ PS=1.78u PD=0.93u rfmode=0
M$2172 \$2082 VSS VSS VSS sg13_lv_nmos L=0.13u W=0.55u AS=0.1045p AD=0.146425p
+ PS=0.93u PD=1.155u rfmode=0
M$2173 VSS \$2082 \$2083 VSS sg13_lv_nmos L=0.13u W=1.48u AS=0.312925p
+ AD=0.4477p PS=2.345u PD=3.43u rfmode=0
M$2175 \$2139 \$2083 VSS VSS sg13_lv_nmos L=0.13u W=1.44u AS=0.4068p AD=0.2772p
+ PS=3.29u PD=2.21u rfmode=0
M$2177 \$2139 \$563 \$2140 VSS sg13_lv_nmos L=0.13u W=1.44u AS=0.2772p
+ AD=0.3816p PS=2.21u PD=3.22u rfmode=0
M$2179 \$2224 \$2140 \$2182 VSS sg13_lv_nmos L=0.13u W=0.42u AS=0.1428p
+ AD=0.0609p PS=1.52u PD=0.71u rfmode=0
M$2180 \$2182 VDD VSS VSS sg13_lv_nmos L=0.13u W=0.42u AS=0.0609p AD=0.1626p
+ PS=0.71u PD=1.415u rfmode=0
M$2181 VSS \$2209 \$2084 VSS sg13_lv_nmos L=0.13u W=0.74u AS=0.1626p AD=0.2516p
+ PS=1.415u PD=2.16u rfmode=0
M$2182 \$1857 \$1797 \$1941 VSS sg13_lv_nmos L=0.13u W=0.42u AS=0.1296p
+ AD=0.081p PS=1.52u PD=0.81u rfmode=0
M$2183 \$1941 \$1958 \$1858 VSS sg13_lv_nmos L=0.13u W=0.42u AS=0.081p
+ AD=0.2163p PS=0.81u PD=1.87u rfmode=0
M$2184 \$2142 \$2210 VSS VSS sg13_lv_nmos L=0.13u W=0.42u AS=0.1428p AD=0.0798p
+ PS=1.52u PD=0.8u rfmode=0
M$2185 VSS VDD \$2178 VSS sg13_lv_nmos L=0.13u W=0.42u AS=0.0798p AD=0.0378p
+ PS=0.8u PD=0.6u rfmode=0
M$2186 \$2178 \$2143 \$2210 VSS sg13_lv_nmos L=0.13u W=0.42u AS=0.0378p
+ AD=0.1428p PS=0.6u PD=1.52u rfmode=0
M$2187 VSS \$2143 \$2145 VSS sg13_lv_nmos L=0.13u W=0.64u AS=0.1331p AD=0.2176p
+ PS=1.12u PD=1.96u rfmode=0
M$2188 VSS \$2143 \$2144 VSS sg13_lv_nmos L=0.13u W=1.48u AS=0.3922p AD=0.2737p
+ PS=3.28u PD=2.24u rfmode=0
M$2190 VSS \$2145 \$2146 VSS sg13_lv_nmos L=0.13u W=1.48u AS=0.3922p AD=0.3922p
+ PS=3.28u PD=3.28u rfmode=0
M$2192 VSS VSS \$1959 VSS sg13_lv_nmos L=0.13u W=1u AS=0.265p AD=0.265p
+ PS=2.56u PD=2.56u rfmode=0
M$2193 \$1959 \$1861 OUTP VSS sg13_lv_nmos L=0.13u W=2u AS=0.38p AD=0.38p
+ PS=3.52u PD=3.52u rfmode=0
M$2195 \$1959 \$1863 OUTN VSS sg13_lv_nmos L=0.13u W=2u AS=0.38p AD=0.38p
+ PS=3.52u PD=3.52u rfmode=0
M$2202 VSS \$186 \$2086 VSS sg13_lv_nmos L=0.13u W=0.55u AS=0.187p AD=0.1045p
+ PS=1.78u PD=0.93u rfmode=0
M$2203 \$2086 VSS VSS VSS sg13_lv_nmos L=0.13u W=0.55u AS=0.1045p AD=0.146425p
+ PS=0.93u PD=1.155u rfmode=0
M$2204 VSS \$2086 \$2087 VSS sg13_lv_nmos L=0.13u W=1.48u AS=0.312925p
+ AD=0.4477p PS=2.345u PD=3.43u rfmode=0
M$2206 \$2148 \$2087 VSS VSS sg13_lv_nmos L=0.13u W=1.44u AS=0.4068p AD=0.2772p
+ PS=3.29u PD=2.21u rfmode=0
M$2208 \$2148 \$563 \$2149 VSS sg13_lv_nmos L=0.13u W=1.44u AS=0.2772p
+ AD=0.3816p PS=2.21u PD=3.22u rfmode=0
M$2210 \$2227 \$2149 \$2168 VSS sg13_lv_nmos L=0.13u W=0.42u AS=0.1428p
+ AD=0.0609p PS=1.52u PD=0.71u rfmode=0
M$2211 \$2168 VDD VSS VSS sg13_lv_nmos L=0.13u W=0.42u AS=0.0609p AD=0.1626p
+ PS=0.71u PD=1.415u rfmode=0
M$2212 VSS \$2211 \$2088 VSS sg13_lv_nmos L=0.13u W=0.74u AS=0.1626p AD=0.2516p
+ PS=1.415u PD=2.16u rfmode=0
M$2213 \$1960 \$1801 \$1943 VSS sg13_lv_nmos L=0.13u W=0.42u AS=0.1296p
+ AD=0.081p PS=1.52u PD=0.81u rfmode=0
M$2214 \$1943 \$1961 \$1867 VSS sg13_lv_nmos L=0.13u W=0.42u AS=0.081p
+ AD=0.2163p PS=0.81u PD=1.87u rfmode=0
M$2215 \$2151 \$2212 VSS VSS sg13_lv_nmos L=0.13u W=0.42u AS=0.1428p AD=0.0798p
+ PS=1.52u PD=0.8u rfmode=0
M$2216 VSS VDD \$2165 VSS sg13_lv_nmos L=0.13u W=0.42u AS=0.0798p AD=0.0378p
+ PS=0.8u PD=0.6u rfmode=0
M$2217 \$2165 \$2152 \$2212 VSS sg13_lv_nmos L=0.13u W=0.42u AS=0.0378p
+ AD=0.1428p PS=0.6u PD=1.52u rfmode=0
M$2218 VSS \$2152 \$2154 VSS sg13_lv_nmos L=0.13u W=0.64u AS=0.1331p AD=0.2176p
+ PS=1.12u PD=1.96u rfmode=0
M$2219 VSS \$2152 \$2153 VSS sg13_lv_nmos L=0.13u W=1.48u AS=0.3922p AD=0.2737p
+ PS=3.28u PD=2.24u rfmode=0
M$2221 VSS \$2154 \$2155 VSS sg13_lv_nmos L=0.13u W=1.48u AS=0.3922p AD=0.3922p
+ PS=3.28u PD=3.28u rfmode=0
M$2223 VSS VSS \$1962 VSS sg13_lv_nmos L=0.13u W=1u AS=0.265p AD=0.265p
+ PS=2.56u PD=2.56u rfmode=0
M$2224 \$1962 \$1870 OUTP VSS sg13_lv_nmos L=0.13u W=2u AS=0.38p AD=0.38p
+ PS=3.52u PD=3.52u rfmode=0
M$2226 \$1962 \$1872 OUTN VSS sg13_lv_nmos L=0.13u W=2u AS=0.38p AD=0.38p
+ PS=3.52u PD=3.52u rfmode=0
M$2233 \$1963 \$1805 \$1945 VSS sg13_lv_nmos L=0.13u W=0.42u AS=0.1296p
+ AD=0.081p PS=1.52u PD=0.81u rfmode=0
M$2234 \$1945 \$1964 \$1876 VSS sg13_lv_nmos L=0.13u W=0.42u AS=0.081p
+ AD=0.2163p PS=0.81u PD=1.87u rfmode=0
M$2235 VSS VSS \$1965 VSS sg13_lv_nmos L=0.13u W=1u AS=0.265p AD=0.265p
+ PS=2.56u PD=2.56u rfmode=0
M$2236 \$1965 \$1879 OUTP VSS sg13_lv_nmos L=0.13u W=2u AS=0.38p AD=0.38p
+ PS=3.52u PD=3.52u rfmode=0
M$2238 \$1965 \$1881 OUTN VSS sg13_lv_nmos L=0.13u W=2u AS=0.38p AD=0.38p
+ PS=3.52u PD=3.52u rfmode=0
M$2245 VSS VDD \$2159 VSS sg13_lv_nmos L=0.13u W=0.42u AS=0.1701p AD=0.03885p
+ PS=1.65u PD=0.605u rfmode=0
M$2246 \$2159 \$2064 \$2093 VSS sg13_lv_nmos L=0.13u W=0.42u AS=0.03885p
+ AD=0.1596p PS=0.605u PD=1.6u rfmode=0
M$2247 \$2092 \$2065 \$2199 VSS sg13_lv_nmos L=0.13u W=0.42u AS=0.1296p
+ AD=0.081p PS=1.52u PD=0.81u rfmode=0
M$2248 \$2199 \$2213 \$2093 VSS sg13_lv_nmos L=0.13u W=0.42u AS=0.081p
+ AD=0.2163p PS=0.81u PD=1.87u rfmode=0
M$2249 VSS \$2065 \$2213 VSS sg13_lv_nmos L=0.13u W=0.74u AS=0.43315p
+ AD=0.2516p PS=2.205u PD=2.16u rfmode=0
M$2250 VSS CLK \$2065 VSS sg13_lv_nmos L=0.13u W=0.74u AS=0.43315p AD=0.2516p
+ PS=2.205u PD=2.16u rfmode=0
M$2251 \$2095 \$2065 \$2094 VSS sg13_lv_nmos L=0.13u W=0.42u AS=0.12665p
+ AD=0.1428p PS=1.145u PD=1.52u rfmode=0
M$2252 \$2064 \$2213 \$2095 VSS sg13_lv_nmos L=0.13u W=0.74u AS=0.3473p
+ AD=0.12665p PS=2.71u PD=1.145u rfmode=0
M$2253 VSS VSS \$2214 VSS sg13_lv_nmos L=0.13u W=1u AS=0.265p AD=0.265p
+ PS=2.56u PD=2.56u rfmode=0
M$2254 \$2214 \$2096 OUTP VSS sg13_lv_nmos L=0.13u W=2u AS=0.38p AD=0.38p
+ PS=3.52u PD=3.52u rfmode=0
M$2256 \$2214 \$2098 OUTN VSS sg13_lv_nmos L=0.13u W=2u AS=0.38p AD=0.38p
+ PS=3.52u PD=3.52u rfmode=0
M$2263 VSS VDD \$2170 VSS sg13_lv_nmos L=0.13u W=0.42u AS=0.1701p AD=0.03885p
+ PS=1.65u PD=0.605u rfmode=0
M$2264 \$2170 \$2068 \$2103 VSS sg13_lv_nmos L=0.13u W=0.42u AS=0.03885p
+ AD=0.1596p PS=0.605u PD=1.6u rfmode=0
M$2265 \$2102 \$2069 \$2201 VSS sg13_lv_nmos L=0.13u W=0.42u AS=0.1296p
+ AD=0.081p PS=1.52u PD=0.81u rfmode=0
M$2266 \$2201 \$2215 \$2103 VSS sg13_lv_nmos L=0.13u W=0.42u AS=0.081p
+ AD=0.2163p PS=0.81u PD=1.87u rfmode=0
M$2267 VSS \$2069 \$2215 VSS sg13_lv_nmos L=0.13u W=0.74u AS=0.43315p
+ AD=0.2516p PS=2.205u PD=2.16u rfmode=0
M$2268 VSS CLK \$2069 VSS sg13_lv_nmos L=0.13u W=0.74u AS=0.43315p AD=0.2516p
+ PS=2.205u PD=2.16u rfmode=0
M$2269 \$2105 \$2069 \$2104 VSS sg13_lv_nmos L=0.13u W=0.42u AS=0.12665p
+ AD=0.1428p PS=1.145u PD=1.52u rfmode=0
M$2270 \$2068 \$2215 \$2105 VSS sg13_lv_nmos L=0.13u W=0.74u AS=0.3473p
+ AD=0.12665p PS=2.71u PD=1.145u rfmode=0
M$2271 VSS VSS \$2216 VSS sg13_lv_nmos L=0.13u W=1u AS=0.265p AD=0.265p
+ PS=2.56u PD=2.56u rfmode=0
M$2272 \$2216 \$2106 OUTP VSS sg13_lv_nmos L=0.13u W=2u AS=0.38p AD=0.38p
+ PS=3.52u PD=3.52u rfmode=0
M$2274 \$2216 \$2108 OUTN VSS sg13_lv_nmos L=0.13u W=2u AS=0.38p AD=0.38p
+ PS=3.52u PD=3.52u rfmode=0
M$2281 VSS VDD \$2180 VSS sg13_lv_nmos L=0.13u W=0.42u AS=0.1701p AD=0.03885p
+ PS=1.65u PD=0.605u rfmode=0
M$2282 \$2180 \$2072 \$2112 VSS sg13_lv_nmos L=0.13u W=0.42u AS=0.03885p
+ AD=0.1596p PS=0.605u PD=1.6u rfmode=0
M$2283 \$2217 \$2073 \$2203 VSS sg13_lv_nmos L=0.13u W=0.42u AS=0.1296p
+ AD=0.081p PS=1.52u PD=0.81u rfmode=0
M$2284 \$2203 \$2218 \$2112 VSS sg13_lv_nmos L=0.13u W=0.42u AS=0.081p
+ AD=0.2163p PS=0.81u PD=1.87u rfmode=0
M$2285 VSS \$2073 \$2218 VSS sg13_lv_nmos L=0.13u W=0.74u AS=0.43315p
+ AD=0.2516p PS=2.205u PD=2.16u rfmode=0
M$2286 VSS CLK \$2073 VSS sg13_lv_nmos L=0.13u W=0.74u AS=0.43315p AD=0.2516p
+ PS=2.205u PD=2.16u rfmode=0
M$2287 \$2114 \$2073 \$2113 VSS sg13_lv_nmos L=0.13u W=0.42u AS=0.12665p
+ AD=0.1428p PS=1.145u PD=1.52u rfmode=0
M$2288 \$2072 \$2218 \$2114 VSS sg13_lv_nmos L=0.13u W=0.74u AS=0.3473p
+ AD=0.12665p PS=2.71u PD=1.145u rfmode=0
M$2289 VSS VSS \$2219 VSS sg13_lv_nmos L=0.13u W=1u AS=0.265p AD=0.265p
+ PS=2.56u PD=2.56u rfmode=0
M$2290 \$2219 \$2115 OUTP VSS sg13_lv_nmos L=0.13u W=2u AS=0.38p AD=0.38p
+ PS=3.52u PD=3.52u rfmode=0
M$2292 \$2219 \$2117 OUTN VSS sg13_lv_nmos L=0.13u W=2u AS=0.38p AD=0.38p
+ PS=3.52u PD=3.52u rfmode=0
M$2299 VSS VDD \$2191 VSS sg13_lv_nmos L=0.13u W=0.42u AS=0.1701p AD=0.03885p
+ PS=1.65u PD=0.605u rfmode=0
M$2300 \$2191 \$2076 \$2122 VSS sg13_lv_nmos L=0.13u W=0.42u AS=0.03885p
+ AD=0.1596p PS=0.605u PD=1.6u rfmode=0
M$2301 \$2121 \$2077 \$2205 VSS sg13_lv_nmos L=0.13u W=0.42u AS=0.1296p
+ AD=0.081p PS=1.52u PD=0.81u rfmode=0
M$2302 \$2205 \$2220 \$2122 VSS sg13_lv_nmos L=0.13u W=0.42u AS=0.081p
+ AD=0.2163p PS=0.81u PD=1.87u rfmode=0
M$2303 VSS \$2077 \$2220 VSS sg13_lv_nmos L=0.13u W=0.74u AS=0.43315p
+ AD=0.2516p PS=2.205u PD=2.16u rfmode=0
M$2304 VSS CLK \$2077 VSS sg13_lv_nmos L=0.13u W=0.74u AS=0.43315p AD=0.2516p
+ PS=2.205u PD=2.16u rfmode=0
M$2305 \$2124 \$2077 \$2123 VSS sg13_lv_nmos L=0.13u W=0.42u AS=0.12665p
+ AD=0.1428p PS=1.145u PD=1.52u rfmode=0
M$2306 \$2076 \$2220 \$2124 VSS sg13_lv_nmos L=0.13u W=0.74u AS=0.3473p
+ AD=0.12665p PS=2.71u PD=1.145u rfmode=0
M$2307 VSS VSS \$2221 VSS sg13_lv_nmos L=0.13u W=1u AS=0.265p AD=0.265p
+ PS=2.56u PD=2.56u rfmode=0
M$2308 \$2221 \$2125 OUTP VSS sg13_lv_nmos L=0.13u W=2u AS=0.38p AD=0.38p
+ PS=3.52u PD=3.52u rfmode=0
M$2310 \$2221 \$2127 OUTN VSS sg13_lv_nmos L=0.13u W=2u AS=0.38p AD=0.38p
+ PS=3.52u PD=3.52u rfmode=0
M$2317 VSS VDD \$2196 VSS sg13_lv_nmos L=0.13u W=0.42u AS=0.1701p AD=0.03885p
+ PS=1.65u PD=0.605u rfmode=0
M$2318 \$2196 \$2080 \$2132 VSS sg13_lv_nmos L=0.13u W=0.42u AS=0.03885p
+ AD=0.1596p PS=0.605u PD=1.6u rfmode=0
M$2319 \$2131 \$2081 \$2207 VSS sg13_lv_nmos L=0.13u W=0.42u AS=0.1296p
+ AD=0.081p PS=1.52u PD=0.81u rfmode=0
M$2320 \$2207 \$2222 \$2132 VSS sg13_lv_nmos L=0.13u W=0.42u AS=0.081p
+ AD=0.2163p PS=0.81u PD=1.87u rfmode=0
M$2321 VSS \$2081 \$2222 VSS sg13_lv_nmos L=0.13u W=0.74u AS=0.43315p
+ AD=0.2516p PS=2.205u PD=2.16u rfmode=0
M$2322 VSS CLK \$2081 VSS sg13_lv_nmos L=0.13u W=0.74u AS=0.43315p AD=0.2516p
+ PS=2.205u PD=2.16u rfmode=0
M$2323 \$2134 \$2081 \$2133 VSS sg13_lv_nmos L=0.13u W=0.42u AS=0.12665p
+ AD=0.1428p PS=1.145u PD=1.52u rfmode=0
M$2324 \$2080 \$2222 \$2134 VSS sg13_lv_nmos L=0.13u W=0.74u AS=0.3473p
+ AD=0.12665p PS=2.71u PD=1.145u rfmode=0
M$2325 VSS VSS \$2223 VSS sg13_lv_nmos L=0.13u W=1u AS=0.265p AD=0.265p
+ PS=2.56u PD=2.56u rfmode=0
M$2326 \$2223 \$2135 OUTP VSS sg13_lv_nmos L=0.13u W=2u AS=0.38p AD=0.38p
+ PS=3.52u PD=3.52u rfmode=0
M$2328 \$2223 \$2137 OUTN VSS sg13_lv_nmos L=0.13u W=2u AS=0.38p AD=0.38p
+ PS=3.52u PD=3.52u rfmode=0
M$2335 VSS VDD \$2181 VSS sg13_lv_nmos L=0.13u W=0.42u AS=0.1701p AD=0.03885p
+ PS=1.65u PD=0.605u rfmode=0
M$2336 \$2181 \$2084 \$2141 VSS sg13_lv_nmos L=0.13u W=0.42u AS=0.03885p
+ AD=0.1596p PS=0.605u PD=1.6u rfmode=0
M$2337 \$2224 \$2085 \$2209 VSS sg13_lv_nmos L=0.13u W=0.42u AS=0.1296p
+ AD=0.081p PS=1.52u PD=0.81u rfmode=0
M$2338 \$2209 \$2225 \$2141 VSS sg13_lv_nmos L=0.13u W=0.42u AS=0.081p
+ AD=0.2163p PS=0.81u PD=1.87u rfmode=0
M$2339 VSS \$2085 \$2225 VSS sg13_lv_nmos L=0.13u W=0.74u AS=0.43315p
+ AD=0.2516p PS=2.205u PD=2.16u rfmode=0
M$2340 VSS CLK \$2085 VSS sg13_lv_nmos L=0.13u W=0.74u AS=0.43315p AD=0.2516p
+ PS=2.205u PD=2.16u rfmode=0
M$2341 \$2143 \$2085 \$2142 VSS sg13_lv_nmos L=0.13u W=0.42u AS=0.12665p
+ AD=0.1428p PS=1.145u PD=1.52u rfmode=0
M$2342 \$2084 \$2225 \$2143 VSS sg13_lv_nmos L=0.13u W=0.74u AS=0.3473p
+ AD=0.12665p PS=2.71u PD=1.145u rfmode=0
M$2343 VSS VSS \$2226 VSS sg13_lv_nmos L=0.13u W=1u AS=0.265p AD=0.265p
+ PS=2.56u PD=2.56u rfmode=0
M$2344 \$2226 \$2144 OUTP VSS sg13_lv_nmos L=0.13u W=2u AS=0.38p AD=0.38p
+ PS=3.52u PD=3.52u rfmode=0
M$2346 \$2226 \$2146 OUTN VSS sg13_lv_nmos L=0.13u W=2u AS=0.38p AD=0.38p
+ PS=3.52u PD=3.52u rfmode=0
M$2353 VSS VDD \$2167 VSS sg13_lv_nmos L=0.13u W=0.42u AS=0.1701p AD=0.03885p
+ PS=1.65u PD=0.605u rfmode=0
M$2354 \$2167 \$2088 \$2150 VSS sg13_lv_nmos L=0.13u W=0.42u AS=0.03885p
+ AD=0.1596p PS=0.605u PD=1.6u rfmode=0
M$2355 \$2227 \$2089 \$2211 VSS sg13_lv_nmos L=0.13u W=0.42u AS=0.1296p
+ AD=0.081p PS=1.52u PD=0.81u rfmode=0
M$2356 \$2211 \$2228 \$2150 VSS sg13_lv_nmos L=0.13u W=0.42u AS=0.081p
+ AD=0.2163p PS=0.81u PD=1.87u rfmode=0
M$2357 VSS \$2089 \$2228 VSS sg13_lv_nmos L=0.13u W=0.74u AS=0.43315p
+ AD=0.2516p PS=2.205u PD=2.16u rfmode=0
M$2358 VSS CLK \$2089 VSS sg13_lv_nmos L=0.13u W=0.74u AS=0.43315p AD=0.2516p
+ PS=2.205u PD=2.16u rfmode=0
M$2359 \$2152 \$2089 \$2151 VSS sg13_lv_nmos L=0.13u W=0.42u AS=0.12665p
+ AD=0.1428p PS=1.145u PD=1.52u rfmode=0
M$2360 \$2088 \$2228 \$2152 VSS sg13_lv_nmos L=0.13u W=0.74u AS=0.3473p
+ AD=0.12665p PS=2.71u PD=1.145u rfmode=0
M$2361 VSS VSS \$2229 VSS sg13_lv_nmos L=0.13u W=1u AS=0.265p AD=0.265p
+ PS=2.56u PD=2.56u rfmode=0
M$2362 \$2229 \$2153 OUTP VSS sg13_lv_nmos L=0.13u W=2u AS=0.38p AD=0.38p
+ PS=3.52u PD=3.52u rfmode=0
M$2364 \$2229 \$2155 OUTN VSS sg13_lv_nmos L=0.13u W=2u AS=0.38p AD=0.38p
+ PS=3.52u PD=3.52u rfmode=0
M$2371 VSS \$2348 \$174 VSS sg13_lv_nmos L=0.13u W=1.48u AS=0.4477p
+ AD=0.312925p PS=3.43u PD=2.345u rfmode=0
M$2373 VSS \$2364 \$2348 VSS sg13_lv_nmos L=0.13u W=0.55u AS=0.146425p
+ AD=0.1045p PS=1.155u PD=0.93u rfmode=0
M$2374 \$2348 X7 VSS VSS sg13_lv_nmos L=0.13u W=0.55u AS=0.1045p AD=0.187p
+ PS=0.93u PD=1.78u rfmode=0
M$2375 VSS \$2349 \$180 VSS sg13_lv_nmos L=0.13u W=1.48u AS=0.4218p AD=0.2737p
+ PS=3.36u PD=2.24u rfmode=0
M$2377 VSS \$2365 \$2376 VSS sg13_lv_nmos L=0.13u W=0.64u AS=0.1331p AD=0.1216p
+ PS=1.12u PD=1.02u rfmode=0
M$2378 \$2376 X7 \$2349 VSS sg13_lv_nmos L=0.13u W=0.64u AS=0.1216p AD=0.2176p
+ PS=1.02u PD=1.96u rfmode=0
M$2379 VSS \$2350 \$167 VSS sg13_lv_nmos L=0.13u W=1.48u AS=0.4477p
+ AD=0.312925p PS=3.43u PD=2.345u rfmode=0
M$2381 VSS \$171 \$2350 VSS sg13_lv_nmos L=0.13u W=0.55u AS=0.146425p
+ AD=0.1045p PS=1.155u PD=0.93u rfmode=0
M$2382 \$2350 X5 VSS VSS sg13_lv_nmos L=0.13u W=0.55u AS=0.1045p AD=0.187p
+ PS=0.93u PD=1.78u rfmode=0
M$2383 VSS \$2351 \$186 VSS sg13_lv_nmos L=0.13u W=1.48u AS=0.4218p AD=0.2737p
+ PS=3.36u PD=2.24u rfmode=0
M$2385 VSS \$2366 \$2379 VSS sg13_lv_nmos L=0.13u W=0.64u AS=0.1331p AD=0.1216p
+ PS=1.12u PD=1.02u rfmode=0
M$2386 \$2379 X7 \$2351 VSS sg13_lv_nmos L=0.13u W=0.64u AS=0.1216p AD=0.2176p
+ PS=1.02u PD=1.96u rfmode=0
M$2387 VSS \$2325 \$2324 VSS sg13_lv_nmos L=0.13u W=0.74u AS=0.1626p AD=0.2516p
+ PS=1.415u PD=2.16u rfmode=0
M$2388 \$2323 X4 \$2343 VSS sg13_lv_nmos L=0.13u W=0.42u AS=0.1428p AD=0.0609p
+ PS=1.52u PD=0.71u rfmode=0
M$2389 VSS VDD \$2343 VSS sg13_lv_nmos L=0.13u W=0.42u AS=0.1626p AD=0.0609p
+ PS=1.415u PD=0.71u rfmode=0
M$2390 \$2352 X3 \$2363 VSS sg13_lv_nmos L=0.13u W=0.42u AS=0.1428p AD=0.0609p
+ PS=1.52u PD=0.71u rfmode=0
M$2391 \$2363 VDD VSS VSS sg13_lv_nmos L=0.13u W=0.42u AS=0.0609p AD=0.1626p
+ PS=0.71u PD=1.415u rfmode=0
M$2392 VSS \$2370 \$2346 VSS sg13_lv_nmos L=0.13u W=0.74u AS=0.1626p AD=0.2516p
+ PS=1.415u PD=2.16u rfmode=0
M$2393 VSS VDD \$2369 VSS sg13_lv_nmos L=0.13u W=0.42u AS=0.1701p AD=0.03885p
+ PS=1.65u PD=0.605u rfmode=0
M$2394 \$2369 \$2346 \$2353 VSS sg13_lv_nmos L=0.13u W=0.42u AS=0.03885p
+ AD=0.1596p PS=0.605u PD=1.6u rfmode=0
M$2395 VSS VDD \$2344 VSS sg13_lv_nmos L=0.13u W=0.42u AS=0.1701p AD=0.03885p
+ PS=1.65u PD=0.605u rfmode=0
M$2396 \$2344 \$2324 \$2336 VSS sg13_lv_nmos L=0.13u W=0.42u AS=0.03885p
+ AD=0.1596p PS=0.605u PD=1.6u rfmode=0
M$2397 \$2325 \$2327 \$2323 VSS sg13_lv_nmos L=0.13u W=0.42u AS=0.081p
+ AD=0.1296p PS=0.81u PD=1.52u rfmode=0
M$2398 \$2325 \$2326 \$2336 VSS sg13_lv_nmos L=0.13u W=0.42u AS=0.081p
+ AD=0.2163p PS=0.81u PD=1.87u rfmode=0
M$2399 \$2326 \$2327 VSS VSS sg13_lv_nmos L=0.13u W=0.74u AS=0.2516p
+ AD=0.43315p PS=2.16u PD=2.205u rfmode=0
M$2400 VSS CLK \$2327 VSS sg13_lv_nmos L=0.13u W=0.74u AS=0.43315p AD=0.2516p
+ PS=2.205u PD=2.16u rfmode=0
M$2401 VSS \$2347 \$2371 VSS sg13_lv_nmos L=0.13u W=0.74u AS=0.43315p
+ AD=0.2516p PS=2.205u PD=2.16u rfmode=0
M$2402 VSS CLK \$2347 VSS sg13_lv_nmos L=0.13u W=0.74u AS=0.43315p AD=0.2516p
+ PS=2.205u PD=2.16u rfmode=0
M$2403 \$2368 \$2347 \$2354 VSS sg13_lv_nmos L=0.13u W=0.42u AS=0.12665p
+ AD=0.1428p PS=1.145u PD=1.52u rfmode=0
M$2404 \$2346 \$2371 \$2368 VSS sg13_lv_nmos L=0.13u W=0.74u AS=0.3473p
+ AD=0.12665p PS=2.71u PD=1.145u rfmode=0
M$2405 \$2337 \$2327 \$2338 VSS sg13_lv_nmos L=0.13u W=0.42u AS=0.1428p
+ AD=0.12665p PS=1.52u PD=1.145u rfmode=0
M$2406 \$2338 \$2326 \$2324 VSS sg13_lv_nmos L=0.13u W=0.74u AS=0.12665p
+ AD=0.3473p PS=1.145u PD=2.71u rfmode=0
M$2407 \$2354 \$2372 VSS VSS sg13_lv_nmos L=0.13u W=0.42u AS=0.1428p AD=0.0798p
+ PS=1.52u PD=0.8u rfmode=0
M$2408 VSS VDD \$2362 VSS sg13_lv_nmos L=0.13u W=0.42u AS=0.0798p AD=0.0378p
+ PS=0.8u PD=0.6u rfmode=0
M$2409 \$2362 \$2368 \$2372 VSS sg13_lv_nmos L=0.13u W=0.42u AS=0.0378p
+ AD=0.1428p PS=0.6u PD=1.52u rfmode=0
M$2410 \$2337 \$2328 VSS VSS sg13_lv_nmos L=0.13u W=0.42u AS=0.1428p AD=0.0798p
+ PS=1.52u PD=0.8u rfmode=0
M$2411 VSS VDD \$2345 VSS sg13_lv_nmos L=0.13u W=0.42u AS=0.0798p AD=0.0378p
+ PS=0.8u PD=0.6u rfmode=0
M$2412 \$2345 \$2338 \$2328 VSS sg13_lv_nmos L=0.13u W=0.42u AS=0.0378p
+ AD=0.1428p PS=0.6u PD=1.52u rfmode=0
M$2413 VSS \$2368 \$2356 VSS sg13_lv_nmos L=0.13u W=0.64u AS=0.1331p AD=0.2176p
+ PS=1.12u PD=1.96u rfmode=0
M$2414 VSS \$2368 \$2355 VSS sg13_lv_nmos L=0.13u W=1.48u AS=0.3922p AD=0.2737p
+ PS=3.28u PD=2.24u rfmode=0
M$2416 VSS \$2338 \$2314 VSS sg13_lv_nmos L=0.13u W=1.48u AS=0.3922p AD=0.2737p
+ PS=3.28u PD=2.24u rfmode=0
M$2418 VSS \$2338 \$2329 VSS sg13_lv_nmos L=0.13u W=0.64u AS=0.1331p AD=0.2176p
+ PS=1.12u PD=1.96u rfmode=0
M$2419 VSS \$2329 \$2316 VSS sg13_lv_nmos L=0.13u W=1.48u AS=0.3922p AD=0.3922p
+ PS=3.28u PD=3.28u rfmode=0
M$2421 VSS \$2356 \$2357 VSS sg13_lv_nmos L=0.13u W=1.48u AS=0.3922p AD=0.3922p
+ PS=3.28u PD=3.28u rfmode=0
M$2423 VSS VSS \$2315 VSS sg13_lv_nmos L=0.13u W=1u AS=0.265p AD=0.265p
+ PS=2.56u PD=2.56u rfmode=0
M$2424 \$2315 \$2314 OUTN VSS sg13_lv_nmos L=0.13u W=2u AS=0.38p AD=0.38p
+ PS=3.52u PD=3.52u rfmode=0
M$2426 \$2315 \$2316 OUTP VSS sg13_lv_nmos L=0.13u W=2u AS=0.38p AD=0.38p
+ PS=3.52u PD=3.52u rfmode=0
M$2433 VSS \$2384 \$2364 VSS sg13_lv_nmos L=0.13u W=1.48u AS=0.4218p AD=0.2737p
+ PS=3.36u PD=2.24u rfmode=0
M$2435 VSS X6 \$2393 VSS sg13_lv_nmos L=0.13u W=0.64u AS=0.1331p AD=0.1216p
+ PS=1.12u PD=1.02u rfmode=0
M$2436 \$2393 X5 \$2384 VSS sg13_lv_nmos L=0.13u W=0.64u AS=0.1216p AD=0.2176p
+ PS=1.02u PD=1.96u rfmode=0
M$2437 VSS \$2388 \$2365 VSS sg13_lv_nmos L=0.13u W=1.48u AS=0.4477p
+ AD=0.312925p PS=3.43u PD=2.345u rfmode=0
M$2439 VSS X5 \$2388 VSS sg13_lv_nmos L=0.13u W=0.55u AS=0.146425p AD=0.1045p
+ PS=1.155u PD=0.93u rfmode=0
M$2440 \$2388 X6 VSS VSS sg13_lv_nmos L=0.13u W=0.55u AS=0.1045p AD=0.187p
+ PS=0.93u PD=1.78u rfmode=0
M$2441 VSS \$2389 \$171 VSS sg13_lv_nmos L=0.13u W=1.48u AS=0.4477p
+ AD=0.312925p PS=3.43u PD=2.345u rfmode=0
M$2443 VSS X7 \$2389 VSS sg13_lv_nmos L=0.13u W=0.55u AS=0.146425p AD=0.1045p
+ PS=1.155u PD=0.93u rfmode=0
M$2444 \$2389 X6 VSS VSS sg13_lv_nmos L=0.13u W=0.55u AS=0.1045p AD=0.187p
+ PS=0.93u PD=1.78u rfmode=0
M$2445 VSS \$2390 \$183 VSS sg13_lv_nmos L=0.13u W=1.48u AS=0.4218p AD=0.2737p
+ PS=3.36u PD=2.24u rfmode=0
M$2447 VSS X7 \$2400 VSS sg13_lv_nmos L=0.13u W=0.64u AS=0.1331p AD=0.1216p
+ PS=1.12u PD=1.02u rfmode=0
M$2448 \$2400 X6 \$2390 VSS sg13_lv_nmos L=0.13u W=0.64u AS=0.1216p AD=0.2176p
+ PS=1.02u PD=1.96u rfmode=0
M$2449 VSS \$2385 \$2366 VSS sg13_lv_nmos L=0.13u W=1.48u AS=0.4218p AD=0.2737p
+ PS=3.36u PD=2.24u rfmode=0
M$2451 VSS X6 \$2401 VSS sg13_lv_nmos L=0.13u W=0.64u AS=0.1331p AD=0.1216p
+ PS=1.12u PD=1.02u rfmode=0
M$2452 \$2401 X5 \$2385 VSS sg13_lv_nmos L=0.13u W=0.64u AS=0.1216p AD=0.2176p
+ PS=1.02u PD=1.96u rfmode=0
M$2453 \$2352 \$2347 \$2370 VSS sg13_lv_nmos L=0.13u W=0.42u AS=0.1296p
+ AD=0.081p PS=1.52u PD=0.81u rfmode=0
M$2454 \$2370 \$2371 \$2353 VSS sg13_lv_nmos L=0.13u W=0.42u AS=0.081p
+ AD=0.2163p PS=0.81u PD=1.87u rfmode=0
M$2455 VSS \$2381 \$177 VSS sg13_lv_nmos L=0.13u W=1.48u AS=0.3922p AD=0.2777p
+ PS=3.28u PD=2.24u rfmode=0
M$2457 VSS X7 \$2381 VSS sg13_lv_nmos L=0.13u W=0.64u AS=0.1371p AD=0.2176p
+ PS=1.12u PD=1.96u rfmode=0
M$2458 VSS VSS \$2373 VSS sg13_lv_nmos L=0.13u W=1u AS=0.265p AD=0.265p
+ PS=2.56u PD=2.56u rfmode=0
M$2459 \$2373 \$2355 OUTN VSS sg13_lv_nmos L=0.13u W=2u AS=0.38p AD=0.38p
+ PS=3.52u PD=3.52u rfmode=0
M$2461 \$2373 \$2357 OUTP VSS sg13_lv_nmos L=0.13u W=2u AS=0.38p AD=0.38p
+ PS=3.52u PD=3.52u rfmode=0
M$2468 VSS VSS \$2404 VSS sg13_lv_nmos L=0.13u W=1u AS=0.265p AD=0.265p
+ PS=2.56u PD=2.56u rfmode=0
M$2469 \$2404 \$2403 OUTN VSS sg13_lv_nmos L=0.13u W=2u AS=0.38p AD=0.38p
+ PS=3.52u PD=3.52u rfmode=0
M$2471 \$2404 \$2411 OUTP VSS sg13_lv_nmos L=0.13u W=2u AS=0.38p AD=0.38p
+ PS=3.52u PD=3.52u rfmode=0
M$2478 \$2414 \$2421 \$2412 VSS sg13_lv_nmos L=0.13u W=0.42u AS=0.081p
+ AD=0.1296p PS=0.81u PD=1.52u rfmode=0
M$2479 \$2414 \$2415 \$2420 VSS sg13_lv_nmos L=0.13u W=0.42u AS=0.081p
+ AD=0.2163p PS=0.81u PD=1.87u rfmode=0
M$2480 \$2415 \$2421 VSS VSS sg13_lv_nmos L=0.13u W=0.74u AS=0.2516p
+ AD=0.43315p PS=2.16u PD=2.205u rfmode=0
M$2481 VSS CLK \$2421 VSS sg13_lv_nmos L=0.13u W=0.74u AS=0.43315p AD=0.2516p
+ PS=2.205u PD=2.16u rfmode=0
M$2482 \$2428 \$2421 \$2422 VSS sg13_lv_nmos L=0.13u W=0.42u AS=0.1428p
+ AD=0.12665p PS=1.52u PD=1.145u rfmode=0
M$2483 \$2422 \$2415 \$2413 VSS sg13_lv_nmos L=0.13u W=0.74u AS=0.12665p
+ AD=0.3473p PS=1.145u PD=2.71u rfmode=0
M$2484 VSS VDD \$2433 VSS sg13_lv_nmos L=0.13u W=0.42u AS=0.1701p AD=0.03885p
+ PS=1.65u PD=0.605u rfmode=0
M$2485 \$2433 \$2413 \$2420 VSS sg13_lv_nmos L=0.13u W=0.42u AS=0.03885p
+ AD=0.1596p PS=0.605u PD=1.6u rfmode=0
M$2486 VSS \$2422 \$2403 VSS sg13_lv_nmos L=0.13u W=1.48u AS=0.3922p AD=0.2737p
+ PS=3.28u PD=2.24u rfmode=0
M$2488 VSS \$2422 \$2417 VSS sg13_lv_nmos L=0.13u W=0.64u AS=0.1331p AD=0.2176p
+ PS=1.12u PD=1.96u rfmode=0
M$2489 VSS \$2417 \$2411 VSS sg13_lv_nmos L=0.13u W=1.48u AS=0.3922p AD=0.3922p
+ PS=3.28u PD=3.28u rfmode=0
M$2491 \$2439 X1 \$2446 VSS sg13_lv_nmos L=0.13u W=0.42u AS=0.1428p AD=0.0609p
+ PS=1.52u PD=0.71u rfmode=0
M$2492 \$2446 VDD VSS VSS sg13_lv_nmos L=0.13u W=0.42u AS=0.0609p AD=0.1626p
+ PS=0.71u PD=1.415u rfmode=0
M$2493 VSS \$2449 \$2435 VSS sg13_lv_nmos L=0.13u W=0.74u AS=0.1626p AD=0.2516p
+ PS=1.415u PD=2.16u rfmode=0
M$2494 VSS \$2414 \$2413 VSS sg13_lv_nmos L=0.13u W=0.74u AS=0.1626p AD=0.2516p
+ PS=1.415u PD=2.16u rfmode=0
M$2495 \$2412 X2 \$2432 VSS sg13_lv_nmos L=0.13u W=0.42u AS=0.1428p AD=0.0609p
+ PS=1.52u PD=0.71u rfmode=0
M$2496 VSS VDD \$2432 VSS sg13_lv_nmos L=0.13u W=0.42u AS=0.1626p AD=0.0609p
+ PS=1.415u PD=0.71u rfmode=0
M$2497 \$2441 \$2450 VSS VSS sg13_lv_nmos L=0.13u W=0.42u AS=0.1428p AD=0.0798p
+ PS=1.52u PD=0.8u rfmode=0
M$2498 VSS VDD \$2445 VSS sg13_lv_nmos L=0.13u W=0.42u AS=0.0798p AD=0.0378p
+ PS=0.8u PD=0.6u rfmode=0
M$2499 \$2445 \$2442 \$2450 VSS sg13_lv_nmos L=0.13u W=0.42u AS=0.0378p
+ AD=0.1428p PS=0.6u PD=1.52u rfmode=0
M$2500 \$2428 \$2416 VSS VSS sg13_lv_nmos L=0.13u W=0.42u AS=0.1428p AD=0.0798p
+ PS=1.52u PD=0.8u rfmode=0
M$2501 VSS VDD \$2434 VSS sg13_lv_nmos L=0.13u W=0.42u AS=0.0798p AD=0.0378p
+ PS=0.8u PD=0.6u rfmode=0
M$2502 \$2434 \$2422 \$2416 VSS sg13_lv_nmos L=0.13u W=0.42u AS=0.0378p
+ AD=0.1428p PS=0.6u PD=1.52u rfmode=0
M$2503 VSS \$2442 \$2438 VSS sg13_lv_nmos L=0.13u W=0.64u AS=0.1331p AD=0.2176p
+ PS=1.12u PD=1.96u rfmode=0
M$2504 VSS \$2442 \$2437 VSS sg13_lv_nmos L=0.13u W=1.48u AS=0.3922p AD=0.2737p
+ PS=3.28u PD=2.24u rfmode=0
M$2506 VSS \$2438 \$2443 VSS sg13_lv_nmos L=0.13u W=1.48u AS=0.3922p AD=0.3922p
+ PS=3.28u PD=3.28u rfmode=0
M$2508 VSS VDD \$2447 VSS sg13_lv_nmos L=0.13u W=0.42u AS=0.1701p AD=0.03885p
+ PS=1.65u PD=0.605u rfmode=0
M$2509 \$2447 \$2435 \$2440 VSS sg13_lv_nmos L=0.13u W=0.42u AS=0.03885p
+ AD=0.1596p PS=0.605u PD=1.6u rfmode=0
M$2510 \$2439 \$2436 \$2449 VSS sg13_lv_nmos L=0.13u W=0.42u AS=0.1296p
+ AD=0.081p PS=1.52u PD=0.81u rfmode=0
M$2511 \$2449 \$2458 \$2440 VSS sg13_lv_nmos L=0.13u W=0.42u AS=0.081p
+ AD=0.2163p PS=0.81u PD=1.87u rfmode=0
M$2512 VSS \$2436 \$2458 VSS sg13_lv_nmos L=0.13u W=0.74u AS=0.43315p
+ AD=0.2516p PS=2.205u PD=2.16u rfmode=0
M$2513 VSS CLK \$2436 VSS sg13_lv_nmos L=0.13u W=0.74u AS=0.43315p AD=0.2516p
+ PS=2.205u PD=2.16u rfmode=0
M$2514 \$2442 \$2436 \$2441 VSS sg13_lv_nmos L=0.13u W=0.42u AS=0.12665p
+ AD=0.1428p PS=1.145u PD=1.52u rfmode=0
M$2515 \$2435 \$2458 \$2442 VSS sg13_lv_nmos L=0.13u W=0.74u AS=0.3473p
+ AD=0.12665p PS=2.71u PD=1.145u rfmode=0
M$2516 VSS VSS \$2451 VSS sg13_lv_nmos L=0.13u W=1u AS=0.265p AD=0.265p
+ PS=2.56u PD=2.56u rfmode=0
M$2517 \$2451 \$2437 OUTN VSS sg13_lv_nmos L=0.13u W=2u AS=0.38p AD=0.38p
+ PS=3.52u PD=3.52u rfmode=0
M$2519 \$2451 \$2443 OUTP VSS sg13_lv_nmos L=0.13u W=2u AS=0.38p AD=0.38p
+ PS=3.52u PD=3.52u rfmode=0
M$2526 VSS VSS VSS VSS sg13_hv_nmos L=0.45u W=82.2u AS=21.7605p AD=21.8055p
+ PS=190.31u PD=190.91u rfmode=0
M$2527 VSS VBIAS \$48 VSS sg13_hv_nmos L=0.45u W=5.2u AS=0.988p AD=0.988p
+ PS=8.24u PD=8.24u rfmode=0
M$2537 VSS VBIAS \$58 VSS sg13_hv_nmos L=0.45u W=5.2u AS=0.988p AD=0.988p
+ PS=8.24u PD=8.24u rfmode=0
M$2547 VSS VBIAS \$68 VSS sg13_hv_nmos L=0.45u W=5.2u AS=0.988p AD=0.988p
+ PS=8.24u PD=8.24u rfmode=0
M$2557 VSS VBIAS \$78 VSS sg13_hv_nmos L=0.45u W=5.2u AS=0.988p AD=0.988p
+ PS=8.24u PD=8.24u rfmode=0
M$2567 VSS VBIAS \$88 VSS sg13_hv_nmos L=0.45u W=5.2u AS=0.988p AD=0.988p
+ PS=8.24u PD=8.24u rfmode=0
M$2577 VSS VBIAS \$98 VSS sg13_hv_nmos L=0.45u W=5.2u AS=0.988p AD=0.988p
+ PS=8.24u PD=8.24u rfmode=0
M$2587 VSS VBIAS \$108 VSS sg13_hv_nmos L=0.45u W=5.2u AS=0.988p AD=0.988p
+ PS=8.24u PD=8.24u rfmode=0
M$2597 VSS VBIAS \$118 VSS sg13_hv_nmos L=0.45u W=5.2u AS=0.988p AD=0.988p
+ PS=8.24u PD=8.24u rfmode=0
M$2606 VSS VSS \$197 VSS sg13_hv_nmos L=0.45u W=1.3u AS=0.3445p AD=0.3445p
+ PS=3.01u PD=3.01u rfmode=0
M$2607 \$197 VBIAS \$48 VSS sg13_hv_nmos L=0.45u W=5.2u AS=0.988p AD=0.988p
+ PS=8.24u PD=8.24u rfmode=0
M$2616 VSS VSS \$199 VSS sg13_hv_nmos L=0.45u W=1.3u AS=0.3445p AD=0.3445p
+ PS=3.01u PD=3.01u rfmode=0
M$2617 \$199 VBIAS \$58 VSS sg13_hv_nmos L=0.45u W=5.2u AS=0.988p AD=0.988p
+ PS=8.24u PD=8.24u rfmode=0
M$2626 VSS VSS \$201 VSS sg13_hv_nmos L=0.45u W=1.3u AS=0.3445p AD=0.3445p
+ PS=3.01u PD=3.01u rfmode=0
M$2627 \$201 VBIAS \$68 VSS sg13_hv_nmos L=0.45u W=5.2u AS=0.988p AD=0.988p
+ PS=8.24u PD=8.24u rfmode=0
M$2636 VSS VSS \$203 VSS sg13_hv_nmos L=0.45u W=1.3u AS=0.3445p AD=0.3445p
+ PS=3.01u PD=3.01u rfmode=0
M$2637 \$203 VBIAS \$78 VSS sg13_hv_nmos L=0.45u W=5.2u AS=0.988p AD=0.988p
+ PS=8.24u PD=8.24u rfmode=0
M$2646 VSS VSS \$205 VSS sg13_hv_nmos L=0.45u W=1.3u AS=0.3445p AD=0.3445p
+ PS=3.01u PD=3.01u rfmode=0
M$2647 \$205 VBIAS \$88 VSS sg13_hv_nmos L=0.45u W=5.2u AS=0.988p AD=0.988p
+ PS=8.24u PD=8.24u rfmode=0
M$2656 VSS VSS \$207 VSS sg13_hv_nmos L=0.45u W=1.3u AS=0.3445p AD=0.3445p
+ PS=3.01u PD=3.01u rfmode=0
M$2657 \$207 VBIAS \$98 VSS sg13_hv_nmos L=0.45u W=5.2u AS=0.988p AD=0.988p
+ PS=8.24u PD=8.24u rfmode=0
M$2666 VSS VSS \$209 VSS sg13_hv_nmos L=0.45u W=1.3u AS=0.3445p AD=0.3445p
+ PS=3.01u PD=3.01u rfmode=0
M$2667 \$209 VBIAS \$108 VSS sg13_hv_nmos L=0.45u W=5.2u AS=0.988p AD=0.988p
+ PS=8.24u PD=8.24u rfmode=0
M$2676 VSS VSS \$211 VSS sg13_hv_nmos L=0.45u W=1.3u AS=0.3445p AD=0.3445p
+ PS=3.01u PD=3.01u rfmode=0
M$2677 \$211 VBIAS \$118 VSS sg13_hv_nmos L=0.45u W=5.2u AS=0.988p AD=0.988p
+ PS=8.24u PD=8.24u rfmode=0
M$2687 VSS VBIAS \$368 VSS sg13_hv_nmos L=0.45u W=5.2u AS=0.988p AD=0.988p
+ PS=8.24u PD=8.24u rfmode=0
M$2697 VSS VBIAS \$378 VSS sg13_hv_nmos L=0.45u W=5.2u AS=0.988p AD=0.988p
+ PS=8.24u PD=8.24u rfmode=0
M$2707 VSS VBIAS \$388 VSS sg13_hv_nmos L=0.45u W=5.2u AS=0.988p AD=0.988p
+ PS=8.24u PD=8.24u rfmode=0
M$2717 VSS VBIAS \$398 VSS sg13_hv_nmos L=0.45u W=5.2u AS=0.988p AD=0.988p
+ PS=8.24u PD=8.24u rfmode=0
M$2727 VSS VBIAS \$408 VSS sg13_hv_nmos L=0.45u W=5.2u AS=0.988p AD=0.988p
+ PS=8.24u PD=8.24u rfmode=0
M$2737 VSS VBIAS \$418 VSS sg13_hv_nmos L=0.45u W=5.2u AS=0.988p AD=0.988p
+ PS=8.24u PD=8.24u rfmode=0
M$2747 VSS VBIAS \$428 VSS sg13_hv_nmos L=0.45u W=5.2u AS=0.988p AD=0.988p
+ PS=8.24u PD=8.24u rfmode=0
M$2757 VSS VBIAS \$438 VSS sg13_hv_nmos L=0.45u W=5.2u AS=0.988p AD=0.988p
+ PS=8.24u PD=8.24u rfmode=0
M$2766 VSS VSS \$504 VSS sg13_hv_nmos L=0.45u W=1.3u AS=0.3445p AD=0.3445p
+ PS=3.01u PD=3.01u rfmode=0
M$2767 \$504 VBIAS \$368 VSS sg13_hv_nmos L=0.45u W=5.2u AS=0.988p AD=0.988p
+ PS=8.24u PD=8.24u rfmode=0
M$2776 VSS VSS \$506 VSS sg13_hv_nmos L=0.45u W=1.3u AS=0.3445p AD=0.3445p
+ PS=3.01u PD=3.01u rfmode=0
M$2777 \$506 VBIAS \$378 VSS sg13_hv_nmos L=0.45u W=5.2u AS=0.988p AD=0.988p
+ PS=8.24u PD=8.24u rfmode=0
M$2786 VSS VSS \$508 VSS sg13_hv_nmos L=0.45u W=1.3u AS=0.3445p AD=0.3445p
+ PS=3.01u PD=3.01u rfmode=0
M$2787 \$508 VBIAS \$388 VSS sg13_hv_nmos L=0.45u W=5.2u AS=0.988p AD=0.988p
+ PS=8.24u PD=8.24u rfmode=0
M$2796 VSS VSS \$510 VSS sg13_hv_nmos L=0.45u W=1.3u AS=0.3445p AD=0.3445p
+ PS=3.01u PD=3.01u rfmode=0
M$2797 \$510 VBIAS \$398 VSS sg13_hv_nmos L=0.45u W=5.2u AS=0.988p AD=0.988p
+ PS=8.24u PD=8.24u rfmode=0
M$2806 VSS VSS \$512 VSS sg13_hv_nmos L=0.45u W=1.3u AS=0.3445p AD=0.3445p
+ PS=3.01u PD=3.01u rfmode=0
M$2807 \$512 VBIAS \$408 VSS sg13_hv_nmos L=0.45u W=5.2u AS=0.988p AD=0.988p
+ PS=8.24u PD=8.24u rfmode=0
M$2816 VSS VSS \$514 VSS sg13_hv_nmos L=0.45u W=1.3u AS=0.3445p AD=0.3445p
+ PS=3.01u PD=3.01u rfmode=0
M$2817 \$514 VBIAS \$418 VSS sg13_hv_nmos L=0.45u W=5.2u AS=0.988p AD=0.988p
+ PS=8.24u PD=8.24u rfmode=0
M$2826 VSS VSS \$516 VSS sg13_hv_nmos L=0.45u W=1.3u AS=0.3445p AD=0.3445p
+ PS=3.01u PD=3.01u rfmode=0
M$2827 \$516 VBIAS \$428 VSS sg13_hv_nmos L=0.45u W=5.2u AS=0.988p AD=0.988p
+ PS=8.24u PD=8.24u rfmode=0
M$2836 VSS VSS \$518 VSS sg13_hv_nmos L=0.45u W=1.3u AS=0.3445p AD=0.3445p
+ PS=3.01u PD=3.01u rfmode=0
M$2837 \$518 VBIAS \$438 VSS sg13_hv_nmos L=0.45u W=5.2u AS=0.988p AD=0.988p
+ PS=8.24u PD=8.24u rfmode=0
M$2847 VSS VBIAS \$663 VSS sg13_hv_nmos L=0.45u W=5.2u AS=0.988p AD=0.988p
+ PS=8.24u PD=8.24u rfmode=0
M$2857 VSS VBIAS \$673 VSS sg13_hv_nmos L=0.45u W=5.2u AS=0.988p AD=0.988p
+ PS=8.24u PD=8.24u rfmode=0
M$2867 VSS VBIAS \$683 VSS sg13_hv_nmos L=0.45u W=5.2u AS=0.988p AD=0.988p
+ PS=8.24u PD=8.24u rfmode=0
M$2877 VSS VBIAS \$693 VSS sg13_hv_nmos L=0.45u W=5.2u AS=0.988p AD=0.988p
+ PS=8.24u PD=8.24u rfmode=0
M$2887 VSS VBIAS \$703 VSS sg13_hv_nmos L=0.45u W=5.2u AS=0.988p AD=0.988p
+ PS=8.24u PD=8.24u rfmode=0
M$2897 VSS VBIAS \$712 VSS sg13_hv_nmos L=0.45u W=5.2u AS=0.988p AD=0.988p
+ PS=8.24u PD=8.24u rfmode=0
M$2907 VSS VBIAS \$721 VSS sg13_hv_nmos L=0.45u W=5.2u AS=0.988p AD=0.988p
+ PS=8.24u PD=8.24u rfmode=0
M$2917 VSS VBIAS \$730 VSS sg13_hv_nmos L=0.45u W=5.2u AS=0.988p AD=0.988p
+ PS=8.24u PD=8.24u rfmode=0
M$2926 VSS VSS \$796 VSS sg13_hv_nmos L=0.45u W=1.3u AS=0.3445p AD=0.3445p
+ PS=3.01u PD=3.01u rfmode=0
M$2927 \$796 VBIAS \$663 VSS sg13_hv_nmos L=0.45u W=5.2u AS=0.988p AD=0.988p
+ PS=8.24u PD=8.24u rfmode=0
M$2936 VSS VSS \$798 VSS sg13_hv_nmos L=0.45u W=1.3u AS=0.3445p AD=0.3445p
+ PS=3.01u PD=3.01u rfmode=0
M$2937 \$798 VBIAS \$673 VSS sg13_hv_nmos L=0.45u W=5.2u AS=0.988p AD=0.988p
+ PS=8.24u PD=8.24u rfmode=0
M$2946 VSS VSS \$800 VSS sg13_hv_nmos L=0.45u W=1.3u AS=0.3445p AD=0.3445p
+ PS=3.01u PD=3.01u rfmode=0
M$2947 \$800 VBIAS \$683 VSS sg13_hv_nmos L=0.45u W=5.2u AS=0.988p AD=0.988p
+ PS=8.24u PD=8.24u rfmode=0
M$2956 VSS VSS \$802 VSS sg13_hv_nmos L=0.45u W=1.3u AS=0.3445p AD=0.3445p
+ PS=3.01u PD=3.01u rfmode=0
M$2957 \$802 VBIAS \$693 VSS sg13_hv_nmos L=0.45u W=5.2u AS=0.988p AD=0.988p
+ PS=8.24u PD=8.24u rfmode=0
M$2966 VSS VSS \$804 VSS sg13_hv_nmos L=0.45u W=1.3u AS=0.3445p AD=0.3445p
+ PS=3.01u PD=3.01u rfmode=0
M$2967 \$804 VBIAS \$703 VSS sg13_hv_nmos L=0.45u W=5.2u AS=0.988p AD=0.988p
+ PS=8.24u PD=8.24u rfmode=0
M$2976 VSS VSS \$807 VSS sg13_hv_nmos L=0.45u W=1.3u AS=0.3445p AD=0.3445p
+ PS=3.01u PD=3.01u rfmode=0
M$2977 \$807 VBIAS \$712 VSS sg13_hv_nmos L=0.45u W=5.2u AS=0.988p AD=0.988p
+ PS=8.24u PD=8.24u rfmode=0
M$2986 VSS VSS \$810 VSS sg13_hv_nmos L=0.45u W=1.3u AS=0.3445p AD=0.3445p
+ PS=3.01u PD=3.01u rfmode=0
M$2987 \$810 VBIAS \$721 VSS sg13_hv_nmos L=0.45u W=5.2u AS=0.988p AD=0.988p
+ PS=8.24u PD=8.24u rfmode=0
M$2996 VSS VSS \$813 VSS sg13_hv_nmos L=0.45u W=1.3u AS=0.3445p AD=0.3445p
+ PS=3.01u PD=3.01u rfmode=0
M$2997 \$813 VBIAS \$730 VSS sg13_hv_nmos L=0.45u W=5.2u AS=0.988p AD=0.988p
+ PS=8.24u PD=8.24u rfmode=0
M$3007 VSS VBIAS \$951 VSS sg13_hv_nmos L=0.45u W=5.2u AS=0.988p AD=0.988p
+ PS=8.24u PD=8.24u rfmode=0
M$3017 VSS VBIAS \$960 VSS sg13_hv_nmos L=0.45u W=5.2u AS=0.988p AD=0.988p
+ PS=8.24u PD=8.24u rfmode=0
M$3027 VSS VBIAS \$970 VSS sg13_hv_nmos L=0.45u W=5.2u AS=0.988p AD=0.988p
+ PS=8.24u PD=8.24u rfmode=0
M$3037 VSS VBIAS \$980 VSS sg13_hv_nmos L=0.45u W=5.2u AS=0.988p AD=0.988p
+ PS=8.24u PD=8.24u rfmode=0
M$3047 VSS VBIAS \$990 VSS sg13_hv_nmos L=0.45u W=5.2u AS=0.988p AD=0.988p
+ PS=8.24u PD=8.24u rfmode=0
M$3057 VSS VBIAS \$1000 VSS sg13_hv_nmos L=0.45u W=5.2u AS=0.988p AD=0.988p
+ PS=8.24u PD=8.24u rfmode=0
M$3067 VSS VBIAS \$1010 VSS sg13_hv_nmos L=0.45u W=5.2u AS=0.988p AD=0.988p
+ PS=8.24u PD=8.24u rfmode=0
M$3077 VSS VBIAS \$1020 VSS sg13_hv_nmos L=0.45u W=5.2u AS=0.988p AD=0.988p
+ PS=8.24u PD=8.24u rfmode=0
M$3086 VSS VSS \$1086 VSS sg13_hv_nmos L=0.45u W=1.3u AS=0.3445p AD=0.3445p
+ PS=3.01u PD=3.01u rfmode=0
M$3087 \$1086 VBIAS \$951 VSS sg13_hv_nmos L=0.45u W=5.2u AS=0.988p AD=0.988p
+ PS=8.24u PD=8.24u rfmode=0
M$3096 VSS VSS \$1089 VSS sg13_hv_nmos L=0.45u W=1.3u AS=0.3445p AD=0.3445p
+ PS=3.01u PD=3.01u rfmode=0
M$3097 \$1089 VBIAS \$960 VSS sg13_hv_nmos L=0.45u W=5.2u AS=0.988p AD=0.988p
+ PS=8.24u PD=8.24u rfmode=0
M$3106 VSS VSS \$1091 VSS sg13_hv_nmos L=0.45u W=1.3u AS=0.3445p AD=0.3445p
+ PS=3.01u PD=3.01u rfmode=0
M$3107 \$1091 VBIAS \$970 VSS sg13_hv_nmos L=0.45u W=5.2u AS=0.988p AD=0.988p
+ PS=8.24u PD=8.24u rfmode=0
M$3116 VSS VSS \$1093 VSS sg13_hv_nmos L=0.45u W=1.3u AS=0.3445p AD=0.3445p
+ PS=3.01u PD=3.01u rfmode=0
M$3117 \$1093 VBIAS \$980 VSS sg13_hv_nmos L=0.45u W=5.2u AS=0.988p AD=0.988p
+ PS=8.24u PD=8.24u rfmode=0
M$3126 VSS VSS \$1095 VSS sg13_hv_nmos L=0.45u W=1.3u AS=0.3445p AD=0.3445p
+ PS=3.01u PD=3.01u rfmode=0
M$3127 \$1095 VBIAS \$990 VSS sg13_hv_nmos L=0.45u W=5.2u AS=0.988p AD=0.988p
+ PS=8.24u PD=8.24u rfmode=0
M$3136 VSS VSS \$1097 VSS sg13_hv_nmos L=0.45u W=1.3u AS=0.3445p AD=0.3445p
+ PS=3.01u PD=3.01u rfmode=0
M$3137 \$1097 VBIAS \$1000 VSS sg13_hv_nmos L=0.45u W=5.2u AS=0.988p AD=0.988p
+ PS=8.24u PD=8.24u rfmode=0
M$3146 VSS VSS \$1099 VSS sg13_hv_nmos L=0.45u W=1.3u AS=0.3445p AD=0.3445p
+ PS=3.01u PD=3.01u rfmode=0
M$3147 \$1099 VBIAS \$1010 VSS sg13_hv_nmos L=0.45u W=5.2u AS=0.988p AD=0.988p
+ PS=8.24u PD=8.24u rfmode=0
M$3156 VSS VSS \$1101 VSS sg13_hv_nmos L=0.45u W=1.3u AS=0.3445p AD=0.3445p
+ PS=3.01u PD=3.01u rfmode=0
M$3157 \$1101 VBIAS \$1020 VSS sg13_hv_nmos L=0.45u W=5.2u AS=0.988p AD=0.988p
+ PS=8.24u PD=8.24u rfmode=0
M$3167 VSS VBIAS \$1239 VSS sg13_hv_nmos L=0.45u W=5.2u AS=0.988p AD=0.988p
+ PS=8.24u PD=8.24u rfmode=0
M$3177 VSS VBIAS \$1248 VSS sg13_hv_nmos L=0.45u W=5.2u AS=0.988p AD=0.988p
+ PS=8.24u PD=8.24u rfmode=0
M$3187 VSS VBIAS \$1258 VSS sg13_hv_nmos L=0.45u W=5.2u AS=0.988p AD=0.988p
+ PS=8.24u PD=8.24u rfmode=0
M$3197 VSS VBIAS \$1267 VSS sg13_hv_nmos L=0.45u W=5.2u AS=0.988p AD=0.988p
+ PS=8.24u PD=8.24u rfmode=0
M$3207 VSS VBIAS \$1276 VSS sg13_hv_nmos L=0.45u W=5.2u AS=0.988p AD=0.988p
+ PS=8.24u PD=8.24u rfmode=0
M$3217 VSS VBIAS \$1286 VSS sg13_hv_nmos L=0.45u W=5.2u AS=0.988p AD=0.988p
+ PS=8.24u PD=8.24u rfmode=0
M$3227 VSS VBIAS \$1295 VSS sg13_hv_nmos L=0.45u W=5.2u AS=0.988p AD=0.988p
+ PS=8.24u PD=8.24u rfmode=0
M$3237 VSS VBIAS \$1305 VSS sg13_hv_nmos L=0.45u W=5.2u AS=0.988p AD=0.988p
+ PS=8.24u PD=8.24u rfmode=0
M$3246 VSS VSS \$1371 VSS sg13_hv_nmos L=0.45u W=1.3u AS=0.3445p AD=0.3445p
+ PS=3.01u PD=3.01u rfmode=0
M$3247 \$1371 VBIAS \$1239 VSS sg13_hv_nmos L=0.45u W=5.2u AS=0.988p AD=0.988p
+ PS=8.24u PD=8.24u rfmode=0
M$3256 VSS VSS \$1374 VSS sg13_hv_nmos L=0.45u W=1.3u AS=0.3445p AD=0.3445p
+ PS=3.01u PD=3.01u rfmode=0
M$3257 \$1374 VBIAS \$1248 VSS sg13_hv_nmos L=0.45u W=5.2u AS=0.988p AD=0.988p
+ PS=8.24u PD=8.24u rfmode=0
M$3266 VSS VSS \$1376 VSS sg13_hv_nmos L=0.45u W=1.3u AS=0.3445p AD=0.3445p
+ PS=3.01u PD=3.01u rfmode=0
M$3267 \$1376 VBIAS \$1258 VSS sg13_hv_nmos L=0.45u W=5.2u AS=0.988p AD=0.988p
+ PS=8.24u PD=8.24u rfmode=0
M$3276 VSS VSS \$1379 VSS sg13_hv_nmos L=0.45u W=1.3u AS=0.3445p AD=0.3445p
+ PS=3.01u PD=3.01u rfmode=0
M$3277 \$1379 VBIAS \$1267 VSS sg13_hv_nmos L=0.45u W=5.2u AS=0.988p AD=0.988p
+ PS=8.24u PD=8.24u rfmode=0
M$3286 VSS VSS \$1382 VSS sg13_hv_nmos L=0.45u W=1.3u AS=0.3445p AD=0.3445p
+ PS=3.01u PD=3.01u rfmode=0
M$3287 \$1382 VBIAS \$1276 VSS sg13_hv_nmos L=0.45u W=5.2u AS=0.988p AD=0.988p
+ PS=8.24u PD=8.24u rfmode=0
M$3296 VSS VSS \$1384 VSS sg13_hv_nmos L=0.45u W=1.3u AS=0.3445p AD=0.3445p
+ PS=3.01u PD=3.01u rfmode=0
M$3297 \$1384 VBIAS \$1286 VSS sg13_hv_nmos L=0.45u W=5.2u AS=0.988p AD=0.988p
+ PS=8.24u PD=8.24u rfmode=0
M$3306 VSS VSS \$1387 VSS sg13_hv_nmos L=0.45u W=1.3u AS=0.3445p AD=0.3445p
+ PS=3.01u PD=3.01u rfmode=0
M$3307 \$1387 VBIAS \$1295 VSS sg13_hv_nmos L=0.45u W=5.2u AS=0.988p AD=0.988p
+ PS=8.24u PD=8.24u rfmode=0
M$3316 VSS VSS \$1389 VSS sg13_hv_nmos L=0.45u W=1.3u AS=0.3445p AD=0.3445p
+ PS=3.01u PD=3.01u rfmode=0
M$3317 \$1389 VBIAS \$1305 VSS sg13_hv_nmos L=0.45u W=5.2u AS=0.988p AD=0.988p
+ PS=8.24u PD=8.24u rfmode=0
M$3327 VSS VBIAS \$1527 VSS sg13_hv_nmos L=0.45u W=5.2u AS=0.988p AD=0.988p
+ PS=8.24u PD=8.24u rfmode=0
M$3337 VSS VBIAS \$1537 VSS sg13_hv_nmos L=0.45u W=5.2u AS=0.988p AD=0.988p
+ PS=8.24u PD=8.24u rfmode=0
M$3347 VSS VBIAS \$1547 VSS sg13_hv_nmos L=0.45u W=5.2u AS=0.988p AD=0.988p
+ PS=8.24u PD=8.24u rfmode=0
M$3357 VSS VBIAS \$1557 VSS sg13_hv_nmos L=0.45u W=5.2u AS=0.988p AD=0.988p
+ PS=8.24u PD=8.24u rfmode=0
M$3367 VSS VBIAS \$1567 VSS sg13_hv_nmos L=0.45u W=5.2u AS=0.988p AD=0.988p
+ PS=8.24u PD=8.24u rfmode=0
M$3377 VSS VBIAS \$1577 VSS sg13_hv_nmos L=0.45u W=5.2u AS=0.988p AD=0.988p
+ PS=8.24u PD=8.24u rfmode=0
M$3387 VSS VBIAS \$1587 VSS sg13_hv_nmos L=0.45u W=5.2u AS=0.988p AD=0.988p
+ PS=8.24u PD=8.24u rfmode=0
M$3397 VSS VBIAS \$1597 VSS sg13_hv_nmos L=0.45u W=5.2u AS=0.988p AD=0.988p
+ PS=8.24u PD=8.24u rfmode=0
M$3406 VSS VSS \$1663 VSS sg13_hv_nmos L=0.45u W=1.3u AS=0.3445p AD=0.3445p
+ PS=3.01u PD=3.01u rfmode=0
M$3407 \$1663 VBIAS \$1527 VSS sg13_hv_nmos L=0.45u W=5.2u AS=0.988p AD=0.988p
+ PS=8.24u PD=8.24u rfmode=0
M$3416 VSS VSS \$1665 VSS sg13_hv_nmos L=0.45u W=1.3u AS=0.3445p AD=0.3445p
+ PS=3.01u PD=3.01u rfmode=0
M$3417 \$1665 VBIAS \$1537 VSS sg13_hv_nmos L=0.45u W=5.2u AS=0.988p AD=0.988p
+ PS=8.24u PD=8.24u rfmode=0
M$3426 VSS VSS \$1667 VSS sg13_hv_nmos L=0.45u W=1.3u AS=0.3445p AD=0.3445p
+ PS=3.01u PD=3.01u rfmode=0
M$3427 \$1667 VBIAS \$1547 VSS sg13_hv_nmos L=0.45u W=5.2u AS=0.988p AD=0.988p
+ PS=8.24u PD=8.24u rfmode=0
M$3436 VSS VSS \$1669 VSS sg13_hv_nmos L=0.45u W=1.3u AS=0.3445p AD=0.3445p
+ PS=3.01u PD=3.01u rfmode=0
M$3437 \$1669 VBIAS \$1557 VSS sg13_hv_nmos L=0.45u W=5.2u AS=0.988p AD=0.988p
+ PS=8.24u PD=8.24u rfmode=0
M$3446 VSS VSS \$1671 VSS sg13_hv_nmos L=0.45u W=1.3u AS=0.3445p AD=0.3445p
+ PS=3.01u PD=3.01u rfmode=0
M$3447 \$1671 VBIAS \$1567 VSS sg13_hv_nmos L=0.45u W=5.2u AS=0.988p AD=0.988p
+ PS=8.24u PD=8.24u rfmode=0
M$3456 VSS VSS \$1673 VSS sg13_hv_nmos L=0.45u W=1.3u AS=0.3445p AD=0.3445p
+ PS=3.01u PD=3.01u rfmode=0
M$3457 \$1673 VBIAS \$1577 VSS sg13_hv_nmos L=0.45u W=5.2u AS=0.988p AD=0.988p
+ PS=8.24u PD=8.24u rfmode=0
M$3466 VSS VSS \$1675 VSS sg13_hv_nmos L=0.45u W=1.3u AS=0.3445p AD=0.3445p
+ PS=3.01u PD=3.01u rfmode=0
M$3467 \$1675 VBIAS \$1587 VSS sg13_hv_nmos L=0.45u W=5.2u AS=0.988p AD=0.988p
+ PS=8.24u PD=8.24u rfmode=0
M$3476 VSS VSS \$1677 VSS sg13_hv_nmos L=0.45u W=1.3u AS=0.3445p AD=0.3445p
+ PS=3.01u PD=3.01u rfmode=0
M$3477 \$1677 VBIAS \$1597 VSS sg13_hv_nmos L=0.45u W=5.2u AS=0.988p AD=0.988p
+ PS=8.24u PD=8.24u rfmode=0
M$3487 VSS VBIAS \$1815 VSS sg13_hv_nmos L=0.45u W=5.2u AS=0.988p AD=0.988p
+ PS=8.24u PD=8.24u rfmode=0
M$3497 VSS VBIAS \$1824 VSS sg13_hv_nmos L=0.45u W=5.2u AS=0.988p AD=0.988p
+ PS=8.24u PD=8.24u rfmode=0
M$3507 VSS VBIAS \$1834 VSS sg13_hv_nmos L=0.45u W=5.2u AS=0.988p AD=0.988p
+ PS=8.24u PD=8.24u rfmode=0
M$3517 VSS VBIAS \$1844 VSS sg13_hv_nmos L=0.45u W=5.2u AS=0.988p AD=0.988p
+ PS=8.24u PD=8.24u rfmode=0
M$3527 VSS VBIAS \$1854 VSS sg13_hv_nmos L=0.45u W=5.2u AS=0.988p AD=0.988p
+ PS=8.24u PD=8.24u rfmode=0
M$3537 VSS VBIAS \$1864 VSS sg13_hv_nmos L=0.45u W=5.2u AS=0.988p AD=0.988p
+ PS=8.24u PD=8.24u rfmode=0
M$3547 VSS VBIAS \$1873 VSS sg13_hv_nmos L=0.45u W=5.2u AS=0.988p AD=0.988p
+ PS=8.24u PD=8.24u rfmode=0
M$3557 VSS VBIAS \$1882 VSS sg13_hv_nmos L=0.45u W=5.2u AS=0.988p AD=0.988p
+ PS=8.24u PD=8.24u rfmode=0
M$3566 VSS VSS \$1948 VSS sg13_hv_nmos L=0.45u W=1.3u AS=0.3445p AD=0.3445p
+ PS=3.01u PD=3.01u rfmode=0
M$3567 \$1948 VBIAS \$1815 VSS sg13_hv_nmos L=0.45u W=5.2u AS=0.988p AD=0.988p
+ PS=8.24u PD=8.24u rfmode=0
M$3576 VSS VSS \$1951 VSS sg13_hv_nmos L=0.45u W=1.3u AS=0.3445p AD=0.3445p
+ PS=3.01u PD=3.01u rfmode=0
M$3577 \$1951 VBIAS \$1824 VSS sg13_hv_nmos L=0.45u W=5.2u AS=0.988p AD=0.988p
+ PS=8.24u PD=8.24u rfmode=0
M$3586 VSS VSS \$1953 VSS sg13_hv_nmos L=0.45u W=1.3u AS=0.3445p AD=0.3445p
+ PS=3.01u PD=3.01u rfmode=0
M$3587 \$1953 VBIAS \$1834 VSS sg13_hv_nmos L=0.45u W=5.2u AS=0.988p AD=0.988p
+ PS=8.24u PD=8.24u rfmode=0
M$3596 VSS VSS \$1955 VSS sg13_hv_nmos L=0.45u W=1.3u AS=0.3445p AD=0.3445p
+ PS=3.01u PD=3.01u rfmode=0
M$3597 \$1955 VBIAS \$1844 VSS sg13_hv_nmos L=0.45u W=5.2u AS=0.988p AD=0.988p
+ PS=8.24u PD=8.24u rfmode=0
M$3606 VSS VSS \$1957 VSS sg13_hv_nmos L=0.45u W=1.3u AS=0.3445p AD=0.3445p
+ PS=3.01u PD=3.01u rfmode=0
M$3607 \$1957 VBIAS \$1854 VSS sg13_hv_nmos L=0.45u W=5.2u AS=0.988p AD=0.988p
+ PS=8.24u PD=8.24u rfmode=0
M$3616 VSS VSS \$1959 VSS sg13_hv_nmos L=0.45u W=1.3u AS=0.3445p AD=0.3445p
+ PS=3.01u PD=3.01u rfmode=0
M$3617 \$1959 VBIAS \$1864 VSS sg13_hv_nmos L=0.45u W=5.2u AS=0.988p AD=0.988p
+ PS=8.24u PD=8.24u rfmode=0
M$3626 VSS VSS \$1962 VSS sg13_hv_nmos L=0.45u W=1.3u AS=0.3445p AD=0.3445p
+ PS=3.01u PD=3.01u rfmode=0
M$3627 \$1962 VBIAS \$1873 VSS sg13_hv_nmos L=0.45u W=5.2u AS=0.988p AD=0.988p
+ PS=8.24u PD=8.24u rfmode=0
M$3636 VSS VSS \$1965 VSS sg13_hv_nmos L=0.45u W=1.3u AS=0.3445p AD=0.3445p
+ PS=3.01u PD=3.01u rfmode=0
M$3637 \$1965 VBIAS \$1882 VSS sg13_hv_nmos L=0.45u W=5.2u AS=0.988p AD=0.988p
+ PS=8.24u PD=8.24u rfmode=0
M$3647 VSS VBIAS \$2099 VSS sg13_hv_nmos L=0.45u W=5.2u AS=0.988p AD=0.988p
+ PS=8.24u PD=8.24u rfmode=0
M$3657 VSS VBIAS \$2109 VSS sg13_hv_nmos L=0.45u W=5.2u AS=0.988p AD=0.988p
+ PS=8.24u PD=8.24u rfmode=0
M$3667 VSS VBIAS \$2118 VSS sg13_hv_nmos L=0.45u W=5.2u AS=0.988p AD=0.988p
+ PS=8.24u PD=8.24u rfmode=0
M$3677 VSS VBIAS \$2128 VSS sg13_hv_nmos L=0.45u W=5.2u AS=0.988p AD=0.988p
+ PS=8.24u PD=8.24u rfmode=0
M$3687 VSS VBIAS \$2138 VSS sg13_hv_nmos L=0.45u W=5.2u AS=0.988p AD=0.988p
+ PS=8.24u PD=8.24u rfmode=0
M$3697 VSS VBIAS \$2147 VSS sg13_hv_nmos L=0.45u W=5.2u AS=0.988p AD=0.988p
+ PS=8.24u PD=8.24u rfmode=0
M$3707 VSS VBIAS \$2156 VSS sg13_hv_nmos L=0.45u W=5.2u AS=0.988p AD=0.988p
+ PS=8.24u PD=8.24u rfmode=0
M$3716 VSS VSS \$2214 VSS sg13_hv_nmos L=0.45u W=1.3u AS=0.3445p AD=0.3445p
+ PS=3.01u PD=3.01u rfmode=0
M$3717 \$2214 VBIAS \$2099 VSS sg13_hv_nmos L=0.45u W=5.2u AS=0.988p AD=0.988p
+ PS=8.24u PD=8.24u rfmode=0
M$3726 VSS VSS \$2216 VSS sg13_hv_nmos L=0.45u W=1.3u AS=0.3445p AD=0.3445p
+ PS=3.01u PD=3.01u rfmode=0
M$3727 \$2216 VBIAS \$2109 VSS sg13_hv_nmos L=0.45u W=5.2u AS=0.988p AD=0.988p
+ PS=8.24u PD=8.24u rfmode=0
M$3736 VSS VSS \$2219 VSS sg13_hv_nmos L=0.45u W=1.3u AS=0.3445p AD=0.3445p
+ PS=3.01u PD=3.01u rfmode=0
M$3737 \$2219 VBIAS \$2118 VSS sg13_hv_nmos L=0.45u W=5.2u AS=0.988p AD=0.988p
+ PS=8.24u PD=8.24u rfmode=0
M$3746 VSS VSS \$2221 VSS sg13_hv_nmos L=0.45u W=1.3u AS=0.3445p AD=0.3445p
+ PS=3.01u PD=3.01u rfmode=0
M$3747 \$2221 VBIAS \$2128 VSS sg13_hv_nmos L=0.45u W=5.2u AS=0.988p AD=0.988p
+ PS=8.24u PD=8.24u rfmode=0
M$3756 VSS VSS \$2223 VSS sg13_hv_nmos L=0.45u W=1.3u AS=0.3445p AD=0.3445p
+ PS=3.01u PD=3.01u rfmode=0
M$3757 \$2223 VBIAS \$2138 VSS sg13_hv_nmos L=0.45u W=5.2u AS=0.988p AD=0.988p
+ PS=8.24u PD=8.24u rfmode=0
M$3766 VSS VSS \$2226 VSS sg13_hv_nmos L=0.45u W=1.3u AS=0.3445p AD=0.3445p
+ PS=3.01u PD=3.01u rfmode=0
M$3767 \$2226 VBIAS \$2147 VSS sg13_hv_nmos L=0.45u W=5.2u AS=0.988p AD=0.988p
+ PS=8.24u PD=8.24u rfmode=0
M$3776 VSS VSS \$2229 VSS sg13_hv_nmos L=0.45u W=1.3u AS=0.3445p AD=0.3445p
+ PS=3.01u PD=3.01u rfmode=0
M$3777 \$2229 VBIAS \$2156 VSS sg13_hv_nmos L=0.45u W=5.2u AS=0.988p AD=0.988p
+ PS=8.24u PD=8.24u rfmode=0
M$3786 VSS VSS \$2358 VSS sg13_hv_nmos L=0.45u W=1.2u AS=0.318p AD=0.318p
+ PS=3.92u PD=3.92u rfmode=0
M$3787 \$2358 VBIAS VSS VSS sg13_hv_nmos L=0.45u W=1.2u AS=0.228p AD=0.228p
+ PS=2.72u PD=2.72u rfmode=0
M$3793 \$2358 VBIAS \$2373 VSS sg13_hv_nmos L=0.45u W=1.2u AS=0.228p AD=0.228p
+ PS=2.72u PD=2.72u rfmode=0
M$3798 VSS VSS \$2330 VSS sg13_hv_nmos L=0.45u W=2.4u AS=0.636p AD=0.636p
+ PS=5.72u PD=5.72u rfmode=0
M$3799 \$2330 VBIAS \$2315 VSS sg13_hv_nmos L=0.48u W=2.4u AS=0.456p AD=0.456p
+ PS=3.92u PD=3.92u rfmode=0
M$3805 \$2330 VBIAS VSS VSS sg13_hv_nmos L=0.48u W=2.4u AS=0.456p AD=0.456p
+ PS=3.92u PD=3.92u rfmode=0
M$3810 VSS VSS \$2423 VSS sg13_hv_nmos L=0.45u W=1.2u AS=0.318p AD=0.318p
+ PS=3.92u PD=3.92u rfmode=0
M$3811 \$2423 VBIAS \$2404 VSS sg13_hv_nmos L=0.45u W=0.6u AS=0.114p AD=0.114p
+ PS=1.36u PD=1.36u rfmode=0
M$3815 \$2423 VBIAS VSS VSS sg13_hv_nmos L=0.45u W=0.6u AS=0.114p AD=0.114p
+ PS=1.36u PD=1.36u rfmode=0
M$3818 VSS VSS \$2444 VSS sg13_hv_nmos L=0.45u W=0.6u AS=0.204p AD=0.114p
+ PS=2.56u PD=1.36u rfmode=0
M$3819 \$2444 VBIAS VSS VSS sg13_hv_nmos L=0.45u W=0.3u AS=0.057p AD=0.057p
+ PS=0.68u PD=0.68u rfmode=0
M$3822 \$2444 VBIAS \$2451 VSS sg13_hv_nmos L=0.45u W=0.3u AS=0.057p AD=0.057p
+ PS=0.68u PD=0.68u rfmode=0
M$3823 \$2451 VSS VSS VSS sg13_hv_nmos L=0.45u W=0.3u AS=0.057p AD=0.102p
+ PS=0.68u PD=1.28u rfmode=0
M$3824 VDD X10 \$4 VDD sg13_lv_pmos L=0.13u W=1u AS=0.2086p AD=0.34p PS=1.5u
+ PD=2.68u rfmode=0
M$3825 VDD \$4 \$5 VDD sg13_lv_pmos L=0.13u W=2.24u AS=0.4214p AD=0.9464p PS=3u
+ PD=5.05u rfmode=0
M$3827 VDD \$8 \$40 VDD sg13_lv_pmos L=0.13u W=2.24u AS=0.616p AD=0.4312p
+ PS=4.46u PD=3.01u rfmode=0
M$3829 VDD VDD \$40 VDD sg13_lv_pmos L=0.13u W=2.24u AS=0.4312p AD=0.6048p
+ PS=3.01u PD=4.44u rfmode=0
M$3831 \$196 \$10 VDD VDD sg13_lv_pmos L=0.13u W=1.12u AS=0.3864p AD=0.431025p
+ PS=2.93u PD=2.145u rfmode=0
M$3832 VDD CLK \$10 VDD sg13_lv_pmos L=0.13u W=1.12u AS=0.431025p AD=0.3808p
+ PS=2.145u PD=2.92u rfmode=0
M$3833 VDD \$46 \$47 VDD sg13_lv_pmos L=0.13u W=2.24u AS=0.5964p AD=0.5964p
+ PS=4.425u PD=4.425u rfmode=0
M$3835 VDD \$12 \$50 VDD sg13_lv_pmos L=0.13u W=2.24u AS=0.616p AD=0.4312p
+ PS=4.46u PD=3.01u rfmode=0
M$3837 VDD VDD \$50 VDD sg13_lv_pmos L=0.13u W=2.24u AS=0.4312p AD=0.6048p
+ PS=3.01u PD=4.44u rfmode=0
M$3839 \$198 \$14 VDD VDD sg13_lv_pmos L=0.13u W=1.12u AS=0.3864p AD=0.431025p
+ PS=2.93u PD=2.145u rfmode=0
M$3840 VDD CLK \$14 VDD sg13_lv_pmos L=0.13u W=1.12u AS=0.431025p AD=0.3808p
+ PS=2.145u PD=2.92u rfmode=0
M$3841 VDD \$56 \$57 VDD sg13_lv_pmos L=0.13u W=2.24u AS=0.5964p AD=0.5964p
+ PS=4.425u PD=4.425u rfmode=0
M$3843 VDD \$16 \$60 VDD sg13_lv_pmos L=0.13u W=2.24u AS=0.616p AD=0.4312p
+ PS=4.46u PD=3.01u rfmode=0
M$3845 VDD VDD \$60 VDD sg13_lv_pmos L=0.13u W=2.24u AS=0.4312p AD=0.6048p
+ PS=3.01u PD=4.44u rfmode=0
M$3847 \$200 \$18 VDD VDD sg13_lv_pmos L=0.13u W=1.12u AS=0.3864p AD=0.431025p
+ PS=2.93u PD=2.145u rfmode=0
M$3848 VDD CLK \$18 VDD sg13_lv_pmos L=0.13u W=1.12u AS=0.431025p AD=0.3808p
+ PS=2.145u PD=2.92u rfmode=0
M$3849 VDD \$66 \$67 VDD sg13_lv_pmos L=0.13u W=2.24u AS=0.5964p AD=0.5964p
+ PS=4.425u PD=4.425u rfmode=0
M$3851 VDD \$20 \$70 VDD sg13_lv_pmos L=0.13u W=2.24u AS=0.616p AD=0.4312p
+ PS=4.46u PD=3.01u rfmode=0
M$3853 VDD VDD \$70 VDD sg13_lv_pmos L=0.13u W=2.24u AS=0.4312p AD=0.6048p
+ PS=3.01u PD=4.44u rfmode=0
M$3855 \$202 \$22 VDD VDD sg13_lv_pmos L=0.13u W=1.12u AS=0.3864p AD=0.431025p
+ PS=2.93u PD=2.145u rfmode=0
M$3856 VDD CLK \$22 VDD sg13_lv_pmos L=0.13u W=1.12u AS=0.431025p AD=0.3808p
+ PS=2.145u PD=2.92u rfmode=0
M$3857 VDD \$76 \$77 VDD sg13_lv_pmos L=0.13u W=2.24u AS=0.5964p AD=0.5964p
+ PS=4.425u PD=4.425u rfmode=0
M$3859 VDD \$24 \$80 VDD sg13_lv_pmos L=0.13u W=2.24u AS=0.616p AD=0.4312p
+ PS=4.46u PD=3.01u rfmode=0
M$3861 VDD VDD \$80 VDD sg13_lv_pmos L=0.13u W=2.24u AS=0.4312p AD=0.6048p
+ PS=3.01u PD=4.44u rfmode=0
M$3863 \$204 \$26 VDD VDD sg13_lv_pmos L=0.13u W=1.12u AS=0.3864p AD=0.431025p
+ PS=2.93u PD=2.145u rfmode=0
M$3864 VDD CLK \$26 VDD sg13_lv_pmos L=0.13u W=1.12u AS=0.431025p AD=0.3808p
+ PS=2.145u PD=2.92u rfmode=0
M$3865 VDD \$86 \$87 VDD sg13_lv_pmos L=0.13u W=2.24u AS=0.5964p AD=0.5964p
+ PS=4.425u PD=4.425u rfmode=0
M$3867 VDD \$28 \$90 VDD sg13_lv_pmos L=0.13u W=2.24u AS=0.616p AD=0.4312p
+ PS=4.46u PD=3.01u rfmode=0
M$3869 VDD VDD \$90 VDD sg13_lv_pmos L=0.13u W=2.24u AS=0.4312p AD=0.6048p
+ PS=3.01u PD=4.44u rfmode=0
M$3871 \$206 \$30 VDD VDD sg13_lv_pmos L=0.13u W=1.12u AS=0.3864p AD=0.431025p
+ PS=2.93u PD=2.145u rfmode=0
M$3872 VDD CLK \$30 VDD sg13_lv_pmos L=0.13u W=1.12u AS=0.431025p AD=0.3808p
+ PS=2.145u PD=2.92u rfmode=0
M$3873 VDD \$96 \$97 VDD sg13_lv_pmos L=0.13u W=2.24u AS=0.5964p AD=0.5964p
+ PS=4.425u PD=4.425u rfmode=0
M$3875 VDD \$32 \$100 VDD sg13_lv_pmos L=0.13u W=2.24u AS=0.616p AD=0.4312p
+ PS=4.46u PD=3.01u rfmode=0
M$3877 VDD VDD \$100 VDD sg13_lv_pmos L=0.13u W=2.24u AS=0.4312p AD=0.6048p
+ PS=3.01u PD=4.44u rfmode=0
M$3879 \$208 \$34 VDD VDD sg13_lv_pmos L=0.13u W=1.12u AS=0.3864p AD=0.431025p
+ PS=2.93u PD=2.145u rfmode=0
M$3880 VDD CLK \$34 VDD sg13_lv_pmos L=0.13u W=1.12u AS=0.431025p AD=0.3808p
+ PS=2.145u PD=2.92u rfmode=0
M$3881 VDD \$106 \$107 VDD sg13_lv_pmos L=0.13u W=2.24u AS=0.5964p AD=0.5964p
+ PS=4.425u PD=4.425u rfmode=0
M$3883 VDD \$36 \$110 VDD sg13_lv_pmos L=0.13u W=2.24u AS=0.616p AD=0.4312p
+ PS=4.46u PD=3.01u rfmode=0
M$3885 VDD VDD \$110 VDD sg13_lv_pmos L=0.13u W=2.24u AS=0.4312p AD=0.6048p
+ PS=3.01u PD=4.44u rfmode=0
M$3887 \$210 \$38 VDD VDD sg13_lv_pmos L=0.13u W=1.12u AS=0.3864p AD=0.431025p
+ PS=2.93u PD=2.145u rfmode=0
M$3888 VDD CLK \$38 VDD sg13_lv_pmos L=0.13u W=1.12u AS=0.431025p AD=0.3808p
+ PS=2.145u PD=2.92u rfmode=0
M$3889 VDD \$116 \$117 VDD sg13_lv_pmos L=0.13u W=2.24u AS=0.5964p AD=0.5964p
+ PS=4.425u PD=4.425u rfmode=0
M$3891 \$7 \$167 \$255 VDD sg13_lv_pmos L=0.13u W=0.84u AS=0.2856p AD=0.1596p
+ PS=2.36u PD=1.22u rfmode=0
M$3892 VDD \$321 \$255 VDD sg13_lv_pmos L=0.13u W=0.84u AS=0.2226p AD=0.1596p
+ PS=1.535u PD=1.22u rfmode=0
M$3893 VDD \$7 \$8 VDD sg13_lv_pmos L=0.13u W=2.24u AS=0.4746p AD=0.6776p
+ PS=3.105u PD=4.57u rfmode=0
M$3895 VDD \$40 \$41 VDD sg13_lv_pmos L=0.13u W=0.42u AS=0.1428p AD=0.0798p
+ PS=1.52u PD=0.8u rfmode=0
M$3896 VDD VDD \$41 VDD sg13_lv_pmos L=0.13u W=0.42u AS=0.3623875p AD=0.0798p
+ PS=2.605u PD=0.8u rfmode=0
M$3897 VDD \$168 \$9 VDD sg13_lv_pmos L=0.13u W=1u AS=0.3623875p AD=0.34p
+ PS=2.605u PD=2.68u rfmode=0
M$3898 \$44 \$196 \$217 VDD sg13_lv_pmos L=0.13u W=0.42u AS=0.19115p AD=0.0525p
+ PS=1.565u PD=0.67u rfmode=0
M$3899 \$217 \$170 VDD VDD sg13_lv_pmos L=0.13u W=0.42u AS=0.0525p AD=0.25605p
+ PS=0.67u PD=1.935u rfmode=0
M$3900 VDD VDD \$170 VDD sg13_lv_pmos L=0.13u W=0.42u AS=0.25605p AD=0.0798p
+ PS=1.935u PD=0.8u rfmode=0
M$3901 VDD \$44 \$170 VDD sg13_lv_pmos L=0.13u W=0.42u AS=0.2014p AD=0.0798p
+ PS=1.53u PD=0.8u rfmode=0
M$3902 VDD \$44 \$46 VDD sg13_lv_pmos L=0.13u W=1u AS=0.2083p AD=0.34p PS=1.5u
+ PD=2.68u rfmode=0
M$3903 VDD \$44 \$45 VDD sg13_lv_pmos L=0.13u W=2.24u AS=0.4142p AD=0.4211p
+ PS=3.03u PD=3u rfmode=0
M$3905 \$9 \$10 \$44 VDD sg13_lv_pmos L=0.13u W=1u AS=0.34p AD=0.19115p
+ PS=2.68u PD=1.565u rfmode=0
M$3906 \$11 \$171 \$256 VDD sg13_lv_pmos L=0.13u W=0.84u AS=0.2856p AD=0.1596p
+ PS=2.36u PD=1.22u rfmode=0
M$3907 VDD \$321 \$256 VDD sg13_lv_pmos L=0.13u W=0.84u AS=0.2226p AD=0.1596p
+ PS=1.535u PD=1.22u rfmode=0
M$3908 VDD \$11 \$12 VDD sg13_lv_pmos L=0.13u W=2.24u AS=0.4746p AD=0.6776p
+ PS=3.105u PD=4.57u rfmode=0
M$3910 VDD \$50 \$51 VDD sg13_lv_pmos L=0.13u W=0.42u AS=0.1428p AD=0.0798p
+ PS=1.52u PD=0.8u rfmode=0
M$3911 VDD VDD \$51 VDD sg13_lv_pmos L=0.13u W=0.42u AS=0.3623875p AD=0.0798p
+ PS=2.605u PD=0.8u rfmode=0
M$3912 VDD \$172 \$13 VDD sg13_lv_pmos L=0.13u W=1u AS=0.3623875p AD=0.34p
+ PS=2.605u PD=2.68u rfmode=0
M$3913 \$54 \$198 \$224 VDD sg13_lv_pmos L=0.13u W=0.42u AS=0.19115p AD=0.0525p
+ PS=1.565u PD=0.67u rfmode=0
M$3914 \$224 \$173 VDD VDD sg13_lv_pmos L=0.13u W=0.42u AS=0.0525p AD=0.25605p
+ PS=0.67u PD=1.935u rfmode=0
M$3915 VDD VDD \$173 VDD sg13_lv_pmos L=0.13u W=0.42u AS=0.25605p AD=0.0798p
+ PS=1.935u PD=0.8u rfmode=0
M$3916 VDD \$54 \$173 VDD sg13_lv_pmos L=0.13u W=0.42u AS=0.2014p AD=0.0798p
+ PS=1.53u PD=0.8u rfmode=0
M$3917 VDD \$54 \$56 VDD sg13_lv_pmos L=0.13u W=1u AS=0.2083p AD=0.34p PS=1.5u
+ PD=2.68u rfmode=0
M$3918 VDD \$54 \$55 VDD sg13_lv_pmos L=0.13u W=2.24u AS=0.4142p AD=0.4211p
+ PS=3.03u PD=3u rfmode=0
M$3920 \$13 \$14 \$54 VDD sg13_lv_pmos L=0.13u W=1u AS=0.34p AD=0.19115p
+ PS=2.68u PD=1.565u rfmode=0
M$3921 \$15 \$174 \$257 VDD sg13_lv_pmos L=0.13u W=0.84u AS=0.2856p AD=0.1596p
+ PS=2.36u PD=1.22u rfmode=0
M$3922 VDD \$321 \$257 VDD sg13_lv_pmos L=0.13u W=0.84u AS=0.2226p AD=0.1596p
+ PS=1.535u PD=1.22u rfmode=0
M$3923 VDD \$15 \$16 VDD sg13_lv_pmos L=0.13u W=2.24u AS=0.4746p AD=0.6776p
+ PS=3.105u PD=4.57u rfmode=0
M$3925 VDD \$60 \$61 VDD sg13_lv_pmos L=0.13u W=0.42u AS=0.1428p AD=0.0798p
+ PS=1.52u PD=0.8u rfmode=0
M$3926 VDD VDD \$61 VDD sg13_lv_pmos L=0.13u W=0.42u AS=0.3623875p AD=0.0798p
+ PS=2.605u PD=0.8u rfmode=0
M$3927 VDD \$175 \$17 VDD sg13_lv_pmos L=0.13u W=1u AS=0.3623875p AD=0.34p
+ PS=2.605u PD=2.68u rfmode=0
M$3928 \$64 \$200 \$233 VDD sg13_lv_pmos L=0.13u W=0.42u AS=0.19115p AD=0.0525p
+ PS=1.565u PD=0.67u rfmode=0
M$3929 \$233 \$176 VDD VDD sg13_lv_pmos L=0.13u W=0.42u AS=0.0525p AD=0.25605p
+ PS=0.67u PD=1.935u rfmode=0
M$3930 VDD VDD \$176 VDD sg13_lv_pmos L=0.13u W=0.42u AS=0.25605p AD=0.0798p
+ PS=1.935u PD=0.8u rfmode=0
M$3931 VDD \$64 \$176 VDD sg13_lv_pmos L=0.13u W=0.42u AS=0.2014p AD=0.0798p
+ PS=1.53u PD=0.8u rfmode=0
M$3932 VDD \$64 \$66 VDD sg13_lv_pmos L=0.13u W=1u AS=0.2083p AD=0.34p PS=1.5u
+ PD=2.68u rfmode=0
M$3933 VDD \$64 \$65 VDD sg13_lv_pmos L=0.13u W=2.24u AS=0.4142p AD=0.4211p
+ PS=3.03u PD=3u rfmode=0
M$3935 \$17 \$18 \$64 VDD sg13_lv_pmos L=0.13u W=1u AS=0.34p AD=0.19115p
+ PS=2.68u PD=1.565u rfmode=0
M$3936 \$19 \$177 \$258 VDD sg13_lv_pmos L=0.13u W=0.84u AS=0.2856p AD=0.1596p
+ PS=2.36u PD=1.22u rfmode=0
M$3937 VDD \$321 \$258 VDD sg13_lv_pmos L=0.13u W=0.84u AS=0.2226p AD=0.1596p
+ PS=1.535u PD=1.22u rfmode=0
M$3938 VDD \$19 \$20 VDD sg13_lv_pmos L=0.13u W=2.24u AS=0.4746p AD=0.6776p
+ PS=3.105u PD=4.57u rfmode=0
M$3940 VDD \$70 \$71 VDD sg13_lv_pmos L=0.13u W=0.42u AS=0.1428p AD=0.0798p
+ PS=1.52u PD=0.8u rfmode=0
M$3941 VDD VDD \$71 VDD sg13_lv_pmos L=0.13u W=0.42u AS=0.3623875p AD=0.0798p
+ PS=2.605u PD=0.8u rfmode=0
M$3942 VDD \$178 \$21 VDD sg13_lv_pmos L=0.13u W=1u AS=0.3623875p AD=0.34p
+ PS=2.605u PD=2.68u rfmode=0
M$3943 \$74 \$202 \$241 VDD sg13_lv_pmos L=0.13u W=0.42u AS=0.19115p AD=0.0525p
+ PS=1.565u PD=0.67u rfmode=0
M$3944 \$241 \$179 VDD VDD sg13_lv_pmos L=0.13u W=0.42u AS=0.0525p AD=0.25605p
+ PS=0.67u PD=1.935u rfmode=0
M$3945 VDD VDD \$179 VDD sg13_lv_pmos L=0.13u W=0.42u AS=0.25605p AD=0.0798p
+ PS=1.935u PD=0.8u rfmode=0
M$3946 VDD \$74 \$179 VDD sg13_lv_pmos L=0.13u W=0.42u AS=0.2014p AD=0.0798p
+ PS=1.53u PD=0.8u rfmode=0
M$3947 VDD \$74 \$76 VDD sg13_lv_pmos L=0.13u W=1u AS=0.2083p AD=0.34p PS=1.5u
+ PD=2.68u rfmode=0
M$3948 VDD \$74 \$75 VDD sg13_lv_pmos L=0.13u W=2.24u AS=0.4142p AD=0.4211p
+ PS=3.03u PD=3u rfmode=0
M$3950 \$21 \$22 \$74 VDD sg13_lv_pmos L=0.13u W=1u AS=0.34p AD=0.19115p
+ PS=2.68u PD=1.565u rfmode=0
M$3951 \$23 \$180 \$259 VDD sg13_lv_pmos L=0.13u W=0.84u AS=0.2856p AD=0.1596p
+ PS=2.36u PD=1.22u rfmode=0
M$3952 VDD \$321 \$259 VDD sg13_lv_pmos L=0.13u W=0.84u AS=0.2226p AD=0.1596p
+ PS=1.535u PD=1.22u rfmode=0
M$3953 VDD \$23 \$24 VDD sg13_lv_pmos L=0.13u W=2.24u AS=0.4746p AD=0.6776p
+ PS=3.105u PD=4.57u rfmode=0
M$3955 VDD \$80 \$81 VDD sg13_lv_pmos L=0.13u W=0.42u AS=0.1428p AD=0.0798p
+ PS=1.52u PD=0.8u rfmode=0
M$3956 VDD VDD \$81 VDD sg13_lv_pmos L=0.13u W=0.42u AS=0.3623875p AD=0.0798p
+ PS=2.605u PD=0.8u rfmode=0
M$3957 VDD \$181 \$25 VDD sg13_lv_pmos L=0.13u W=1u AS=0.3623875p AD=0.34p
+ PS=2.605u PD=2.68u rfmode=0
M$3958 \$84 \$204 \$249 VDD sg13_lv_pmos L=0.13u W=0.42u AS=0.19115p AD=0.0525p
+ PS=1.565u PD=0.67u rfmode=0
M$3959 \$249 \$182 VDD VDD sg13_lv_pmos L=0.13u W=0.42u AS=0.0525p AD=0.25605p
+ PS=0.67u PD=1.935u rfmode=0
M$3960 VDD VDD \$182 VDD sg13_lv_pmos L=0.13u W=0.42u AS=0.25605p AD=0.0798p
+ PS=1.935u PD=0.8u rfmode=0
M$3961 VDD \$84 \$182 VDD sg13_lv_pmos L=0.13u W=0.42u AS=0.2014p AD=0.0798p
+ PS=1.53u PD=0.8u rfmode=0
M$3962 VDD \$84 \$86 VDD sg13_lv_pmos L=0.13u W=1u AS=0.2083p AD=0.34p PS=1.5u
+ PD=2.68u rfmode=0
M$3963 VDD \$84 \$85 VDD sg13_lv_pmos L=0.13u W=2.24u AS=0.4142p AD=0.4211p
+ PS=3.03u PD=3u rfmode=0
M$3965 \$25 \$26 \$84 VDD sg13_lv_pmos L=0.13u W=1u AS=0.34p AD=0.19115p
+ PS=2.68u PD=1.565u rfmode=0
M$3966 \$27 \$183 \$260 VDD sg13_lv_pmos L=0.13u W=0.84u AS=0.2856p AD=0.1596p
+ PS=2.36u PD=1.22u rfmode=0
M$3967 VDD \$321 \$260 VDD sg13_lv_pmos L=0.13u W=0.84u AS=0.2226p AD=0.1596p
+ PS=1.535u PD=1.22u rfmode=0
M$3968 VDD \$27 \$28 VDD sg13_lv_pmos L=0.13u W=2.24u AS=0.4746p AD=0.6776p
+ PS=3.105u PD=4.57u rfmode=0
M$3970 VDD \$90 \$91 VDD sg13_lv_pmos L=0.13u W=0.42u AS=0.1428p AD=0.0798p
+ PS=1.52u PD=0.8u rfmode=0
M$3971 VDD VDD \$91 VDD sg13_lv_pmos L=0.13u W=0.42u AS=0.3623875p AD=0.0798p
+ PS=2.605u PD=0.8u rfmode=0
M$3972 VDD \$184 \$29 VDD sg13_lv_pmos L=0.13u W=1u AS=0.3623875p AD=0.34p
+ PS=2.605u PD=2.68u rfmode=0
M$3973 \$94 \$206 \$242 VDD sg13_lv_pmos L=0.13u W=0.42u AS=0.19115p AD=0.0525p
+ PS=1.565u PD=0.67u rfmode=0
M$3974 \$242 \$185 VDD VDD sg13_lv_pmos L=0.13u W=0.42u AS=0.0525p AD=0.25605p
+ PS=0.67u PD=1.935u rfmode=0
M$3975 VDD VDD \$185 VDD sg13_lv_pmos L=0.13u W=0.42u AS=0.25605p AD=0.0798p
+ PS=1.935u PD=0.8u rfmode=0
M$3976 VDD \$94 \$185 VDD sg13_lv_pmos L=0.13u W=0.42u AS=0.2014p AD=0.0798p
+ PS=1.53u PD=0.8u rfmode=0
M$3977 VDD \$94 \$96 VDD sg13_lv_pmos L=0.13u W=1u AS=0.2083p AD=0.34p PS=1.5u
+ PD=2.68u rfmode=0
M$3978 VDD \$94 \$95 VDD sg13_lv_pmos L=0.13u W=2.24u AS=0.4142p AD=0.4211p
+ PS=3.03u PD=3u rfmode=0
M$3980 \$29 \$30 \$94 VDD sg13_lv_pmos L=0.13u W=1u AS=0.34p AD=0.19115p
+ PS=2.68u PD=1.565u rfmode=0
M$3981 \$31 \$186 \$262 VDD sg13_lv_pmos L=0.13u W=0.84u AS=0.2856p AD=0.1596p
+ PS=2.36u PD=1.22u rfmode=0
M$3982 VDD \$321 \$262 VDD sg13_lv_pmos L=0.13u W=0.84u AS=0.2226p AD=0.1596p
+ PS=1.535u PD=1.22u rfmode=0
M$3983 VDD \$31 \$32 VDD sg13_lv_pmos L=0.13u W=2.24u AS=0.4746p AD=0.6776p
+ PS=3.105u PD=4.57u rfmode=0
M$3985 VDD \$100 \$101 VDD sg13_lv_pmos L=0.13u W=0.42u AS=0.1428p AD=0.0798p
+ PS=1.52u PD=0.8u rfmode=0
M$3986 VDD VDD \$101 VDD sg13_lv_pmos L=0.13u W=0.42u AS=0.3623875p AD=0.0798p
+ PS=2.605u PD=0.8u rfmode=0
M$3987 VDD \$187 \$33 VDD sg13_lv_pmos L=0.13u W=1u AS=0.3623875p AD=0.34p
+ PS=2.605u PD=2.68u rfmode=0
M$3988 \$104 \$208 \$230 VDD sg13_lv_pmos L=0.13u W=0.42u AS=0.19115p
+ AD=0.0525p PS=1.565u PD=0.67u rfmode=0
M$3989 \$230 \$188 VDD VDD sg13_lv_pmos L=0.13u W=0.42u AS=0.0525p AD=0.25605p
+ PS=0.67u PD=1.935u rfmode=0
M$3990 VDD VDD \$188 VDD sg13_lv_pmos L=0.13u W=0.42u AS=0.25605p AD=0.0798p
+ PS=1.935u PD=0.8u rfmode=0
M$3991 VDD \$104 \$188 VDD sg13_lv_pmos L=0.13u W=0.42u AS=0.2014p AD=0.0798p
+ PS=1.53u PD=0.8u rfmode=0
M$3992 VDD \$104 \$106 VDD sg13_lv_pmos L=0.13u W=1u AS=0.2083p AD=0.34p
+ PS=1.5u PD=2.68u rfmode=0
M$3993 VDD \$104 \$105 VDD sg13_lv_pmos L=0.13u W=2.24u AS=0.4142p AD=0.4211p
+ PS=3.03u PD=3u rfmode=0
M$3995 \$33 \$34 \$104 VDD sg13_lv_pmos L=0.13u W=1u AS=0.34p AD=0.19115p
+ PS=2.68u PD=1.565u rfmode=0
M$3996 \$35 VSS \$261 VDD sg13_lv_pmos L=0.13u W=0.84u AS=0.2856p AD=0.1596p
+ PS=2.36u PD=1.22u rfmode=0
M$3997 VDD \$321 \$261 VDD sg13_lv_pmos L=0.13u W=0.84u AS=0.2226p AD=0.1596p
+ PS=1.535u PD=1.22u rfmode=0
M$3998 VDD \$35 \$36 VDD sg13_lv_pmos L=0.13u W=2.24u AS=0.4746p AD=0.6776p
+ PS=3.105u PD=4.57u rfmode=0
M$4000 VDD \$110 \$111 VDD sg13_lv_pmos L=0.13u W=0.42u AS=0.1428p AD=0.0798p
+ PS=1.52u PD=0.8u rfmode=0
M$4001 VDD VDD \$111 VDD sg13_lv_pmos L=0.13u W=0.42u AS=0.3623875p AD=0.0798p
+ PS=2.605u PD=0.8u rfmode=0
M$4002 VDD \$189 \$37 VDD sg13_lv_pmos L=0.13u W=1u AS=0.3623875p AD=0.34p
+ PS=2.605u PD=2.68u rfmode=0
M$4003 \$114 \$210 \$216 VDD sg13_lv_pmos L=0.13u W=0.42u AS=0.19115p
+ AD=0.0525p PS=1.565u PD=0.67u rfmode=0
M$4004 \$216 \$190 VDD VDD sg13_lv_pmos L=0.13u W=0.42u AS=0.0525p AD=0.25605p
+ PS=0.67u PD=1.935u rfmode=0
M$4005 VDD VDD \$190 VDD sg13_lv_pmos L=0.13u W=0.42u AS=0.25605p AD=0.0798p
+ PS=1.935u PD=0.8u rfmode=0
M$4006 VDD \$114 \$190 VDD sg13_lv_pmos L=0.13u W=0.42u AS=0.2014p AD=0.0798p
+ PS=1.53u PD=0.8u rfmode=0
M$4007 VDD \$114 \$116 VDD sg13_lv_pmos L=0.13u W=1u AS=0.2083p AD=0.34p
+ PS=1.5u PD=2.68u rfmode=0
M$4008 VDD \$114 \$115 VDD sg13_lv_pmos L=0.13u W=2.24u AS=0.4142p AD=0.4211p
+ PS=3.03u PD=3u rfmode=0
M$4010 \$37 \$38 \$114 VDD sg13_lv_pmos L=0.13u W=1u AS=0.34p AD=0.19115p
+ PS=2.68u PD=1.565u rfmode=0
M$4011 \$313 X9 \$317 VDD sg13_lv_pmos L=0.13u W=0.84u AS=0.2856p AD=0.1596p
+ PS=2.36u PD=1.22u rfmode=0
M$4012 \$317 X8 VDD VDD sg13_lv_pmos L=0.13u W=0.84u AS=0.1596p AD=0.2226p
+ PS=1.22u PD=1.535u rfmode=0
M$4013 VDD \$313 \$314 VDD sg13_lv_pmos L=0.13u W=2.24u AS=0.4746p AD=0.6776p
+ PS=3.105u PD=4.57u rfmode=0
M$4015 \$318 X9 \$325 VDD sg13_lv_pmos L=0.13u W=0.84u AS=0.2856p AD=0.1596p
+ PS=2.36u PD=1.22u rfmode=0
M$4016 VDD X10 \$325 VDD sg13_lv_pmos L=0.13u W=0.84u AS=0.2226p AD=0.1596p
+ PS=1.535u PD=1.22u rfmode=0
M$4017 VDD \$318 \$319 VDD sg13_lv_pmos L=0.13u W=2.24u AS=0.4746p AD=0.6776p
+ PS=3.105u PD=4.57u rfmode=0
M$4019 VDD X9 \$323 VDD sg13_lv_pmos L=0.13u W=0.84u AS=0.2856p AD=0.1596p
+ PS=2.36u PD=1.22u rfmode=0
M$4020 \$323 X10 VDD VDD sg13_lv_pmos L=0.13u W=0.84u AS=0.1596p AD=0.1918p
+ PS=1.22u PD=1.5u rfmode=0
M$4021 VDD \$323 \$324 VDD sg13_lv_pmos L=0.13u W=2.24u AS=0.4046p AD=0.6384p
+ PS=3u PD=4.5u rfmode=0
M$4023 VDD X8 \$192 VDD sg13_lv_pmos L=0.13u W=0.84u AS=0.2856p AD=0.1596p
+ PS=2.36u PD=1.22u rfmode=0
M$4024 VDD X9 \$192 VDD sg13_lv_pmos L=0.13u W=0.84u AS=0.1918p AD=0.1596p
+ PS=1.5u PD=1.22u rfmode=0
M$4025 VDD \$192 \$193 VDD sg13_lv_pmos L=0.13u W=2.24u AS=0.4046p AD=0.6384p
+ PS=3u PD=4.5u rfmode=0
M$4027 \$194 X10 \$265 VDD sg13_lv_pmos L=0.13u W=0.84u AS=0.2856p AD=0.1596p
+ PS=2.36u PD=1.22u rfmode=0
M$4028 VDD \$193 \$265 VDD sg13_lv_pmos L=0.13u W=0.84u AS=0.2226p AD=0.1596p
+ PS=1.535u PD=1.22u rfmode=0
M$4029 VDD \$194 \$195 VDD sg13_lv_pmos L=0.13u W=2.24u AS=0.4746p AD=0.6776p
+ PS=3.105u PD=4.57u rfmode=0
M$4031 \$320 X8 \$326 VDD sg13_lv_pmos L=0.13u W=0.84u AS=0.2856p AD=0.1596p
+ PS=2.36u PD=1.22u rfmode=0
M$4032 VDD \$319 \$326 VDD sg13_lv_pmos L=0.13u W=0.84u AS=0.2226p AD=0.1596p
+ PS=1.535u PD=1.22u rfmode=0
M$4033 VDD \$320 \$321 VDD sg13_lv_pmos L=0.13u W=2.24u AS=0.4746p AD=0.6776p
+ PS=3.105u PD=4.57u rfmode=0
M$4035 VDD X10 \$315 VDD sg13_lv_pmos L=0.13u W=0.84u AS=0.2856p AD=0.1596p
+ PS=2.36u PD=1.22u rfmode=0
M$4036 \$315 \$314 VDD VDD sg13_lv_pmos L=0.13u W=0.84u AS=0.1596p AD=0.1918p
+ PS=1.22u PD=1.5u rfmode=0
M$4037 VDD \$315 \$316 VDD sg13_lv_pmos L=0.13u W=2.24u AS=0.4046p AD=0.6384p
+ PS=3u PD=4.5u rfmode=0
M$4039 VDD \$328 \$360 VDD sg13_lv_pmos L=0.13u W=2.24u AS=0.616p AD=0.4312p
+ PS=4.46u PD=3.01u rfmode=0
M$4041 VDD \$321 \$360 VDD sg13_lv_pmos L=0.13u W=2.24u AS=0.4312p AD=0.6048p
+ PS=3.01u PD=4.44u rfmode=0
M$4043 \$168 VDD VDD VDD sg13_lv_pmos L=0.13u W=0.42u AS=0.147p AD=0.1563p
+ PS=1.54u PD=1.22u rfmode=0
M$4044 VDD \$9 \$215 VDD sg13_lv_pmos L=0.13u W=0.42u AS=0.1563p AD=0.0546p
+ PS=1.22u PD=0.68u rfmode=0
M$4045 \$215 \$10 \$168 VDD sg13_lv_pmos L=0.13u W=0.42u AS=0.0546p AD=0.0798p
+ PS=0.68u PD=0.8u rfmode=0
M$4046 \$168 \$196 \$41 VDD sg13_lv_pmos L=0.13u W=0.42u AS=0.0798p AD=0.1428p
+ PS=0.8u PD=1.52u rfmode=0
M$4047 \$503 \$330 VDD VDD sg13_lv_pmos L=0.13u W=1.12u AS=0.3864p AD=0.431025p
+ PS=2.93u PD=2.145u rfmode=0
M$4048 VDD CLK \$330 VDD sg13_lv_pmos L=0.13u W=1.12u AS=0.431025p AD=0.3808p
+ PS=2.145u PD=2.92u rfmode=0
M$4049 \$364 \$503 \$525 VDD sg13_lv_pmos L=0.13u W=0.42u AS=0.19115p
+ AD=0.0525p PS=1.565u PD=0.67u rfmode=0
M$4050 \$525 \$488 VDD VDD sg13_lv_pmos L=0.13u W=0.42u AS=0.0525p AD=0.25605p
+ PS=0.67u PD=1.935u rfmode=0
M$4051 VDD VDD \$488 VDD sg13_lv_pmos L=0.13u W=0.42u AS=0.25605p AD=0.0798p
+ PS=1.935u PD=0.8u rfmode=0
M$4052 VDD \$364 \$488 VDD sg13_lv_pmos L=0.13u W=0.42u AS=0.2014p AD=0.0798p
+ PS=1.53u PD=0.8u rfmode=0
M$4053 VDD \$364 \$366 VDD sg13_lv_pmos L=0.13u W=1u AS=0.2083p AD=0.34p
+ PS=1.5u PD=2.68u rfmode=0
M$4054 VDD \$364 \$365 VDD sg13_lv_pmos L=0.13u W=2.24u AS=0.4142p AD=0.4211p
+ PS=3.03u PD=3u rfmode=0
M$4056 \$329 \$330 \$364 VDD sg13_lv_pmos L=0.13u W=1u AS=0.34p AD=0.19115p
+ PS=2.68u PD=1.565u rfmode=0
M$4057 VDD \$366 \$367 VDD sg13_lv_pmos L=0.13u W=2.24u AS=0.5964p AD=0.5964p
+ PS=4.425u PD=4.425u rfmode=0
M$4059 VDD \$332 \$370 VDD sg13_lv_pmos L=0.13u W=2.24u AS=0.616p AD=0.4312p
+ PS=4.46u PD=3.01u rfmode=0
M$4061 VDD \$321 \$370 VDD sg13_lv_pmos L=0.13u W=2.24u AS=0.4312p AD=0.6048p
+ PS=3.01u PD=4.44u rfmode=0
M$4063 \$172 VDD VDD VDD sg13_lv_pmos L=0.13u W=0.42u AS=0.147p AD=0.1563p
+ PS=1.54u PD=1.22u rfmode=0
M$4064 VDD \$13 \$223 VDD sg13_lv_pmos L=0.13u W=0.42u AS=0.1563p AD=0.0546p
+ PS=1.22u PD=0.68u rfmode=0
M$4065 \$223 \$14 \$172 VDD sg13_lv_pmos L=0.13u W=0.42u AS=0.0546p AD=0.0798p
+ PS=0.68u PD=0.8u rfmode=0
M$4066 \$172 \$198 \$51 VDD sg13_lv_pmos L=0.13u W=0.42u AS=0.0798p AD=0.1428p
+ PS=0.8u PD=1.52u rfmode=0
M$4067 \$505 \$334 VDD VDD sg13_lv_pmos L=0.13u W=1.12u AS=0.3864p AD=0.431025p
+ PS=2.93u PD=2.145u rfmode=0
M$4068 VDD CLK \$334 VDD sg13_lv_pmos L=0.13u W=1.12u AS=0.431025p AD=0.3808p
+ PS=2.145u PD=2.92u rfmode=0
M$4069 \$374 \$505 \$532 VDD sg13_lv_pmos L=0.13u W=0.42u AS=0.19115p
+ AD=0.0525p PS=1.565u PD=0.67u rfmode=0
M$4070 \$532 \$490 VDD VDD sg13_lv_pmos L=0.13u W=0.42u AS=0.0525p AD=0.25605p
+ PS=0.67u PD=1.935u rfmode=0
M$4071 VDD VDD \$490 VDD sg13_lv_pmos L=0.13u W=0.42u AS=0.25605p AD=0.0798p
+ PS=1.935u PD=0.8u rfmode=0
M$4072 VDD \$374 \$490 VDD sg13_lv_pmos L=0.13u W=0.42u AS=0.2014p AD=0.0798p
+ PS=1.53u PD=0.8u rfmode=0
M$4073 VDD \$374 \$376 VDD sg13_lv_pmos L=0.13u W=1u AS=0.2083p AD=0.34p
+ PS=1.5u PD=2.68u rfmode=0
M$4074 VDD \$374 \$375 VDD sg13_lv_pmos L=0.13u W=2.24u AS=0.4142p AD=0.4211p
+ PS=3.03u PD=3u rfmode=0
M$4076 \$333 \$334 \$374 VDD sg13_lv_pmos L=0.13u W=1u AS=0.34p AD=0.19115p
+ PS=2.68u PD=1.565u rfmode=0
M$4077 VDD \$376 \$377 VDD sg13_lv_pmos L=0.13u W=2.24u AS=0.5964p AD=0.5964p
+ PS=4.425u PD=4.425u rfmode=0
M$4079 VDD \$336 \$380 VDD sg13_lv_pmos L=0.13u W=2.24u AS=0.616p AD=0.4312p
+ PS=4.46u PD=3.01u rfmode=0
M$4081 VDD \$321 \$380 VDD sg13_lv_pmos L=0.13u W=2.24u AS=0.4312p AD=0.6048p
+ PS=3.01u PD=4.44u rfmode=0
M$4083 \$175 VDD VDD VDD sg13_lv_pmos L=0.13u W=0.42u AS=0.147p AD=0.1563p
+ PS=1.54u PD=1.22u rfmode=0
M$4084 VDD \$17 \$232 VDD sg13_lv_pmos L=0.13u W=0.42u AS=0.1563p AD=0.0546p
+ PS=1.22u PD=0.68u rfmode=0
M$4085 \$232 \$18 \$175 VDD sg13_lv_pmos L=0.13u W=0.42u AS=0.0546p AD=0.0798p
+ PS=0.68u PD=0.8u rfmode=0
M$4086 \$175 \$200 \$61 VDD sg13_lv_pmos L=0.13u W=0.42u AS=0.0798p AD=0.1428p
+ PS=0.8u PD=1.52u rfmode=0
M$4087 \$507 \$338 VDD VDD sg13_lv_pmos L=0.13u W=1.12u AS=0.3864p AD=0.431025p
+ PS=2.93u PD=2.145u rfmode=0
M$4088 VDD CLK \$338 VDD sg13_lv_pmos L=0.13u W=1.12u AS=0.431025p AD=0.3808p
+ PS=2.145u PD=2.92u rfmode=0
M$4089 \$384 \$507 \$541 VDD sg13_lv_pmos L=0.13u W=0.42u AS=0.19115p
+ AD=0.0525p PS=1.565u PD=0.67u rfmode=0
M$4090 \$541 \$492 VDD VDD sg13_lv_pmos L=0.13u W=0.42u AS=0.0525p AD=0.25605p
+ PS=0.67u PD=1.935u rfmode=0
M$4091 VDD VDD \$492 VDD sg13_lv_pmos L=0.13u W=0.42u AS=0.25605p AD=0.0798p
+ PS=1.935u PD=0.8u rfmode=0
M$4092 VDD \$384 \$492 VDD sg13_lv_pmos L=0.13u W=0.42u AS=0.2014p AD=0.0798p
+ PS=1.53u PD=0.8u rfmode=0
M$4093 VDD \$384 \$386 VDD sg13_lv_pmos L=0.13u W=1u AS=0.2083p AD=0.34p
+ PS=1.5u PD=2.68u rfmode=0
M$4094 VDD \$384 \$385 VDD sg13_lv_pmos L=0.13u W=2.24u AS=0.4142p AD=0.4211p
+ PS=3.03u PD=3u rfmode=0
M$4096 \$337 \$338 \$384 VDD sg13_lv_pmos L=0.13u W=1u AS=0.34p AD=0.19115p
+ PS=2.68u PD=1.565u rfmode=0
M$4097 VDD \$386 \$387 VDD sg13_lv_pmos L=0.13u W=2.24u AS=0.5964p AD=0.5964p
+ PS=4.425u PD=4.425u rfmode=0
M$4099 VDD \$340 \$390 VDD sg13_lv_pmos L=0.13u W=2.24u AS=0.616p AD=0.4312p
+ PS=4.46u PD=3.01u rfmode=0
M$4101 VDD \$321 \$390 VDD sg13_lv_pmos L=0.13u W=2.24u AS=0.4312p AD=0.6048p
+ PS=3.01u PD=4.44u rfmode=0
M$4103 \$178 VDD VDD VDD sg13_lv_pmos L=0.13u W=0.42u AS=0.147p AD=0.1563p
+ PS=1.54u PD=1.22u rfmode=0
M$4104 VDD \$21 \$240 VDD sg13_lv_pmos L=0.13u W=0.42u AS=0.1563p AD=0.0546p
+ PS=1.22u PD=0.68u rfmode=0
M$4105 \$240 \$22 \$178 VDD sg13_lv_pmos L=0.13u W=0.42u AS=0.0546p AD=0.0798p
+ PS=0.68u PD=0.8u rfmode=0
M$4106 \$178 \$202 \$71 VDD sg13_lv_pmos L=0.13u W=0.42u AS=0.0798p AD=0.1428p
+ PS=0.8u PD=1.52u rfmode=0
M$4107 \$509 \$342 VDD VDD sg13_lv_pmos L=0.13u W=1.12u AS=0.3864p AD=0.431025p
+ PS=2.93u PD=2.145u rfmode=0
M$4108 VDD CLK \$342 VDD sg13_lv_pmos L=0.13u W=1.12u AS=0.431025p AD=0.3808p
+ PS=2.145u PD=2.92u rfmode=0
M$4109 \$394 \$509 \$549 VDD sg13_lv_pmos L=0.13u W=0.42u AS=0.19115p
+ AD=0.0525p PS=1.565u PD=0.67u rfmode=0
M$4110 \$549 \$494 VDD VDD sg13_lv_pmos L=0.13u W=0.42u AS=0.0525p AD=0.25605p
+ PS=0.67u PD=1.935u rfmode=0
M$4111 VDD VDD \$494 VDD sg13_lv_pmos L=0.13u W=0.42u AS=0.25605p AD=0.0798p
+ PS=1.935u PD=0.8u rfmode=0
M$4112 VDD \$394 \$494 VDD sg13_lv_pmos L=0.13u W=0.42u AS=0.2014p AD=0.0798p
+ PS=1.53u PD=0.8u rfmode=0
M$4113 VDD \$394 \$396 VDD sg13_lv_pmos L=0.13u W=1u AS=0.2083p AD=0.34p
+ PS=1.5u PD=2.68u rfmode=0
M$4114 VDD \$394 \$395 VDD sg13_lv_pmos L=0.13u W=2.24u AS=0.4142p AD=0.4211p
+ PS=3.03u PD=3u rfmode=0
M$4116 \$341 \$342 \$394 VDD sg13_lv_pmos L=0.13u W=1u AS=0.34p AD=0.19115p
+ PS=2.68u PD=1.565u rfmode=0
M$4117 VDD \$396 \$397 VDD sg13_lv_pmos L=0.13u W=2.24u AS=0.5964p AD=0.5964p
+ PS=4.425u PD=4.425u rfmode=0
M$4119 VDD \$344 \$400 VDD sg13_lv_pmos L=0.13u W=2.24u AS=0.616p AD=0.4312p
+ PS=4.46u PD=3.01u rfmode=0
M$4121 VDD \$321 \$400 VDD sg13_lv_pmos L=0.13u W=2.24u AS=0.4312p AD=0.6048p
+ PS=3.01u PD=4.44u rfmode=0
M$4123 \$181 VDD VDD VDD sg13_lv_pmos L=0.13u W=0.42u AS=0.147p AD=0.1563p
+ PS=1.54u PD=1.22u rfmode=0
M$4124 VDD \$25 \$248 VDD sg13_lv_pmos L=0.13u W=0.42u AS=0.1563p AD=0.0546p
+ PS=1.22u PD=0.68u rfmode=0
M$4125 \$248 \$26 \$181 VDD sg13_lv_pmos L=0.13u W=0.42u AS=0.0546p AD=0.0798p
+ PS=0.68u PD=0.8u rfmode=0
M$4126 \$181 \$204 \$81 VDD sg13_lv_pmos L=0.13u W=0.42u AS=0.0798p AD=0.1428p
+ PS=0.8u PD=1.52u rfmode=0
M$4127 \$511 \$346 VDD VDD sg13_lv_pmos L=0.13u W=1.12u AS=0.3864p AD=0.431025p
+ PS=2.93u PD=2.145u rfmode=0
M$4128 VDD CLK \$346 VDD sg13_lv_pmos L=0.13u W=1.12u AS=0.431025p AD=0.3808p
+ PS=2.145u PD=2.92u rfmode=0
M$4129 \$404 \$511 \$557 VDD sg13_lv_pmos L=0.13u W=0.42u AS=0.19115p
+ AD=0.0525p PS=1.565u PD=0.67u rfmode=0
M$4130 \$557 \$496 VDD VDD sg13_lv_pmos L=0.13u W=0.42u AS=0.0525p AD=0.25605p
+ PS=0.67u PD=1.935u rfmode=0
M$4131 VDD VDD \$496 VDD sg13_lv_pmos L=0.13u W=0.42u AS=0.25605p AD=0.0798p
+ PS=1.935u PD=0.8u rfmode=0
M$4132 VDD \$404 \$496 VDD sg13_lv_pmos L=0.13u W=0.42u AS=0.2014p AD=0.0798p
+ PS=1.53u PD=0.8u rfmode=0
M$4133 VDD \$404 \$406 VDD sg13_lv_pmos L=0.13u W=1u AS=0.2083p AD=0.34p
+ PS=1.5u PD=2.68u rfmode=0
M$4134 VDD \$404 \$405 VDD sg13_lv_pmos L=0.13u W=2.24u AS=0.4142p AD=0.4211p
+ PS=3.03u PD=3u rfmode=0
M$4136 \$345 \$346 \$404 VDD sg13_lv_pmos L=0.13u W=1u AS=0.34p AD=0.19115p
+ PS=2.68u PD=1.565u rfmode=0
M$4137 VDD \$406 \$407 VDD sg13_lv_pmos L=0.13u W=2.24u AS=0.5964p AD=0.5964p
+ PS=4.425u PD=4.425u rfmode=0
M$4139 VDD \$348 \$410 VDD sg13_lv_pmos L=0.13u W=2.24u AS=0.616p AD=0.4312p
+ PS=4.46u PD=3.01u rfmode=0
M$4141 VDD \$321 \$410 VDD sg13_lv_pmos L=0.13u W=2.24u AS=0.4312p AD=0.6048p
+ PS=3.01u PD=4.44u rfmode=0
M$4143 \$184 VDD VDD VDD sg13_lv_pmos L=0.13u W=0.42u AS=0.147p AD=0.1563p
+ PS=1.54u PD=1.22u rfmode=0
M$4144 VDD \$29 \$244 VDD sg13_lv_pmos L=0.13u W=0.42u AS=0.1563p AD=0.0546p
+ PS=1.22u PD=0.68u rfmode=0
M$4145 \$244 \$30 \$184 VDD sg13_lv_pmos L=0.13u W=0.42u AS=0.0546p AD=0.0798p
+ PS=0.68u PD=0.8u rfmode=0
M$4146 \$184 \$206 \$91 VDD sg13_lv_pmos L=0.13u W=0.42u AS=0.0798p AD=0.1428p
+ PS=0.8u PD=1.52u rfmode=0
M$4147 \$513 \$350 VDD VDD sg13_lv_pmos L=0.13u W=1.12u AS=0.3864p AD=0.431025p
+ PS=2.93u PD=2.145u rfmode=0
M$4148 VDD CLK \$350 VDD sg13_lv_pmos L=0.13u W=1.12u AS=0.431025p AD=0.3808p
+ PS=2.145u PD=2.92u rfmode=0
M$4149 \$414 \$513 \$550 VDD sg13_lv_pmos L=0.13u W=0.42u AS=0.19115p
+ AD=0.0525p PS=1.565u PD=0.67u rfmode=0
M$4150 \$550 \$498 VDD VDD sg13_lv_pmos L=0.13u W=0.42u AS=0.0525p AD=0.25605p
+ PS=0.67u PD=1.935u rfmode=0
M$4151 VDD VDD \$498 VDD sg13_lv_pmos L=0.13u W=0.42u AS=0.25605p AD=0.0798p
+ PS=1.935u PD=0.8u rfmode=0
M$4152 VDD \$414 \$498 VDD sg13_lv_pmos L=0.13u W=0.42u AS=0.2014p AD=0.0798p
+ PS=1.53u PD=0.8u rfmode=0
M$4153 VDD \$414 \$416 VDD sg13_lv_pmos L=0.13u W=1u AS=0.2083p AD=0.34p
+ PS=1.5u PD=2.68u rfmode=0
M$4154 VDD \$414 \$415 VDD sg13_lv_pmos L=0.13u W=2.24u AS=0.4142p AD=0.4211p
+ PS=3.03u PD=3u rfmode=0
M$4156 \$349 \$350 \$414 VDD sg13_lv_pmos L=0.13u W=1u AS=0.34p AD=0.19115p
+ PS=2.68u PD=1.565u rfmode=0
M$4157 VDD \$416 \$417 VDD sg13_lv_pmos L=0.13u W=2.24u AS=0.5964p AD=0.5964p
+ PS=4.425u PD=4.425u rfmode=0
M$4159 VDD \$352 \$420 VDD sg13_lv_pmos L=0.13u W=2.24u AS=0.616p AD=0.4312p
+ PS=4.46u PD=3.01u rfmode=0
M$4161 VDD \$321 \$420 VDD sg13_lv_pmos L=0.13u W=2.24u AS=0.4312p AD=0.6048p
+ PS=3.01u PD=4.44u rfmode=0
M$4163 \$187 VDD VDD VDD sg13_lv_pmos L=0.13u W=0.42u AS=0.147p AD=0.1563p
+ PS=1.54u PD=1.22u rfmode=0
M$4164 VDD \$33 \$231 VDD sg13_lv_pmos L=0.13u W=0.42u AS=0.1563p AD=0.0546p
+ PS=1.22u PD=0.68u rfmode=0
M$4165 \$231 \$34 \$187 VDD sg13_lv_pmos L=0.13u W=0.42u AS=0.0546p AD=0.0798p
+ PS=0.68u PD=0.8u rfmode=0
M$4166 \$187 \$208 \$101 VDD sg13_lv_pmos L=0.13u W=0.42u AS=0.0798p AD=0.1428p
+ PS=0.8u PD=1.52u rfmode=0
M$4167 \$515 \$354 VDD VDD sg13_lv_pmos L=0.13u W=1.12u AS=0.3864p AD=0.431025p
+ PS=2.93u PD=2.145u rfmode=0
M$4168 VDD CLK \$354 VDD sg13_lv_pmos L=0.13u W=1.12u AS=0.431025p AD=0.3808p
+ PS=2.145u PD=2.92u rfmode=0
M$4169 \$424 \$515 \$538 VDD sg13_lv_pmos L=0.13u W=0.42u AS=0.19115p
+ AD=0.0525p PS=1.565u PD=0.67u rfmode=0
M$4170 \$538 \$500 VDD VDD sg13_lv_pmos L=0.13u W=0.42u AS=0.0525p AD=0.25605p
+ PS=0.67u PD=1.935u rfmode=0
M$4171 VDD VDD \$500 VDD sg13_lv_pmos L=0.13u W=0.42u AS=0.25605p AD=0.0798p
+ PS=1.935u PD=0.8u rfmode=0
M$4172 VDD \$424 \$500 VDD sg13_lv_pmos L=0.13u W=0.42u AS=0.2014p AD=0.0798p
+ PS=1.53u PD=0.8u rfmode=0
M$4173 VDD \$424 \$426 VDD sg13_lv_pmos L=0.13u W=1u AS=0.2083p AD=0.34p
+ PS=1.5u PD=2.68u rfmode=0
M$4174 VDD \$424 \$425 VDD sg13_lv_pmos L=0.13u W=2.24u AS=0.4142p AD=0.4211p
+ PS=3.03u PD=3u rfmode=0
M$4176 \$353 \$354 \$424 VDD sg13_lv_pmos L=0.13u W=1u AS=0.34p AD=0.19115p
+ PS=2.68u PD=1.565u rfmode=0
M$4177 VDD \$426 \$427 VDD sg13_lv_pmos L=0.13u W=2.24u AS=0.5964p AD=0.5964p
+ PS=4.425u PD=4.425u rfmode=0
M$4179 VDD \$356 \$430 VDD sg13_lv_pmos L=0.13u W=2.24u AS=0.616p AD=0.4312p
+ PS=4.46u PD=3.01u rfmode=0
M$4181 VDD \$321 \$430 VDD sg13_lv_pmos L=0.13u W=2.24u AS=0.4312p AD=0.6048p
+ PS=3.01u PD=4.44u rfmode=0
M$4183 \$189 VDD VDD VDD sg13_lv_pmos L=0.13u W=0.42u AS=0.147p AD=0.1563p
+ PS=1.54u PD=1.22u rfmode=0
M$4184 VDD \$37 \$218 VDD sg13_lv_pmos L=0.13u W=0.42u AS=0.1563p AD=0.0546p
+ PS=1.22u PD=0.68u rfmode=0
M$4185 \$218 \$38 \$189 VDD sg13_lv_pmos L=0.13u W=0.42u AS=0.0546p AD=0.0798p
+ PS=0.68u PD=0.8u rfmode=0
M$4186 \$189 \$210 \$111 VDD sg13_lv_pmos L=0.13u W=0.42u AS=0.0798p AD=0.1428p
+ PS=0.8u PD=1.52u rfmode=0
M$4187 \$517 \$358 VDD VDD sg13_lv_pmos L=0.13u W=1.12u AS=0.3864p AD=0.431025p
+ PS=2.93u PD=2.145u rfmode=0
M$4188 VDD CLK \$358 VDD sg13_lv_pmos L=0.13u W=1.12u AS=0.431025p AD=0.3808p
+ PS=2.145u PD=2.92u rfmode=0
M$4189 \$434 \$517 \$524 VDD sg13_lv_pmos L=0.13u W=0.42u AS=0.19115p
+ AD=0.0525p PS=1.565u PD=0.67u rfmode=0
M$4190 \$524 \$502 VDD VDD sg13_lv_pmos L=0.13u W=0.42u AS=0.0525p AD=0.25605p
+ PS=0.67u PD=1.935u rfmode=0
M$4191 VDD VDD \$502 VDD sg13_lv_pmos L=0.13u W=0.42u AS=0.25605p AD=0.0798p
+ PS=1.935u PD=0.8u rfmode=0
M$4192 VDD \$434 \$502 VDD sg13_lv_pmos L=0.13u W=0.42u AS=0.2014p AD=0.0798p
+ PS=1.53u PD=0.8u rfmode=0
M$4193 VDD \$434 \$436 VDD sg13_lv_pmos L=0.13u W=1u AS=0.2083p AD=0.34p
+ PS=1.5u PD=2.68u rfmode=0
M$4194 VDD \$434 \$435 VDD sg13_lv_pmos L=0.13u W=2.24u AS=0.4142p AD=0.4211p
+ PS=3.03u PD=3u rfmode=0
M$4196 \$357 \$358 \$434 VDD sg13_lv_pmos L=0.13u W=1u AS=0.34p AD=0.19115p
+ PS=2.68u PD=1.565u rfmode=0
M$4197 VDD \$436 \$437 VDD sg13_lv_pmos L=0.13u W=2.24u AS=0.5964p AD=0.5964p
+ PS=4.425u PD=4.425u rfmode=0
M$4199 VDD X8 \$560 VDD sg13_lv_pmos L=0.13u W=0.84u AS=0.2856p AD=0.1596p
+ PS=2.36u PD=1.22u rfmode=0
M$4200 VDD X9 \$560 VDD sg13_lv_pmos L=0.13u W=0.84u AS=0.1918p AD=0.1596p
+ PS=1.5u PD=1.22u rfmode=0
M$4201 VDD \$560 \$561 VDD sg13_lv_pmos L=0.13u W=2.24u AS=0.4046p AD=0.6384p
+ PS=3u PD=4.5u rfmode=0
M$4203 VDD X10 \$562 VDD sg13_lv_pmos L=0.13u W=0.84u AS=0.2856p AD=0.1596p
+ PS=2.36u PD=1.22u rfmode=0
M$4204 VDD \$561 \$562 VDD sg13_lv_pmos L=0.13u W=0.84u AS=0.1918p AD=0.1596p
+ PS=1.5u PD=1.22u rfmode=0
M$4205 VDD \$562 \$563 VDD sg13_lv_pmos L=0.13u W=2.24u AS=0.4046p AD=0.6384p
+ PS=3u PD=4.5u rfmode=0
M$4207 \$327 \$167 \$564 VDD sg13_lv_pmos L=0.13u W=0.84u AS=0.2856p AD=0.1596p
+ PS=2.36u PD=1.22u rfmode=0
M$4208 VDD \$319 \$564 VDD sg13_lv_pmos L=0.13u W=0.84u AS=0.2226p AD=0.1596p
+ PS=1.535u PD=1.22u rfmode=0
M$4209 VDD \$327 \$328 VDD sg13_lv_pmos L=0.13u W=2.24u AS=0.4746p AD=0.6776p
+ PS=3.105u PD=4.57u rfmode=0
M$4211 VDD \$360 \$361 VDD sg13_lv_pmos L=0.13u W=0.42u AS=0.1428p AD=0.0798p
+ PS=1.52u PD=0.8u rfmode=0
M$4212 VDD VDD \$361 VDD sg13_lv_pmos L=0.13u W=0.42u AS=0.3623875p AD=0.0798p
+ PS=2.605u PD=0.8u rfmode=0
M$4213 VDD \$487 \$329 VDD sg13_lv_pmos L=0.13u W=1u AS=0.3623875p AD=0.34p
+ PS=2.605u PD=2.68u rfmode=0
M$4214 \$487 VDD VDD VDD sg13_lv_pmos L=0.13u W=0.42u AS=0.147p AD=0.1563p
+ PS=1.54u PD=1.22u rfmode=0
M$4215 VDD \$329 \$523 VDD sg13_lv_pmos L=0.13u W=0.42u AS=0.1563p AD=0.0546p
+ PS=1.22u PD=0.68u rfmode=0
M$4216 \$523 \$330 \$487 VDD sg13_lv_pmos L=0.13u W=0.42u AS=0.0546p AD=0.0798p
+ PS=0.68u PD=0.8u rfmode=0
M$4217 \$487 \$503 \$361 VDD sg13_lv_pmos L=0.13u W=0.42u AS=0.0798p AD=0.1428p
+ PS=0.8u PD=1.52u rfmode=0
M$4218 \$795 \$625 VDD VDD sg13_lv_pmos L=0.13u W=1.12u AS=0.3864p AD=0.431025p
+ PS=2.93u PD=2.145u rfmode=0
M$4219 VDD CLK \$625 VDD sg13_lv_pmos L=0.13u W=1.12u AS=0.431025p AD=0.3808p
+ PS=2.145u PD=2.92u rfmode=0
M$4220 \$331 \$171 \$565 VDD sg13_lv_pmos L=0.13u W=0.84u AS=0.2856p AD=0.1596p
+ PS=2.36u PD=1.22u rfmode=0
M$4221 VDD \$319 \$565 VDD sg13_lv_pmos L=0.13u W=0.84u AS=0.2226p AD=0.1596p
+ PS=1.535u PD=1.22u rfmode=0
M$4222 VDD \$331 \$332 VDD sg13_lv_pmos L=0.13u W=2.24u AS=0.4746p AD=0.6776p
+ PS=3.105u PD=4.57u rfmode=0
M$4224 VDD \$370 \$371 VDD sg13_lv_pmos L=0.13u W=0.42u AS=0.1428p AD=0.0798p
+ PS=1.52u PD=0.8u rfmode=0
M$4225 VDD VDD \$371 VDD sg13_lv_pmos L=0.13u W=0.42u AS=0.3623875p AD=0.0798p
+ PS=2.605u PD=0.8u rfmode=0
M$4226 VDD \$489 \$333 VDD sg13_lv_pmos L=0.13u W=1u AS=0.3623875p AD=0.34p
+ PS=2.605u PD=2.68u rfmode=0
M$4227 \$489 VDD VDD VDD sg13_lv_pmos L=0.13u W=0.42u AS=0.147p AD=0.1563p
+ PS=1.54u PD=1.22u rfmode=0
M$4228 VDD \$333 \$531 VDD sg13_lv_pmos L=0.13u W=0.42u AS=0.1563p AD=0.0546p
+ PS=1.22u PD=0.68u rfmode=0
M$4229 \$531 \$334 \$489 VDD sg13_lv_pmos L=0.13u W=0.42u AS=0.0546p AD=0.0798p
+ PS=0.68u PD=0.8u rfmode=0
M$4230 \$489 \$505 \$371 VDD sg13_lv_pmos L=0.13u W=0.42u AS=0.0798p AD=0.1428p
+ PS=0.8u PD=1.52u rfmode=0
M$4231 \$797 \$629 VDD VDD sg13_lv_pmos L=0.13u W=1.12u AS=0.3864p AD=0.431025p
+ PS=2.93u PD=2.145u rfmode=0
M$4232 VDD CLK \$629 VDD sg13_lv_pmos L=0.13u W=1.12u AS=0.431025p AD=0.3808p
+ PS=2.145u PD=2.92u rfmode=0
M$4233 \$335 \$174 \$566 VDD sg13_lv_pmos L=0.13u W=0.84u AS=0.2856p AD=0.1596p
+ PS=2.36u PD=1.22u rfmode=0
M$4234 VDD \$319 \$566 VDD sg13_lv_pmos L=0.13u W=0.84u AS=0.2226p AD=0.1596p
+ PS=1.535u PD=1.22u rfmode=0
M$4235 VDD \$335 \$336 VDD sg13_lv_pmos L=0.13u W=2.24u AS=0.4746p AD=0.6776p
+ PS=3.105u PD=4.57u rfmode=0
M$4237 VDD \$380 \$381 VDD sg13_lv_pmos L=0.13u W=0.42u AS=0.1428p AD=0.0798p
+ PS=1.52u PD=0.8u rfmode=0
M$4238 VDD VDD \$381 VDD sg13_lv_pmos L=0.13u W=0.42u AS=0.3623875p AD=0.0798p
+ PS=2.605u PD=0.8u rfmode=0
M$4239 VDD \$491 \$337 VDD sg13_lv_pmos L=0.13u W=1u AS=0.3623875p AD=0.34p
+ PS=2.605u PD=2.68u rfmode=0
M$4240 \$491 VDD VDD VDD sg13_lv_pmos L=0.13u W=0.42u AS=0.147p AD=0.1563p
+ PS=1.54u PD=1.22u rfmode=0
M$4241 VDD \$337 \$540 VDD sg13_lv_pmos L=0.13u W=0.42u AS=0.1563p AD=0.0546p
+ PS=1.22u PD=0.68u rfmode=0
M$4242 \$540 \$338 \$491 VDD sg13_lv_pmos L=0.13u W=0.42u AS=0.0546p AD=0.0798p
+ PS=0.68u PD=0.8u rfmode=0
M$4243 \$491 \$507 \$381 VDD sg13_lv_pmos L=0.13u W=0.42u AS=0.0798p AD=0.1428p
+ PS=0.8u PD=1.52u rfmode=0
M$4244 \$799 \$633 VDD VDD sg13_lv_pmos L=0.13u W=1.12u AS=0.3864p AD=0.431025p
+ PS=2.93u PD=2.145u rfmode=0
M$4245 VDD CLK \$633 VDD sg13_lv_pmos L=0.13u W=1.12u AS=0.431025p AD=0.3808p
+ PS=2.145u PD=2.92u rfmode=0
M$4246 \$339 \$177 \$567 VDD sg13_lv_pmos L=0.13u W=0.84u AS=0.2856p AD=0.1596p
+ PS=2.36u PD=1.22u rfmode=0
M$4247 VDD \$319 \$567 VDD sg13_lv_pmos L=0.13u W=0.84u AS=0.2226p AD=0.1596p
+ PS=1.535u PD=1.22u rfmode=0
M$4248 VDD \$339 \$340 VDD sg13_lv_pmos L=0.13u W=2.24u AS=0.4746p AD=0.6776p
+ PS=3.105u PD=4.57u rfmode=0
M$4250 VDD \$390 \$391 VDD sg13_lv_pmos L=0.13u W=0.42u AS=0.1428p AD=0.0798p
+ PS=1.52u PD=0.8u rfmode=0
M$4251 VDD VDD \$391 VDD sg13_lv_pmos L=0.13u W=0.42u AS=0.3623875p AD=0.0798p
+ PS=2.605u PD=0.8u rfmode=0
M$4252 VDD \$493 \$341 VDD sg13_lv_pmos L=0.13u W=1u AS=0.3623875p AD=0.34p
+ PS=2.605u PD=2.68u rfmode=0
M$4253 \$493 VDD VDD VDD sg13_lv_pmos L=0.13u W=0.42u AS=0.147p AD=0.1563p
+ PS=1.54u PD=1.22u rfmode=0
M$4254 VDD \$341 \$548 VDD sg13_lv_pmos L=0.13u W=0.42u AS=0.1563p AD=0.0546p
+ PS=1.22u PD=0.68u rfmode=0
M$4255 \$548 \$342 \$493 VDD sg13_lv_pmos L=0.13u W=0.42u AS=0.0546p AD=0.0798p
+ PS=0.68u PD=0.8u rfmode=0
M$4256 \$493 \$509 \$391 VDD sg13_lv_pmos L=0.13u W=0.42u AS=0.0798p AD=0.1428p
+ PS=0.8u PD=1.52u rfmode=0
M$4257 \$801 \$637 VDD VDD sg13_lv_pmos L=0.13u W=1.12u AS=0.3864p AD=0.431025p
+ PS=2.93u PD=2.145u rfmode=0
M$4258 VDD CLK \$637 VDD sg13_lv_pmos L=0.13u W=1.12u AS=0.431025p AD=0.3808p
+ PS=2.145u PD=2.92u rfmode=0
M$4259 \$343 \$180 \$568 VDD sg13_lv_pmos L=0.13u W=0.84u AS=0.2856p AD=0.1596p
+ PS=2.36u PD=1.22u rfmode=0
M$4260 VDD \$319 \$568 VDD sg13_lv_pmos L=0.13u W=0.84u AS=0.2226p AD=0.1596p
+ PS=1.535u PD=1.22u rfmode=0
M$4261 VDD \$343 \$344 VDD sg13_lv_pmos L=0.13u W=2.24u AS=0.4746p AD=0.6776p
+ PS=3.105u PD=4.57u rfmode=0
M$4263 VDD \$400 \$401 VDD sg13_lv_pmos L=0.13u W=0.42u AS=0.1428p AD=0.0798p
+ PS=1.52u PD=0.8u rfmode=0
M$4264 VDD VDD \$401 VDD sg13_lv_pmos L=0.13u W=0.42u AS=0.3623875p AD=0.0798p
+ PS=2.605u PD=0.8u rfmode=0
M$4265 VDD \$495 \$345 VDD sg13_lv_pmos L=0.13u W=1u AS=0.3623875p AD=0.34p
+ PS=2.605u PD=2.68u rfmode=0
M$4266 \$495 VDD VDD VDD sg13_lv_pmos L=0.13u W=0.42u AS=0.147p AD=0.1563p
+ PS=1.54u PD=1.22u rfmode=0
M$4267 VDD \$345 \$556 VDD sg13_lv_pmos L=0.13u W=0.42u AS=0.1563p AD=0.0546p
+ PS=1.22u PD=0.68u rfmode=0
M$4268 \$556 \$346 \$495 VDD sg13_lv_pmos L=0.13u W=0.42u AS=0.0546p AD=0.0798p
+ PS=0.68u PD=0.8u rfmode=0
M$4269 \$495 \$511 \$401 VDD sg13_lv_pmos L=0.13u W=0.42u AS=0.0798p AD=0.1428p
+ PS=0.8u PD=1.52u rfmode=0
M$4270 \$803 \$641 VDD VDD sg13_lv_pmos L=0.13u W=1.12u AS=0.3864p AD=0.431025p
+ PS=2.93u PD=2.145u rfmode=0
M$4271 VDD CLK \$641 VDD sg13_lv_pmos L=0.13u W=1.12u AS=0.431025p AD=0.3808p
+ PS=2.145u PD=2.92u rfmode=0
M$4272 \$347 \$183 \$569 VDD sg13_lv_pmos L=0.13u W=0.84u AS=0.2856p AD=0.1596p
+ PS=2.36u PD=1.22u rfmode=0
M$4273 VDD \$319 \$569 VDD sg13_lv_pmos L=0.13u W=0.84u AS=0.2226p AD=0.1596p
+ PS=1.535u PD=1.22u rfmode=0
M$4274 VDD \$347 \$348 VDD sg13_lv_pmos L=0.13u W=2.24u AS=0.4746p AD=0.6776p
+ PS=3.105u PD=4.57u rfmode=0
M$4276 VDD \$410 \$411 VDD sg13_lv_pmos L=0.13u W=0.42u AS=0.1428p AD=0.0798p
+ PS=1.52u PD=0.8u rfmode=0
M$4277 VDD VDD \$411 VDD sg13_lv_pmos L=0.13u W=0.42u AS=0.3623875p AD=0.0798p
+ PS=2.605u PD=0.8u rfmode=0
M$4278 VDD \$497 \$349 VDD sg13_lv_pmos L=0.13u W=1u AS=0.3623875p AD=0.34p
+ PS=2.605u PD=2.68u rfmode=0
M$4279 \$497 VDD VDD VDD sg13_lv_pmos L=0.13u W=0.42u AS=0.147p AD=0.1563p
+ PS=1.54u PD=1.22u rfmode=0
M$4280 VDD \$349 \$551 VDD sg13_lv_pmos L=0.13u W=0.42u AS=0.1563p AD=0.0546p
+ PS=1.22u PD=0.68u rfmode=0
M$4281 \$551 \$350 \$497 VDD sg13_lv_pmos L=0.13u W=0.42u AS=0.0546p AD=0.0798p
+ PS=0.68u PD=0.8u rfmode=0
M$4282 \$497 \$513 \$411 VDD sg13_lv_pmos L=0.13u W=0.42u AS=0.0798p AD=0.1428p
+ PS=0.8u PD=1.52u rfmode=0
M$4283 \$806 \$645 VDD VDD sg13_lv_pmos L=0.13u W=1.12u AS=0.3864p AD=0.431025p
+ PS=2.93u PD=2.145u rfmode=0
M$4284 VDD CLK \$645 VDD sg13_lv_pmos L=0.13u W=1.12u AS=0.431025p AD=0.3808p
+ PS=2.145u PD=2.92u rfmode=0
M$4285 \$351 \$186 \$571 VDD sg13_lv_pmos L=0.13u W=0.84u AS=0.2856p AD=0.1596p
+ PS=2.36u PD=1.22u rfmode=0
M$4286 VDD \$319 \$571 VDD sg13_lv_pmos L=0.13u W=0.84u AS=0.2226p AD=0.1596p
+ PS=1.535u PD=1.22u rfmode=0
M$4287 VDD \$351 \$352 VDD sg13_lv_pmos L=0.13u W=2.24u AS=0.4746p AD=0.6776p
+ PS=3.105u PD=4.57u rfmode=0
M$4289 VDD \$420 \$421 VDD sg13_lv_pmos L=0.13u W=0.42u AS=0.1428p AD=0.0798p
+ PS=1.52u PD=0.8u rfmode=0
M$4290 VDD VDD \$421 VDD sg13_lv_pmos L=0.13u W=0.42u AS=0.3623875p AD=0.0798p
+ PS=2.605u PD=0.8u rfmode=0
M$4291 VDD \$499 \$353 VDD sg13_lv_pmos L=0.13u W=1u AS=0.3623875p AD=0.34p
+ PS=2.605u PD=2.68u rfmode=0
M$4292 \$499 VDD VDD VDD sg13_lv_pmos L=0.13u W=0.42u AS=0.147p AD=0.1563p
+ PS=1.54u PD=1.22u rfmode=0
M$4293 VDD \$353 \$539 VDD sg13_lv_pmos L=0.13u W=0.42u AS=0.1563p AD=0.0546p
+ PS=1.22u PD=0.68u rfmode=0
M$4294 \$539 \$354 \$499 VDD sg13_lv_pmos L=0.13u W=0.42u AS=0.0546p AD=0.0798p
+ PS=0.68u PD=0.8u rfmode=0
M$4295 \$499 \$515 \$421 VDD sg13_lv_pmos L=0.13u W=0.42u AS=0.0798p AD=0.1428p
+ PS=0.8u PD=1.52u rfmode=0
M$4296 \$809 \$649 VDD VDD sg13_lv_pmos L=0.13u W=1.12u AS=0.3864p AD=0.431025p
+ PS=2.93u PD=2.145u rfmode=0
M$4297 VDD CLK \$649 VDD sg13_lv_pmos L=0.13u W=1.12u AS=0.431025p AD=0.3808p
+ PS=2.145u PD=2.92u rfmode=0
M$4298 \$355 VSS \$570 VDD sg13_lv_pmos L=0.13u W=0.84u AS=0.2856p AD=0.1596p
+ PS=2.36u PD=1.22u rfmode=0
M$4299 VDD \$319 \$570 VDD sg13_lv_pmos L=0.13u W=0.84u AS=0.2226p AD=0.1596p
+ PS=1.535u PD=1.22u rfmode=0
M$4300 VDD \$355 \$356 VDD sg13_lv_pmos L=0.13u W=2.24u AS=0.4746p AD=0.6776p
+ PS=3.105u PD=4.57u rfmode=0
M$4302 VDD \$430 \$431 VDD sg13_lv_pmos L=0.13u W=0.42u AS=0.1428p AD=0.0798p
+ PS=1.52u PD=0.8u rfmode=0
M$4303 VDD VDD \$431 VDD sg13_lv_pmos L=0.13u W=0.42u AS=0.3623875p AD=0.0798p
+ PS=2.605u PD=0.8u rfmode=0
M$4304 VDD \$501 \$357 VDD sg13_lv_pmos L=0.13u W=1u AS=0.3623875p AD=0.34p
+ PS=2.605u PD=2.68u rfmode=0
M$4305 \$501 VDD VDD VDD sg13_lv_pmos L=0.13u W=0.42u AS=0.147p AD=0.1563p
+ PS=1.54u PD=1.22u rfmode=0
M$4306 VDD \$357 \$526 VDD sg13_lv_pmos L=0.13u W=0.42u AS=0.1563p AD=0.0546p
+ PS=1.22u PD=0.68u rfmode=0
M$4307 \$526 \$358 \$501 VDD sg13_lv_pmos L=0.13u W=0.42u AS=0.0546p AD=0.0798p
+ PS=0.68u PD=0.8u rfmode=0
M$4308 \$501 \$517 \$431 VDD sg13_lv_pmos L=0.13u W=0.42u AS=0.0798p AD=0.1428p
+ PS=0.8u PD=1.52u rfmode=0
M$4309 \$812 \$653 VDD VDD sg13_lv_pmos L=0.13u W=1.12u AS=0.3864p AD=0.431025p
+ PS=2.93u PD=2.145u rfmode=0
M$4310 VDD CLK \$653 VDD sg13_lv_pmos L=0.13u W=1.12u AS=0.431025p AD=0.3808p
+ PS=2.145u PD=2.92u rfmode=0
M$4311 VDD \$623 \$655 VDD sg13_lv_pmos L=0.13u W=2.24u AS=0.616p AD=0.4312p
+ PS=4.46u PD=3.01u rfmode=0
M$4313 VDD \$319 \$655 VDD sg13_lv_pmos L=0.13u W=2.24u AS=0.4312p AD=0.6048p
+ PS=3.01u PD=4.44u rfmode=0
M$4315 VDD \$661 \$662 VDD sg13_lv_pmos L=0.13u W=2.24u AS=0.5964p AD=0.5964p
+ PS=4.425u PD=4.425u rfmode=0
M$4317 VDD \$627 \$665 VDD sg13_lv_pmos L=0.13u W=2.24u AS=0.616p AD=0.4312p
+ PS=4.46u PD=3.01u rfmode=0
M$4319 VDD \$319 \$665 VDD sg13_lv_pmos L=0.13u W=2.24u AS=0.4312p AD=0.6048p
+ PS=3.01u PD=4.44u rfmode=0
M$4321 VDD \$671 \$672 VDD sg13_lv_pmos L=0.13u W=2.24u AS=0.5964p AD=0.5964p
+ PS=4.425u PD=4.425u rfmode=0
M$4323 VDD \$631 \$675 VDD sg13_lv_pmos L=0.13u W=2.24u AS=0.616p AD=0.4312p
+ PS=4.46u PD=3.01u rfmode=0
M$4325 VDD \$319 \$675 VDD sg13_lv_pmos L=0.13u W=2.24u AS=0.4312p AD=0.6048p
+ PS=3.01u PD=4.44u rfmode=0
M$4327 VDD \$681 \$682 VDD sg13_lv_pmos L=0.13u W=2.24u AS=0.5964p AD=0.5964p
+ PS=4.425u PD=4.425u rfmode=0
M$4329 VDD \$635 \$685 VDD sg13_lv_pmos L=0.13u W=2.24u AS=0.616p AD=0.4312p
+ PS=4.46u PD=3.01u rfmode=0
M$4331 VDD \$319 \$685 VDD sg13_lv_pmos L=0.13u W=2.24u AS=0.4312p AD=0.6048p
+ PS=3.01u PD=4.44u rfmode=0
M$4333 VDD \$691 \$692 VDD sg13_lv_pmos L=0.13u W=2.24u AS=0.5964p AD=0.5964p
+ PS=4.425u PD=4.425u rfmode=0
M$4335 VDD \$639 \$695 VDD sg13_lv_pmos L=0.13u W=2.24u AS=0.616p AD=0.4312p
+ PS=4.46u PD=3.01u rfmode=0
M$4337 VDD \$319 \$695 VDD sg13_lv_pmos L=0.13u W=2.24u AS=0.4312p AD=0.6048p
+ PS=3.01u PD=4.44u rfmode=0
M$4339 VDD \$701 \$702 VDD sg13_lv_pmos L=0.13u W=2.24u AS=0.5964p AD=0.5964p
+ PS=4.425u PD=4.425u rfmode=0
M$4341 VDD \$643 \$705 VDD sg13_lv_pmos L=0.13u W=2.24u AS=0.616p AD=0.4312p
+ PS=4.46u PD=3.01u rfmode=0
M$4343 VDD \$319 \$705 VDD sg13_lv_pmos L=0.13u W=2.24u AS=0.4312p AD=0.6048p
+ PS=3.01u PD=4.44u rfmode=0
M$4345 VDD \$710 \$711 VDD sg13_lv_pmos L=0.13u W=2.24u AS=0.5964p AD=0.5964p
+ PS=4.425u PD=4.425u rfmode=0
M$4347 VDD \$647 \$714 VDD sg13_lv_pmos L=0.13u W=2.24u AS=0.616p AD=0.4312p
+ PS=4.46u PD=3.01u rfmode=0
M$4349 VDD \$319 \$714 VDD sg13_lv_pmos L=0.13u W=2.24u AS=0.4312p AD=0.6048p
+ PS=3.01u PD=4.44u rfmode=0
M$4351 VDD \$719 \$720 VDD sg13_lv_pmos L=0.13u W=2.24u AS=0.5964p AD=0.5964p
+ PS=4.425u PD=4.425u rfmode=0
M$4353 VDD \$651 \$723 VDD sg13_lv_pmos L=0.13u W=2.24u AS=0.616p AD=0.4312p
+ PS=4.46u PD=3.01u rfmode=0
M$4355 VDD \$319 \$723 VDD sg13_lv_pmos L=0.13u W=2.24u AS=0.4312p AD=0.6048p
+ PS=3.01u PD=4.44u rfmode=0
M$4357 VDD \$728 \$729 VDD sg13_lv_pmos L=0.13u W=2.24u AS=0.5964p AD=0.5964p
+ PS=4.425u PD=4.425u rfmode=0
M$4359 \$622 \$167 \$815 VDD sg13_lv_pmos L=0.13u W=0.84u AS=0.2856p AD=0.1596p
+ PS=2.36u PD=1.22u rfmode=0
M$4360 VDD \$195 \$815 VDD sg13_lv_pmos L=0.13u W=0.84u AS=0.2226p AD=0.1596p
+ PS=1.535u PD=1.22u rfmode=0
M$4361 VDD \$622 \$623 VDD sg13_lv_pmos L=0.13u W=2.24u AS=0.4746p AD=0.6776p
+ PS=3.105u PD=4.57u rfmode=0
M$4363 VDD \$655 \$656 VDD sg13_lv_pmos L=0.13u W=0.42u AS=0.1428p AD=0.0798p
+ PS=1.52u PD=0.8u rfmode=0
M$4364 VDD VDD \$656 VDD sg13_lv_pmos L=0.13u W=0.42u AS=0.3623875p AD=0.0798p
+ PS=2.605u PD=0.8u rfmode=0
M$4365 VDD \$779 \$624 VDD sg13_lv_pmos L=0.13u W=1u AS=0.3623875p AD=0.34p
+ PS=2.605u PD=2.68u rfmode=0
M$4366 \$659 \$795 \$817 VDD sg13_lv_pmos L=0.13u W=0.42u AS=0.19115p
+ AD=0.0525p PS=1.565u PD=0.67u rfmode=0
M$4367 \$817 \$780 VDD VDD sg13_lv_pmos L=0.13u W=0.42u AS=0.0525p AD=0.25605p
+ PS=0.67u PD=1.935u rfmode=0
M$4368 VDD VDD \$780 VDD sg13_lv_pmos L=0.13u W=0.42u AS=0.25605p AD=0.0798p
+ PS=1.935u PD=0.8u rfmode=0
M$4369 VDD \$659 \$780 VDD sg13_lv_pmos L=0.13u W=0.42u AS=0.2014p AD=0.0798p
+ PS=1.53u PD=0.8u rfmode=0
M$4370 VDD \$659 \$661 VDD sg13_lv_pmos L=0.13u W=1u AS=0.2083p AD=0.34p
+ PS=1.5u PD=2.68u rfmode=0
M$4371 VDD \$659 \$660 VDD sg13_lv_pmos L=0.13u W=2.24u AS=0.4142p AD=0.4211p
+ PS=3.03u PD=3u rfmode=0
M$4373 \$624 \$625 \$659 VDD sg13_lv_pmos L=0.13u W=1u AS=0.34p AD=0.19115p
+ PS=2.68u PD=1.565u rfmode=0
M$4374 \$626 \$171 \$821 VDD sg13_lv_pmos L=0.13u W=0.84u AS=0.2856p AD=0.1596p
+ PS=2.36u PD=1.22u rfmode=0
M$4375 VDD \$195 \$821 VDD sg13_lv_pmos L=0.13u W=0.84u AS=0.2226p AD=0.1596p
+ PS=1.535u PD=1.22u rfmode=0
M$4376 VDD \$626 \$627 VDD sg13_lv_pmos L=0.13u W=2.24u AS=0.4746p AD=0.6776p
+ PS=3.105u PD=4.57u rfmode=0
M$4378 VDD \$665 \$666 VDD sg13_lv_pmos L=0.13u W=0.42u AS=0.1428p AD=0.0798p
+ PS=1.52u PD=0.8u rfmode=0
M$4379 VDD VDD \$666 VDD sg13_lv_pmos L=0.13u W=0.42u AS=0.3623875p AD=0.0798p
+ PS=2.605u PD=0.8u rfmode=0
M$4380 VDD \$781 \$628 VDD sg13_lv_pmos L=0.13u W=1u AS=0.3623875p AD=0.34p
+ PS=2.605u PD=2.68u rfmode=0
M$4381 \$669 \$797 \$823 VDD sg13_lv_pmos L=0.13u W=0.42u AS=0.19115p
+ AD=0.0525p PS=1.565u PD=0.67u rfmode=0
M$4382 \$823 \$782 VDD VDD sg13_lv_pmos L=0.13u W=0.42u AS=0.0525p AD=0.25605p
+ PS=0.67u PD=1.935u rfmode=0
M$4383 VDD VDD \$782 VDD sg13_lv_pmos L=0.13u W=0.42u AS=0.25605p AD=0.0798p
+ PS=1.935u PD=0.8u rfmode=0
M$4384 VDD \$669 \$782 VDD sg13_lv_pmos L=0.13u W=0.42u AS=0.2014p AD=0.0798p
+ PS=1.53u PD=0.8u rfmode=0
M$4385 VDD \$669 \$671 VDD sg13_lv_pmos L=0.13u W=1u AS=0.2083p AD=0.34p
+ PS=1.5u PD=2.68u rfmode=0
M$4386 VDD \$669 \$670 VDD sg13_lv_pmos L=0.13u W=2.24u AS=0.4142p AD=0.4211p
+ PS=3.03u PD=3u rfmode=0
M$4388 \$628 \$629 \$669 VDD sg13_lv_pmos L=0.13u W=1u AS=0.34p AD=0.19115p
+ PS=2.68u PD=1.565u rfmode=0
M$4389 \$630 \$174 \$827 VDD sg13_lv_pmos L=0.13u W=0.84u AS=0.2856p AD=0.1596p
+ PS=2.36u PD=1.22u rfmode=0
M$4390 VDD \$195 \$827 VDD sg13_lv_pmos L=0.13u W=0.84u AS=0.2226p AD=0.1596p
+ PS=1.535u PD=1.22u rfmode=0
M$4391 VDD \$630 \$631 VDD sg13_lv_pmos L=0.13u W=2.24u AS=0.4746p AD=0.6776p
+ PS=3.105u PD=4.57u rfmode=0
M$4393 VDD \$675 \$676 VDD sg13_lv_pmos L=0.13u W=0.42u AS=0.1428p AD=0.0798p
+ PS=1.52u PD=0.8u rfmode=0
M$4394 VDD VDD \$676 VDD sg13_lv_pmos L=0.13u W=0.42u AS=0.3623875p AD=0.0798p
+ PS=2.605u PD=0.8u rfmode=0
M$4395 VDD \$783 \$632 VDD sg13_lv_pmos L=0.13u W=1u AS=0.3623875p AD=0.34p
+ PS=2.605u PD=2.68u rfmode=0
M$4396 \$679 \$799 \$830 VDD sg13_lv_pmos L=0.13u W=0.42u AS=0.19115p
+ AD=0.0525p PS=1.565u PD=0.67u rfmode=0
M$4397 \$830 \$784 VDD VDD sg13_lv_pmos L=0.13u W=0.42u AS=0.0525p AD=0.25605p
+ PS=0.67u PD=1.935u rfmode=0
M$4398 VDD VDD \$784 VDD sg13_lv_pmos L=0.13u W=0.42u AS=0.25605p AD=0.0798p
+ PS=1.935u PD=0.8u rfmode=0
M$4399 VDD \$679 \$784 VDD sg13_lv_pmos L=0.13u W=0.42u AS=0.2014p AD=0.0798p
+ PS=1.53u PD=0.8u rfmode=0
M$4400 VDD \$679 \$681 VDD sg13_lv_pmos L=0.13u W=1u AS=0.2083p AD=0.34p
+ PS=1.5u PD=2.68u rfmode=0
M$4401 VDD \$679 \$680 VDD sg13_lv_pmos L=0.13u W=2.24u AS=0.4142p AD=0.4211p
+ PS=3.03u PD=3u rfmode=0
M$4403 \$632 \$633 \$679 VDD sg13_lv_pmos L=0.13u W=1u AS=0.34p AD=0.19115p
+ PS=2.68u PD=1.565u rfmode=0
M$4404 \$634 \$177 \$835 VDD sg13_lv_pmos L=0.13u W=0.84u AS=0.2856p AD=0.1596p
+ PS=2.36u PD=1.22u rfmode=0
M$4405 VDD \$195 \$835 VDD sg13_lv_pmos L=0.13u W=0.84u AS=0.2226p AD=0.1596p
+ PS=1.535u PD=1.22u rfmode=0
M$4406 VDD \$634 \$635 VDD sg13_lv_pmos L=0.13u W=2.24u AS=0.4746p AD=0.6776p
+ PS=3.105u PD=4.57u rfmode=0
M$4408 VDD \$685 \$686 VDD sg13_lv_pmos L=0.13u W=0.42u AS=0.1428p AD=0.0798p
+ PS=1.52u PD=0.8u rfmode=0
M$4409 VDD VDD \$686 VDD sg13_lv_pmos L=0.13u W=0.42u AS=0.3623875p AD=0.0798p
+ PS=2.605u PD=0.8u rfmode=0
M$4410 VDD \$785 \$636 VDD sg13_lv_pmos L=0.13u W=1u AS=0.3623875p AD=0.34p
+ PS=2.605u PD=2.68u rfmode=0
M$4411 \$689 \$801 \$837 VDD sg13_lv_pmos L=0.13u W=0.42u AS=0.19115p
+ AD=0.0525p PS=1.565u PD=0.67u rfmode=0
M$4412 \$837 \$786 VDD VDD sg13_lv_pmos L=0.13u W=0.42u AS=0.0525p AD=0.25605p
+ PS=0.67u PD=1.935u rfmode=0
M$4413 VDD VDD \$786 VDD sg13_lv_pmos L=0.13u W=0.42u AS=0.25605p AD=0.0798p
+ PS=1.935u PD=0.8u rfmode=0
M$4414 VDD \$689 \$786 VDD sg13_lv_pmos L=0.13u W=0.42u AS=0.2014p AD=0.0798p
+ PS=1.53u PD=0.8u rfmode=0
M$4415 VDD \$689 \$691 VDD sg13_lv_pmos L=0.13u W=1u AS=0.2083p AD=0.34p
+ PS=1.5u PD=2.68u rfmode=0
M$4416 VDD \$689 \$690 VDD sg13_lv_pmos L=0.13u W=2.24u AS=0.4142p AD=0.4211p
+ PS=3.03u PD=3u rfmode=0
M$4418 \$636 \$637 \$689 VDD sg13_lv_pmos L=0.13u W=1u AS=0.34p AD=0.19115p
+ PS=2.68u PD=1.565u rfmode=0
M$4419 \$638 \$180 \$841 VDD sg13_lv_pmos L=0.13u W=0.84u AS=0.2856p AD=0.1596p
+ PS=2.36u PD=1.22u rfmode=0
M$4420 VDD \$195 \$841 VDD sg13_lv_pmos L=0.13u W=0.84u AS=0.2226p AD=0.1596p
+ PS=1.535u PD=1.22u rfmode=0
M$4421 VDD \$638 \$639 VDD sg13_lv_pmos L=0.13u W=2.24u AS=0.4746p AD=0.6776p
+ PS=3.105u PD=4.57u rfmode=0
M$4423 VDD \$695 \$696 VDD sg13_lv_pmos L=0.13u W=0.42u AS=0.1428p AD=0.0798p
+ PS=1.52u PD=0.8u rfmode=0
M$4424 VDD VDD \$696 VDD sg13_lv_pmos L=0.13u W=0.42u AS=0.3623875p AD=0.0798p
+ PS=2.605u PD=0.8u rfmode=0
M$4425 VDD \$787 \$640 VDD sg13_lv_pmos L=0.13u W=1u AS=0.3623875p AD=0.34p
+ PS=2.605u PD=2.68u rfmode=0
M$4426 \$699 \$803 \$843 VDD sg13_lv_pmos L=0.13u W=0.42u AS=0.19115p
+ AD=0.0525p PS=1.565u PD=0.67u rfmode=0
M$4427 \$843 \$788 VDD VDD sg13_lv_pmos L=0.13u W=0.42u AS=0.0525p AD=0.25605p
+ PS=0.67u PD=1.935u rfmode=0
M$4428 VDD VDD \$788 VDD sg13_lv_pmos L=0.13u W=0.42u AS=0.25605p AD=0.0798p
+ PS=1.935u PD=0.8u rfmode=0
M$4429 VDD \$699 \$788 VDD sg13_lv_pmos L=0.13u W=0.42u AS=0.2014p AD=0.0798p
+ PS=1.53u PD=0.8u rfmode=0
M$4430 VDD \$699 \$701 VDD sg13_lv_pmos L=0.13u W=1u AS=0.2083p AD=0.34p
+ PS=1.5u PD=2.68u rfmode=0
M$4431 VDD \$699 \$700 VDD sg13_lv_pmos L=0.13u W=2.24u AS=0.4142p AD=0.4211p
+ PS=3.03u PD=3u rfmode=0
M$4433 \$640 \$641 \$699 VDD sg13_lv_pmos L=0.13u W=1u AS=0.34p AD=0.19115p
+ PS=2.68u PD=1.565u rfmode=0
M$4434 \$642 \$183 \$848 VDD sg13_lv_pmos L=0.13u W=0.84u AS=0.2856p AD=0.1596p
+ PS=2.36u PD=1.22u rfmode=0
M$4435 VDD \$195 \$848 VDD sg13_lv_pmos L=0.13u W=0.84u AS=0.2226p AD=0.1596p
+ PS=1.535u PD=1.22u rfmode=0
M$4436 VDD \$642 \$643 VDD sg13_lv_pmos L=0.13u W=2.24u AS=0.4746p AD=0.6776p
+ PS=3.105u PD=4.57u rfmode=0
M$4438 VDD \$705 \$805 VDD sg13_lv_pmos L=0.13u W=0.42u AS=0.1428p AD=0.0798p
+ PS=1.52u PD=0.8u rfmode=0
M$4439 VDD VDD \$805 VDD sg13_lv_pmos L=0.13u W=0.42u AS=0.3623875p AD=0.0798p
+ PS=2.605u PD=0.8u rfmode=0
M$4440 VDD \$789 \$644 VDD sg13_lv_pmos L=0.13u W=1u AS=0.3623875p AD=0.34p
+ PS=2.605u PD=2.68u rfmode=0
M$4441 \$708 \$806 \$850 VDD sg13_lv_pmos L=0.13u W=0.42u AS=0.19115p
+ AD=0.0525p PS=1.565u PD=0.67u rfmode=0
M$4442 \$850 \$790 VDD VDD sg13_lv_pmos L=0.13u W=0.42u AS=0.0525p AD=0.25605p
+ PS=0.67u PD=1.935u rfmode=0
M$4443 VDD VDD \$790 VDD sg13_lv_pmos L=0.13u W=0.42u AS=0.25605p AD=0.0798p
+ PS=1.935u PD=0.8u rfmode=0
M$4444 VDD \$708 \$790 VDD sg13_lv_pmos L=0.13u W=0.42u AS=0.2014p AD=0.0798p
+ PS=1.53u PD=0.8u rfmode=0
M$4445 VDD \$708 \$710 VDD sg13_lv_pmos L=0.13u W=1u AS=0.2083p AD=0.34p
+ PS=1.5u PD=2.68u rfmode=0
M$4446 VDD \$708 \$709 VDD sg13_lv_pmos L=0.13u W=2.24u AS=0.4142p AD=0.4211p
+ PS=3.03u PD=3u rfmode=0
M$4448 \$644 \$645 \$708 VDD sg13_lv_pmos L=0.13u W=1u AS=0.34p AD=0.19115p
+ PS=2.68u PD=1.565u rfmode=0
M$4449 \$646 \$186 \$854 VDD sg13_lv_pmos L=0.13u W=0.84u AS=0.2856p AD=0.1596p
+ PS=2.36u PD=1.22u rfmode=0
M$4450 VDD \$195 \$854 VDD sg13_lv_pmos L=0.13u W=0.84u AS=0.2226p AD=0.1596p
+ PS=1.535u PD=1.22u rfmode=0
M$4451 VDD \$646 \$647 VDD sg13_lv_pmos L=0.13u W=2.24u AS=0.4746p AD=0.6776p
+ PS=3.105u PD=4.57u rfmode=0
M$4453 VDD \$714 \$808 VDD sg13_lv_pmos L=0.13u W=0.42u AS=0.1428p AD=0.0798p
+ PS=1.52u PD=0.8u rfmode=0
M$4454 VDD VDD \$808 VDD sg13_lv_pmos L=0.13u W=0.42u AS=0.3623875p AD=0.0798p
+ PS=2.605u PD=0.8u rfmode=0
M$4455 VDD \$791 \$648 VDD sg13_lv_pmos L=0.13u W=1u AS=0.3623875p AD=0.34p
+ PS=2.605u PD=2.68u rfmode=0
M$4456 \$717 \$809 \$857 VDD sg13_lv_pmos L=0.13u W=0.42u AS=0.19115p
+ AD=0.0525p PS=1.565u PD=0.67u rfmode=0
M$4457 \$857 \$792 VDD VDD sg13_lv_pmos L=0.13u W=0.42u AS=0.0525p AD=0.25605p
+ PS=0.67u PD=1.935u rfmode=0
M$4458 VDD VDD \$792 VDD sg13_lv_pmos L=0.13u W=0.42u AS=0.25605p AD=0.0798p
+ PS=1.935u PD=0.8u rfmode=0
M$4459 VDD \$717 \$792 VDD sg13_lv_pmos L=0.13u W=0.42u AS=0.2014p AD=0.0798p
+ PS=1.53u PD=0.8u rfmode=0
M$4460 VDD \$717 \$719 VDD sg13_lv_pmos L=0.13u W=1u AS=0.2083p AD=0.34p
+ PS=1.5u PD=2.68u rfmode=0
M$4461 VDD \$717 \$718 VDD sg13_lv_pmos L=0.13u W=2.24u AS=0.4142p AD=0.4211p
+ PS=3.03u PD=3u rfmode=0
M$4463 \$648 \$649 \$717 VDD sg13_lv_pmos L=0.13u W=1u AS=0.34p AD=0.19115p
+ PS=2.68u PD=1.565u rfmode=0
M$4464 \$650 VSS \$861 VDD sg13_lv_pmos L=0.13u W=0.84u AS=0.2856p AD=0.1596p
+ PS=2.36u PD=1.22u rfmode=0
M$4465 VDD \$195 \$861 VDD sg13_lv_pmos L=0.13u W=0.84u AS=0.2226p AD=0.1596p
+ PS=1.535u PD=1.22u rfmode=0
M$4466 VDD \$650 \$651 VDD sg13_lv_pmos L=0.13u W=2.24u AS=0.4746p AD=0.6776p
+ PS=3.105u PD=4.57u rfmode=0
M$4468 VDD \$723 \$811 VDD sg13_lv_pmos L=0.13u W=0.42u AS=0.1428p AD=0.0798p
+ PS=1.52u PD=0.8u rfmode=0
M$4469 VDD VDD \$811 VDD sg13_lv_pmos L=0.13u W=0.42u AS=0.3623875p AD=0.0798p
+ PS=2.605u PD=0.8u rfmode=0
M$4470 VDD \$793 \$652 VDD sg13_lv_pmos L=0.13u W=1u AS=0.3623875p AD=0.34p
+ PS=2.605u PD=2.68u rfmode=0
M$4471 \$726 \$812 \$845 VDD sg13_lv_pmos L=0.13u W=0.42u AS=0.19115p
+ AD=0.0525p PS=1.565u PD=0.67u rfmode=0
M$4472 \$845 \$794 VDD VDD sg13_lv_pmos L=0.13u W=0.42u AS=0.0525p AD=0.25605p
+ PS=0.67u PD=1.935u rfmode=0
M$4473 VDD VDD \$794 VDD sg13_lv_pmos L=0.13u W=0.42u AS=0.25605p AD=0.0798p
+ PS=1.935u PD=0.8u rfmode=0
M$4474 VDD \$726 \$794 VDD sg13_lv_pmos L=0.13u W=0.42u AS=0.2014p AD=0.0798p
+ PS=1.53u PD=0.8u rfmode=0
M$4475 VDD \$726 \$728 VDD sg13_lv_pmos L=0.13u W=1u AS=0.2083p AD=0.34p
+ PS=1.5u PD=2.68u rfmode=0
M$4476 VDD \$726 \$727 VDD sg13_lv_pmos L=0.13u W=2.24u AS=0.4142p AD=0.4211p
+ PS=3.03u PD=3u rfmode=0
M$4478 \$652 \$653 \$726 VDD sg13_lv_pmos L=0.13u W=1u AS=0.34p AD=0.19115p
+ PS=2.68u PD=1.565u rfmode=0
M$4479 VDD \$911 \$943 VDD sg13_lv_pmos L=0.13u W=2.24u AS=0.616p AD=0.4312p
+ PS=4.46u PD=3.01u rfmode=0
M$4481 VDD \$195 \$943 VDD sg13_lv_pmos L=0.13u W=2.24u AS=0.4312p AD=0.6048p
+ PS=3.01u PD=4.44u rfmode=0
M$4483 VDD \$943 \$944 VDD sg13_lv_pmos L=0.13u W=0.42u AS=0.1428p AD=0.0798p
+ PS=1.52u PD=0.8u rfmode=0
M$4484 VDD VDD \$944 VDD sg13_lv_pmos L=0.13u W=0.42u AS=0.3623875p AD=0.0798p
+ PS=2.605u PD=0.8u rfmode=0
M$4485 VDD \$1069 \$912 VDD sg13_lv_pmos L=0.13u W=1u AS=0.3623875p AD=0.34p
+ PS=2.605u PD=2.68u rfmode=0
M$4486 \$779 VDD VDD VDD sg13_lv_pmos L=0.13u W=0.42u AS=0.147p AD=0.1563p
+ PS=1.54u PD=1.22u rfmode=0
M$4487 VDD \$624 \$816 VDD sg13_lv_pmos L=0.13u W=0.42u AS=0.1563p AD=0.0546p
+ PS=1.22u PD=0.68u rfmode=0
M$4488 \$816 \$625 \$779 VDD sg13_lv_pmos L=0.13u W=0.42u AS=0.0546p AD=0.0798p
+ PS=0.68u PD=0.8u rfmode=0
M$4489 \$779 \$795 \$656 VDD sg13_lv_pmos L=0.13u W=0.42u AS=0.0798p AD=0.1428p
+ PS=0.8u PD=1.52u rfmode=0
M$4490 \$1085 \$913 VDD VDD sg13_lv_pmos L=0.13u W=1.12u AS=0.3864p
+ AD=0.431025p PS=2.93u PD=2.145u rfmode=0
M$4491 VDD CLK \$913 VDD sg13_lv_pmos L=0.13u W=1.12u AS=0.431025p AD=0.3808p
+ PS=2.145u PD=2.92u rfmode=0
M$4492 \$947 \$1085 \$1105 VDD sg13_lv_pmos L=0.13u W=0.42u AS=0.19115p
+ AD=0.0525p PS=1.565u PD=0.67u rfmode=0
M$4493 \$1105 \$1070 VDD VDD sg13_lv_pmos L=0.13u W=0.42u AS=0.0525p
+ AD=0.25605p PS=0.67u PD=1.935u rfmode=0
M$4494 VDD VDD \$1070 VDD sg13_lv_pmos L=0.13u W=0.42u AS=0.25605p AD=0.0798p
+ PS=1.935u PD=0.8u rfmode=0
M$4495 VDD \$947 \$1070 VDD sg13_lv_pmos L=0.13u W=0.42u AS=0.2014p AD=0.0798p
+ PS=1.53u PD=0.8u rfmode=0
M$4496 VDD \$947 \$949 VDD sg13_lv_pmos L=0.13u W=1u AS=0.2083p AD=0.34p
+ PS=1.5u PD=2.68u rfmode=0
M$4497 VDD \$947 \$948 VDD sg13_lv_pmos L=0.13u W=2.24u AS=0.4142p AD=0.4211p
+ PS=3.03u PD=3u rfmode=0
M$4499 \$912 \$913 \$947 VDD sg13_lv_pmos L=0.13u W=1u AS=0.34p AD=0.19115p
+ PS=2.68u PD=1.565u rfmode=0
M$4500 VDD \$949 \$950 VDD sg13_lv_pmos L=0.13u W=2.24u AS=0.5964p AD=0.5964p
+ PS=4.425u PD=4.425u rfmode=0
M$4502 VDD \$915 \$953 VDD sg13_lv_pmos L=0.13u W=2.24u AS=0.616p AD=0.4312p
+ PS=4.46u PD=3.01u rfmode=0
M$4504 VDD \$195 \$953 VDD sg13_lv_pmos L=0.13u W=2.24u AS=0.4312p AD=0.6048p
+ PS=3.01u PD=4.44u rfmode=0
M$4506 VDD \$953 \$1087 VDD sg13_lv_pmos L=0.13u W=0.42u AS=0.1428p AD=0.0798p
+ PS=1.52u PD=0.8u rfmode=0
M$4507 VDD VDD \$1087 VDD sg13_lv_pmos L=0.13u W=0.42u AS=0.3623875p AD=0.0798p
+ PS=2.605u PD=0.8u rfmode=0
M$4508 VDD \$1071 \$916 VDD sg13_lv_pmos L=0.13u W=1u AS=0.3623875p AD=0.34p
+ PS=2.605u PD=2.68u rfmode=0
M$4509 \$781 VDD VDD VDD sg13_lv_pmos L=0.13u W=0.42u AS=0.147p AD=0.1563p
+ PS=1.54u PD=1.22u rfmode=0
M$4510 VDD \$628 \$822 VDD sg13_lv_pmos L=0.13u W=0.42u AS=0.1563p AD=0.0546p
+ PS=1.22u PD=0.68u rfmode=0
M$4511 \$822 \$629 \$781 VDD sg13_lv_pmos L=0.13u W=0.42u AS=0.0546p AD=0.0798p
+ PS=0.68u PD=0.8u rfmode=0
M$4512 \$781 \$797 \$666 VDD sg13_lv_pmos L=0.13u W=0.42u AS=0.0798p AD=0.1428p
+ PS=0.8u PD=1.52u rfmode=0
M$4513 \$1088 \$917 VDD VDD sg13_lv_pmos L=0.13u W=1.12u AS=0.3864p
+ AD=0.431025p PS=2.93u PD=2.145u rfmode=0
M$4514 VDD CLK \$917 VDD sg13_lv_pmos L=0.13u W=1.12u AS=0.431025p AD=0.3808p
+ PS=2.145u PD=2.92u rfmode=0
M$4515 \$956 \$1088 \$1111 VDD sg13_lv_pmos L=0.13u W=0.42u AS=0.19115p
+ AD=0.0525p PS=1.565u PD=0.67u rfmode=0
M$4516 \$1111 \$1072 VDD VDD sg13_lv_pmos L=0.13u W=0.42u AS=0.0525p
+ AD=0.25605p PS=0.67u PD=1.935u rfmode=0
M$4517 VDD VDD \$1072 VDD sg13_lv_pmos L=0.13u W=0.42u AS=0.25605p AD=0.0798p
+ PS=1.935u PD=0.8u rfmode=0
M$4518 VDD \$956 \$1072 VDD sg13_lv_pmos L=0.13u W=0.42u AS=0.2014p AD=0.0798p
+ PS=1.53u PD=0.8u rfmode=0
M$4519 VDD \$956 \$958 VDD sg13_lv_pmos L=0.13u W=1u AS=0.2083p AD=0.34p
+ PS=1.5u PD=2.68u rfmode=0
M$4520 VDD \$956 \$957 VDD sg13_lv_pmos L=0.13u W=2.24u AS=0.4142p AD=0.4211p
+ PS=3.03u PD=3u rfmode=0
M$4522 \$916 \$917 \$956 VDD sg13_lv_pmos L=0.13u W=1u AS=0.34p AD=0.19115p
+ PS=2.68u PD=1.565u rfmode=0
M$4523 VDD \$958 \$959 VDD sg13_lv_pmos L=0.13u W=2.24u AS=0.5964p AD=0.5964p
+ PS=4.425u PD=4.425u rfmode=0
M$4525 VDD \$919 \$962 VDD sg13_lv_pmos L=0.13u W=2.24u AS=0.616p AD=0.4312p
+ PS=4.46u PD=3.01u rfmode=0
M$4527 VDD \$195 \$962 VDD sg13_lv_pmos L=0.13u W=2.24u AS=0.4312p AD=0.6048p
+ PS=3.01u PD=4.44u rfmode=0
M$4529 VDD \$962 \$963 VDD sg13_lv_pmos L=0.13u W=0.42u AS=0.1428p AD=0.0798p
+ PS=1.52u PD=0.8u rfmode=0
M$4530 VDD VDD \$963 VDD sg13_lv_pmos L=0.13u W=0.42u AS=0.3623875p AD=0.0798p
+ PS=2.605u PD=0.8u rfmode=0
M$4531 VDD \$1073 \$920 VDD sg13_lv_pmos L=0.13u W=1u AS=0.3623875p AD=0.34p
+ PS=2.605u PD=2.68u rfmode=0
M$4532 \$783 VDD VDD VDD sg13_lv_pmos L=0.13u W=0.42u AS=0.147p AD=0.1563p
+ PS=1.54u PD=1.22u rfmode=0
M$4533 VDD \$632 \$829 VDD sg13_lv_pmos L=0.13u W=0.42u AS=0.1563p AD=0.0546p
+ PS=1.22u PD=0.68u rfmode=0
M$4534 \$829 \$633 \$783 VDD sg13_lv_pmos L=0.13u W=0.42u AS=0.0546p AD=0.0798p
+ PS=0.68u PD=0.8u rfmode=0
M$4535 \$783 \$799 \$676 VDD sg13_lv_pmos L=0.13u W=0.42u AS=0.0798p AD=0.1428p
+ PS=0.8u PD=1.52u rfmode=0
M$4536 \$1090 \$921 VDD VDD sg13_lv_pmos L=0.13u W=1.12u AS=0.3864p
+ AD=0.431025p PS=2.93u PD=2.145u rfmode=0
M$4537 VDD CLK \$921 VDD sg13_lv_pmos L=0.13u W=1.12u AS=0.431025p AD=0.3808p
+ PS=2.145u PD=2.92u rfmode=0
M$4538 \$966 \$1090 \$1118 VDD sg13_lv_pmos L=0.13u W=0.42u AS=0.19115p
+ AD=0.0525p PS=1.565u PD=0.67u rfmode=0
M$4539 \$1118 \$1074 VDD VDD sg13_lv_pmos L=0.13u W=0.42u AS=0.0525p
+ AD=0.25605p PS=0.67u PD=1.935u rfmode=0
M$4540 VDD VDD \$1074 VDD sg13_lv_pmos L=0.13u W=0.42u AS=0.25605p AD=0.0798p
+ PS=1.935u PD=0.8u rfmode=0
M$4541 VDD \$966 \$1074 VDD sg13_lv_pmos L=0.13u W=0.42u AS=0.2014p AD=0.0798p
+ PS=1.53u PD=0.8u rfmode=0
M$4542 VDD \$966 \$968 VDD sg13_lv_pmos L=0.13u W=1u AS=0.2083p AD=0.34p
+ PS=1.5u PD=2.68u rfmode=0
M$4543 VDD \$966 \$967 VDD sg13_lv_pmos L=0.13u W=2.24u AS=0.4142p AD=0.4211p
+ PS=3.03u PD=3u rfmode=0
M$4545 \$920 \$921 \$966 VDD sg13_lv_pmos L=0.13u W=1u AS=0.34p AD=0.19115p
+ PS=2.68u PD=1.565u rfmode=0
M$4546 VDD \$968 \$969 VDD sg13_lv_pmos L=0.13u W=2.24u AS=0.5964p AD=0.5964p
+ PS=4.425u PD=4.425u rfmode=0
M$4548 VDD \$923 \$972 VDD sg13_lv_pmos L=0.13u W=2.24u AS=0.616p AD=0.4312p
+ PS=4.46u PD=3.01u rfmode=0
M$4550 VDD \$195 \$972 VDD sg13_lv_pmos L=0.13u W=2.24u AS=0.4312p AD=0.6048p
+ PS=3.01u PD=4.44u rfmode=0
M$4552 VDD \$972 \$973 VDD sg13_lv_pmos L=0.13u W=0.42u AS=0.1428p AD=0.0798p
+ PS=1.52u PD=0.8u rfmode=0
M$4553 VDD VDD \$973 VDD sg13_lv_pmos L=0.13u W=0.42u AS=0.3623875p AD=0.0798p
+ PS=2.605u PD=0.8u rfmode=0
M$4554 VDD \$1075 \$924 VDD sg13_lv_pmos L=0.13u W=1u AS=0.3623875p AD=0.34p
+ PS=2.605u PD=2.68u rfmode=0
M$4555 \$785 VDD VDD VDD sg13_lv_pmos L=0.13u W=0.42u AS=0.147p AD=0.1563p
+ PS=1.54u PD=1.22u rfmode=0
M$4556 VDD \$636 \$836 VDD sg13_lv_pmos L=0.13u W=0.42u AS=0.1563p AD=0.0546p
+ PS=1.22u PD=0.68u rfmode=0
M$4557 \$836 \$637 \$785 VDD sg13_lv_pmos L=0.13u W=0.42u AS=0.0546p AD=0.0798p
+ PS=0.68u PD=0.8u rfmode=0
M$4558 \$785 \$801 \$686 VDD sg13_lv_pmos L=0.13u W=0.42u AS=0.0798p AD=0.1428p
+ PS=0.8u PD=1.52u rfmode=0
M$4559 \$1092 \$925 VDD VDD sg13_lv_pmos L=0.13u W=1.12u AS=0.3864p
+ AD=0.431025p PS=2.93u PD=2.145u rfmode=0
M$4560 VDD CLK \$925 VDD sg13_lv_pmos L=0.13u W=1.12u AS=0.431025p AD=0.3808p
+ PS=2.145u PD=2.92u rfmode=0
M$4561 \$976 \$1092 \$1125 VDD sg13_lv_pmos L=0.13u W=0.42u AS=0.19115p
+ AD=0.0525p PS=1.565u PD=0.67u rfmode=0
M$4562 \$1125 \$1076 VDD VDD sg13_lv_pmos L=0.13u W=0.42u AS=0.0525p
+ AD=0.25605p PS=0.67u PD=1.935u rfmode=0
M$4563 VDD VDD \$1076 VDD sg13_lv_pmos L=0.13u W=0.42u AS=0.25605p AD=0.0798p
+ PS=1.935u PD=0.8u rfmode=0
M$4564 VDD \$976 \$1076 VDD sg13_lv_pmos L=0.13u W=0.42u AS=0.2014p AD=0.0798p
+ PS=1.53u PD=0.8u rfmode=0
M$4565 VDD \$976 \$978 VDD sg13_lv_pmos L=0.13u W=1u AS=0.2083p AD=0.34p
+ PS=1.5u PD=2.68u rfmode=0
M$4566 VDD \$976 \$977 VDD sg13_lv_pmos L=0.13u W=2.24u AS=0.4142p AD=0.4211p
+ PS=3.03u PD=3u rfmode=0
M$4568 \$924 \$925 \$976 VDD sg13_lv_pmos L=0.13u W=1u AS=0.34p AD=0.19115p
+ PS=2.68u PD=1.565u rfmode=0
M$4569 VDD \$978 \$979 VDD sg13_lv_pmos L=0.13u W=2.24u AS=0.5964p AD=0.5964p
+ PS=4.425u PD=4.425u rfmode=0
M$4571 VDD \$927 \$982 VDD sg13_lv_pmos L=0.13u W=2.24u AS=0.616p AD=0.4312p
+ PS=4.46u PD=3.01u rfmode=0
M$4573 VDD \$195 \$982 VDD sg13_lv_pmos L=0.13u W=2.24u AS=0.4312p AD=0.6048p
+ PS=3.01u PD=4.44u rfmode=0
M$4575 VDD \$982 \$983 VDD sg13_lv_pmos L=0.13u W=0.42u AS=0.1428p AD=0.0798p
+ PS=1.52u PD=0.8u rfmode=0
M$4576 VDD VDD \$983 VDD sg13_lv_pmos L=0.13u W=0.42u AS=0.3623875p AD=0.0798p
+ PS=2.605u PD=0.8u rfmode=0
M$4577 VDD \$1077 \$928 VDD sg13_lv_pmos L=0.13u W=1u AS=0.3623875p AD=0.34p
+ PS=2.605u PD=2.68u rfmode=0
M$4578 \$787 VDD VDD VDD sg13_lv_pmos L=0.13u W=0.42u AS=0.147p AD=0.1563p
+ PS=1.54u PD=1.22u rfmode=0
M$4579 VDD \$640 \$842 VDD sg13_lv_pmos L=0.13u W=0.42u AS=0.1563p AD=0.0546p
+ PS=1.22u PD=0.68u rfmode=0
M$4580 \$842 \$641 \$787 VDD sg13_lv_pmos L=0.13u W=0.42u AS=0.0546p AD=0.0798p
+ PS=0.68u PD=0.8u rfmode=0
M$4581 \$787 \$803 \$696 VDD sg13_lv_pmos L=0.13u W=0.42u AS=0.0798p AD=0.1428p
+ PS=0.8u PD=1.52u rfmode=0
M$4582 \$1094 \$929 VDD VDD sg13_lv_pmos L=0.13u W=1.12u AS=0.3864p
+ AD=0.431025p PS=2.93u PD=2.145u rfmode=0
M$4583 VDD CLK \$929 VDD sg13_lv_pmos L=0.13u W=1.12u AS=0.431025p AD=0.3808p
+ PS=2.145u PD=2.92u rfmode=0
M$4584 \$986 \$1094 \$1131 VDD sg13_lv_pmos L=0.13u W=0.42u AS=0.19115p
+ AD=0.0525p PS=1.565u PD=0.67u rfmode=0
M$4585 \$1131 \$1078 VDD VDD sg13_lv_pmos L=0.13u W=0.42u AS=0.0525p
+ AD=0.25605p PS=0.67u PD=1.935u rfmode=0
M$4586 VDD VDD \$1078 VDD sg13_lv_pmos L=0.13u W=0.42u AS=0.25605p AD=0.0798p
+ PS=1.935u PD=0.8u rfmode=0
M$4587 VDD \$986 \$1078 VDD sg13_lv_pmos L=0.13u W=0.42u AS=0.2014p AD=0.0798p
+ PS=1.53u PD=0.8u rfmode=0
M$4588 VDD \$986 \$988 VDD sg13_lv_pmos L=0.13u W=1u AS=0.2083p AD=0.34p
+ PS=1.5u PD=2.68u rfmode=0
M$4589 VDD \$986 \$987 VDD sg13_lv_pmos L=0.13u W=2.24u AS=0.4142p AD=0.4211p
+ PS=3.03u PD=3u rfmode=0
M$4591 \$928 \$929 \$986 VDD sg13_lv_pmos L=0.13u W=1u AS=0.34p AD=0.19115p
+ PS=2.68u PD=1.565u rfmode=0
M$4592 VDD \$988 \$989 VDD sg13_lv_pmos L=0.13u W=2.24u AS=0.5964p AD=0.5964p
+ PS=4.425u PD=4.425u rfmode=0
M$4594 VDD \$931 \$992 VDD sg13_lv_pmos L=0.13u W=2.24u AS=0.616p AD=0.4312p
+ PS=4.46u PD=3.01u rfmode=0
M$4596 VDD \$195 \$992 VDD sg13_lv_pmos L=0.13u W=2.24u AS=0.4312p AD=0.6048p
+ PS=3.01u PD=4.44u rfmode=0
M$4598 VDD \$992 \$993 VDD sg13_lv_pmos L=0.13u W=0.42u AS=0.1428p AD=0.0798p
+ PS=1.52u PD=0.8u rfmode=0
M$4599 VDD VDD \$993 VDD sg13_lv_pmos L=0.13u W=0.42u AS=0.3623875p AD=0.0798p
+ PS=2.605u PD=0.8u rfmode=0
M$4600 VDD \$1079 \$932 VDD sg13_lv_pmos L=0.13u W=1u AS=0.3623875p AD=0.34p
+ PS=2.605u PD=2.68u rfmode=0
M$4601 \$789 VDD VDD VDD sg13_lv_pmos L=0.13u W=0.42u AS=0.147p AD=0.1563p
+ PS=1.54u PD=1.22u rfmode=0
M$4602 VDD \$644 \$849 VDD sg13_lv_pmos L=0.13u W=0.42u AS=0.1563p AD=0.0546p
+ PS=1.22u PD=0.68u rfmode=0
M$4603 \$849 \$645 \$789 VDD sg13_lv_pmos L=0.13u W=0.42u AS=0.0546p AD=0.0798p
+ PS=0.68u PD=0.8u rfmode=0
M$4604 \$789 \$806 \$805 VDD sg13_lv_pmos L=0.13u W=0.42u AS=0.0798p AD=0.1428p
+ PS=0.8u PD=1.52u rfmode=0
M$4605 \$1096 \$933 VDD VDD sg13_lv_pmos L=0.13u W=1.12u AS=0.3864p
+ AD=0.431025p PS=2.93u PD=2.145u rfmode=0
M$4606 VDD CLK \$933 VDD sg13_lv_pmos L=0.13u W=1.12u AS=0.431025p AD=0.3808p
+ PS=2.145u PD=2.92u rfmode=0
M$4607 \$996 \$1096 \$1138 VDD sg13_lv_pmos L=0.13u W=0.42u AS=0.19115p
+ AD=0.0525p PS=1.565u PD=0.67u rfmode=0
M$4608 \$1138 \$1080 VDD VDD sg13_lv_pmos L=0.13u W=0.42u AS=0.0525p
+ AD=0.25605p PS=0.67u PD=1.935u rfmode=0
M$4609 VDD VDD \$1080 VDD sg13_lv_pmos L=0.13u W=0.42u AS=0.25605p AD=0.0798p
+ PS=1.935u PD=0.8u rfmode=0
M$4610 VDD \$996 \$1080 VDD sg13_lv_pmos L=0.13u W=0.42u AS=0.2014p AD=0.0798p
+ PS=1.53u PD=0.8u rfmode=0
M$4611 VDD \$996 \$998 VDD sg13_lv_pmos L=0.13u W=1u AS=0.2083p AD=0.34p
+ PS=1.5u PD=2.68u rfmode=0
M$4612 VDD \$996 \$997 VDD sg13_lv_pmos L=0.13u W=2.24u AS=0.4142p AD=0.4211p
+ PS=3.03u PD=3u rfmode=0
M$4614 \$932 \$933 \$996 VDD sg13_lv_pmos L=0.13u W=1u AS=0.34p AD=0.19115p
+ PS=2.68u PD=1.565u rfmode=0
M$4615 VDD \$998 \$999 VDD sg13_lv_pmos L=0.13u W=2.24u AS=0.5964p AD=0.5964p
+ PS=4.425u PD=4.425u rfmode=0
M$4617 VDD \$935 \$1002 VDD sg13_lv_pmos L=0.13u W=2.24u AS=0.616p AD=0.4312p
+ PS=4.46u PD=3.01u rfmode=0
M$4619 VDD \$195 \$1002 VDD sg13_lv_pmos L=0.13u W=2.24u AS=0.4312p AD=0.6048p
+ PS=3.01u PD=4.44u rfmode=0
M$4621 VDD \$1002 \$1003 VDD sg13_lv_pmos L=0.13u W=0.42u AS=0.1428p AD=0.0798p
+ PS=1.52u PD=0.8u rfmode=0
M$4622 VDD VDD \$1003 VDD sg13_lv_pmos L=0.13u W=0.42u AS=0.3623875p AD=0.0798p
+ PS=2.605u PD=0.8u rfmode=0
M$4623 VDD \$1081 \$936 VDD sg13_lv_pmos L=0.13u W=1u AS=0.3623875p AD=0.34p
+ PS=2.605u PD=2.68u rfmode=0
M$4624 \$791 VDD VDD VDD sg13_lv_pmos L=0.13u W=0.42u AS=0.147p AD=0.1563p
+ PS=1.54u PD=1.22u rfmode=0
M$4625 VDD \$648 \$856 VDD sg13_lv_pmos L=0.13u W=0.42u AS=0.1563p AD=0.0546p
+ PS=1.22u PD=0.68u rfmode=0
M$4626 \$856 \$649 \$791 VDD sg13_lv_pmos L=0.13u W=0.42u AS=0.0546p AD=0.0798p
+ PS=0.68u PD=0.8u rfmode=0
M$4627 \$791 \$809 \$808 VDD sg13_lv_pmos L=0.13u W=0.42u AS=0.0798p AD=0.1428p
+ PS=0.8u PD=1.52u rfmode=0
M$4628 \$1098 \$937 VDD VDD sg13_lv_pmos L=0.13u W=1.12u AS=0.3864p
+ AD=0.431025p PS=2.93u PD=2.145u rfmode=0
M$4629 VDD CLK \$937 VDD sg13_lv_pmos L=0.13u W=1.12u AS=0.431025p AD=0.3808p
+ PS=2.145u PD=2.92u rfmode=0
M$4630 \$1006 \$1098 \$1145 VDD sg13_lv_pmos L=0.13u W=0.42u AS=0.19115p
+ AD=0.0525p PS=1.565u PD=0.67u rfmode=0
M$4631 \$1145 \$1082 VDD VDD sg13_lv_pmos L=0.13u W=0.42u AS=0.0525p
+ AD=0.25605p PS=0.67u PD=1.935u rfmode=0
M$4632 VDD VDD \$1082 VDD sg13_lv_pmos L=0.13u W=0.42u AS=0.25605p AD=0.0798p
+ PS=1.935u PD=0.8u rfmode=0
M$4633 VDD \$1006 \$1082 VDD sg13_lv_pmos L=0.13u W=0.42u AS=0.2014p AD=0.0798p
+ PS=1.53u PD=0.8u rfmode=0
M$4634 VDD \$1006 \$1008 VDD sg13_lv_pmos L=0.13u W=1u AS=0.2083p AD=0.34p
+ PS=1.5u PD=2.68u rfmode=0
M$4635 VDD \$1006 \$1007 VDD sg13_lv_pmos L=0.13u W=2.24u AS=0.4142p AD=0.4211p
+ PS=3.03u PD=3u rfmode=0
M$4637 \$936 \$937 \$1006 VDD sg13_lv_pmos L=0.13u W=1u AS=0.34p AD=0.19115p
+ PS=2.68u PD=1.565u rfmode=0
M$4638 VDD \$1008 \$1009 VDD sg13_lv_pmos L=0.13u W=2.24u AS=0.5964p AD=0.5964p
+ PS=4.425u PD=4.425u rfmode=0
M$4640 VDD \$939 \$1012 VDD sg13_lv_pmos L=0.13u W=2.24u AS=0.616p AD=0.4312p
+ PS=4.46u PD=3.01u rfmode=0
M$4642 VDD \$195 \$1012 VDD sg13_lv_pmos L=0.13u W=2.24u AS=0.4312p AD=0.6048p
+ PS=3.01u PD=4.44u rfmode=0
M$4644 VDD \$1012 \$1013 VDD sg13_lv_pmos L=0.13u W=0.42u AS=0.1428p AD=0.0798p
+ PS=1.52u PD=0.8u rfmode=0
M$4645 VDD VDD \$1013 VDD sg13_lv_pmos L=0.13u W=0.42u AS=0.3623875p AD=0.0798p
+ PS=2.605u PD=0.8u rfmode=0
M$4646 VDD \$1083 \$940 VDD sg13_lv_pmos L=0.13u W=1u AS=0.3623875p AD=0.34p
+ PS=2.605u PD=2.68u rfmode=0
M$4647 \$793 VDD VDD VDD sg13_lv_pmos L=0.13u W=0.42u AS=0.147p AD=0.1563p
+ PS=1.54u PD=1.22u rfmode=0
M$4648 VDD \$652 \$855 VDD sg13_lv_pmos L=0.13u W=0.42u AS=0.1563p AD=0.0546p
+ PS=1.22u PD=0.68u rfmode=0
M$4649 \$855 \$653 \$793 VDD sg13_lv_pmos L=0.13u W=0.42u AS=0.0546p AD=0.0798p
+ PS=0.68u PD=0.8u rfmode=0
M$4650 \$793 \$812 \$811 VDD sg13_lv_pmos L=0.13u W=0.42u AS=0.0798p AD=0.1428p
+ PS=0.8u PD=1.52u rfmode=0
M$4651 \$1100 \$941 VDD VDD sg13_lv_pmos L=0.13u W=1.12u AS=0.3864p
+ AD=0.431025p PS=2.93u PD=2.145u rfmode=0
M$4652 VDD CLK \$941 VDD sg13_lv_pmos L=0.13u W=1.12u AS=0.431025p AD=0.3808p
+ PS=2.145u PD=2.92u rfmode=0
M$4653 \$1016 \$1100 \$1134 VDD sg13_lv_pmos L=0.13u W=0.42u AS=0.19115p
+ AD=0.0525p PS=1.565u PD=0.67u rfmode=0
M$4654 \$1134 \$1084 VDD VDD sg13_lv_pmos L=0.13u W=0.42u AS=0.0525p
+ AD=0.25605p PS=0.67u PD=1.935u rfmode=0
M$4655 VDD VDD \$1084 VDD sg13_lv_pmos L=0.13u W=0.42u AS=0.25605p AD=0.0798p
+ PS=1.935u PD=0.8u rfmode=0
M$4656 VDD \$1016 \$1084 VDD sg13_lv_pmos L=0.13u W=0.42u AS=0.2014p AD=0.0798p
+ PS=1.53u PD=0.8u rfmode=0
M$4657 VDD \$1016 \$1018 VDD sg13_lv_pmos L=0.13u W=1u AS=0.2083p AD=0.34p
+ PS=1.5u PD=2.68u rfmode=0
M$4658 VDD \$1016 \$1017 VDD sg13_lv_pmos L=0.13u W=2.24u AS=0.4142p AD=0.4211p
+ PS=3.03u PD=3u rfmode=0
M$4660 \$940 \$941 \$1016 VDD sg13_lv_pmos L=0.13u W=1u AS=0.34p AD=0.19115p
+ PS=2.68u PD=1.565u rfmode=0
M$4661 VDD \$1018 \$1019 VDD sg13_lv_pmos L=0.13u W=2.24u AS=0.5964p AD=0.5964p
+ PS=4.425u PD=4.425u rfmode=0
M$4663 \$910 \$167 \$1103 VDD sg13_lv_pmos L=0.13u W=0.84u AS=0.2856p
+ AD=0.1596p PS=2.36u PD=1.22u rfmode=0
M$4664 VDD \$5 \$1103 VDD sg13_lv_pmos L=0.13u W=0.84u AS=0.2226p AD=0.1596p
+ PS=1.535u PD=1.22u rfmode=0
M$4665 VDD \$910 \$911 VDD sg13_lv_pmos L=0.13u W=2.24u AS=0.4746p AD=0.6776p
+ PS=3.105u PD=4.57u rfmode=0
M$4667 VDD \$1199 \$1231 VDD sg13_lv_pmos L=0.13u W=2.24u AS=0.616p AD=0.4312p
+ PS=4.46u PD=3.01u rfmode=0
M$4669 VDD \$5 \$1231 VDD sg13_lv_pmos L=0.13u W=2.24u AS=0.4312p AD=0.6048p
+ PS=3.01u PD=4.44u rfmode=0
M$4671 \$1069 VDD VDD VDD sg13_lv_pmos L=0.13u W=0.42u AS=0.147p AD=0.1563p
+ PS=1.54u PD=1.22u rfmode=0
M$4672 VDD \$912 \$1104 VDD sg13_lv_pmos L=0.13u W=0.42u AS=0.1563p AD=0.0546p
+ PS=1.22u PD=0.68u rfmode=0
M$4673 \$1104 \$913 \$1069 VDD sg13_lv_pmos L=0.13u W=0.42u AS=0.0546p
+ AD=0.0798p PS=0.68u PD=0.8u rfmode=0
M$4674 \$1069 \$1085 \$944 VDD sg13_lv_pmos L=0.13u W=0.42u AS=0.0798p
+ AD=0.1428p PS=0.8u PD=1.52u rfmode=0
M$4675 \$1370 \$1201 VDD VDD sg13_lv_pmos L=0.13u W=1.12u AS=0.3864p
+ AD=0.431025p PS=2.93u PD=2.145u rfmode=0
M$4676 VDD CLK \$1201 VDD sg13_lv_pmos L=0.13u W=1.12u AS=0.431025p AD=0.3808p
+ PS=2.145u PD=2.92u rfmode=0
M$4677 VDD \$1237 \$1238 VDD sg13_lv_pmos L=0.13u W=2.24u AS=0.5964p AD=0.5964p
+ PS=4.425u PD=4.425u rfmode=0
M$4679 \$914 \$171 \$1109 VDD sg13_lv_pmos L=0.13u W=0.84u AS=0.2856p
+ AD=0.1596p PS=2.36u PD=1.22u rfmode=0
M$4680 VDD \$5 \$1109 VDD sg13_lv_pmos L=0.13u W=0.84u AS=0.2226p AD=0.1596p
+ PS=1.535u PD=1.22u rfmode=0
M$4681 VDD \$914 \$915 VDD sg13_lv_pmos L=0.13u W=2.24u AS=0.4746p AD=0.6776p
+ PS=3.105u PD=4.57u rfmode=0
M$4683 VDD \$1203 \$1241 VDD sg13_lv_pmos L=0.13u W=2.24u AS=0.616p AD=0.4312p
+ PS=4.46u PD=3.01u rfmode=0
M$4685 VDD \$5 \$1241 VDD sg13_lv_pmos L=0.13u W=2.24u AS=0.4312p AD=0.6048p
+ PS=3.01u PD=4.44u rfmode=0
M$4687 \$1071 VDD VDD VDD sg13_lv_pmos L=0.13u W=0.42u AS=0.147p AD=0.1563p
+ PS=1.54u PD=1.22u rfmode=0
M$4688 VDD \$916 \$1110 VDD sg13_lv_pmos L=0.13u W=0.42u AS=0.1563p AD=0.0546p
+ PS=1.22u PD=0.68u rfmode=0
M$4689 \$1110 \$917 \$1071 VDD sg13_lv_pmos L=0.13u W=0.42u AS=0.0546p
+ AD=0.0798p PS=0.68u PD=0.8u rfmode=0
M$4690 \$1071 \$1088 \$1087 VDD sg13_lv_pmos L=0.13u W=0.42u AS=0.0798p
+ AD=0.1428p PS=0.8u PD=1.52u rfmode=0
M$4691 \$1373 \$1205 VDD VDD sg13_lv_pmos L=0.13u W=1.12u AS=0.3864p
+ AD=0.431025p PS=2.93u PD=2.145u rfmode=0
M$4692 VDD CLK \$1205 VDD sg13_lv_pmos L=0.13u W=1.12u AS=0.431025p AD=0.3808p
+ PS=2.145u PD=2.92u rfmode=0
M$4693 VDD \$1246 \$1247 VDD sg13_lv_pmos L=0.13u W=2.24u AS=0.5964p AD=0.5964p
+ PS=4.425u PD=4.425u rfmode=0
M$4695 \$918 \$174 \$1115 VDD sg13_lv_pmos L=0.13u W=0.84u AS=0.2856p
+ AD=0.1596p PS=2.36u PD=1.22u rfmode=0
M$4696 VDD \$5 \$1115 VDD sg13_lv_pmos L=0.13u W=0.84u AS=0.2226p AD=0.1596p
+ PS=1.535u PD=1.22u rfmode=0
M$4697 VDD \$918 \$919 VDD sg13_lv_pmos L=0.13u W=2.24u AS=0.4746p AD=0.6776p
+ PS=3.105u PD=4.57u rfmode=0
M$4699 VDD \$1207 \$1250 VDD sg13_lv_pmos L=0.13u W=2.24u AS=0.616p AD=0.4312p
+ PS=4.46u PD=3.01u rfmode=0
M$4701 VDD \$5 \$1250 VDD sg13_lv_pmos L=0.13u W=2.24u AS=0.4312p AD=0.6048p
+ PS=3.01u PD=4.44u rfmode=0
M$4703 \$1073 VDD VDD VDD sg13_lv_pmos L=0.13u W=0.42u AS=0.147p AD=0.1563p
+ PS=1.54u PD=1.22u rfmode=0
M$4704 VDD \$920 \$1117 VDD sg13_lv_pmos L=0.13u W=0.42u AS=0.1563p AD=0.0546p
+ PS=1.22u PD=0.68u rfmode=0
M$4705 \$1117 \$921 \$1073 VDD sg13_lv_pmos L=0.13u W=0.42u AS=0.0546p
+ AD=0.0798p PS=0.68u PD=0.8u rfmode=0
M$4706 \$1073 \$1090 \$963 VDD sg13_lv_pmos L=0.13u W=0.42u AS=0.0798p
+ AD=0.1428p PS=0.8u PD=1.52u rfmode=0
M$4707 \$1375 \$1209 VDD VDD sg13_lv_pmos L=0.13u W=1.12u AS=0.3864p
+ AD=0.431025p PS=2.93u PD=2.145u rfmode=0
M$4708 VDD CLK \$1209 VDD sg13_lv_pmos L=0.13u W=1.12u AS=0.431025p AD=0.3808p
+ PS=2.145u PD=2.92u rfmode=0
M$4709 VDD \$1256 \$1257 VDD sg13_lv_pmos L=0.13u W=2.24u AS=0.5964p AD=0.5964p
+ PS=4.425u PD=4.425u rfmode=0
M$4711 \$922 \$177 \$1123 VDD sg13_lv_pmos L=0.13u W=0.84u AS=0.2856p
+ AD=0.1596p PS=2.36u PD=1.22u rfmode=0
M$4712 VDD \$5 \$1123 VDD sg13_lv_pmos L=0.13u W=0.84u AS=0.2226p AD=0.1596p
+ PS=1.535u PD=1.22u rfmode=0
M$4713 VDD \$922 \$923 VDD sg13_lv_pmos L=0.13u W=2.24u AS=0.4746p AD=0.6776p
+ PS=3.105u PD=4.57u rfmode=0
M$4715 VDD \$1211 \$1260 VDD sg13_lv_pmos L=0.13u W=2.24u AS=0.616p AD=0.4312p
+ PS=4.46u PD=3.01u rfmode=0
M$4717 VDD \$5 \$1260 VDD sg13_lv_pmos L=0.13u W=2.24u AS=0.4312p AD=0.6048p
+ PS=3.01u PD=4.44u rfmode=0
M$4719 \$1075 VDD VDD VDD sg13_lv_pmos L=0.13u W=0.42u AS=0.147p AD=0.1563p
+ PS=1.54u PD=1.22u rfmode=0
M$4720 VDD \$924 \$1124 VDD sg13_lv_pmos L=0.13u W=0.42u AS=0.1563p AD=0.0546p
+ PS=1.22u PD=0.68u rfmode=0
M$4721 \$1124 \$925 \$1075 VDD sg13_lv_pmos L=0.13u W=0.42u AS=0.0546p
+ AD=0.0798p PS=0.68u PD=0.8u rfmode=0
M$4722 \$1075 \$1092 \$973 VDD sg13_lv_pmos L=0.13u W=0.42u AS=0.0798p
+ AD=0.1428p PS=0.8u PD=1.52u rfmode=0
M$4723 \$1378 \$1213 VDD VDD sg13_lv_pmos L=0.13u W=1.12u AS=0.3864p
+ AD=0.431025p PS=2.93u PD=2.145u rfmode=0
M$4724 VDD CLK \$1213 VDD sg13_lv_pmos L=0.13u W=1.12u AS=0.431025p AD=0.3808p
+ PS=2.145u PD=2.92u rfmode=0
M$4725 VDD \$1265 \$1266 VDD sg13_lv_pmos L=0.13u W=2.24u AS=0.5964p AD=0.5964p
+ PS=4.425u PD=4.425u rfmode=0
M$4727 \$926 \$180 \$1129 VDD sg13_lv_pmos L=0.13u W=0.84u AS=0.2856p
+ AD=0.1596p PS=2.36u PD=1.22u rfmode=0
M$4728 VDD \$5 \$1129 VDD sg13_lv_pmos L=0.13u W=0.84u AS=0.2226p AD=0.1596p
+ PS=1.535u PD=1.22u rfmode=0
M$4729 VDD \$926 \$927 VDD sg13_lv_pmos L=0.13u W=2.24u AS=0.4746p AD=0.6776p
+ PS=3.105u PD=4.57u rfmode=0
M$4731 VDD \$1215 \$1269 VDD sg13_lv_pmos L=0.13u W=2.24u AS=0.616p AD=0.4312p
+ PS=4.46u PD=3.01u rfmode=0
M$4733 VDD \$5 \$1269 VDD sg13_lv_pmos L=0.13u W=2.24u AS=0.4312p AD=0.6048p
+ PS=3.01u PD=4.44u rfmode=0
M$4735 \$1077 VDD VDD VDD sg13_lv_pmos L=0.13u W=0.42u AS=0.147p AD=0.1563p
+ PS=1.54u PD=1.22u rfmode=0
M$4736 VDD \$928 \$1130 VDD sg13_lv_pmos L=0.13u W=0.42u AS=0.1563p AD=0.0546p
+ PS=1.22u PD=0.68u rfmode=0
M$4737 \$1130 \$929 \$1077 VDD sg13_lv_pmos L=0.13u W=0.42u AS=0.0546p
+ AD=0.0798p PS=0.68u PD=0.8u rfmode=0
M$4738 \$1077 \$1094 \$983 VDD sg13_lv_pmos L=0.13u W=0.42u AS=0.0798p
+ AD=0.1428p PS=0.8u PD=1.52u rfmode=0
M$4739 \$1381 \$1217 VDD VDD sg13_lv_pmos L=0.13u W=1.12u AS=0.3864p
+ AD=0.431025p PS=2.93u PD=2.145u rfmode=0
M$4740 VDD CLK \$1217 VDD sg13_lv_pmos L=0.13u W=1.12u AS=0.431025p AD=0.3808p
+ PS=2.145u PD=2.92u rfmode=0
M$4741 VDD \$1274 \$1275 VDD sg13_lv_pmos L=0.13u W=2.24u AS=0.5964p AD=0.5964p
+ PS=4.425u PD=4.425u rfmode=0
M$4743 \$930 \$183 \$1136 VDD sg13_lv_pmos L=0.13u W=0.84u AS=0.2856p
+ AD=0.1596p PS=2.36u PD=1.22u rfmode=0
M$4744 VDD \$5 \$1136 VDD sg13_lv_pmos L=0.13u W=0.84u AS=0.2226p AD=0.1596p
+ PS=1.535u PD=1.22u rfmode=0
M$4745 VDD \$930 \$931 VDD sg13_lv_pmos L=0.13u W=2.24u AS=0.4746p AD=0.6776p
+ PS=3.105u PD=4.57u rfmode=0
M$4747 VDD \$1219 \$1278 VDD sg13_lv_pmos L=0.13u W=2.24u AS=0.616p AD=0.4312p
+ PS=4.46u PD=3.01u rfmode=0
M$4749 VDD \$5 \$1278 VDD sg13_lv_pmos L=0.13u W=2.24u AS=0.4312p AD=0.6048p
+ PS=3.01u PD=4.44u rfmode=0
M$4751 \$1079 VDD VDD VDD sg13_lv_pmos L=0.13u W=0.42u AS=0.147p AD=0.1563p
+ PS=1.54u PD=1.22u rfmode=0
M$4752 VDD \$932 \$1137 VDD sg13_lv_pmos L=0.13u W=0.42u AS=0.1563p AD=0.0546p
+ PS=1.22u PD=0.68u rfmode=0
M$4753 \$1137 \$933 \$1079 VDD sg13_lv_pmos L=0.13u W=0.42u AS=0.0546p
+ AD=0.0798p PS=0.68u PD=0.8u rfmode=0
M$4754 \$1079 \$1096 \$993 VDD sg13_lv_pmos L=0.13u W=0.42u AS=0.0798p
+ AD=0.1428p PS=0.8u PD=1.52u rfmode=0
M$4755 \$1383 \$1221 VDD VDD sg13_lv_pmos L=0.13u W=1.12u AS=0.3864p
+ AD=0.431025p PS=2.93u PD=2.145u rfmode=0
M$4756 VDD CLK \$1221 VDD sg13_lv_pmos L=0.13u W=1.12u AS=0.431025p AD=0.3808p
+ PS=2.145u PD=2.92u rfmode=0
M$4757 VDD \$1284 \$1285 VDD sg13_lv_pmos L=0.13u W=2.24u AS=0.5964p AD=0.5964p
+ PS=4.425u PD=4.425u rfmode=0
M$4759 \$934 \$186 \$1142 VDD sg13_lv_pmos L=0.13u W=0.84u AS=0.2856p
+ AD=0.1596p PS=2.36u PD=1.22u rfmode=0
M$4760 VDD \$5 \$1142 VDD sg13_lv_pmos L=0.13u W=0.84u AS=0.2226p AD=0.1596p
+ PS=1.535u PD=1.22u rfmode=0
M$4761 VDD \$934 \$935 VDD sg13_lv_pmos L=0.13u W=2.24u AS=0.4746p AD=0.6776p
+ PS=3.105u PD=4.57u rfmode=0
M$4763 VDD \$1223 \$1288 VDD sg13_lv_pmos L=0.13u W=2.24u AS=0.616p AD=0.4312p
+ PS=4.46u PD=3.01u rfmode=0
M$4765 VDD \$5 \$1288 VDD sg13_lv_pmos L=0.13u W=2.24u AS=0.4312p AD=0.6048p
+ PS=3.01u PD=4.44u rfmode=0
M$4767 \$1081 VDD VDD VDD sg13_lv_pmos L=0.13u W=0.42u AS=0.147p AD=0.1563p
+ PS=1.54u PD=1.22u rfmode=0
M$4768 VDD \$936 \$1144 VDD sg13_lv_pmos L=0.13u W=0.42u AS=0.1563p AD=0.0546p
+ PS=1.22u PD=0.68u rfmode=0
M$4769 \$1144 \$937 \$1081 VDD sg13_lv_pmos L=0.13u W=0.42u AS=0.0546p
+ AD=0.0798p PS=0.68u PD=0.8u rfmode=0
M$4770 \$1081 \$1098 \$1003 VDD sg13_lv_pmos L=0.13u W=0.42u AS=0.0798p
+ AD=0.1428p PS=0.8u PD=1.52u rfmode=0
M$4771 \$1386 \$1225 VDD VDD sg13_lv_pmos L=0.13u W=1.12u AS=0.3864p
+ AD=0.431025p PS=2.93u PD=2.145u rfmode=0
M$4772 VDD CLK \$1225 VDD sg13_lv_pmos L=0.13u W=1.12u AS=0.431025p AD=0.3808p
+ PS=2.145u PD=2.92u rfmode=0
M$4773 VDD \$1293 \$1294 VDD sg13_lv_pmos L=0.13u W=2.24u AS=0.5964p AD=0.5964p
+ PS=4.425u PD=4.425u rfmode=0
M$4775 \$938 VSS \$1149 VDD sg13_lv_pmos L=0.13u W=0.84u AS=0.2856p AD=0.1596p
+ PS=2.36u PD=1.22u rfmode=0
M$4776 VDD \$5 \$1149 VDD sg13_lv_pmos L=0.13u W=0.84u AS=0.2226p AD=0.1596p
+ PS=1.535u PD=1.22u rfmode=0
M$4777 VDD \$938 \$939 VDD sg13_lv_pmos L=0.13u W=2.24u AS=0.4746p AD=0.6776p
+ PS=3.105u PD=4.57u rfmode=0
M$4779 VDD \$1227 \$1297 VDD sg13_lv_pmos L=0.13u W=2.24u AS=0.616p AD=0.4312p
+ PS=4.46u PD=3.01u rfmode=0
M$4781 VDD \$5 \$1297 VDD sg13_lv_pmos L=0.13u W=2.24u AS=0.4312p AD=0.6048p
+ PS=3.01u PD=4.44u rfmode=0
M$4783 \$1083 VDD VDD VDD sg13_lv_pmos L=0.13u W=0.42u AS=0.147p AD=0.1563p
+ PS=1.54u PD=1.22u rfmode=0
M$4784 VDD \$940 \$1143 VDD sg13_lv_pmos L=0.13u W=0.42u AS=0.1563p AD=0.0546p
+ PS=1.22u PD=0.68u rfmode=0
M$4785 \$1143 \$941 \$1083 VDD sg13_lv_pmos L=0.13u W=0.42u AS=0.0546p
+ AD=0.0798p PS=0.68u PD=0.8u rfmode=0
M$4786 \$1083 \$1100 \$1013 VDD sg13_lv_pmos L=0.13u W=0.42u AS=0.0798p
+ AD=0.1428p PS=0.8u PD=1.52u rfmode=0
M$4787 \$1388 \$1229 VDD VDD sg13_lv_pmos L=0.13u W=1.12u AS=0.3864p
+ AD=0.431025p PS=2.93u PD=2.145u rfmode=0
M$4788 VDD CLK \$1229 VDD sg13_lv_pmos L=0.13u W=1.12u AS=0.431025p AD=0.3808p
+ PS=2.145u PD=2.92u rfmode=0
M$4789 VDD \$1303 \$1304 VDD sg13_lv_pmos L=0.13u W=2.24u AS=0.5964p AD=0.5964p
+ PS=4.425u PD=4.425u rfmode=0
M$4791 \$1198 \$167 \$1391 VDD sg13_lv_pmos L=0.13u W=0.84u AS=0.2856p
+ AD=0.1596p PS=2.36u PD=1.22u rfmode=0
M$4792 VDD \$316 \$1391 VDD sg13_lv_pmos L=0.13u W=0.84u AS=0.2226p AD=0.1596p
+ PS=1.535u PD=1.22u rfmode=0
M$4793 VDD \$1198 \$1199 VDD sg13_lv_pmos L=0.13u W=2.24u AS=0.4746p AD=0.6776p
+ PS=3.105u PD=4.57u rfmode=0
M$4795 VDD \$1231 \$1232 VDD sg13_lv_pmos L=0.13u W=0.42u AS=0.1428p AD=0.0798p
+ PS=1.52u PD=0.8u rfmode=0
M$4796 VDD VDD \$1232 VDD sg13_lv_pmos L=0.13u W=0.42u AS=0.3623875p AD=0.0798p
+ PS=2.605u PD=0.8u rfmode=0
M$4797 VDD \$1354 \$1200 VDD sg13_lv_pmos L=0.13u W=1u AS=0.3623875p AD=0.34p
+ PS=2.605u PD=2.68u rfmode=0
M$4798 \$1235 \$1370 \$1393 VDD sg13_lv_pmos L=0.13u W=0.42u AS=0.19115p
+ AD=0.0525p PS=1.565u PD=0.67u rfmode=0
M$4799 \$1393 \$1355 VDD VDD sg13_lv_pmos L=0.13u W=0.42u AS=0.0525p
+ AD=0.25605p PS=0.67u PD=1.935u rfmode=0
M$4800 VDD VDD \$1355 VDD sg13_lv_pmos L=0.13u W=0.42u AS=0.25605p AD=0.0798p
+ PS=1.935u PD=0.8u rfmode=0
M$4801 VDD \$1235 \$1355 VDD sg13_lv_pmos L=0.13u W=0.42u AS=0.2014p AD=0.0798p
+ PS=1.53u PD=0.8u rfmode=0
M$4802 VDD \$1235 \$1237 VDD sg13_lv_pmos L=0.13u W=1u AS=0.2083p AD=0.34p
+ PS=1.5u PD=2.68u rfmode=0
M$4803 VDD \$1235 \$1236 VDD sg13_lv_pmos L=0.13u W=2.24u AS=0.4142p AD=0.4211p
+ PS=3.03u PD=3u rfmode=0
M$4805 \$1200 \$1201 \$1235 VDD sg13_lv_pmos L=0.13u W=1u AS=0.34p AD=0.19115p
+ PS=2.68u PD=1.565u rfmode=0
M$4806 \$1202 \$171 \$1397 VDD sg13_lv_pmos L=0.13u W=0.84u AS=0.2856p
+ AD=0.1596p PS=2.36u PD=1.22u rfmode=0
M$4807 VDD \$316 \$1397 VDD sg13_lv_pmos L=0.13u W=0.84u AS=0.2226p AD=0.1596p
+ PS=1.535u PD=1.22u rfmode=0
M$4808 VDD \$1202 \$1203 VDD sg13_lv_pmos L=0.13u W=2.24u AS=0.4746p AD=0.6776p
+ PS=3.105u PD=4.57u rfmode=0
M$4810 VDD \$1241 \$1372 VDD sg13_lv_pmos L=0.13u W=0.42u AS=0.1428p AD=0.0798p
+ PS=1.52u PD=0.8u rfmode=0
M$4811 VDD VDD \$1372 VDD sg13_lv_pmos L=0.13u W=0.42u AS=0.3623875p AD=0.0798p
+ PS=2.605u PD=0.8u rfmode=0
M$4812 VDD \$1356 \$1204 VDD sg13_lv_pmos L=0.13u W=1u AS=0.3623875p AD=0.34p
+ PS=2.605u PD=2.68u rfmode=0
M$4813 \$1244 \$1373 \$1399 VDD sg13_lv_pmos L=0.13u W=0.42u AS=0.19115p
+ AD=0.0525p PS=1.565u PD=0.67u rfmode=0
M$4814 \$1399 \$1357 VDD VDD sg13_lv_pmos L=0.13u W=0.42u AS=0.0525p
+ AD=0.25605p PS=0.67u PD=1.935u rfmode=0
M$4815 VDD VDD \$1357 VDD sg13_lv_pmos L=0.13u W=0.42u AS=0.25605p AD=0.0798p
+ PS=1.935u PD=0.8u rfmode=0
M$4816 VDD \$1244 \$1357 VDD sg13_lv_pmos L=0.13u W=0.42u AS=0.2014p AD=0.0798p
+ PS=1.53u PD=0.8u rfmode=0
M$4817 VDD \$1244 \$1246 VDD sg13_lv_pmos L=0.13u W=1u AS=0.2083p AD=0.34p
+ PS=1.5u PD=2.68u rfmode=0
M$4818 VDD \$1244 \$1245 VDD sg13_lv_pmos L=0.13u W=2.24u AS=0.4142p AD=0.4211p
+ PS=3.03u PD=3u rfmode=0
M$4820 \$1204 \$1205 \$1244 VDD sg13_lv_pmos L=0.13u W=1u AS=0.34p AD=0.19115p
+ PS=2.68u PD=1.565u rfmode=0
M$4821 \$1206 \$174 \$1403 VDD sg13_lv_pmos L=0.13u W=0.84u AS=0.2856p
+ AD=0.1596p PS=2.36u PD=1.22u rfmode=0
M$4822 VDD \$316 \$1403 VDD sg13_lv_pmos L=0.13u W=0.84u AS=0.2226p AD=0.1596p
+ PS=1.535u PD=1.22u rfmode=0
M$4823 VDD \$1206 \$1207 VDD sg13_lv_pmos L=0.13u W=2.24u AS=0.4746p AD=0.6776p
+ PS=3.105u PD=4.57u rfmode=0
M$4825 VDD \$1250 \$1251 VDD sg13_lv_pmos L=0.13u W=0.42u AS=0.1428p AD=0.0798p
+ PS=1.52u PD=0.8u rfmode=0
M$4826 VDD VDD \$1251 VDD sg13_lv_pmos L=0.13u W=0.42u AS=0.3623875p AD=0.0798p
+ PS=2.605u PD=0.8u rfmode=0
M$4827 VDD \$1358 \$1208 VDD sg13_lv_pmos L=0.13u W=1u AS=0.3623875p AD=0.34p
+ PS=2.605u PD=2.68u rfmode=0
M$4828 \$1254 \$1375 \$1406 VDD sg13_lv_pmos L=0.13u W=0.42u AS=0.19115p
+ AD=0.0525p PS=1.565u PD=0.67u rfmode=0
M$4829 \$1406 \$1359 VDD VDD sg13_lv_pmos L=0.13u W=0.42u AS=0.0525p
+ AD=0.25605p PS=0.67u PD=1.935u rfmode=0
M$4830 VDD VDD \$1359 VDD sg13_lv_pmos L=0.13u W=0.42u AS=0.25605p AD=0.0798p
+ PS=1.935u PD=0.8u rfmode=0
M$4831 VDD \$1254 \$1359 VDD sg13_lv_pmos L=0.13u W=0.42u AS=0.2014p AD=0.0798p
+ PS=1.53u PD=0.8u rfmode=0
M$4832 VDD \$1254 \$1256 VDD sg13_lv_pmos L=0.13u W=1u AS=0.2083p AD=0.34p
+ PS=1.5u PD=2.68u rfmode=0
M$4833 VDD \$1254 \$1255 VDD sg13_lv_pmos L=0.13u W=2.24u AS=0.4142p AD=0.4211p
+ PS=3.03u PD=3u rfmode=0
M$4835 \$1208 \$1209 \$1254 VDD sg13_lv_pmos L=0.13u W=1u AS=0.34p AD=0.19115p
+ PS=2.68u PD=1.565u rfmode=0
M$4836 \$1210 \$177 \$1411 VDD sg13_lv_pmos L=0.13u W=0.84u AS=0.2856p
+ AD=0.1596p PS=2.36u PD=1.22u rfmode=0
M$4837 VDD \$316 \$1411 VDD sg13_lv_pmos L=0.13u W=0.84u AS=0.2226p AD=0.1596p
+ PS=1.535u PD=1.22u rfmode=0
M$4838 VDD \$1210 \$1211 VDD sg13_lv_pmos L=0.13u W=2.24u AS=0.4746p AD=0.6776p
+ PS=3.105u PD=4.57u rfmode=0
M$4840 VDD \$1260 \$1377 VDD sg13_lv_pmos L=0.13u W=0.42u AS=0.1428p AD=0.0798p
+ PS=1.52u PD=0.8u rfmode=0
M$4841 VDD VDD \$1377 VDD sg13_lv_pmos L=0.13u W=0.42u AS=0.3623875p AD=0.0798p
+ PS=2.605u PD=0.8u rfmode=0
M$4842 VDD \$1360 \$1212 VDD sg13_lv_pmos L=0.13u W=1u AS=0.3623875p AD=0.34p
+ PS=2.605u PD=2.68u rfmode=0
M$4843 \$1263 \$1378 \$1413 VDD sg13_lv_pmos L=0.13u W=0.42u AS=0.19115p
+ AD=0.0525p PS=1.565u PD=0.67u rfmode=0
M$4844 \$1413 \$1361 VDD VDD sg13_lv_pmos L=0.13u W=0.42u AS=0.0525p
+ AD=0.25605p PS=0.67u PD=1.935u rfmode=0
M$4845 VDD VDD \$1361 VDD sg13_lv_pmos L=0.13u W=0.42u AS=0.25605p AD=0.0798p
+ PS=1.935u PD=0.8u rfmode=0
M$4846 VDD \$1263 \$1361 VDD sg13_lv_pmos L=0.13u W=0.42u AS=0.2014p AD=0.0798p
+ PS=1.53u PD=0.8u rfmode=0
M$4847 VDD \$1263 \$1265 VDD sg13_lv_pmos L=0.13u W=1u AS=0.2083p AD=0.34p
+ PS=1.5u PD=2.68u rfmode=0
M$4848 VDD \$1263 \$1264 VDD sg13_lv_pmos L=0.13u W=2.24u AS=0.4142p AD=0.4211p
+ PS=3.03u PD=3u rfmode=0
M$4850 \$1212 \$1213 \$1263 VDD sg13_lv_pmos L=0.13u W=1u AS=0.34p AD=0.19115p
+ PS=2.68u PD=1.565u rfmode=0
M$4851 \$1214 \$180 \$1417 VDD sg13_lv_pmos L=0.13u W=0.84u AS=0.2856p
+ AD=0.1596p PS=2.36u PD=1.22u rfmode=0
M$4852 VDD \$316 \$1417 VDD sg13_lv_pmos L=0.13u W=0.84u AS=0.2226p AD=0.1596p
+ PS=1.535u PD=1.22u rfmode=0
M$4853 VDD \$1214 \$1215 VDD sg13_lv_pmos L=0.13u W=2.24u AS=0.4746p AD=0.6776p
+ PS=3.105u PD=4.57u rfmode=0
M$4855 VDD \$1269 \$1380 VDD sg13_lv_pmos L=0.13u W=0.42u AS=0.1428p AD=0.0798p
+ PS=1.52u PD=0.8u rfmode=0
M$4856 VDD VDD \$1380 VDD sg13_lv_pmos L=0.13u W=0.42u AS=0.3623875p AD=0.0798p
+ PS=2.605u PD=0.8u rfmode=0
M$4857 VDD \$1362 \$1216 VDD sg13_lv_pmos L=0.13u W=1u AS=0.3623875p AD=0.34p
+ PS=2.605u PD=2.68u rfmode=0
M$4858 \$1272 \$1381 \$1419 VDD sg13_lv_pmos L=0.13u W=0.42u AS=0.19115p
+ AD=0.0525p PS=1.565u PD=0.67u rfmode=0
M$4859 \$1419 \$1363 VDD VDD sg13_lv_pmos L=0.13u W=0.42u AS=0.0525p
+ AD=0.25605p PS=0.67u PD=1.935u rfmode=0
M$4860 VDD VDD \$1363 VDD sg13_lv_pmos L=0.13u W=0.42u AS=0.25605p AD=0.0798p
+ PS=1.935u PD=0.8u rfmode=0
M$4861 VDD \$1272 \$1363 VDD sg13_lv_pmos L=0.13u W=0.42u AS=0.2014p AD=0.0798p
+ PS=1.53u PD=0.8u rfmode=0
M$4862 VDD \$1272 \$1274 VDD sg13_lv_pmos L=0.13u W=1u AS=0.2083p AD=0.34p
+ PS=1.5u PD=2.68u rfmode=0
M$4863 VDD \$1272 \$1273 VDD sg13_lv_pmos L=0.13u W=2.24u AS=0.4142p AD=0.4211p
+ PS=3.03u PD=3u rfmode=0
M$4865 \$1216 \$1217 \$1272 VDD sg13_lv_pmos L=0.13u W=1u AS=0.34p AD=0.19115p
+ PS=2.68u PD=1.565u rfmode=0
M$4866 \$1218 \$183 \$1423 VDD sg13_lv_pmos L=0.13u W=0.84u AS=0.2856p
+ AD=0.1596p PS=2.36u PD=1.22u rfmode=0
M$4867 VDD \$316 \$1423 VDD sg13_lv_pmos L=0.13u W=0.84u AS=0.2226p AD=0.1596p
+ PS=1.535u PD=1.22u rfmode=0
M$4868 VDD \$1218 \$1219 VDD sg13_lv_pmos L=0.13u W=2.24u AS=0.4746p AD=0.6776p
+ PS=3.105u PD=4.57u rfmode=0
M$4870 VDD \$1278 \$1279 VDD sg13_lv_pmos L=0.13u W=0.42u AS=0.1428p AD=0.0798p
+ PS=1.52u PD=0.8u rfmode=0
M$4871 VDD VDD \$1279 VDD sg13_lv_pmos L=0.13u W=0.42u AS=0.3623875p AD=0.0798p
+ PS=2.605u PD=0.8u rfmode=0
M$4872 VDD \$1364 \$1220 VDD sg13_lv_pmos L=0.13u W=1u AS=0.3623875p AD=0.34p
+ PS=2.605u PD=2.68u rfmode=0
M$4873 \$1282 \$1383 \$1426 VDD sg13_lv_pmos L=0.13u W=0.42u AS=0.19115p
+ AD=0.0525p PS=1.565u PD=0.67u rfmode=0
M$4874 \$1426 \$1365 VDD VDD sg13_lv_pmos L=0.13u W=0.42u AS=0.0525p
+ AD=0.25605p PS=0.67u PD=1.935u rfmode=0
M$4875 VDD VDD \$1365 VDD sg13_lv_pmos L=0.13u W=0.42u AS=0.25605p AD=0.0798p
+ PS=1.935u PD=0.8u rfmode=0
M$4876 VDD \$1282 \$1365 VDD sg13_lv_pmos L=0.13u W=0.42u AS=0.2014p AD=0.0798p
+ PS=1.53u PD=0.8u rfmode=0
M$4877 VDD \$1282 \$1284 VDD sg13_lv_pmos L=0.13u W=1u AS=0.2083p AD=0.34p
+ PS=1.5u PD=2.68u rfmode=0
M$4878 VDD \$1282 \$1283 VDD sg13_lv_pmos L=0.13u W=2.24u AS=0.4142p AD=0.4211p
+ PS=3.03u PD=3u rfmode=0
M$4880 \$1220 \$1221 \$1282 VDD sg13_lv_pmos L=0.13u W=1u AS=0.34p AD=0.19115p
+ PS=2.68u PD=1.565u rfmode=0
M$4881 \$1222 \$186 \$1430 VDD sg13_lv_pmos L=0.13u W=0.84u AS=0.2856p
+ AD=0.1596p PS=2.36u PD=1.22u rfmode=0
M$4882 VDD \$316 \$1430 VDD sg13_lv_pmos L=0.13u W=0.84u AS=0.2226p AD=0.1596p
+ PS=1.535u PD=1.22u rfmode=0
M$4883 VDD \$1222 \$1223 VDD sg13_lv_pmos L=0.13u W=2.24u AS=0.4746p AD=0.6776p
+ PS=3.105u PD=4.57u rfmode=0
M$4885 VDD \$1288 \$1385 VDD sg13_lv_pmos L=0.13u W=0.42u AS=0.1428p AD=0.0798p
+ PS=1.52u PD=0.8u rfmode=0
M$4886 VDD VDD \$1385 VDD sg13_lv_pmos L=0.13u W=0.42u AS=0.3623875p AD=0.0798p
+ PS=2.605u PD=0.8u rfmode=0
M$4887 VDD \$1366 \$1224 VDD sg13_lv_pmos L=0.13u W=1u AS=0.3623875p AD=0.34p
+ PS=2.605u PD=2.68u rfmode=0
M$4888 \$1291 \$1386 \$1433 VDD sg13_lv_pmos L=0.13u W=0.42u AS=0.19115p
+ AD=0.0525p PS=1.565u PD=0.67u rfmode=0
M$4889 \$1433 \$1367 VDD VDD sg13_lv_pmos L=0.13u W=0.42u AS=0.0525p
+ AD=0.25605p PS=0.67u PD=1.935u rfmode=0
M$4890 VDD VDD \$1367 VDD sg13_lv_pmos L=0.13u W=0.42u AS=0.25605p AD=0.0798p
+ PS=1.935u PD=0.8u rfmode=0
M$4891 VDD \$1291 \$1367 VDD sg13_lv_pmos L=0.13u W=0.42u AS=0.2014p AD=0.0798p
+ PS=1.53u PD=0.8u rfmode=0
M$4892 VDD \$1291 \$1293 VDD sg13_lv_pmos L=0.13u W=1u AS=0.2083p AD=0.34p
+ PS=1.5u PD=2.68u rfmode=0
M$4893 VDD \$1291 \$1292 VDD sg13_lv_pmos L=0.13u W=2.24u AS=0.4142p AD=0.4211p
+ PS=3.03u PD=3u rfmode=0
M$4895 \$1224 \$1225 \$1291 VDD sg13_lv_pmos L=0.13u W=1u AS=0.34p AD=0.19115p
+ PS=2.68u PD=1.565u rfmode=0
M$4896 \$1226 VSS \$1437 VDD sg13_lv_pmos L=0.13u W=0.84u AS=0.2856p AD=0.1596p
+ PS=2.36u PD=1.22u rfmode=0
M$4897 VDD \$316 \$1437 VDD sg13_lv_pmos L=0.13u W=0.84u AS=0.2226p AD=0.1596p
+ PS=1.535u PD=1.22u rfmode=0
M$4898 VDD \$1226 \$1227 VDD sg13_lv_pmos L=0.13u W=2.24u AS=0.4746p AD=0.6776p
+ PS=3.105u PD=4.57u rfmode=0
M$4900 VDD \$1297 \$1298 VDD sg13_lv_pmos L=0.13u W=0.42u AS=0.1428p AD=0.0798p
+ PS=1.52u PD=0.8u rfmode=0
M$4901 VDD VDD \$1298 VDD sg13_lv_pmos L=0.13u W=0.42u AS=0.3623875p AD=0.0798p
+ PS=2.605u PD=0.8u rfmode=0
M$4902 VDD \$1368 \$1228 VDD sg13_lv_pmos L=0.13u W=1u AS=0.3623875p AD=0.34p
+ PS=2.605u PD=2.68u rfmode=0
M$4903 \$1301 \$1388 \$1424 VDD sg13_lv_pmos L=0.13u W=0.42u AS=0.19115p
+ AD=0.0525p PS=1.565u PD=0.67u rfmode=0
M$4904 \$1424 \$1369 VDD VDD sg13_lv_pmos L=0.13u W=0.42u AS=0.0525p
+ AD=0.25605p PS=0.67u PD=1.935u rfmode=0
M$4905 VDD VDD \$1369 VDD sg13_lv_pmos L=0.13u W=0.42u AS=0.25605p AD=0.0798p
+ PS=1.935u PD=0.8u rfmode=0
M$4906 VDD \$1301 \$1369 VDD sg13_lv_pmos L=0.13u W=0.42u AS=0.2014p AD=0.0798p
+ PS=1.53u PD=0.8u rfmode=0
M$4907 VDD \$1301 \$1303 VDD sg13_lv_pmos L=0.13u W=1u AS=0.2083p AD=0.34p
+ PS=1.5u PD=2.68u rfmode=0
M$4908 VDD \$1301 \$1302 VDD sg13_lv_pmos L=0.13u W=2.24u AS=0.4142p AD=0.4211p
+ PS=3.03u PD=3u rfmode=0
M$4910 \$1228 \$1229 \$1301 VDD sg13_lv_pmos L=0.13u W=1u AS=0.34p AD=0.19115p
+ PS=2.68u PD=1.565u rfmode=0
M$4911 VDD \$1487 \$1519 VDD sg13_lv_pmos L=0.13u W=2.24u AS=0.616p AD=0.4312p
+ PS=4.46u PD=3.01u rfmode=0
M$4913 VDD \$316 \$1519 VDD sg13_lv_pmos L=0.13u W=2.24u AS=0.4312p AD=0.6048p
+ PS=3.01u PD=4.44u rfmode=0
M$4915 VDD \$1519 \$1520 VDD sg13_lv_pmos L=0.13u W=0.42u AS=0.1428p AD=0.0798p
+ PS=1.52u PD=0.8u rfmode=0
M$4916 VDD VDD \$1520 VDD sg13_lv_pmos L=0.13u W=0.42u AS=0.3623875p AD=0.0798p
+ PS=2.605u PD=0.8u rfmode=0
M$4917 VDD \$1646 \$1488 VDD sg13_lv_pmos L=0.13u W=1u AS=0.3623875p AD=0.34p
+ PS=2.605u PD=2.68u rfmode=0
M$4918 \$1354 VDD VDD VDD sg13_lv_pmos L=0.13u W=0.42u AS=0.147p AD=0.1563p
+ PS=1.54u PD=1.22u rfmode=0
M$4919 VDD \$1200 \$1392 VDD sg13_lv_pmos L=0.13u W=0.42u AS=0.1563p AD=0.0546p
+ PS=1.22u PD=0.68u rfmode=0
M$4920 \$1392 \$1201 \$1354 VDD sg13_lv_pmos L=0.13u W=0.42u AS=0.0546p
+ AD=0.0798p PS=0.68u PD=0.8u rfmode=0
M$4921 \$1354 \$1370 \$1232 VDD sg13_lv_pmos L=0.13u W=0.42u AS=0.0798p
+ AD=0.1428p PS=0.8u PD=1.52u rfmode=0
M$4922 \$1662 \$1489 VDD VDD sg13_lv_pmos L=0.13u W=1.12u AS=0.3864p
+ AD=0.431025p PS=2.93u PD=2.145u rfmode=0
M$4923 VDD CLK \$1489 VDD sg13_lv_pmos L=0.13u W=1.12u AS=0.431025p AD=0.3808p
+ PS=2.145u PD=2.92u rfmode=0
M$4924 \$1523 \$1662 \$1680 VDD sg13_lv_pmos L=0.13u W=0.42u AS=0.19115p
+ AD=0.0525p PS=1.565u PD=0.67u rfmode=0
M$4925 \$1680 \$1647 VDD VDD sg13_lv_pmos L=0.13u W=0.42u AS=0.0525p
+ AD=0.25605p PS=0.67u PD=1.935u rfmode=0
M$4926 VDD VDD \$1647 VDD sg13_lv_pmos L=0.13u W=0.42u AS=0.25605p AD=0.0798p
+ PS=1.935u PD=0.8u rfmode=0
M$4927 VDD \$1523 \$1647 VDD sg13_lv_pmos L=0.13u W=0.42u AS=0.2014p AD=0.0798p
+ PS=1.53u PD=0.8u rfmode=0
M$4928 VDD \$1523 \$1525 VDD sg13_lv_pmos L=0.13u W=1u AS=0.2083p AD=0.34p
+ PS=1.5u PD=2.68u rfmode=0
M$4929 VDD \$1523 \$1524 VDD sg13_lv_pmos L=0.13u W=2.24u AS=0.4142p AD=0.4211p
+ PS=3.03u PD=3u rfmode=0
M$4931 \$1488 \$1489 \$1523 VDD sg13_lv_pmos L=0.13u W=1u AS=0.34p AD=0.19115p
+ PS=2.68u PD=1.565u rfmode=0
M$4932 VDD \$1525 \$1526 VDD sg13_lv_pmos L=0.13u W=2.24u AS=0.5964p AD=0.5964p
+ PS=4.425u PD=4.425u rfmode=0
M$4934 VDD \$1491 \$1529 VDD sg13_lv_pmos L=0.13u W=2.24u AS=0.616p AD=0.4312p
+ PS=4.46u PD=3.01u rfmode=0
M$4936 VDD \$316 \$1529 VDD sg13_lv_pmos L=0.13u W=2.24u AS=0.4312p AD=0.6048p
+ PS=3.01u PD=4.44u rfmode=0
M$4938 VDD \$1529 \$1530 VDD sg13_lv_pmos L=0.13u W=0.42u AS=0.1428p AD=0.0798p
+ PS=1.52u PD=0.8u rfmode=0
M$4939 VDD VDD \$1530 VDD sg13_lv_pmos L=0.13u W=0.42u AS=0.3623875p AD=0.0798p
+ PS=2.605u PD=0.8u rfmode=0
M$4940 VDD \$1648 \$1492 VDD sg13_lv_pmos L=0.13u W=1u AS=0.3623875p AD=0.34p
+ PS=2.605u PD=2.68u rfmode=0
M$4941 \$1356 VDD VDD VDD sg13_lv_pmos L=0.13u W=0.42u AS=0.147p AD=0.1563p
+ PS=1.54u PD=1.22u rfmode=0
M$4942 VDD \$1204 \$1398 VDD sg13_lv_pmos L=0.13u W=0.42u AS=0.1563p AD=0.0546p
+ PS=1.22u PD=0.68u rfmode=0
M$4943 \$1398 \$1205 \$1356 VDD sg13_lv_pmos L=0.13u W=0.42u AS=0.0546p
+ AD=0.0798p PS=0.68u PD=0.8u rfmode=0
M$4944 \$1356 \$1373 \$1372 VDD sg13_lv_pmos L=0.13u W=0.42u AS=0.0798p
+ AD=0.1428p PS=0.8u PD=1.52u rfmode=0
M$4945 \$1664 \$1493 VDD VDD sg13_lv_pmos L=0.13u W=1.12u AS=0.3864p
+ AD=0.431025p PS=2.93u PD=2.145u rfmode=0
M$4946 VDD CLK \$1493 VDD sg13_lv_pmos L=0.13u W=1.12u AS=0.431025p AD=0.3808p
+ PS=2.145u PD=2.92u rfmode=0
M$4947 \$1533 \$1664 \$1687 VDD sg13_lv_pmos L=0.13u W=0.42u AS=0.19115p
+ AD=0.0525p PS=1.565u PD=0.67u rfmode=0
M$4948 \$1687 \$1649 VDD VDD sg13_lv_pmos L=0.13u W=0.42u AS=0.0525p
+ AD=0.25605p PS=0.67u PD=1.935u rfmode=0
M$4949 VDD VDD \$1649 VDD sg13_lv_pmos L=0.13u W=0.42u AS=0.25605p AD=0.0798p
+ PS=1.935u PD=0.8u rfmode=0
M$4950 VDD \$1533 \$1649 VDD sg13_lv_pmos L=0.13u W=0.42u AS=0.2014p AD=0.0798p
+ PS=1.53u PD=0.8u rfmode=0
M$4951 VDD \$1533 \$1535 VDD sg13_lv_pmos L=0.13u W=1u AS=0.2083p AD=0.34p
+ PS=1.5u PD=2.68u rfmode=0
M$4952 VDD \$1533 \$1534 VDD sg13_lv_pmos L=0.13u W=2.24u AS=0.4142p AD=0.4211p
+ PS=3.03u PD=3u rfmode=0
M$4954 \$1492 \$1493 \$1533 VDD sg13_lv_pmos L=0.13u W=1u AS=0.34p AD=0.19115p
+ PS=2.68u PD=1.565u rfmode=0
M$4955 VDD \$1535 \$1536 VDD sg13_lv_pmos L=0.13u W=2.24u AS=0.5964p AD=0.5964p
+ PS=4.425u PD=4.425u rfmode=0
M$4957 VDD \$1495 \$1539 VDD sg13_lv_pmos L=0.13u W=2.24u AS=0.616p AD=0.4312p
+ PS=4.46u PD=3.01u rfmode=0
M$4959 VDD \$316 \$1539 VDD sg13_lv_pmos L=0.13u W=2.24u AS=0.4312p AD=0.6048p
+ PS=3.01u PD=4.44u rfmode=0
M$4961 VDD \$1539 \$1540 VDD sg13_lv_pmos L=0.13u W=0.42u AS=0.1428p AD=0.0798p
+ PS=1.52u PD=0.8u rfmode=0
M$4962 VDD VDD \$1540 VDD sg13_lv_pmos L=0.13u W=0.42u AS=0.3623875p AD=0.0798p
+ PS=2.605u PD=0.8u rfmode=0
M$4963 VDD \$1650 \$1496 VDD sg13_lv_pmos L=0.13u W=1u AS=0.3623875p AD=0.34p
+ PS=2.605u PD=2.68u rfmode=0
M$4964 \$1358 VDD VDD VDD sg13_lv_pmos L=0.13u W=0.42u AS=0.147p AD=0.1563p
+ PS=1.54u PD=1.22u rfmode=0
M$4965 VDD \$1208 \$1405 VDD sg13_lv_pmos L=0.13u W=0.42u AS=0.1563p AD=0.0546p
+ PS=1.22u PD=0.68u rfmode=0
M$4966 \$1405 \$1209 \$1358 VDD sg13_lv_pmos L=0.13u W=0.42u AS=0.0546p
+ AD=0.0798p PS=0.68u PD=0.8u rfmode=0
M$4967 \$1358 \$1375 \$1251 VDD sg13_lv_pmos L=0.13u W=0.42u AS=0.0798p
+ AD=0.1428p PS=0.8u PD=1.52u rfmode=0
M$4968 \$1666 \$1497 VDD VDD sg13_lv_pmos L=0.13u W=1.12u AS=0.3864p
+ AD=0.431025p PS=2.93u PD=2.145u rfmode=0
M$4969 VDD CLK \$1497 VDD sg13_lv_pmos L=0.13u W=1.12u AS=0.431025p AD=0.3808p
+ PS=2.145u PD=2.92u rfmode=0
M$4970 \$1543 \$1666 \$1694 VDD sg13_lv_pmos L=0.13u W=0.42u AS=0.19115p
+ AD=0.0525p PS=1.565u PD=0.67u rfmode=0
M$4971 \$1694 \$1651 VDD VDD sg13_lv_pmos L=0.13u W=0.42u AS=0.0525p
+ AD=0.25605p PS=0.67u PD=1.935u rfmode=0
M$4972 VDD VDD \$1651 VDD sg13_lv_pmos L=0.13u W=0.42u AS=0.25605p AD=0.0798p
+ PS=1.935u PD=0.8u rfmode=0
M$4973 VDD \$1543 \$1651 VDD sg13_lv_pmos L=0.13u W=0.42u AS=0.2014p AD=0.0798p
+ PS=1.53u PD=0.8u rfmode=0
M$4974 VDD \$1543 \$1545 VDD sg13_lv_pmos L=0.13u W=1u AS=0.2083p AD=0.34p
+ PS=1.5u PD=2.68u rfmode=0
M$4975 VDD \$1543 \$1544 VDD sg13_lv_pmos L=0.13u W=2.24u AS=0.4142p AD=0.4211p
+ PS=3.03u PD=3u rfmode=0
M$4977 \$1496 \$1497 \$1543 VDD sg13_lv_pmos L=0.13u W=1u AS=0.34p AD=0.19115p
+ PS=2.68u PD=1.565u rfmode=0
M$4978 VDD \$1545 \$1546 VDD sg13_lv_pmos L=0.13u W=2.24u AS=0.5964p AD=0.5964p
+ PS=4.425u PD=4.425u rfmode=0
M$4980 VDD \$1499 \$1549 VDD sg13_lv_pmos L=0.13u W=2.24u AS=0.616p AD=0.4312p
+ PS=4.46u PD=3.01u rfmode=0
M$4982 VDD \$316 \$1549 VDD sg13_lv_pmos L=0.13u W=2.24u AS=0.4312p AD=0.6048p
+ PS=3.01u PD=4.44u rfmode=0
M$4984 VDD \$1549 \$1550 VDD sg13_lv_pmos L=0.13u W=0.42u AS=0.1428p AD=0.0798p
+ PS=1.52u PD=0.8u rfmode=0
M$4985 VDD VDD \$1550 VDD sg13_lv_pmos L=0.13u W=0.42u AS=0.3623875p AD=0.0798p
+ PS=2.605u PD=0.8u rfmode=0
M$4986 VDD \$1652 \$1500 VDD sg13_lv_pmos L=0.13u W=1u AS=0.3623875p AD=0.34p
+ PS=2.605u PD=2.68u rfmode=0
M$4987 \$1360 VDD VDD VDD sg13_lv_pmos L=0.13u W=0.42u AS=0.147p AD=0.1563p
+ PS=1.54u PD=1.22u rfmode=0
M$4988 VDD \$1212 \$1412 VDD sg13_lv_pmos L=0.13u W=0.42u AS=0.1563p AD=0.0546p
+ PS=1.22u PD=0.68u rfmode=0
M$4989 \$1412 \$1213 \$1360 VDD sg13_lv_pmos L=0.13u W=0.42u AS=0.0546p
+ AD=0.0798p PS=0.68u PD=0.8u rfmode=0
M$4990 \$1360 \$1378 \$1377 VDD sg13_lv_pmos L=0.13u W=0.42u AS=0.0798p
+ AD=0.1428p PS=0.8u PD=1.52u rfmode=0
M$4991 \$1668 \$1501 VDD VDD sg13_lv_pmos L=0.13u W=1.12u AS=0.3864p
+ AD=0.431025p PS=2.93u PD=2.145u rfmode=0
M$4992 VDD CLK \$1501 VDD sg13_lv_pmos L=0.13u W=1.12u AS=0.431025p AD=0.3808p
+ PS=2.145u PD=2.92u rfmode=0
M$4993 \$1553 \$1668 \$1700 VDD sg13_lv_pmos L=0.13u W=0.42u AS=0.19115p
+ AD=0.0525p PS=1.565u PD=0.67u rfmode=0
M$4994 \$1700 \$1653 VDD VDD sg13_lv_pmos L=0.13u W=0.42u AS=0.0525p
+ AD=0.25605p PS=0.67u PD=1.935u rfmode=0
M$4995 VDD VDD \$1653 VDD sg13_lv_pmos L=0.13u W=0.42u AS=0.25605p AD=0.0798p
+ PS=1.935u PD=0.8u rfmode=0
M$4996 VDD \$1553 \$1653 VDD sg13_lv_pmos L=0.13u W=0.42u AS=0.2014p AD=0.0798p
+ PS=1.53u PD=0.8u rfmode=0
M$4997 VDD \$1553 \$1555 VDD sg13_lv_pmos L=0.13u W=1u AS=0.2083p AD=0.34p
+ PS=1.5u PD=2.68u rfmode=0
M$4998 VDD \$1553 \$1554 VDD sg13_lv_pmos L=0.13u W=2.24u AS=0.4142p AD=0.4211p
+ PS=3.03u PD=3u rfmode=0
M$5000 \$1500 \$1501 \$1553 VDD sg13_lv_pmos L=0.13u W=1u AS=0.34p AD=0.19115p
+ PS=2.68u PD=1.565u rfmode=0
M$5001 VDD \$1555 \$1556 VDD sg13_lv_pmos L=0.13u W=2.24u AS=0.5964p AD=0.5964p
+ PS=4.425u PD=4.425u rfmode=0
M$5003 VDD \$1503 \$1559 VDD sg13_lv_pmos L=0.13u W=2.24u AS=0.616p AD=0.4312p
+ PS=4.46u PD=3.01u rfmode=0
M$5005 VDD \$316 \$1559 VDD sg13_lv_pmos L=0.13u W=2.24u AS=0.4312p AD=0.6048p
+ PS=3.01u PD=4.44u rfmode=0
M$5007 VDD \$1559 \$1560 VDD sg13_lv_pmos L=0.13u W=0.42u AS=0.1428p AD=0.0798p
+ PS=1.52u PD=0.8u rfmode=0
M$5008 VDD VDD \$1560 VDD sg13_lv_pmos L=0.13u W=0.42u AS=0.3623875p AD=0.0798p
+ PS=2.605u PD=0.8u rfmode=0
M$5009 VDD \$1654 \$1504 VDD sg13_lv_pmos L=0.13u W=1u AS=0.3623875p AD=0.34p
+ PS=2.605u PD=2.68u rfmode=0
M$5010 \$1362 VDD VDD VDD sg13_lv_pmos L=0.13u W=0.42u AS=0.147p AD=0.1563p
+ PS=1.54u PD=1.22u rfmode=0
M$5011 VDD \$1216 \$1418 VDD sg13_lv_pmos L=0.13u W=0.42u AS=0.1563p AD=0.0546p
+ PS=1.22u PD=0.68u rfmode=0
M$5012 \$1418 \$1217 \$1362 VDD sg13_lv_pmos L=0.13u W=0.42u AS=0.0546p
+ AD=0.0798p PS=0.68u PD=0.8u rfmode=0
M$5013 \$1362 \$1381 \$1380 VDD sg13_lv_pmos L=0.13u W=0.42u AS=0.0798p
+ AD=0.1428p PS=0.8u PD=1.52u rfmode=0
M$5014 \$1670 \$1505 VDD VDD sg13_lv_pmos L=0.13u W=1.12u AS=0.3864p
+ AD=0.431025p PS=2.93u PD=2.145u rfmode=0
M$5015 VDD CLK \$1505 VDD sg13_lv_pmos L=0.13u W=1.12u AS=0.431025p AD=0.3808p
+ PS=2.145u PD=2.92u rfmode=0
M$5016 \$1563 \$1670 \$1707 VDD sg13_lv_pmos L=0.13u W=0.42u AS=0.19115p
+ AD=0.0525p PS=1.565u PD=0.67u rfmode=0
M$5017 \$1707 \$1655 VDD VDD sg13_lv_pmos L=0.13u W=0.42u AS=0.0525p
+ AD=0.25605p PS=0.67u PD=1.935u rfmode=0
M$5018 VDD VDD \$1655 VDD sg13_lv_pmos L=0.13u W=0.42u AS=0.25605p AD=0.0798p
+ PS=1.935u PD=0.8u rfmode=0
M$5019 VDD \$1563 \$1655 VDD sg13_lv_pmos L=0.13u W=0.42u AS=0.2014p AD=0.0798p
+ PS=1.53u PD=0.8u rfmode=0
M$5020 VDD \$1563 \$1565 VDD sg13_lv_pmos L=0.13u W=1u AS=0.2083p AD=0.34p
+ PS=1.5u PD=2.68u rfmode=0
M$5021 VDD \$1563 \$1564 VDD sg13_lv_pmos L=0.13u W=2.24u AS=0.4142p AD=0.4211p
+ PS=3.03u PD=3u rfmode=0
M$5023 \$1504 \$1505 \$1563 VDD sg13_lv_pmos L=0.13u W=1u AS=0.34p AD=0.19115p
+ PS=2.68u PD=1.565u rfmode=0
M$5024 VDD \$1565 \$1566 VDD sg13_lv_pmos L=0.13u W=2.24u AS=0.5964p AD=0.5964p
+ PS=4.425u PD=4.425u rfmode=0
M$5026 VDD \$1507 \$1569 VDD sg13_lv_pmos L=0.13u W=2.24u AS=0.616p AD=0.4312p
+ PS=4.46u PD=3.01u rfmode=0
M$5028 VDD \$316 \$1569 VDD sg13_lv_pmos L=0.13u W=2.24u AS=0.4312p AD=0.6048p
+ PS=3.01u PD=4.44u rfmode=0
M$5030 VDD \$1569 \$1570 VDD sg13_lv_pmos L=0.13u W=0.42u AS=0.1428p AD=0.0798p
+ PS=1.52u PD=0.8u rfmode=0
M$5031 VDD VDD \$1570 VDD sg13_lv_pmos L=0.13u W=0.42u AS=0.3623875p AD=0.0798p
+ PS=2.605u PD=0.8u rfmode=0
M$5032 VDD \$1656 \$1508 VDD sg13_lv_pmos L=0.13u W=1u AS=0.3623875p AD=0.34p
+ PS=2.605u PD=2.68u rfmode=0
M$5033 \$1364 VDD VDD VDD sg13_lv_pmos L=0.13u W=0.42u AS=0.147p AD=0.1563p
+ PS=1.54u PD=1.22u rfmode=0
M$5034 VDD \$1220 \$1425 VDD sg13_lv_pmos L=0.13u W=0.42u AS=0.1563p AD=0.0546p
+ PS=1.22u PD=0.68u rfmode=0
M$5035 \$1425 \$1221 \$1364 VDD sg13_lv_pmos L=0.13u W=0.42u AS=0.0546p
+ AD=0.0798p PS=0.68u PD=0.8u rfmode=0
M$5036 \$1364 \$1383 \$1279 VDD sg13_lv_pmos L=0.13u W=0.42u AS=0.0798p
+ AD=0.1428p PS=0.8u PD=1.52u rfmode=0
M$5037 \$1672 \$1509 VDD VDD sg13_lv_pmos L=0.13u W=1.12u AS=0.3864p
+ AD=0.431025p PS=2.93u PD=2.145u rfmode=0
M$5038 VDD CLK \$1509 VDD sg13_lv_pmos L=0.13u W=1.12u AS=0.431025p AD=0.3808p
+ PS=2.145u PD=2.92u rfmode=0
M$5039 \$1573 \$1672 \$1704 VDD sg13_lv_pmos L=0.13u W=0.42u AS=0.19115p
+ AD=0.0525p PS=1.565u PD=0.67u rfmode=0
M$5040 \$1704 \$1657 VDD VDD sg13_lv_pmos L=0.13u W=0.42u AS=0.0525p
+ AD=0.25605p PS=0.67u PD=1.935u rfmode=0
M$5041 VDD VDD \$1657 VDD sg13_lv_pmos L=0.13u W=0.42u AS=0.25605p AD=0.0798p
+ PS=1.935u PD=0.8u rfmode=0
M$5042 VDD \$1573 \$1657 VDD sg13_lv_pmos L=0.13u W=0.42u AS=0.2014p AD=0.0798p
+ PS=1.53u PD=0.8u rfmode=0
M$5043 VDD \$1573 \$1575 VDD sg13_lv_pmos L=0.13u W=1u AS=0.2083p AD=0.34p
+ PS=1.5u PD=2.68u rfmode=0
M$5044 VDD \$1573 \$1574 VDD sg13_lv_pmos L=0.13u W=2.24u AS=0.4142p AD=0.4211p
+ PS=3.03u PD=3u rfmode=0
M$5046 \$1508 \$1509 \$1573 VDD sg13_lv_pmos L=0.13u W=1u AS=0.34p AD=0.19115p
+ PS=2.68u PD=1.565u rfmode=0
M$5047 VDD \$1575 \$1576 VDD sg13_lv_pmos L=0.13u W=2.24u AS=0.5964p AD=0.5964p
+ PS=4.425u PD=4.425u rfmode=0
M$5049 VDD \$1511 \$1579 VDD sg13_lv_pmos L=0.13u W=2.24u AS=0.616p AD=0.4312p
+ PS=4.46u PD=3.01u rfmode=0
M$5051 VDD \$316 \$1579 VDD sg13_lv_pmos L=0.13u W=2.24u AS=0.4312p AD=0.6048p
+ PS=3.01u PD=4.44u rfmode=0
M$5053 VDD \$1579 \$1580 VDD sg13_lv_pmos L=0.13u W=0.42u AS=0.1428p AD=0.0798p
+ PS=1.52u PD=0.8u rfmode=0
M$5054 VDD VDD \$1580 VDD sg13_lv_pmos L=0.13u W=0.42u AS=0.3623875p AD=0.0798p
+ PS=2.605u PD=0.8u rfmode=0
M$5055 VDD \$1658 \$1512 VDD sg13_lv_pmos L=0.13u W=1u AS=0.3623875p AD=0.34p
+ PS=2.605u PD=2.68u rfmode=0
M$5056 \$1366 VDD VDD VDD sg13_lv_pmos L=0.13u W=0.42u AS=0.147p AD=0.1563p
+ PS=1.54u PD=1.22u rfmode=0
M$5057 VDD \$1224 \$1431 VDD sg13_lv_pmos L=0.13u W=0.42u AS=0.1563p AD=0.0546p
+ PS=1.22u PD=0.68u rfmode=0
M$5058 \$1431 \$1225 \$1366 VDD sg13_lv_pmos L=0.13u W=0.42u AS=0.0546p
+ AD=0.0798p PS=0.68u PD=0.8u rfmode=0
M$5059 \$1366 \$1386 \$1385 VDD sg13_lv_pmos L=0.13u W=0.42u AS=0.0798p
+ AD=0.1428p PS=0.8u PD=1.52u rfmode=0
M$5060 \$1674 \$1513 VDD VDD sg13_lv_pmos L=0.13u W=1.12u AS=0.3864p
+ AD=0.431025p PS=2.93u PD=2.145u rfmode=0
M$5061 VDD CLK \$1513 VDD sg13_lv_pmos L=0.13u W=1.12u AS=0.431025p AD=0.3808p
+ PS=2.145u PD=2.92u rfmode=0
M$5062 \$1583 \$1674 \$1693 VDD sg13_lv_pmos L=0.13u W=0.42u AS=0.19115p
+ AD=0.0525p PS=1.565u PD=0.67u rfmode=0
M$5063 \$1693 \$1659 VDD VDD sg13_lv_pmos L=0.13u W=0.42u AS=0.0525p
+ AD=0.25605p PS=0.67u PD=1.935u rfmode=0
M$5064 VDD VDD \$1659 VDD sg13_lv_pmos L=0.13u W=0.42u AS=0.25605p AD=0.0798p
+ PS=1.935u PD=0.8u rfmode=0
M$5065 VDD \$1583 \$1659 VDD sg13_lv_pmos L=0.13u W=0.42u AS=0.2014p AD=0.0798p
+ PS=1.53u PD=0.8u rfmode=0
M$5066 VDD \$1583 \$1585 VDD sg13_lv_pmos L=0.13u W=1u AS=0.2083p AD=0.34p
+ PS=1.5u PD=2.68u rfmode=0
M$5067 VDD \$1583 \$1584 VDD sg13_lv_pmos L=0.13u W=2.24u AS=0.4142p AD=0.4211p
+ PS=3.03u PD=3u rfmode=0
M$5069 \$1512 \$1513 \$1583 VDD sg13_lv_pmos L=0.13u W=1u AS=0.34p AD=0.19115p
+ PS=2.68u PD=1.565u rfmode=0
M$5070 VDD \$1585 \$1586 VDD sg13_lv_pmos L=0.13u W=2.24u AS=0.5964p AD=0.5964p
+ PS=4.425u PD=4.425u rfmode=0
M$5072 VDD \$1515 \$1589 VDD sg13_lv_pmos L=0.13u W=2.24u AS=0.616p AD=0.4312p
+ PS=4.46u PD=3.01u rfmode=0
M$5074 VDD \$316 \$1589 VDD sg13_lv_pmos L=0.13u W=2.24u AS=0.4312p AD=0.6048p
+ PS=3.01u PD=4.44u rfmode=0
M$5076 VDD \$1589 \$1590 VDD sg13_lv_pmos L=0.13u W=0.42u AS=0.1428p AD=0.0798p
+ PS=1.52u PD=0.8u rfmode=0
M$5077 VDD VDD \$1590 VDD sg13_lv_pmos L=0.13u W=0.42u AS=0.3623875p AD=0.0798p
+ PS=2.605u PD=0.8u rfmode=0
M$5078 VDD \$1660 \$1516 VDD sg13_lv_pmos L=0.13u W=1u AS=0.3623875p AD=0.34p
+ PS=2.605u PD=2.68u rfmode=0
M$5079 \$1368 VDD VDD VDD sg13_lv_pmos L=0.13u W=0.42u AS=0.147p AD=0.1563p
+ PS=1.54u PD=1.22u rfmode=0
M$5080 VDD \$1228 \$1432 VDD sg13_lv_pmos L=0.13u W=0.42u AS=0.1563p AD=0.0546p
+ PS=1.22u PD=0.68u rfmode=0
M$5081 \$1432 \$1229 \$1368 VDD sg13_lv_pmos L=0.13u W=0.42u AS=0.0546p
+ AD=0.0798p PS=0.68u PD=0.8u rfmode=0
M$5082 \$1368 \$1388 \$1298 VDD sg13_lv_pmos L=0.13u W=0.42u AS=0.0798p
+ AD=0.1428p PS=0.8u PD=1.52u rfmode=0
M$5083 \$1676 \$1517 VDD VDD sg13_lv_pmos L=0.13u W=1.12u AS=0.3864p
+ AD=0.431025p PS=2.93u PD=2.145u rfmode=0
M$5084 VDD CLK \$1517 VDD sg13_lv_pmos L=0.13u W=1.12u AS=0.431025p AD=0.3808p
+ PS=2.145u PD=2.92u rfmode=0
M$5085 \$1593 \$1676 \$1684 VDD sg13_lv_pmos L=0.13u W=0.42u AS=0.19115p
+ AD=0.0525p PS=1.565u PD=0.67u rfmode=0
M$5086 \$1684 \$1661 VDD VDD sg13_lv_pmos L=0.13u W=0.42u AS=0.0525p
+ AD=0.25605p PS=0.67u PD=1.935u rfmode=0
M$5087 VDD VDD \$1661 VDD sg13_lv_pmos L=0.13u W=0.42u AS=0.25605p AD=0.0798p
+ PS=1.935u PD=0.8u rfmode=0
M$5088 VDD \$1593 \$1661 VDD sg13_lv_pmos L=0.13u W=0.42u AS=0.2014p AD=0.0798p
+ PS=1.53u PD=0.8u rfmode=0
M$5089 VDD \$1593 \$1595 VDD sg13_lv_pmos L=0.13u W=1u AS=0.2083p AD=0.34p
+ PS=1.5u PD=2.68u rfmode=0
M$5090 VDD \$1593 \$1594 VDD sg13_lv_pmos L=0.13u W=2.24u AS=0.4142p AD=0.4211p
+ PS=3.03u PD=3u rfmode=0
M$5092 \$1516 \$1517 \$1593 VDD sg13_lv_pmos L=0.13u W=1u AS=0.34p AD=0.19115p
+ PS=2.68u PD=1.565u rfmode=0
M$5093 VDD \$1595 \$1596 VDD sg13_lv_pmos L=0.13u W=2.24u AS=0.5964p AD=0.5964p
+ PS=4.425u PD=4.425u rfmode=0
M$5095 \$1486 \$167 \$1710 VDD sg13_lv_pmos L=0.13u W=0.84u AS=0.2856p
+ AD=0.1596p PS=2.36u PD=1.22u rfmode=0
M$5096 VDD \$324 \$1710 VDD sg13_lv_pmos L=0.13u W=0.84u AS=0.2226p AD=0.1596p
+ PS=1.535u PD=1.22u rfmode=0
M$5097 VDD \$1486 \$1487 VDD sg13_lv_pmos L=0.13u W=2.24u AS=0.4746p AD=0.6776p
+ PS=3.105u PD=4.57u rfmode=0
M$5099 VDD \$1775 \$1807 VDD sg13_lv_pmos L=0.13u W=2.24u AS=0.616p AD=0.4312p
+ PS=4.46u PD=3.01u rfmode=0
M$5101 VDD \$324 \$1807 VDD sg13_lv_pmos L=0.13u W=2.24u AS=0.4312p AD=0.6048p
+ PS=3.01u PD=4.44u rfmode=0
M$5103 \$1646 VDD VDD VDD sg13_lv_pmos L=0.13u W=0.42u AS=0.147p AD=0.1563p
+ PS=1.54u PD=1.22u rfmode=0
M$5104 VDD \$1488 \$1711 VDD sg13_lv_pmos L=0.13u W=0.42u AS=0.1563p AD=0.0546p
+ PS=1.22u PD=0.68u rfmode=0
M$5105 \$1711 \$1489 \$1646 VDD sg13_lv_pmos L=0.13u W=0.42u AS=0.0546p
+ AD=0.0798p PS=0.68u PD=0.8u rfmode=0
M$5106 \$1646 \$1662 \$1520 VDD sg13_lv_pmos L=0.13u W=0.42u AS=0.0798p
+ AD=0.1428p PS=0.8u PD=1.52u rfmode=0
M$5107 \$1947 \$1777 VDD VDD sg13_lv_pmos L=0.13u W=1.12u AS=0.3864p
+ AD=0.431025p PS=2.93u PD=2.145u rfmode=0
M$5108 VDD CLK \$1777 VDD sg13_lv_pmos L=0.13u W=1.12u AS=0.431025p AD=0.3808p
+ PS=2.145u PD=2.92u rfmode=0
M$5109 VDD \$1813 \$1814 VDD sg13_lv_pmos L=0.13u W=2.24u AS=0.5964p AD=0.5964p
+ PS=4.425u PD=4.425u rfmode=0
M$5111 \$1490 \$171 \$1712 VDD sg13_lv_pmos L=0.13u W=0.84u AS=0.2856p
+ AD=0.1596p PS=2.36u PD=1.22u rfmode=0
M$5112 VDD \$324 \$1712 VDD sg13_lv_pmos L=0.13u W=0.84u AS=0.2226p AD=0.1596p
+ PS=1.535u PD=1.22u rfmode=0
M$5113 VDD \$1490 \$1491 VDD sg13_lv_pmos L=0.13u W=2.24u AS=0.4746p AD=0.6776p
+ PS=3.105u PD=4.57u rfmode=0
M$5115 VDD \$1779 \$1817 VDD sg13_lv_pmos L=0.13u W=2.24u AS=0.616p AD=0.4312p
+ PS=4.46u PD=3.01u rfmode=0
M$5117 VDD \$324 \$1817 VDD sg13_lv_pmos L=0.13u W=2.24u AS=0.4312p AD=0.6048p
+ PS=3.01u PD=4.44u rfmode=0
M$5119 \$1648 VDD VDD VDD sg13_lv_pmos L=0.13u W=0.42u AS=0.147p AD=0.1563p
+ PS=1.54u PD=1.22u rfmode=0
M$5120 VDD \$1492 \$1713 VDD sg13_lv_pmos L=0.13u W=0.42u AS=0.1563p AD=0.0546p
+ PS=1.22u PD=0.68u rfmode=0
M$5121 \$1713 \$1493 \$1648 VDD sg13_lv_pmos L=0.13u W=0.42u AS=0.0546p
+ AD=0.0798p PS=0.68u PD=0.8u rfmode=0
M$5122 \$1648 \$1664 \$1530 VDD sg13_lv_pmos L=0.13u W=0.42u AS=0.0798p
+ AD=0.1428p PS=0.8u PD=1.52u rfmode=0
M$5123 \$1950 \$1781 VDD VDD sg13_lv_pmos L=0.13u W=1.12u AS=0.3864p
+ AD=0.431025p PS=2.93u PD=2.145u rfmode=0
M$5124 VDD CLK \$1781 VDD sg13_lv_pmos L=0.13u W=1.12u AS=0.431025p AD=0.3808p
+ PS=2.145u PD=2.92u rfmode=0
M$5125 VDD \$1822 \$1823 VDD sg13_lv_pmos L=0.13u W=2.24u AS=0.5964p AD=0.5964p
+ PS=4.425u PD=4.425u rfmode=0
M$5127 \$1494 \$174 \$1714 VDD sg13_lv_pmos L=0.13u W=0.84u AS=0.2856p
+ AD=0.1596p PS=2.36u PD=1.22u rfmode=0
M$5128 VDD \$324 \$1714 VDD sg13_lv_pmos L=0.13u W=0.84u AS=0.2226p AD=0.1596p
+ PS=1.535u PD=1.22u rfmode=0
M$5129 VDD \$1494 \$1495 VDD sg13_lv_pmos L=0.13u W=2.24u AS=0.4746p AD=0.6776p
+ PS=3.105u PD=4.57u rfmode=0
M$5131 VDD \$1783 \$1826 VDD sg13_lv_pmos L=0.13u W=2.24u AS=0.616p AD=0.4312p
+ PS=4.46u PD=3.01u rfmode=0
M$5133 VDD \$324 \$1826 VDD sg13_lv_pmos L=0.13u W=2.24u AS=0.4312p AD=0.6048p
+ PS=3.01u PD=4.44u rfmode=0
M$5135 \$1650 VDD VDD VDD sg13_lv_pmos L=0.13u W=0.42u AS=0.147p AD=0.1563p
+ PS=1.54u PD=1.22u rfmode=0
M$5136 VDD \$1496 \$1715 VDD sg13_lv_pmos L=0.13u W=0.42u AS=0.1563p AD=0.0546p
+ PS=1.22u PD=0.68u rfmode=0
M$5137 \$1715 \$1497 \$1650 VDD sg13_lv_pmos L=0.13u W=0.42u AS=0.0546p
+ AD=0.0798p PS=0.68u PD=0.8u rfmode=0
M$5138 \$1650 \$1666 \$1540 VDD sg13_lv_pmos L=0.13u W=0.42u AS=0.0798p
+ AD=0.1428p PS=0.8u PD=1.52u rfmode=0
M$5139 \$1952 \$1785 VDD VDD sg13_lv_pmos L=0.13u W=1.12u AS=0.3864p
+ AD=0.431025p PS=2.93u PD=2.145u rfmode=0
M$5140 VDD CLK \$1785 VDD sg13_lv_pmos L=0.13u W=1.12u AS=0.431025p AD=0.3808p
+ PS=2.145u PD=2.92u rfmode=0
M$5141 VDD \$1832 \$1833 VDD sg13_lv_pmos L=0.13u W=2.24u AS=0.5964p AD=0.5964p
+ PS=4.425u PD=4.425u rfmode=0
M$5143 \$1498 \$177 \$1717 VDD sg13_lv_pmos L=0.13u W=0.84u AS=0.2856p
+ AD=0.1596p PS=2.36u PD=1.22u rfmode=0
M$5144 VDD \$324 \$1717 VDD sg13_lv_pmos L=0.13u W=0.84u AS=0.2226p AD=0.1596p
+ PS=1.535u PD=1.22u rfmode=0
M$5145 VDD \$1498 \$1499 VDD sg13_lv_pmos L=0.13u W=2.24u AS=0.4746p AD=0.6776p
+ PS=3.105u PD=4.57u rfmode=0
M$5147 VDD \$1787 \$1836 VDD sg13_lv_pmos L=0.13u W=2.24u AS=0.616p AD=0.4312p
+ PS=4.46u PD=3.01u rfmode=0
M$5149 VDD \$324 \$1836 VDD sg13_lv_pmos L=0.13u W=2.24u AS=0.4312p AD=0.6048p
+ PS=3.01u PD=4.44u rfmode=0
M$5151 \$1652 VDD VDD VDD sg13_lv_pmos L=0.13u W=0.42u AS=0.147p AD=0.1563p
+ PS=1.54u PD=1.22u rfmode=0
M$5152 VDD \$1500 \$1718 VDD sg13_lv_pmos L=0.13u W=0.42u AS=0.1563p AD=0.0546p
+ PS=1.22u PD=0.68u rfmode=0
M$5153 \$1718 \$1501 \$1652 VDD sg13_lv_pmos L=0.13u W=0.42u AS=0.0546p
+ AD=0.0798p PS=0.68u PD=0.8u rfmode=0
M$5154 \$1652 \$1668 \$1550 VDD sg13_lv_pmos L=0.13u W=0.42u AS=0.0798p
+ AD=0.1428p PS=0.8u PD=1.52u rfmode=0
M$5155 \$1954 \$1789 VDD VDD sg13_lv_pmos L=0.13u W=1.12u AS=0.3864p
+ AD=0.431025p PS=2.93u PD=2.145u rfmode=0
M$5156 VDD CLK \$1789 VDD sg13_lv_pmos L=0.13u W=1.12u AS=0.431025p AD=0.3808p
+ PS=2.145u PD=2.92u rfmode=0
M$5157 VDD \$1842 \$1843 VDD sg13_lv_pmos L=0.13u W=2.24u AS=0.5964p AD=0.5964p
+ PS=4.425u PD=4.425u rfmode=0
M$5159 \$1502 \$180 \$1719 VDD sg13_lv_pmos L=0.13u W=0.84u AS=0.2856p
+ AD=0.1596p PS=2.36u PD=1.22u rfmode=0
M$5160 VDD \$324 \$1719 VDD sg13_lv_pmos L=0.13u W=0.84u AS=0.2226p AD=0.1596p
+ PS=1.535u PD=1.22u rfmode=0
M$5161 VDD \$1502 \$1503 VDD sg13_lv_pmos L=0.13u W=2.24u AS=0.4746p AD=0.6776p
+ PS=3.105u PD=4.57u rfmode=0
M$5163 VDD \$1791 \$1846 VDD sg13_lv_pmos L=0.13u W=2.24u AS=0.616p AD=0.4312p
+ PS=4.46u PD=3.01u rfmode=0
M$5165 VDD \$324 \$1846 VDD sg13_lv_pmos L=0.13u W=2.24u AS=0.4312p AD=0.6048p
+ PS=3.01u PD=4.44u rfmode=0
M$5167 \$1654 VDD VDD VDD sg13_lv_pmos L=0.13u W=0.42u AS=0.147p AD=0.1563p
+ PS=1.54u PD=1.22u rfmode=0
M$5168 VDD \$1504 \$1720 VDD sg13_lv_pmos L=0.13u W=0.42u AS=0.1563p AD=0.0546p
+ PS=1.22u PD=0.68u rfmode=0
M$5169 \$1720 \$1505 \$1654 VDD sg13_lv_pmos L=0.13u W=0.42u AS=0.0546p
+ AD=0.0798p PS=0.68u PD=0.8u rfmode=0
M$5170 \$1654 \$1670 \$1560 VDD sg13_lv_pmos L=0.13u W=0.42u AS=0.0798p
+ AD=0.1428p PS=0.8u PD=1.52u rfmode=0
M$5171 \$1956 \$1793 VDD VDD sg13_lv_pmos L=0.13u W=1.12u AS=0.3864p
+ AD=0.431025p PS=2.93u PD=2.145u rfmode=0
M$5172 VDD CLK \$1793 VDD sg13_lv_pmos L=0.13u W=1.12u AS=0.431025p AD=0.3808p
+ PS=2.145u PD=2.92u rfmode=0
M$5173 VDD \$1852 \$1853 VDD sg13_lv_pmos L=0.13u W=2.24u AS=0.5964p AD=0.5964p
+ PS=4.425u PD=4.425u rfmode=0
M$5175 \$1506 \$183 \$1721 VDD sg13_lv_pmos L=0.13u W=0.84u AS=0.2856p
+ AD=0.1596p PS=2.36u PD=1.22u rfmode=0
M$5176 VDD \$324 \$1721 VDD sg13_lv_pmos L=0.13u W=0.84u AS=0.2226p AD=0.1596p
+ PS=1.535u PD=1.22u rfmode=0
M$5177 VDD \$1506 \$1507 VDD sg13_lv_pmos L=0.13u W=2.24u AS=0.4746p AD=0.6776p
+ PS=3.105u PD=4.57u rfmode=0
M$5179 VDD \$1795 \$1856 VDD sg13_lv_pmos L=0.13u W=2.24u AS=0.616p AD=0.4312p
+ PS=4.46u PD=3.01u rfmode=0
M$5181 VDD \$324 \$1856 VDD sg13_lv_pmos L=0.13u W=2.24u AS=0.4312p AD=0.6048p
+ PS=3.01u PD=4.44u rfmode=0
M$5183 \$1656 VDD VDD VDD sg13_lv_pmos L=0.13u W=0.42u AS=0.147p AD=0.1563p
+ PS=1.54u PD=1.22u rfmode=0
M$5184 VDD \$1508 \$1722 VDD sg13_lv_pmos L=0.13u W=0.42u AS=0.1563p AD=0.0546p
+ PS=1.22u PD=0.68u rfmode=0
M$5185 \$1722 \$1509 \$1656 VDD sg13_lv_pmos L=0.13u W=0.42u AS=0.0546p
+ AD=0.0798p PS=0.68u PD=0.8u rfmode=0
M$5186 \$1656 \$1672 \$1570 VDD sg13_lv_pmos L=0.13u W=0.42u AS=0.0798p
+ AD=0.1428p PS=0.8u PD=1.52u rfmode=0
M$5187 \$1958 \$1797 VDD VDD sg13_lv_pmos L=0.13u W=1.12u AS=0.3864p
+ AD=0.431025p PS=2.93u PD=2.145u rfmode=0
M$5188 VDD CLK \$1797 VDD sg13_lv_pmos L=0.13u W=1.12u AS=0.431025p AD=0.3808p
+ PS=2.145u PD=2.92u rfmode=0
M$5189 VDD \$1862 \$1863 VDD sg13_lv_pmos L=0.13u W=2.24u AS=0.5964p AD=0.5964p
+ PS=4.425u PD=4.425u rfmode=0
M$5191 \$1510 \$186 \$1724 VDD sg13_lv_pmos L=0.13u W=0.84u AS=0.2856p
+ AD=0.1596p PS=2.36u PD=1.22u rfmode=0
M$5192 VDD \$324 \$1724 VDD sg13_lv_pmos L=0.13u W=0.84u AS=0.2226p AD=0.1596p
+ PS=1.535u PD=1.22u rfmode=0
M$5193 VDD \$1510 \$1511 VDD sg13_lv_pmos L=0.13u W=2.24u AS=0.4746p AD=0.6776p
+ PS=3.105u PD=4.57u rfmode=0
M$5195 VDD \$1799 \$1866 VDD sg13_lv_pmos L=0.13u W=2.24u AS=0.616p AD=0.4312p
+ PS=4.46u PD=3.01u rfmode=0
M$5197 VDD \$324 \$1866 VDD sg13_lv_pmos L=0.13u W=2.24u AS=0.4312p AD=0.6048p
+ PS=3.01u PD=4.44u rfmode=0
M$5199 \$1658 VDD VDD VDD sg13_lv_pmos L=0.13u W=0.42u AS=0.147p AD=0.1563p
+ PS=1.54u PD=1.22u rfmode=0
M$5200 VDD \$1512 \$1725 VDD sg13_lv_pmos L=0.13u W=0.42u AS=0.1563p AD=0.0546p
+ PS=1.22u PD=0.68u rfmode=0
M$5201 \$1725 \$1513 \$1658 VDD sg13_lv_pmos L=0.13u W=0.42u AS=0.0546p
+ AD=0.0798p PS=0.68u PD=0.8u rfmode=0
M$5202 \$1658 \$1674 \$1580 VDD sg13_lv_pmos L=0.13u W=0.42u AS=0.0798p
+ AD=0.1428p PS=0.8u PD=1.52u rfmode=0
M$5203 \$1961 \$1801 VDD VDD sg13_lv_pmos L=0.13u W=1.12u AS=0.3864p
+ AD=0.431025p PS=2.93u PD=2.145u rfmode=0
M$5204 VDD CLK \$1801 VDD sg13_lv_pmos L=0.13u W=1.12u AS=0.431025p AD=0.3808p
+ PS=2.145u PD=2.92u rfmode=0
M$5205 VDD \$1871 \$1872 VDD sg13_lv_pmos L=0.13u W=2.24u AS=0.5964p AD=0.5964p
+ PS=4.425u PD=4.425u rfmode=0
M$5207 \$1514 VSS \$1723 VDD sg13_lv_pmos L=0.13u W=0.84u AS=0.2856p AD=0.1596p
+ PS=2.36u PD=1.22u rfmode=0
M$5208 VDD \$324 \$1723 VDD sg13_lv_pmos L=0.13u W=0.84u AS=0.2226p AD=0.1596p
+ PS=1.535u PD=1.22u rfmode=0
M$5209 VDD \$1514 \$1515 VDD sg13_lv_pmos L=0.13u W=2.24u AS=0.4746p AD=0.6776p
+ PS=3.105u PD=4.57u rfmode=0
M$5211 VDD \$1803 \$1875 VDD sg13_lv_pmos L=0.13u W=2.24u AS=0.616p AD=0.4312p
+ PS=4.46u PD=3.01u rfmode=0
M$5213 VDD \$324 \$1875 VDD sg13_lv_pmos L=0.13u W=2.24u AS=0.4312p AD=0.6048p
+ PS=3.01u PD=4.44u rfmode=0
M$5215 \$1660 VDD VDD VDD sg13_lv_pmos L=0.13u W=0.42u AS=0.147p AD=0.1563p
+ PS=1.54u PD=1.22u rfmode=0
M$5216 VDD \$1516 \$1716 VDD sg13_lv_pmos L=0.13u W=0.42u AS=0.1563p AD=0.0546p
+ PS=1.22u PD=0.68u rfmode=0
M$5217 \$1716 \$1517 \$1660 VDD sg13_lv_pmos L=0.13u W=0.42u AS=0.0546p
+ AD=0.0798p PS=0.68u PD=0.8u rfmode=0
M$5218 \$1660 \$1676 \$1590 VDD sg13_lv_pmos L=0.13u W=0.42u AS=0.0798p
+ AD=0.1428p PS=0.8u PD=1.52u rfmode=0
M$5219 \$1964 \$1805 VDD VDD sg13_lv_pmos L=0.13u W=1.12u AS=0.3864p
+ AD=0.431025p PS=2.93u PD=2.145u rfmode=0
M$5220 VDD CLK \$1805 VDD sg13_lv_pmos L=0.13u W=1.12u AS=0.431025p AD=0.3808p
+ PS=2.145u PD=2.92u rfmode=0
M$5221 VDD \$1880 \$1881 VDD sg13_lv_pmos L=0.13u W=2.24u AS=0.5964p AD=0.5964p
+ PS=4.425u PD=4.425u rfmode=0
M$5223 \$1774 \$167 \$1967 VDD sg13_lv_pmos L=0.13u W=0.84u AS=0.2856p
+ AD=0.1596p PS=2.36u PD=1.22u rfmode=0
M$5224 VDD \$563 \$1967 VDD sg13_lv_pmos L=0.13u W=0.84u AS=0.2226p AD=0.1596p
+ PS=1.535u PD=1.22u rfmode=0
M$5225 VDD \$1774 \$1775 VDD sg13_lv_pmos L=0.13u W=2.24u AS=0.4746p AD=0.6776p
+ PS=3.105u PD=4.57u rfmode=0
M$5227 VDD \$1807 \$1808 VDD sg13_lv_pmos L=0.13u W=0.42u AS=0.1428p AD=0.0798p
+ PS=1.52u PD=0.8u rfmode=0
M$5228 VDD VDD \$1808 VDD sg13_lv_pmos L=0.13u W=0.42u AS=0.3623875p AD=0.0798p
+ PS=2.605u PD=0.8u rfmode=0
M$5229 VDD \$1931 \$1776 VDD sg13_lv_pmos L=0.13u W=1u AS=0.3623875p AD=0.34p
+ PS=2.605u PD=2.68u rfmode=0
M$5230 \$1811 \$1947 \$1969 VDD sg13_lv_pmos L=0.13u W=0.42u AS=0.19115p
+ AD=0.0525p PS=1.565u PD=0.67u rfmode=0
M$5231 \$1969 \$1932 VDD VDD sg13_lv_pmos L=0.13u W=0.42u AS=0.0525p
+ AD=0.25605p PS=0.67u PD=1.935u rfmode=0
M$5232 VDD VDD \$1932 VDD sg13_lv_pmos L=0.13u W=0.42u AS=0.25605p AD=0.0798p
+ PS=1.935u PD=0.8u rfmode=0
M$5233 VDD \$1811 \$1932 VDD sg13_lv_pmos L=0.13u W=0.42u AS=0.2014p AD=0.0798p
+ PS=1.53u PD=0.8u rfmode=0
M$5234 VDD \$1811 \$1813 VDD sg13_lv_pmos L=0.13u W=1u AS=0.2083p AD=0.34p
+ PS=1.5u PD=2.68u rfmode=0
M$5235 VDD \$1811 \$1812 VDD sg13_lv_pmos L=0.13u W=2.24u AS=0.4142p AD=0.4211p
+ PS=3.03u PD=3u rfmode=0
M$5237 \$1776 \$1777 \$1811 VDD sg13_lv_pmos L=0.13u W=1u AS=0.34p AD=0.19115p
+ PS=2.68u PD=1.565u rfmode=0
M$5238 \$1778 \$171 \$1973 VDD sg13_lv_pmos L=0.13u W=0.84u AS=0.2856p
+ AD=0.1596p PS=2.36u PD=1.22u rfmode=0
M$5239 VDD \$563 \$1973 VDD sg13_lv_pmos L=0.13u W=0.84u AS=0.2226p AD=0.1596p
+ PS=1.535u PD=1.22u rfmode=0
M$5240 VDD \$1778 \$1779 VDD sg13_lv_pmos L=0.13u W=2.24u AS=0.4746p AD=0.6776p
+ PS=3.105u PD=4.57u rfmode=0
M$5242 VDD \$1817 \$1949 VDD sg13_lv_pmos L=0.13u W=0.42u AS=0.1428p AD=0.0798p
+ PS=1.52u PD=0.8u rfmode=0
M$5243 VDD VDD \$1949 VDD sg13_lv_pmos L=0.13u W=0.42u AS=0.3623875p AD=0.0798p
+ PS=2.605u PD=0.8u rfmode=0
M$5244 VDD \$1933 \$1780 VDD sg13_lv_pmos L=0.13u W=1u AS=0.3623875p AD=0.34p
+ PS=2.605u PD=2.68u rfmode=0
M$5245 \$1820 \$1950 \$1975 VDD sg13_lv_pmos L=0.13u W=0.42u AS=0.19115p
+ AD=0.0525p PS=1.565u PD=0.67u rfmode=0
M$5246 \$1975 \$1934 VDD VDD sg13_lv_pmos L=0.13u W=0.42u AS=0.0525p
+ AD=0.25605p PS=0.67u PD=1.935u rfmode=0
M$5247 VDD VDD \$1934 VDD sg13_lv_pmos L=0.13u W=0.42u AS=0.25605p AD=0.0798p
+ PS=1.935u PD=0.8u rfmode=0
M$5248 VDD \$1820 \$1934 VDD sg13_lv_pmos L=0.13u W=0.42u AS=0.2014p AD=0.0798p
+ PS=1.53u PD=0.8u rfmode=0
M$5249 VDD \$1820 \$1822 VDD sg13_lv_pmos L=0.13u W=1u AS=0.2083p AD=0.34p
+ PS=1.5u PD=2.68u rfmode=0
M$5250 VDD \$1820 \$1821 VDD sg13_lv_pmos L=0.13u W=2.24u AS=0.4142p AD=0.4211p
+ PS=3.03u PD=3u rfmode=0
M$5252 \$1780 \$1781 \$1820 VDD sg13_lv_pmos L=0.13u W=1u AS=0.34p AD=0.19115p
+ PS=2.68u PD=1.565u rfmode=0
M$5253 \$1782 \$174 \$1979 VDD sg13_lv_pmos L=0.13u W=0.84u AS=0.2856p
+ AD=0.1596p PS=2.36u PD=1.22u rfmode=0
M$5254 VDD \$563 \$1979 VDD sg13_lv_pmos L=0.13u W=0.84u AS=0.2226p AD=0.1596p
+ PS=1.535u PD=1.22u rfmode=0
M$5255 VDD \$1782 \$1783 VDD sg13_lv_pmos L=0.13u W=2.24u AS=0.4746p AD=0.6776p
+ PS=3.105u PD=4.57u rfmode=0
M$5257 VDD \$1826 \$1827 VDD sg13_lv_pmos L=0.13u W=0.42u AS=0.1428p AD=0.0798p
+ PS=1.52u PD=0.8u rfmode=0
M$5258 VDD VDD \$1827 VDD sg13_lv_pmos L=0.13u W=0.42u AS=0.3623875p AD=0.0798p
+ PS=2.605u PD=0.8u rfmode=0
M$5259 VDD \$1935 \$1784 VDD sg13_lv_pmos L=0.13u W=1u AS=0.3623875p AD=0.34p
+ PS=2.605u PD=2.68u rfmode=0
M$5260 \$1830 \$1952 \$1982 VDD sg13_lv_pmos L=0.13u W=0.42u AS=0.19115p
+ AD=0.0525p PS=1.565u PD=0.67u rfmode=0
M$5261 \$1982 \$1936 VDD VDD sg13_lv_pmos L=0.13u W=0.42u AS=0.0525p
+ AD=0.25605p PS=0.67u PD=1.935u rfmode=0
M$5262 VDD VDD \$1936 VDD sg13_lv_pmos L=0.13u W=0.42u AS=0.25605p AD=0.0798p
+ PS=1.935u PD=0.8u rfmode=0
M$5263 VDD \$1830 \$1936 VDD sg13_lv_pmos L=0.13u W=0.42u AS=0.2014p AD=0.0798p
+ PS=1.53u PD=0.8u rfmode=0
M$5264 VDD \$1830 \$1832 VDD sg13_lv_pmos L=0.13u W=1u AS=0.2083p AD=0.34p
+ PS=1.5u PD=2.68u rfmode=0
M$5265 VDD \$1830 \$1831 VDD sg13_lv_pmos L=0.13u W=2.24u AS=0.4142p AD=0.4211p
+ PS=3.03u PD=3u rfmode=0
M$5267 \$1784 \$1785 \$1830 VDD sg13_lv_pmos L=0.13u W=1u AS=0.34p AD=0.19115p
+ PS=2.68u PD=1.565u rfmode=0
M$5268 \$1786 \$177 \$1987 VDD sg13_lv_pmos L=0.13u W=0.84u AS=0.2856p
+ AD=0.1596p PS=2.36u PD=1.22u rfmode=0
M$5269 VDD \$563 \$1987 VDD sg13_lv_pmos L=0.13u W=0.84u AS=0.2226p AD=0.1596p
+ PS=1.535u PD=1.22u rfmode=0
M$5270 VDD \$1786 \$1787 VDD sg13_lv_pmos L=0.13u W=2.24u AS=0.4746p AD=0.6776p
+ PS=3.105u PD=4.57u rfmode=0
M$5272 VDD \$1836 \$1837 VDD sg13_lv_pmos L=0.13u W=0.42u AS=0.1428p AD=0.0798p
+ PS=1.52u PD=0.8u rfmode=0
M$5273 VDD VDD \$1837 VDD sg13_lv_pmos L=0.13u W=0.42u AS=0.3623875p AD=0.0798p
+ PS=2.605u PD=0.8u rfmode=0
M$5274 VDD \$1937 \$1788 VDD sg13_lv_pmos L=0.13u W=1u AS=0.3623875p AD=0.34p
+ PS=2.605u PD=2.68u rfmode=0
M$5275 \$1840 \$1954 \$1989 VDD sg13_lv_pmos L=0.13u W=0.42u AS=0.19115p
+ AD=0.0525p PS=1.565u PD=0.67u rfmode=0
M$5276 \$1989 \$1938 VDD VDD sg13_lv_pmos L=0.13u W=0.42u AS=0.0525p
+ AD=0.25605p PS=0.67u PD=1.935u rfmode=0
M$5277 VDD VDD \$1938 VDD sg13_lv_pmos L=0.13u W=0.42u AS=0.25605p AD=0.0798p
+ PS=1.935u PD=0.8u rfmode=0
M$5278 VDD \$1840 \$1938 VDD sg13_lv_pmos L=0.13u W=0.42u AS=0.2014p AD=0.0798p
+ PS=1.53u PD=0.8u rfmode=0
M$5279 VDD \$1840 \$1842 VDD sg13_lv_pmos L=0.13u W=1u AS=0.2083p AD=0.34p
+ PS=1.5u PD=2.68u rfmode=0
M$5280 VDD \$1840 \$1841 VDD sg13_lv_pmos L=0.13u W=2.24u AS=0.4142p AD=0.4211p
+ PS=3.03u PD=3u rfmode=0
M$5282 \$1788 \$1789 \$1840 VDD sg13_lv_pmos L=0.13u W=1u AS=0.34p AD=0.19115p
+ PS=2.68u PD=1.565u rfmode=0
M$5283 \$1790 \$180 \$1993 VDD sg13_lv_pmos L=0.13u W=0.84u AS=0.2856p
+ AD=0.1596p PS=2.36u PD=1.22u rfmode=0
M$5284 VDD \$563 \$1993 VDD sg13_lv_pmos L=0.13u W=0.84u AS=0.2226p AD=0.1596p
+ PS=1.535u PD=1.22u rfmode=0
M$5285 VDD \$1790 \$1791 VDD sg13_lv_pmos L=0.13u W=2.24u AS=0.4746p AD=0.6776p
+ PS=3.105u PD=4.57u rfmode=0
M$5287 VDD \$1846 \$1847 VDD sg13_lv_pmos L=0.13u W=0.42u AS=0.1428p AD=0.0798p
+ PS=1.52u PD=0.8u rfmode=0
M$5288 VDD VDD \$1847 VDD sg13_lv_pmos L=0.13u W=0.42u AS=0.3623875p AD=0.0798p
+ PS=2.605u PD=0.8u rfmode=0
M$5289 VDD \$1939 \$1792 VDD sg13_lv_pmos L=0.13u W=1u AS=0.3623875p AD=0.34p
+ PS=2.605u PD=2.68u rfmode=0
M$5290 \$1850 \$1956 \$1995 VDD sg13_lv_pmos L=0.13u W=0.42u AS=0.19115p
+ AD=0.0525p PS=1.565u PD=0.67u rfmode=0
M$5291 \$1995 \$1940 VDD VDD sg13_lv_pmos L=0.13u W=0.42u AS=0.0525p
+ AD=0.25605p PS=0.67u PD=1.935u rfmode=0
M$5292 VDD VDD \$1940 VDD sg13_lv_pmos L=0.13u W=0.42u AS=0.25605p AD=0.0798p
+ PS=1.935u PD=0.8u rfmode=0
M$5293 VDD \$1850 \$1940 VDD sg13_lv_pmos L=0.13u W=0.42u AS=0.2014p AD=0.0798p
+ PS=1.53u PD=0.8u rfmode=0
M$5294 VDD \$1850 \$1852 VDD sg13_lv_pmos L=0.13u W=1u AS=0.2083p AD=0.34p
+ PS=1.5u PD=2.68u rfmode=0
M$5295 VDD \$1850 \$1851 VDD sg13_lv_pmos L=0.13u W=2.24u AS=0.4142p AD=0.4211p
+ PS=3.03u PD=3u rfmode=0
M$5297 \$1792 \$1793 \$1850 VDD sg13_lv_pmos L=0.13u W=1u AS=0.34p AD=0.19115p
+ PS=2.68u PD=1.565u rfmode=0
M$5298 \$1794 \$183 \$1999 VDD sg13_lv_pmos L=0.13u W=0.84u AS=0.2856p
+ AD=0.1596p PS=2.36u PD=1.22u rfmode=0
M$5299 VDD \$563 \$1999 VDD sg13_lv_pmos L=0.13u W=0.84u AS=0.2226p AD=0.1596p
+ PS=1.535u PD=1.22u rfmode=0
M$5300 VDD \$1794 \$1795 VDD sg13_lv_pmos L=0.13u W=2.24u AS=0.4746p AD=0.6776p
+ PS=3.105u PD=4.57u rfmode=0
M$5302 VDD \$1856 \$1857 VDD sg13_lv_pmos L=0.13u W=0.42u AS=0.1428p AD=0.0798p
+ PS=1.52u PD=0.8u rfmode=0
M$5303 VDD VDD \$1857 VDD sg13_lv_pmos L=0.13u W=0.42u AS=0.3623875p AD=0.0798p
+ PS=2.605u PD=0.8u rfmode=0
M$5304 VDD \$1941 \$1796 VDD sg13_lv_pmos L=0.13u W=1u AS=0.3623875p AD=0.34p
+ PS=2.605u PD=2.68u rfmode=0
M$5305 \$1860 \$1958 \$2002 VDD sg13_lv_pmos L=0.13u W=0.42u AS=0.19115p
+ AD=0.0525p PS=1.565u PD=0.67u rfmode=0
M$5306 \$2002 \$1942 VDD VDD sg13_lv_pmos L=0.13u W=0.42u AS=0.0525p
+ AD=0.25605p PS=0.67u PD=1.935u rfmode=0
M$5307 VDD VDD \$1942 VDD sg13_lv_pmos L=0.13u W=0.42u AS=0.25605p AD=0.0798p
+ PS=1.935u PD=0.8u rfmode=0
M$5308 VDD \$1860 \$1942 VDD sg13_lv_pmos L=0.13u W=0.42u AS=0.2014p AD=0.0798p
+ PS=1.53u PD=0.8u rfmode=0
M$5309 VDD \$1860 \$1862 VDD sg13_lv_pmos L=0.13u W=1u AS=0.2083p AD=0.34p
+ PS=1.5u PD=2.68u rfmode=0
M$5310 VDD \$1860 \$1861 VDD sg13_lv_pmos L=0.13u W=2.24u AS=0.4142p AD=0.4211p
+ PS=3.03u PD=3u rfmode=0
M$5312 \$1796 \$1797 \$1860 VDD sg13_lv_pmos L=0.13u W=1u AS=0.34p AD=0.19115p
+ PS=2.68u PD=1.565u rfmode=0
M$5313 \$1798 \$186 \$2006 VDD sg13_lv_pmos L=0.13u W=0.84u AS=0.2856p
+ AD=0.1596p PS=2.36u PD=1.22u rfmode=0
M$5314 VDD \$563 \$2006 VDD sg13_lv_pmos L=0.13u W=0.84u AS=0.2226p AD=0.1596p
+ PS=1.535u PD=1.22u rfmode=0
M$5315 VDD \$1798 \$1799 VDD sg13_lv_pmos L=0.13u W=2.24u AS=0.4746p AD=0.6776p
+ PS=3.105u PD=4.57u rfmode=0
M$5317 VDD \$1866 \$1960 VDD sg13_lv_pmos L=0.13u W=0.42u AS=0.1428p AD=0.0798p
+ PS=1.52u PD=0.8u rfmode=0
M$5318 VDD VDD \$1960 VDD sg13_lv_pmos L=0.13u W=0.42u AS=0.3623875p AD=0.0798p
+ PS=2.605u PD=0.8u rfmode=0
M$5319 VDD \$1943 \$1800 VDD sg13_lv_pmos L=0.13u W=1u AS=0.3623875p AD=0.34p
+ PS=2.605u PD=2.68u rfmode=0
M$5320 \$1869 \$1961 \$2009 VDD sg13_lv_pmos L=0.13u W=0.42u AS=0.19115p
+ AD=0.0525p PS=1.565u PD=0.67u rfmode=0
M$5321 \$2009 \$1944 VDD VDD sg13_lv_pmos L=0.13u W=0.42u AS=0.0525p
+ AD=0.25605p PS=0.67u PD=1.935u rfmode=0
M$5322 VDD VDD \$1944 VDD sg13_lv_pmos L=0.13u W=0.42u AS=0.25605p AD=0.0798p
+ PS=1.935u PD=0.8u rfmode=0
M$5323 VDD \$1869 \$1944 VDD sg13_lv_pmos L=0.13u W=0.42u AS=0.2014p AD=0.0798p
+ PS=1.53u PD=0.8u rfmode=0
M$5324 VDD \$1869 \$1871 VDD sg13_lv_pmos L=0.13u W=1u AS=0.2083p AD=0.34p
+ PS=1.5u PD=2.68u rfmode=0
M$5325 VDD \$1869 \$1870 VDD sg13_lv_pmos L=0.13u W=2.24u AS=0.4142p AD=0.4211p
+ PS=3.03u PD=3u rfmode=0
M$5327 \$1800 \$1801 \$1869 VDD sg13_lv_pmos L=0.13u W=1u AS=0.34p AD=0.19115p
+ PS=2.68u PD=1.565u rfmode=0
M$5328 \$1802 VSS \$2013 VDD sg13_lv_pmos L=0.13u W=0.84u AS=0.2856p AD=0.1596p
+ PS=2.36u PD=1.22u rfmode=0
M$5329 VDD \$563 \$2013 VDD sg13_lv_pmos L=0.13u W=0.84u AS=0.2226p AD=0.1596p
+ PS=1.535u PD=1.22u rfmode=0
M$5330 VDD \$1802 \$1803 VDD sg13_lv_pmos L=0.13u W=2.24u AS=0.4746p AD=0.6776p
+ PS=3.105u PD=4.57u rfmode=0
M$5332 VDD \$1875 \$1963 VDD sg13_lv_pmos L=0.13u W=0.42u AS=0.1428p AD=0.0798p
+ PS=1.52u PD=0.8u rfmode=0
M$5333 VDD VDD \$1963 VDD sg13_lv_pmos L=0.13u W=0.42u AS=0.3623875p AD=0.0798p
+ PS=2.605u PD=0.8u rfmode=0
M$5334 VDD \$1945 \$1804 VDD sg13_lv_pmos L=0.13u W=1u AS=0.3623875p AD=0.34p
+ PS=2.605u PD=2.68u rfmode=0
M$5335 \$1878 \$1964 \$2000 VDD sg13_lv_pmos L=0.13u W=0.42u AS=0.19115p
+ AD=0.0525p PS=1.565u PD=0.67u rfmode=0
M$5336 \$2000 \$1946 VDD VDD sg13_lv_pmos L=0.13u W=0.42u AS=0.0525p
+ AD=0.25605p PS=0.67u PD=1.935u rfmode=0
M$5337 VDD VDD \$1946 VDD sg13_lv_pmos L=0.13u W=0.42u AS=0.25605p AD=0.0798p
+ PS=1.935u PD=0.8u rfmode=0
M$5338 VDD \$1878 \$1946 VDD sg13_lv_pmos L=0.13u W=0.42u AS=0.2014p AD=0.0798p
+ PS=1.53u PD=0.8u rfmode=0
M$5339 VDD \$1878 \$1880 VDD sg13_lv_pmos L=0.13u W=1u AS=0.2083p AD=0.34p
+ PS=1.5u PD=2.68u rfmode=0
M$5340 VDD \$1878 \$1879 VDD sg13_lv_pmos L=0.13u W=2.24u AS=0.4142p AD=0.4211p
+ PS=3.03u PD=3u rfmode=0
M$5342 \$1804 \$1805 \$1878 VDD sg13_lv_pmos L=0.13u W=1u AS=0.34p AD=0.19115p
+ PS=2.68u PD=1.565u rfmode=0
M$5343 \$2062 \$167 \$2230 VDD sg13_lv_pmos L=0.13u W=0.84u AS=0.2856p
+ AD=0.1596p PS=2.36u PD=1.22u rfmode=0
M$5344 VDD VSS \$2230 VDD sg13_lv_pmos L=0.13u W=0.84u AS=0.2226p AD=0.1596p
+ PS=1.535u PD=1.22u rfmode=0
M$5345 VDD \$2062 \$2063 VDD sg13_lv_pmos L=0.13u W=2.24u AS=0.4746p AD=0.6776p
+ PS=3.105u PD=4.57u rfmode=0
M$5347 VDD \$2063 \$2091 VDD sg13_lv_pmos L=0.13u W=2.24u AS=0.616p AD=0.4312p
+ PS=4.46u PD=3.01u rfmode=0
M$5349 VDD \$563 \$2091 VDD sg13_lv_pmos L=0.13u W=2.24u AS=0.4312p AD=0.6048p
+ PS=3.01u PD=4.44u rfmode=0
M$5351 VDD \$2091 \$2092 VDD sg13_lv_pmos L=0.13u W=0.42u AS=0.1428p AD=0.0798p
+ PS=1.52u PD=0.8u rfmode=0
M$5352 VDD VDD \$2092 VDD sg13_lv_pmos L=0.13u W=0.42u AS=0.3623875p AD=0.0798p
+ PS=2.605u PD=0.8u rfmode=0
M$5353 VDD \$2199 \$2064 VDD sg13_lv_pmos L=0.13u W=1u AS=0.3623875p AD=0.34p
+ PS=2.605u PD=2.68u rfmode=0
M$5354 \$1931 VDD VDD VDD sg13_lv_pmos L=0.13u W=0.42u AS=0.147p AD=0.1563p
+ PS=1.54u PD=1.22u rfmode=0
M$5355 VDD \$1776 \$1968 VDD sg13_lv_pmos L=0.13u W=0.42u AS=0.1563p AD=0.0546p
+ PS=1.22u PD=0.68u rfmode=0
M$5356 \$1968 \$1777 \$1931 VDD sg13_lv_pmos L=0.13u W=0.42u AS=0.0546p
+ AD=0.0798p PS=0.68u PD=0.8u rfmode=0
M$5357 \$1931 \$1947 \$1808 VDD sg13_lv_pmos L=0.13u W=0.42u AS=0.0798p
+ AD=0.1428p PS=0.8u PD=1.52u rfmode=0
M$5358 \$2213 \$2065 VDD VDD sg13_lv_pmos L=0.13u W=1.12u AS=0.3864p
+ AD=0.431025p PS=2.93u PD=2.145u rfmode=0
M$5359 VDD CLK \$2065 VDD sg13_lv_pmos L=0.13u W=1.12u AS=0.431025p AD=0.3808p
+ PS=2.145u PD=2.92u rfmode=0
M$5360 \$2095 \$2213 \$2233 VDD sg13_lv_pmos L=0.13u W=0.42u AS=0.19115p
+ AD=0.0525p PS=1.565u PD=0.67u rfmode=0
M$5361 \$2233 \$2200 VDD VDD sg13_lv_pmos L=0.13u W=0.42u AS=0.0525p
+ AD=0.25605p PS=0.67u PD=1.935u rfmode=0
M$5362 VDD VDD \$2200 VDD sg13_lv_pmos L=0.13u W=0.42u AS=0.25605p AD=0.0798p
+ PS=1.935u PD=0.8u rfmode=0
M$5363 VDD \$2095 \$2200 VDD sg13_lv_pmos L=0.13u W=0.42u AS=0.2014p AD=0.0798p
+ PS=1.53u PD=0.8u rfmode=0
M$5364 VDD \$2095 \$2097 VDD sg13_lv_pmos L=0.13u W=1u AS=0.2083p AD=0.34p
+ PS=1.5u PD=2.68u rfmode=0
M$5365 VDD \$2095 \$2096 VDD sg13_lv_pmos L=0.13u W=2.24u AS=0.4142p AD=0.4211p
+ PS=3.03u PD=3u rfmode=0
M$5367 \$2064 \$2065 \$2095 VDD sg13_lv_pmos L=0.13u W=1u AS=0.34p AD=0.19115p
+ PS=2.68u PD=1.565u rfmode=0
M$5368 VDD \$2097 \$2098 VDD sg13_lv_pmos L=0.13u W=2.24u AS=0.5964p AD=0.5964p
+ PS=4.425u PD=4.425u rfmode=0
M$5370 \$2066 \$171 \$2237 VDD sg13_lv_pmos L=0.13u W=0.84u AS=0.2856p
+ AD=0.1596p PS=2.36u PD=1.22u rfmode=0
M$5371 VDD VSS \$2237 VDD sg13_lv_pmos L=0.13u W=0.84u AS=0.2226p AD=0.1596p
+ PS=1.535u PD=1.22u rfmode=0
M$5372 VDD \$2066 \$2067 VDD sg13_lv_pmos L=0.13u W=2.24u AS=0.4746p AD=0.6776p
+ PS=3.105u PD=4.57u rfmode=0
M$5374 VDD \$2067 \$2101 VDD sg13_lv_pmos L=0.13u W=2.24u AS=0.616p AD=0.4312p
+ PS=4.46u PD=3.01u rfmode=0
M$5376 VDD \$563 \$2101 VDD sg13_lv_pmos L=0.13u W=2.24u AS=0.4312p AD=0.6048p
+ PS=3.01u PD=4.44u rfmode=0
M$5378 VDD \$2101 \$2102 VDD sg13_lv_pmos L=0.13u W=0.42u AS=0.1428p AD=0.0798p
+ PS=1.52u PD=0.8u rfmode=0
M$5379 VDD VDD \$2102 VDD sg13_lv_pmos L=0.13u W=0.42u AS=0.3623875p AD=0.0798p
+ PS=2.605u PD=0.8u rfmode=0
M$5380 VDD \$2201 \$2068 VDD sg13_lv_pmos L=0.13u W=1u AS=0.3623875p AD=0.34p
+ PS=2.605u PD=2.68u rfmode=0
M$5381 \$1933 VDD VDD VDD sg13_lv_pmos L=0.13u W=0.42u AS=0.147p AD=0.1563p
+ PS=1.54u PD=1.22u rfmode=0
M$5382 VDD \$1780 \$1974 VDD sg13_lv_pmos L=0.13u W=0.42u AS=0.1563p AD=0.0546p
+ PS=1.22u PD=0.68u rfmode=0
M$5383 \$1974 \$1781 \$1933 VDD sg13_lv_pmos L=0.13u W=0.42u AS=0.0546p
+ AD=0.0798p PS=0.68u PD=0.8u rfmode=0
M$5384 \$1933 \$1950 \$1949 VDD sg13_lv_pmos L=0.13u W=0.42u AS=0.0798p
+ AD=0.1428p PS=0.8u PD=1.52u rfmode=0
M$5385 \$2215 \$2069 VDD VDD sg13_lv_pmos L=0.13u W=1.12u AS=0.3864p
+ AD=0.431025p PS=2.93u PD=2.145u rfmode=0
M$5386 VDD CLK \$2069 VDD sg13_lv_pmos L=0.13u W=1.12u AS=0.431025p AD=0.3808p
+ PS=2.145u PD=2.92u rfmode=0
M$5387 \$2105 \$2215 \$2239 VDD sg13_lv_pmos L=0.13u W=0.42u AS=0.19115p
+ AD=0.0525p PS=1.565u PD=0.67u rfmode=0
M$5388 \$2239 \$2202 VDD VDD sg13_lv_pmos L=0.13u W=0.42u AS=0.0525p
+ AD=0.25605p PS=0.67u PD=1.935u rfmode=0
M$5389 VDD VDD \$2202 VDD sg13_lv_pmos L=0.13u W=0.42u AS=0.25605p AD=0.0798p
+ PS=1.935u PD=0.8u rfmode=0
M$5390 VDD \$2105 \$2202 VDD sg13_lv_pmos L=0.13u W=0.42u AS=0.2014p AD=0.0798p
+ PS=1.53u PD=0.8u rfmode=0
M$5391 VDD \$2105 \$2107 VDD sg13_lv_pmos L=0.13u W=1u AS=0.2083p AD=0.34p
+ PS=1.5u PD=2.68u rfmode=0
M$5392 VDD \$2105 \$2106 VDD sg13_lv_pmos L=0.13u W=2.24u AS=0.4142p AD=0.4211p
+ PS=3.03u PD=3u rfmode=0
M$5394 \$2068 \$2069 \$2105 VDD sg13_lv_pmos L=0.13u W=1u AS=0.34p AD=0.19115p
+ PS=2.68u PD=1.565u rfmode=0
M$5395 VDD \$2107 \$2108 VDD sg13_lv_pmos L=0.13u W=2.24u AS=0.5964p AD=0.5964p
+ PS=4.425u PD=4.425u rfmode=0
M$5397 \$2070 \$174 \$2243 VDD sg13_lv_pmos L=0.13u W=0.84u AS=0.2856p
+ AD=0.1596p PS=2.36u PD=1.22u rfmode=0
M$5398 VDD VSS \$2243 VDD sg13_lv_pmos L=0.13u W=0.84u AS=0.2226p AD=0.1596p
+ PS=1.535u PD=1.22u rfmode=0
M$5399 VDD \$2070 \$2071 VDD sg13_lv_pmos L=0.13u W=2.24u AS=0.4746p AD=0.6776p
+ PS=3.105u PD=4.57u rfmode=0
M$5401 VDD \$2071 \$2111 VDD sg13_lv_pmos L=0.13u W=2.24u AS=0.616p AD=0.4312p
+ PS=4.46u PD=3.01u rfmode=0
M$5403 VDD \$563 \$2111 VDD sg13_lv_pmos L=0.13u W=2.24u AS=0.4312p AD=0.6048p
+ PS=3.01u PD=4.44u rfmode=0
M$5405 VDD \$2111 \$2217 VDD sg13_lv_pmos L=0.13u W=0.42u AS=0.1428p AD=0.0798p
+ PS=1.52u PD=0.8u rfmode=0
M$5406 VDD VDD \$2217 VDD sg13_lv_pmos L=0.13u W=0.42u AS=0.3623875p AD=0.0798p
+ PS=2.605u PD=0.8u rfmode=0
M$5407 VDD \$2203 \$2072 VDD sg13_lv_pmos L=0.13u W=1u AS=0.3623875p AD=0.34p
+ PS=2.605u PD=2.68u rfmode=0
M$5408 \$1935 VDD VDD VDD sg13_lv_pmos L=0.13u W=0.42u AS=0.147p AD=0.1563p
+ PS=1.54u PD=1.22u rfmode=0
M$5409 VDD \$1784 \$1981 VDD sg13_lv_pmos L=0.13u W=0.42u AS=0.1563p AD=0.0546p
+ PS=1.22u PD=0.68u rfmode=0
M$5410 \$1981 \$1785 \$1935 VDD sg13_lv_pmos L=0.13u W=0.42u AS=0.0546p
+ AD=0.0798p PS=0.68u PD=0.8u rfmode=0
M$5411 \$1935 \$1952 \$1827 VDD sg13_lv_pmos L=0.13u W=0.42u AS=0.0798p
+ AD=0.1428p PS=0.8u PD=1.52u rfmode=0
M$5412 \$2218 \$2073 VDD VDD sg13_lv_pmos L=0.13u W=1.12u AS=0.3864p
+ AD=0.431025p PS=2.93u PD=2.145u rfmode=0
M$5413 VDD CLK \$2073 VDD sg13_lv_pmos L=0.13u W=1.12u AS=0.431025p AD=0.3808p
+ PS=2.145u PD=2.92u rfmode=0
M$5414 \$2114 \$2218 \$2246 VDD sg13_lv_pmos L=0.13u W=0.42u AS=0.19115p
+ AD=0.0525p PS=1.565u PD=0.67u rfmode=0
M$5415 \$2246 \$2204 VDD VDD sg13_lv_pmos L=0.13u W=0.42u AS=0.0525p
+ AD=0.25605p PS=0.67u PD=1.935u rfmode=0
M$5416 VDD VDD \$2204 VDD sg13_lv_pmos L=0.13u W=0.42u AS=0.25605p AD=0.0798p
+ PS=1.935u PD=0.8u rfmode=0
M$5417 VDD \$2114 \$2204 VDD sg13_lv_pmos L=0.13u W=0.42u AS=0.2014p AD=0.0798p
+ PS=1.53u PD=0.8u rfmode=0
M$5418 VDD \$2114 \$2116 VDD sg13_lv_pmos L=0.13u W=1u AS=0.2083p AD=0.34p
+ PS=1.5u PD=2.68u rfmode=0
M$5419 VDD \$2114 \$2115 VDD sg13_lv_pmos L=0.13u W=2.24u AS=0.4142p AD=0.4211p
+ PS=3.03u PD=3u rfmode=0
M$5421 \$2072 \$2073 \$2114 VDD sg13_lv_pmos L=0.13u W=1u AS=0.34p AD=0.19115p
+ PS=2.68u PD=1.565u rfmode=0
M$5422 VDD \$2116 \$2117 VDD sg13_lv_pmos L=0.13u W=2.24u AS=0.5964p AD=0.5964p
+ PS=4.425u PD=4.425u rfmode=0
M$5424 \$2074 \$177 \$2251 VDD sg13_lv_pmos L=0.13u W=0.84u AS=0.2856p
+ AD=0.1596p PS=2.36u PD=1.22u rfmode=0
M$5425 VDD VSS \$2251 VDD sg13_lv_pmos L=0.13u W=0.84u AS=0.2226p AD=0.1596p
+ PS=1.535u PD=1.22u rfmode=0
M$5426 VDD \$2074 \$2075 VDD sg13_lv_pmos L=0.13u W=2.24u AS=0.4746p AD=0.6776p
+ PS=3.105u PD=4.57u rfmode=0
M$5428 VDD \$2075 \$2120 VDD sg13_lv_pmos L=0.13u W=2.24u AS=0.616p AD=0.4312p
+ PS=4.46u PD=3.01u rfmode=0
M$5430 VDD \$563 \$2120 VDD sg13_lv_pmos L=0.13u W=2.24u AS=0.4312p AD=0.6048p
+ PS=3.01u PD=4.44u rfmode=0
M$5432 VDD \$2120 \$2121 VDD sg13_lv_pmos L=0.13u W=0.42u AS=0.1428p AD=0.0798p
+ PS=1.52u PD=0.8u rfmode=0
M$5433 VDD VDD \$2121 VDD sg13_lv_pmos L=0.13u W=0.42u AS=0.3623875p AD=0.0798p
+ PS=2.605u PD=0.8u rfmode=0
M$5434 VDD \$2205 \$2076 VDD sg13_lv_pmos L=0.13u W=1u AS=0.3623875p AD=0.34p
+ PS=2.605u PD=2.68u rfmode=0
M$5435 \$1937 VDD VDD VDD sg13_lv_pmos L=0.13u W=0.42u AS=0.147p AD=0.1563p
+ PS=1.54u PD=1.22u rfmode=0
M$5436 VDD \$1788 \$1988 VDD sg13_lv_pmos L=0.13u W=0.42u AS=0.1563p AD=0.0546p
+ PS=1.22u PD=0.68u rfmode=0
M$5437 \$1988 \$1789 \$1937 VDD sg13_lv_pmos L=0.13u W=0.42u AS=0.0546p
+ AD=0.0798p PS=0.68u PD=0.8u rfmode=0
M$5438 \$1937 \$1954 \$1837 VDD sg13_lv_pmos L=0.13u W=0.42u AS=0.0798p
+ AD=0.1428p PS=0.8u PD=1.52u rfmode=0
M$5439 \$2220 \$2077 VDD VDD sg13_lv_pmos L=0.13u W=1.12u AS=0.3864p
+ AD=0.431025p PS=2.93u PD=2.145u rfmode=0
M$5440 VDD CLK \$2077 VDD sg13_lv_pmos L=0.13u W=1.12u AS=0.431025p AD=0.3808p
+ PS=2.145u PD=2.92u rfmode=0
M$5441 \$2124 \$2220 \$2253 VDD sg13_lv_pmos L=0.13u W=0.42u AS=0.19115p
+ AD=0.0525p PS=1.565u PD=0.67u rfmode=0
M$5442 \$2253 \$2206 VDD VDD sg13_lv_pmos L=0.13u W=0.42u AS=0.0525p
+ AD=0.25605p PS=0.67u PD=1.935u rfmode=0
M$5443 VDD VDD \$2206 VDD sg13_lv_pmos L=0.13u W=0.42u AS=0.25605p AD=0.0798p
+ PS=1.935u PD=0.8u rfmode=0
M$5444 VDD \$2124 \$2206 VDD sg13_lv_pmos L=0.13u W=0.42u AS=0.2014p AD=0.0798p
+ PS=1.53u PD=0.8u rfmode=0
M$5445 VDD \$2124 \$2126 VDD sg13_lv_pmos L=0.13u W=1u AS=0.2083p AD=0.34p
+ PS=1.5u PD=2.68u rfmode=0
M$5446 VDD \$2124 \$2125 VDD sg13_lv_pmos L=0.13u W=2.24u AS=0.4142p AD=0.4211p
+ PS=3.03u PD=3u rfmode=0
M$5448 \$2076 \$2077 \$2124 VDD sg13_lv_pmos L=0.13u W=1u AS=0.34p AD=0.19115p
+ PS=2.68u PD=1.565u rfmode=0
M$5449 VDD \$2126 \$2127 VDD sg13_lv_pmos L=0.13u W=2.24u AS=0.5964p AD=0.5964p
+ PS=4.425u PD=4.425u rfmode=0
M$5451 \$2078 \$180 \$2257 VDD sg13_lv_pmos L=0.13u W=0.84u AS=0.2856p
+ AD=0.1596p PS=2.36u PD=1.22u rfmode=0
M$5452 VDD VSS \$2257 VDD sg13_lv_pmos L=0.13u W=0.84u AS=0.2226p AD=0.1596p
+ PS=1.535u PD=1.22u rfmode=0
M$5453 VDD \$2078 \$2079 VDD sg13_lv_pmos L=0.13u W=2.24u AS=0.4746p AD=0.6776p
+ PS=3.105u PD=4.57u rfmode=0
M$5455 VDD \$2079 \$2130 VDD sg13_lv_pmos L=0.13u W=2.24u AS=0.616p AD=0.4312p
+ PS=4.46u PD=3.01u rfmode=0
M$5457 VDD \$563 \$2130 VDD sg13_lv_pmos L=0.13u W=2.24u AS=0.4312p AD=0.6048p
+ PS=3.01u PD=4.44u rfmode=0
M$5459 VDD \$2130 \$2131 VDD sg13_lv_pmos L=0.13u W=0.42u AS=0.1428p AD=0.0798p
+ PS=1.52u PD=0.8u rfmode=0
M$5460 VDD VDD \$2131 VDD sg13_lv_pmos L=0.13u W=0.42u AS=0.3623875p AD=0.0798p
+ PS=2.605u PD=0.8u rfmode=0
M$5461 VDD \$2207 \$2080 VDD sg13_lv_pmos L=0.13u W=1u AS=0.3623875p AD=0.34p
+ PS=2.605u PD=2.68u rfmode=0
M$5462 \$1939 VDD VDD VDD sg13_lv_pmos L=0.13u W=0.42u AS=0.147p AD=0.1563p
+ PS=1.54u PD=1.22u rfmode=0
M$5463 VDD \$1792 \$1994 VDD sg13_lv_pmos L=0.13u W=0.42u AS=0.1563p AD=0.0546p
+ PS=1.22u PD=0.68u rfmode=0
M$5464 \$1994 \$1793 \$1939 VDD sg13_lv_pmos L=0.13u W=0.42u AS=0.0546p
+ AD=0.0798p PS=0.68u PD=0.8u rfmode=0
M$5465 \$1939 \$1956 \$1847 VDD sg13_lv_pmos L=0.13u W=0.42u AS=0.0798p
+ AD=0.1428p PS=0.8u PD=1.52u rfmode=0
M$5466 \$2222 \$2081 VDD VDD sg13_lv_pmos L=0.13u W=1.12u AS=0.3864p
+ AD=0.431025p PS=2.93u PD=2.145u rfmode=0
M$5467 VDD CLK \$2081 VDD sg13_lv_pmos L=0.13u W=1.12u AS=0.431025p AD=0.3808p
+ PS=2.145u PD=2.92u rfmode=0
M$5468 \$2134 \$2222 \$2259 VDD sg13_lv_pmos L=0.13u W=0.42u AS=0.19115p
+ AD=0.0525p PS=1.565u PD=0.67u rfmode=0
M$5469 \$2259 \$2208 VDD VDD sg13_lv_pmos L=0.13u W=0.42u AS=0.0525p
+ AD=0.25605p PS=0.67u PD=1.935u rfmode=0
M$5470 VDD VDD \$2208 VDD sg13_lv_pmos L=0.13u W=0.42u AS=0.25605p AD=0.0798p
+ PS=1.935u PD=0.8u rfmode=0
M$5471 VDD \$2134 \$2208 VDD sg13_lv_pmos L=0.13u W=0.42u AS=0.2014p AD=0.0798p
+ PS=1.53u PD=0.8u rfmode=0
M$5472 VDD \$2134 \$2136 VDD sg13_lv_pmos L=0.13u W=1u AS=0.2083p AD=0.34p
+ PS=1.5u PD=2.68u rfmode=0
M$5473 VDD \$2134 \$2135 VDD sg13_lv_pmos L=0.13u W=2.24u AS=0.4142p AD=0.4211p
+ PS=3.03u PD=3u rfmode=0
M$5475 \$2080 \$2081 \$2134 VDD sg13_lv_pmos L=0.13u W=1u AS=0.34p AD=0.19115p
+ PS=2.68u PD=1.565u rfmode=0
M$5476 VDD \$2136 \$2137 VDD sg13_lv_pmos L=0.13u W=2.24u AS=0.5964p AD=0.5964p
+ PS=4.425u PD=4.425u rfmode=0
M$5478 \$2082 \$183 \$2263 VDD sg13_lv_pmos L=0.13u W=0.84u AS=0.2856p
+ AD=0.1596p PS=2.36u PD=1.22u rfmode=0
M$5479 VDD VSS \$2263 VDD sg13_lv_pmos L=0.13u W=0.84u AS=0.2226p AD=0.1596p
+ PS=1.535u PD=1.22u rfmode=0
M$5480 VDD \$2082 \$2083 VDD sg13_lv_pmos L=0.13u W=2.24u AS=0.4746p AD=0.6776p
+ PS=3.105u PD=4.57u rfmode=0
M$5482 VDD \$2083 \$2140 VDD sg13_lv_pmos L=0.13u W=2.24u AS=0.616p AD=0.4312p
+ PS=4.46u PD=3.01u rfmode=0
M$5484 VDD \$563 \$2140 VDD sg13_lv_pmos L=0.13u W=2.24u AS=0.4312p AD=0.6048p
+ PS=3.01u PD=4.44u rfmode=0
M$5486 VDD \$2140 \$2224 VDD sg13_lv_pmos L=0.13u W=0.42u AS=0.1428p AD=0.0798p
+ PS=1.52u PD=0.8u rfmode=0
M$5487 VDD VDD \$2224 VDD sg13_lv_pmos L=0.13u W=0.42u AS=0.3623875p AD=0.0798p
+ PS=2.605u PD=0.8u rfmode=0
M$5488 VDD \$2209 \$2084 VDD sg13_lv_pmos L=0.13u W=1u AS=0.3623875p AD=0.34p
+ PS=2.605u PD=2.68u rfmode=0
M$5489 \$1941 VDD VDD VDD sg13_lv_pmos L=0.13u W=0.42u AS=0.147p AD=0.1563p
+ PS=1.54u PD=1.22u rfmode=0
M$5490 VDD \$1796 \$2001 VDD sg13_lv_pmos L=0.13u W=0.42u AS=0.1563p AD=0.0546p
+ PS=1.22u PD=0.68u rfmode=0
M$5491 \$2001 \$1797 \$1941 VDD sg13_lv_pmos L=0.13u W=0.42u AS=0.0546p
+ AD=0.0798p PS=0.68u PD=0.8u rfmode=0
M$5492 \$1941 \$1958 \$1857 VDD sg13_lv_pmos L=0.13u W=0.42u AS=0.0798p
+ AD=0.1428p PS=0.8u PD=1.52u rfmode=0
M$5493 \$2225 \$2085 VDD VDD sg13_lv_pmos L=0.13u W=1.12u AS=0.3864p
+ AD=0.431025p PS=2.93u PD=2.145u rfmode=0
M$5494 VDD CLK \$2085 VDD sg13_lv_pmos L=0.13u W=1.12u AS=0.431025p AD=0.3808p
+ PS=2.145u PD=2.92u rfmode=0
M$5495 \$2143 \$2225 \$2266 VDD sg13_lv_pmos L=0.13u W=0.42u AS=0.19115p
+ AD=0.0525p PS=1.565u PD=0.67u rfmode=0
M$5496 \$2266 \$2210 VDD VDD sg13_lv_pmos L=0.13u W=0.42u AS=0.0525p
+ AD=0.25605p PS=0.67u PD=1.935u rfmode=0
M$5497 VDD VDD \$2210 VDD sg13_lv_pmos L=0.13u W=0.42u AS=0.25605p AD=0.0798p
+ PS=1.935u PD=0.8u rfmode=0
M$5498 VDD \$2143 \$2210 VDD sg13_lv_pmos L=0.13u W=0.42u AS=0.2014p AD=0.0798p
+ PS=1.53u PD=0.8u rfmode=0
M$5499 VDD \$2143 \$2145 VDD sg13_lv_pmos L=0.13u W=1u AS=0.2083p AD=0.34p
+ PS=1.5u PD=2.68u rfmode=0
M$5500 VDD \$2143 \$2144 VDD sg13_lv_pmos L=0.13u W=2.24u AS=0.4142p AD=0.4211p
+ PS=3.03u PD=3u rfmode=0
M$5502 \$2084 \$2085 \$2143 VDD sg13_lv_pmos L=0.13u W=1u AS=0.34p AD=0.19115p
+ PS=2.68u PD=1.565u rfmode=0
M$5503 VDD \$2145 \$2146 VDD sg13_lv_pmos L=0.13u W=2.24u AS=0.5964p AD=0.5964p
+ PS=4.425u PD=4.425u rfmode=0
M$5505 \$2086 \$186 \$2270 VDD sg13_lv_pmos L=0.13u W=0.84u AS=0.2856p
+ AD=0.1596p PS=2.36u PD=1.22u rfmode=0
M$5506 VDD VSS \$2270 VDD sg13_lv_pmos L=0.13u W=0.84u AS=0.2226p AD=0.1596p
+ PS=1.535u PD=1.22u rfmode=0
M$5507 VDD \$2086 \$2087 VDD sg13_lv_pmos L=0.13u W=2.24u AS=0.4746p AD=0.6776p
+ PS=3.105u PD=4.57u rfmode=0
M$5509 VDD \$2087 \$2149 VDD sg13_lv_pmos L=0.13u W=2.24u AS=0.616p AD=0.4312p
+ PS=4.46u PD=3.01u rfmode=0
M$5511 VDD \$563 \$2149 VDD sg13_lv_pmos L=0.13u W=2.24u AS=0.4312p AD=0.6048p
+ PS=3.01u PD=4.44u rfmode=0
M$5513 VDD \$2149 \$2227 VDD sg13_lv_pmos L=0.13u W=0.42u AS=0.1428p AD=0.0798p
+ PS=1.52u PD=0.8u rfmode=0
M$5514 VDD VDD \$2227 VDD sg13_lv_pmos L=0.13u W=0.42u AS=0.3623875p AD=0.0798p
+ PS=2.605u PD=0.8u rfmode=0
M$5515 VDD \$2211 \$2088 VDD sg13_lv_pmos L=0.13u W=1u AS=0.3623875p AD=0.34p
+ PS=2.605u PD=2.68u rfmode=0
M$5516 \$1943 VDD VDD VDD sg13_lv_pmos L=0.13u W=0.42u AS=0.147p AD=0.1563p
+ PS=1.54u PD=1.22u rfmode=0
M$5517 VDD \$1800 \$2007 VDD sg13_lv_pmos L=0.13u W=0.42u AS=0.1563p AD=0.0546p
+ PS=1.22u PD=0.68u rfmode=0
M$5518 \$2007 \$1801 \$1943 VDD sg13_lv_pmos L=0.13u W=0.42u AS=0.0546p
+ AD=0.0798p PS=0.68u PD=0.8u rfmode=0
M$5519 \$1943 \$1961 \$1960 VDD sg13_lv_pmos L=0.13u W=0.42u AS=0.0798p
+ AD=0.1428p PS=0.8u PD=1.52u rfmode=0
M$5520 \$2228 \$2089 VDD VDD sg13_lv_pmos L=0.13u W=1.12u AS=0.3864p
+ AD=0.431025p PS=2.93u PD=2.145u rfmode=0
M$5521 VDD CLK \$2089 VDD sg13_lv_pmos L=0.13u W=1.12u AS=0.431025p AD=0.3808p
+ PS=2.145u PD=2.92u rfmode=0
M$5522 \$2152 \$2228 \$2264 VDD sg13_lv_pmos L=0.13u W=0.42u AS=0.19115p
+ AD=0.0525p PS=1.565u PD=0.67u rfmode=0
M$5523 \$2264 \$2212 VDD VDD sg13_lv_pmos L=0.13u W=0.42u AS=0.0525p
+ AD=0.25605p PS=0.67u PD=1.935u rfmode=0
M$5524 VDD VDD \$2212 VDD sg13_lv_pmos L=0.13u W=0.42u AS=0.25605p AD=0.0798p
+ PS=1.935u PD=0.8u rfmode=0
M$5525 VDD \$2152 \$2212 VDD sg13_lv_pmos L=0.13u W=0.42u AS=0.2014p AD=0.0798p
+ PS=1.53u PD=0.8u rfmode=0
M$5526 VDD \$2152 \$2154 VDD sg13_lv_pmos L=0.13u W=1u AS=0.2083p AD=0.34p
+ PS=1.5u PD=2.68u rfmode=0
M$5527 VDD \$2152 \$2153 VDD sg13_lv_pmos L=0.13u W=2.24u AS=0.4142p AD=0.4211p
+ PS=3.03u PD=3u rfmode=0
M$5529 \$2088 \$2089 \$2152 VDD sg13_lv_pmos L=0.13u W=1u AS=0.34p AD=0.19115p
+ PS=2.68u PD=1.565u rfmode=0
M$5530 VDD \$2154 \$2155 VDD sg13_lv_pmos L=0.13u W=2.24u AS=0.5964p AD=0.5964p
+ PS=4.425u PD=4.425u rfmode=0
M$5532 \$1945 VDD VDD VDD sg13_lv_pmos L=0.13u W=0.42u AS=0.147p AD=0.1563p
+ PS=1.54u PD=1.22u rfmode=0
M$5533 VDD \$1804 \$2008 VDD sg13_lv_pmos L=0.13u W=0.42u AS=0.1563p AD=0.0546p
+ PS=1.22u PD=0.68u rfmode=0
M$5534 \$2008 \$1805 \$1945 VDD sg13_lv_pmos L=0.13u W=0.42u AS=0.0546p
+ AD=0.0798p PS=0.68u PD=0.8u rfmode=0
M$5535 \$1945 \$1964 \$1963 VDD sg13_lv_pmos L=0.13u W=0.42u AS=0.0798p
+ AD=0.1428p PS=0.8u PD=1.52u rfmode=0
M$5536 VDD \$2381 \$177 VDD sg13_lv_pmos L=0.13u W=2.24u AS=0.9464p AD=0.4214p
+ PS=5.05u PD=3u rfmode=0
M$5538 VDD X7 \$2381 VDD sg13_lv_pmos L=0.13u W=1u AS=0.2086p AD=0.34p PS=1.5u
+ PD=2.68u rfmode=0
M$5539 VDD \$2384 \$2364 VDD sg13_lv_pmos L=0.13u W=2.24u AS=0.6384p AD=0.4046p
+ PS=4.5u PD=3u rfmode=0
M$5541 VDD X6 \$2384 VDD sg13_lv_pmos L=0.13u W=0.84u AS=0.1918p AD=0.1596p
+ PS=1.5u PD=1.22u rfmode=0
M$5542 \$2384 X5 VDD VDD sg13_lv_pmos L=0.13u W=0.84u AS=0.1596p AD=0.2856p
+ PS=1.22u PD=2.36u rfmode=0
M$5543 VDD \$2348 \$174 VDD sg13_lv_pmos L=0.13u W=2.24u AS=0.6776p AD=0.4746p
+ PS=4.57u PD=3.105u rfmode=0
M$5545 VDD \$2364 \$2374 VDD sg13_lv_pmos L=0.13u W=0.84u AS=0.2226p AD=0.1596p
+ PS=1.535u PD=1.22u rfmode=0
M$5546 \$2374 X7 \$2348 VDD sg13_lv_pmos L=0.13u W=0.84u AS=0.1596p AD=0.2856p
+ PS=1.22u PD=2.36u rfmode=0
M$5547 VDD \$2388 \$2365 VDD sg13_lv_pmos L=0.13u W=2.24u AS=0.6776p AD=0.4746p
+ PS=4.57u PD=3.105u rfmode=0
M$5549 VDD X5 \$2395 VDD sg13_lv_pmos L=0.13u W=0.84u AS=0.2226p AD=0.1596p
+ PS=1.535u PD=1.22u rfmode=0
M$5550 \$2395 X6 \$2388 VDD sg13_lv_pmos L=0.13u W=0.84u AS=0.1596p AD=0.2856p
+ PS=1.22u PD=2.36u rfmode=0
M$5551 VDD \$2349 \$180 VDD sg13_lv_pmos L=0.13u W=2.24u AS=0.6384p AD=0.4046p
+ PS=4.5u PD=3u rfmode=0
M$5553 VDD \$2365 \$2349 VDD sg13_lv_pmos L=0.13u W=0.84u AS=0.1918p AD=0.1596p
+ PS=1.5u PD=1.22u rfmode=0
M$5554 \$2349 X7 VDD VDD sg13_lv_pmos L=0.13u W=0.84u AS=0.1596p AD=0.2856p
+ PS=1.22u PD=2.36u rfmode=0
M$5555 \$2199 VDD VDD VDD sg13_lv_pmos L=0.13u W=0.42u AS=0.147p AD=0.1563p
+ PS=1.54u PD=1.22u rfmode=0
M$5556 VDD \$2064 \$2232 VDD sg13_lv_pmos L=0.13u W=0.42u AS=0.1563p AD=0.0546p
+ PS=1.22u PD=0.68u rfmode=0
M$5557 \$2232 \$2065 \$2199 VDD sg13_lv_pmos L=0.13u W=0.42u AS=0.0546p
+ AD=0.0798p PS=0.68u PD=0.8u rfmode=0
M$5558 \$2199 \$2213 \$2092 VDD sg13_lv_pmos L=0.13u W=0.42u AS=0.0798p
+ AD=0.1428p PS=0.8u PD=1.52u rfmode=0
M$5559 VDD \$2389 \$171 VDD sg13_lv_pmos L=0.13u W=2.24u AS=0.6776p AD=0.4746p
+ PS=4.57u PD=3.105u rfmode=0
M$5561 VDD X7 \$2397 VDD sg13_lv_pmos L=0.13u W=0.84u AS=0.2226p AD=0.1596p
+ PS=1.535u PD=1.22u rfmode=0
M$5562 \$2397 X6 \$2389 VDD sg13_lv_pmos L=0.13u W=0.84u AS=0.1596p AD=0.2856p
+ PS=1.22u PD=2.36u rfmode=0
M$5563 VDD \$2350 \$167 VDD sg13_lv_pmos L=0.13u W=2.24u AS=0.6776p AD=0.4746p
+ PS=4.57u PD=3.105u rfmode=0
M$5565 VDD \$171 \$2378 VDD sg13_lv_pmos L=0.13u W=0.84u AS=0.2226p AD=0.1596p
+ PS=1.535u PD=1.22u rfmode=0
M$5566 \$2378 X5 \$2350 VDD sg13_lv_pmos L=0.13u W=0.84u AS=0.1596p AD=0.2856p
+ PS=1.22u PD=2.36u rfmode=0
M$5567 VDD \$2390 \$183 VDD sg13_lv_pmos L=0.13u W=2.24u AS=0.6384p AD=0.4046p
+ PS=4.5u PD=3u rfmode=0
M$5569 VDD X7 \$2390 VDD sg13_lv_pmos L=0.13u W=0.84u AS=0.1918p AD=0.1596p
+ PS=1.5u PD=1.22u rfmode=0
M$5570 \$2390 X6 VDD VDD sg13_lv_pmos L=0.13u W=0.84u AS=0.1596p AD=0.2856p
+ PS=1.22u PD=2.36u rfmode=0
M$5571 VDD \$2351 \$186 VDD sg13_lv_pmos L=0.13u W=2.24u AS=0.6384p AD=0.4046p
+ PS=4.5u PD=3u rfmode=0
M$5573 VDD \$2366 \$2351 VDD sg13_lv_pmos L=0.13u W=0.84u AS=0.1918p AD=0.1596p
+ PS=1.5u PD=1.22u rfmode=0
M$5574 \$2351 X7 VDD VDD sg13_lv_pmos L=0.13u W=0.84u AS=0.1596p AD=0.2856p
+ PS=1.22u PD=2.36u rfmode=0
M$5575 VDD \$2385 \$2366 VDD sg13_lv_pmos L=0.13u W=2.24u AS=0.6384p AD=0.4046p
+ PS=4.5u PD=3u rfmode=0
M$5577 VDD X6 \$2385 VDD sg13_lv_pmos L=0.13u W=0.84u AS=0.1918p AD=0.1596p
+ PS=1.5u PD=1.22u rfmode=0
M$5578 \$2385 X5 VDD VDD sg13_lv_pmos L=0.13u W=0.84u AS=0.1596p AD=0.2856p
+ PS=1.22u PD=2.36u rfmode=0
M$5579 \$2201 VDD VDD VDD sg13_lv_pmos L=0.13u W=0.42u AS=0.147p AD=0.1563p
+ PS=1.54u PD=1.22u rfmode=0
M$5580 VDD \$2068 \$2238 VDD sg13_lv_pmos L=0.13u W=0.42u AS=0.1563p AD=0.0546p
+ PS=1.22u PD=0.68u rfmode=0
M$5581 \$2238 \$2069 \$2201 VDD sg13_lv_pmos L=0.13u W=0.42u AS=0.0546p
+ AD=0.0798p PS=0.68u PD=0.8u rfmode=0
M$5582 \$2201 \$2215 \$2102 VDD sg13_lv_pmos L=0.13u W=0.42u AS=0.0798p
+ AD=0.1428p PS=0.8u PD=1.52u rfmode=0
M$5583 \$2203 VDD VDD VDD sg13_lv_pmos L=0.13u W=0.42u AS=0.147p AD=0.1563p
+ PS=1.54u PD=1.22u rfmode=0
M$5584 VDD \$2072 \$2245 VDD sg13_lv_pmos L=0.13u W=0.42u AS=0.1563p AD=0.0546p
+ PS=1.22u PD=0.68u rfmode=0
M$5585 \$2245 \$2073 \$2203 VDD sg13_lv_pmos L=0.13u W=0.42u AS=0.0546p
+ AD=0.0798p PS=0.68u PD=0.8u rfmode=0
M$5586 \$2203 \$2218 \$2217 VDD sg13_lv_pmos L=0.13u W=0.42u AS=0.0798p
+ AD=0.1428p PS=0.8u PD=1.52u rfmode=0
M$5587 \$2205 VDD VDD VDD sg13_lv_pmos L=0.13u W=0.42u AS=0.147p AD=0.1563p
+ PS=1.54u PD=1.22u rfmode=0
M$5588 VDD \$2076 \$2252 VDD sg13_lv_pmos L=0.13u W=0.42u AS=0.1563p AD=0.0546p
+ PS=1.22u PD=0.68u rfmode=0
M$5589 \$2252 \$2077 \$2205 VDD sg13_lv_pmos L=0.13u W=0.42u AS=0.0546p
+ AD=0.0798p PS=0.68u PD=0.8u rfmode=0
M$5590 \$2205 \$2220 \$2121 VDD sg13_lv_pmos L=0.13u W=0.42u AS=0.0798p
+ AD=0.1428p PS=0.8u PD=1.52u rfmode=0
M$5591 \$2207 VDD VDD VDD sg13_lv_pmos L=0.13u W=0.42u AS=0.147p AD=0.1563p
+ PS=1.54u PD=1.22u rfmode=0
M$5592 VDD \$2080 \$2258 VDD sg13_lv_pmos L=0.13u W=0.42u AS=0.1563p AD=0.0546p
+ PS=1.22u PD=0.68u rfmode=0
M$5593 \$2258 \$2081 \$2207 VDD sg13_lv_pmos L=0.13u W=0.42u AS=0.0546p
+ AD=0.0798p PS=0.68u PD=0.8u rfmode=0
M$5594 \$2207 \$2222 \$2131 VDD sg13_lv_pmos L=0.13u W=0.42u AS=0.0798p
+ AD=0.1428p PS=0.8u PD=1.52u rfmode=0
M$5595 \$2209 VDD VDD VDD sg13_lv_pmos L=0.13u W=0.42u AS=0.147p AD=0.1563p
+ PS=1.54u PD=1.22u rfmode=0
M$5596 VDD \$2084 \$2265 VDD sg13_lv_pmos L=0.13u W=0.42u AS=0.1563p AD=0.0546p
+ PS=1.22u PD=0.68u rfmode=0
M$5597 \$2265 \$2085 \$2209 VDD sg13_lv_pmos L=0.13u W=0.42u AS=0.0546p
+ AD=0.0798p PS=0.68u PD=0.8u rfmode=0
M$5598 \$2209 \$2225 \$2224 VDD sg13_lv_pmos L=0.13u W=0.42u AS=0.0798p
+ AD=0.1428p PS=0.8u PD=1.52u rfmode=0
M$5599 \$2211 VDD VDD VDD sg13_lv_pmos L=0.13u W=0.42u AS=0.147p AD=0.1563p
+ PS=1.54u PD=1.22u rfmode=0
M$5600 VDD \$2088 \$2271 VDD sg13_lv_pmos L=0.13u W=0.42u AS=0.1563p AD=0.0546p
+ PS=1.22u PD=0.68u rfmode=0
M$5601 \$2271 \$2089 \$2211 VDD sg13_lv_pmos L=0.13u W=0.42u AS=0.0546p
+ AD=0.0798p PS=0.68u PD=0.8u rfmode=0
M$5602 \$2211 \$2228 \$2227 VDD sg13_lv_pmos L=0.13u W=0.42u AS=0.0798p
+ AD=0.1428p PS=0.8u PD=1.52u rfmode=0
M$5603 VDD X3 \$2352 VDD sg13_lv_pmos L=0.13u W=0.42u AS=0.1428p AD=0.0798p
+ PS=1.52u PD=0.8u rfmode=0
M$5604 VDD VDD \$2352 VDD sg13_lv_pmos L=0.13u W=0.42u AS=0.3623875p AD=0.0798p
+ PS=2.605u PD=0.8u rfmode=0
M$5605 VDD \$2370 \$2346 VDD sg13_lv_pmos L=0.13u W=1u AS=0.3623875p AD=0.34p
+ PS=2.605u PD=2.68u rfmode=0
M$5606 VDD X4 \$2323 VDD sg13_lv_pmos L=0.13u W=0.42u AS=0.1428p AD=0.0798p
+ PS=1.52u PD=0.8u rfmode=0
M$5607 VDD VDD \$2323 VDD sg13_lv_pmos L=0.13u W=0.42u AS=0.3623875p AD=0.0798p
+ PS=2.605u PD=0.8u rfmode=0
M$5608 VDD \$2325 \$2324 VDD sg13_lv_pmos L=0.13u W=1u AS=0.3623875p AD=0.34p
+ PS=2.605u PD=2.68u rfmode=0
M$5609 VDD X1 \$2439 VDD sg13_lv_pmos L=0.13u W=0.42u AS=0.1428p AD=0.0798p
+ PS=1.52u PD=0.8u rfmode=0
M$5610 VDD VDD \$2439 VDD sg13_lv_pmos L=0.13u W=0.42u AS=0.3623875p AD=0.0798p
+ PS=2.605u PD=0.8u rfmode=0
M$5611 VDD \$2449 \$2435 VDD sg13_lv_pmos L=0.13u W=1u AS=0.3623875p AD=0.34p
+ PS=2.605u PD=2.68u rfmode=0
M$5612 VDD X2 \$2412 VDD sg13_lv_pmos L=0.13u W=0.42u AS=0.1428p AD=0.0798p
+ PS=1.52u PD=0.8u rfmode=0
M$5613 VDD VDD \$2412 VDD sg13_lv_pmos L=0.13u W=0.42u AS=0.3623875p AD=0.0798p
+ PS=2.605u PD=0.8u rfmode=0
M$5614 VDD \$2414 \$2413 VDD sg13_lv_pmos L=0.13u W=1u AS=0.3623875p AD=0.34p
+ PS=2.605u PD=2.68u rfmode=0
M$5615 \$2370 VDD VDD VDD sg13_lv_pmos L=0.13u W=0.42u AS=0.147p AD=0.1563p
+ PS=1.54u PD=1.22u rfmode=0
M$5616 VDD \$2346 \$2382 VDD sg13_lv_pmos L=0.13u W=0.42u AS=0.1563p AD=0.0546p
+ PS=1.22u PD=0.68u rfmode=0
M$5617 \$2382 \$2347 \$2370 VDD sg13_lv_pmos L=0.13u W=0.42u AS=0.0546p
+ AD=0.0798p PS=0.68u PD=0.8u rfmode=0
M$5618 \$2370 \$2371 \$2352 VDD sg13_lv_pmos L=0.13u W=0.42u AS=0.0798p
+ AD=0.1428p PS=0.8u PD=1.52u rfmode=0
M$5619 VDD VDD \$2325 VDD sg13_lv_pmos L=0.13u W=0.42u AS=0.1563p AD=0.147p
+ PS=1.22u PD=1.54u rfmode=0
M$5620 VDD \$2324 \$2334 VDD sg13_lv_pmos L=0.13u W=0.42u AS=0.1563p AD=0.0546p
+ PS=1.22u PD=0.68u rfmode=0
M$5621 \$2334 \$2327 \$2325 VDD sg13_lv_pmos L=0.13u W=0.42u AS=0.0546p
+ AD=0.0798p PS=0.68u PD=0.8u rfmode=0
M$5622 \$2325 \$2326 \$2323 VDD sg13_lv_pmos L=0.13u W=0.42u AS=0.0798p
+ AD=0.1428p PS=0.8u PD=1.52u rfmode=0
M$5623 VDD VDD \$2414 VDD sg13_lv_pmos L=0.13u W=0.42u AS=0.1563p AD=0.147p
+ PS=1.22u PD=1.54u rfmode=0
M$5624 VDD \$2413 \$2418 VDD sg13_lv_pmos L=0.13u W=0.42u AS=0.1563p AD=0.0546p
+ PS=1.22u PD=0.68u rfmode=0
M$5625 \$2418 \$2421 \$2414 VDD sg13_lv_pmos L=0.13u W=0.42u AS=0.0546p
+ AD=0.0798p PS=0.68u PD=0.8u rfmode=0
M$5626 \$2414 \$2415 \$2412 VDD sg13_lv_pmos L=0.13u W=0.42u AS=0.0798p
+ AD=0.1428p PS=0.8u PD=1.52u rfmode=0
M$5627 \$2449 VDD VDD VDD sg13_lv_pmos L=0.13u W=0.42u AS=0.147p AD=0.1563p
+ PS=1.54u PD=1.22u rfmode=0
M$5628 VDD \$2435 \$2459 VDD sg13_lv_pmos L=0.13u W=0.42u AS=0.1563p AD=0.0546p
+ PS=1.22u PD=0.68u rfmode=0
M$5629 \$2459 \$2436 \$2449 VDD sg13_lv_pmos L=0.13u W=0.42u AS=0.0546p
+ AD=0.0798p PS=0.68u PD=0.8u rfmode=0
M$5630 \$2449 \$2458 \$2439 VDD sg13_lv_pmos L=0.13u W=0.42u AS=0.0798p
+ AD=0.1428p PS=0.8u PD=1.52u rfmode=0
M$5631 VDD \$2327 \$2326 VDD sg13_lv_pmos L=0.13u W=1.12u AS=0.431025p
+ AD=0.3864p PS=2.145u PD=2.93u rfmode=0
M$5632 VDD CLK \$2327 VDD sg13_lv_pmos L=0.13u W=1.12u AS=0.431025p AD=0.3808p
+ PS=2.145u PD=2.92u rfmode=0
M$5633 \$2371 \$2347 VDD VDD sg13_lv_pmos L=0.13u W=1.12u AS=0.3864p
+ AD=0.431025p PS=2.93u PD=2.145u rfmode=0
M$5634 VDD CLK \$2347 VDD sg13_lv_pmos L=0.13u W=1.12u AS=0.431025p AD=0.3808p
+ PS=2.145u PD=2.92u rfmode=0
M$5635 \$2458 \$2436 VDD VDD sg13_lv_pmos L=0.13u W=1.12u AS=0.3864p
+ AD=0.431025p PS=2.93u PD=2.145u rfmode=0
M$5636 VDD CLK \$2436 VDD sg13_lv_pmos L=0.13u W=1.12u AS=0.431025p AD=0.3808p
+ PS=2.145u PD=2.92u rfmode=0
M$5637 VDD \$2421 \$2415 VDD sg13_lv_pmos L=0.13u W=1.12u AS=0.431025p
+ AD=0.3864p PS=2.145u PD=2.93u rfmode=0
M$5638 VDD CLK \$2421 VDD sg13_lv_pmos L=0.13u W=1.12u AS=0.431025p AD=0.3808p
+ PS=2.145u PD=2.92u rfmode=0
M$5639 \$2368 \$2371 \$2383 VDD sg13_lv_pmos L=0.13u W=0.42u AS=0.19115p
+ AD=0.0525p PS=1.565u PD=0.67u rfmode=0
M$5640 \$2383 \$2372 VDD VDD sg13_lv_pmos L=0.13u W=0.42u AS=0.0525p
+ AD=0.25605p PS=0.67u PD=1.935u rfmode=0
M$5641 VDD VDD \$2372 VDD sg13_lv_pmos L=0.13u W=0.42u AS=0.25605p AD=0.0798p
+ PS=1.935u PD=0.8u rfmode=0
M$5642 VDD \$2368 \$2372 VDD sg13_lv_pmos L=0.13u W=0.42u AS=0.2014p AD=0.0798p
+ PS=1.53u PD=0.8u rfmode=0
M$5643 VDD \$2368 \$2356 VDD sg13_lv_pmos L=0.13u W=1u AS=0.2083p AD=0.34p
+ PS=1.5u PD=2.68u rfmode=0
M$5644 VDD \$2368 \$2355 VDD sg13_lv_pmos L=0.13u W=2.24u AS=0.4142p AD=0.4211p
+ PS=3.03u PD=3u rfmode=0
M$5646 \$2346 \$2347 \$2368 VDD sg13_lv_pmos L=0.13u W=1u AS=0.34p AD=0.19115p
+ PS=2.68u PD=1.565u rfmode=0
M$5647 \$2324 \$2327 \$2338 VDD sg13_lv_pmos L=0.13u W=1u AS=0.34p AD=0.19115p
+ PS=2.68u PD=1.565u rfmode=0
M$5648 \$2338 \$2326 \$2342 VDD sg13_lv_pmos L=0.13u W=0.42u AS=0.19115p
+ AD=0.0525p PS=1.565u PD=0.67u rfmode=0
M$5649 VDD \$2328 \$2342 VDD sg13_lv_pmos L=0.13u W=0.42u AS=0.25605p
+ AD=0.0525p PS=1.935u PD=0.67u rfmode=0
M$5650 VDD VDD \$2328 VDD sg13_lv_pmos L=0.13u W=0.42u AS=0.25605p AD=0.0798p
+ PS=1.935u PD=0.8u rfmode=0
M$5651 VDD \$2338 \$2328 VDD sg13_lv_pmos L=0.13u W=0.42u AS=0.2014p AD=0.0798p
+ PS=1.53u PD=0.8u rfmode=0
M$5652 VDD \$2338 \$2314 VDD sg13_lv_pmos L=0.13u W=2.24u AS=0.4142p AD=0.4211p
+ PS=3.03u PD=3u rfmode=0
M$5654 VDD \$2338 \$2329 VDD sg13_lv_pmos L=0.13u W=1u AS=0.2083p AD=0.34p
+ PS=1.5u PD=2.68u rfmode=0
M$5655 \$2442 \$2458 \$2460 VDD sg13_lv_pmos L=0.13u W=0.42u AS=0.19115p
+ AD=0.0525p PS=1.565u PD=0.67u rfmode=0
M$5656 \$2460 \$2450 VDD VDD sg13_lv_pmos L=0.13u W=0.42u AS=0.0525p
+ AD=0.25605p PS=0.67u PD=1.935u rfmode=0
M$5657 VDD VDD \$2450 VDD sg13_lv_pmos L=0.13u W=0.42u AS=0.25605p AD=0.0798p
+ PS=1.935u PD=0.8u rfmode=0
M$5658 VDD \$2442 \$2450 VDD sg13_lv_pmos L=0.13u W=0.42u AS=0.2014p AD=0.0798p
+ PS=1.53u PD=0.8u rfmode=0
M$5659 VDD \$2442 \$2438 VDD sg13_lv_pmos L=0.13u W=1u AS=0.2083p AD=0.34p
+ PS=1.5u PD=2.68u rfmode=0
M$5660 VDD \$2442 \$2437 VDD sg13_lv_pmos L=0.13u W=2.24u AS=0.4142p AD=0.4211p
+ PS=3.03u PD=3u rfmode=0
M$5662 \$2435 \$2436 \$2442 VDD sg13_lv_pmos L=0.13u W=1u AS=0.34p AD=0.19115p
+ PS=2.68u PD=1.565u rfmode=0
M$5663 \$2413 \$2421 \$2422 VDD sg13_lv_pmos L=0.13u W=1u AS=0.34p AD=0.19115p
+ PS=2.68u PD=1.565u rfmode=0
M$5664 \$2422 \$2415 \$2427 VDD sg13_lv_pmos L=0.13u W=0.42u AS=0.19115p
+ AD=0.0525p PS=1.565u PD=0.67u rfmode=0
M$5665 VDD \$2416 \$2427 VDD sg13_lv_pmos L=0.13u W=0.42u AS=0.25605p
+ AD=0.0525p PS=1.935u PD=0.67u rfmode=0
M$5666 VDD VDD \$2416 VDD sg13_lv_pmos L=0.13u W=0.42u AS=0.25605p AD=0.0798p
+ PS=1.935u PD=0.8u rfmode=0
M$5667 VDD \$2422 \$2416 VDD sg13_lv_pmos L=0.13u W=0.42u AS=0.2014p AD=0.0798p
+ PS=1.53u PD=0.8u rfmode=0
M$5668 VDD \$2422 \$2403 VDD sg13_lv_pmos L=0.13u W=2.24u AS=0.4142p AD=0.4211p
+ PS=3.03u PD=3u rfmode=0
M$5670 VDD \$2422 \$2417 VDD sg13_lv_pmos L=0.13u W=1u AS=0.2083p AD=0.34p
+ PS=1.5u PD=2.68u rfmode=0
M$5671 VDD \$2329 \$2316 VDD sg13_lv_pmos L=0.13u W=2.24u AS=0.5964p AD=0.5964p
+ PS=4.425u PD=4.425u rfmode=0
M$5673 VDD \$2356 \$2357 VDD sg13_lv_pmos L=0.13u W=2.24u AS=0.5964p AD=0.5964p
+ PS=4.425u PD=4.425u rfmode=0
M$5675 VDD \$2417 \$2411 VDD sg13_lv_pmos L=0.13u W=2.24u AS=0.5964p AD=0.5964p
+ PS=4.425u PD=4.425u rfmode=0
M$5677 VDD \$2438 \$2443 VDD sg13_lv_pmos L=0.13u W=2.24u AS=0.5964p AD=0.5964p
+ PS=4.425u PD=4.425u rfmode=0
.ENDS CS_DAC_10b

.SUBCKT sg13g2_IOPadIn \$1 pad iovss iovss$1 iovdd vdd vss p2c
X$1 \$1 iovss pad pad sg13g2_DCNDiode
X$2 \$1 iovss$1 pad iovdd vss p2c vdd sg13g2_LevelDown
X$3 \$1 iovss$1 iovdd pad pad sg13g2_DCPDiode
R$1 vss \$1 ptap1 A=21.981p P=147.74u
R$3 iovss$1 \$1 ptap1 A=5379.0466p P=677.04u
.ENDS sg13g2_IOPadIn

.SUBCKT sg13g2_IOPadVss \$1 vss iovss iovss$1 iovdd
X$1 \$1 iovss vss vss sg13g2_DCNDiode
X$2 \$1 iovss$1 iovdd vss vss sg13g2_DCPDiode
R$1 vss \$1 ptap1 A=24p P=160.6u
R$2 iovss$1 \$1 ptap1 A=5379.0466p P=677.04u
.ENDS sg13g2_IOPadVss

.SUBCKT sg13g2_IOPadVdd \$1 vdd iovss iovss$1 vss
X$1 \$1 iovss vdd vdd vdd vdd vdd vdd vdd vdd vdd vdd vdd vdd vdd vdd vdd vdd
+ vdd vdd vdd vdd vdd vdd \$10 sg13g2_Clamp_N43N43D4R
X$3 \$1 iovss$1 vdd \$10 vdd sg13g2_RCClampInverter
R$1 iovss$1 \$1 ptap1 A=1997.6623p P=411.58u
R$2 vss \$1 ptap1 A=24p P=160.6u
.ENDS sg13g2_IOPadVdd

.SUBCKT sg13g2_IOPadIOVss \$1 iovss iovdd vss
X$1 \$1 iovss iovss iovss sg13g2_DCNDiode
X$2 \$1 iovss iovdd iovss iovss sg13g2_DCPDiode
R$1 vss \$1 ptap1 A=24p P=160.6u
R$2 iovss \$1 ptap1 A=5379.0466p P=677.04u
.ENDS sg13g2_IOPadIOVss

.SUBCKT sg13g2_IOPadIOVdd \$1 iovdd iovss iovss$1 vss
X$2 \$1 iovss iovdd iovdd iovdd iovdd iovdd iovdd iovdd iovdd iovdd iovdd iovdd
+ iovdd iovdd iovdd iovdd iovdd iovdd iovdd iovdd iovdd iovdd iovdd \$7
+ sg13g2_Clamp_N43N43D4R
X$3 \$1 iovss$1 iovdd \$7 iovdd sg13g2_RCClampInverter
R$1 iovss$1 \$1 ptap1 A=1997.9154p P=411.58u
R$2 vss \$1 ptap1 A=24p P=160.6u
.ENDS sg13g2_IOPadIOVdd

.SUBCKT sg13g2_Filler200 \$1 iovss iovss$1 iovss$2 vss
R$1 vss \$1 ptap1 A=0.678p P=5.12u
R$2 iovss$2 \$1 ptap1 A=13.748p P=50.22u
R$3 iovss \$1 ptap1 A=13.7536p P=50.24u
R$4 iovss$1 \$1 ptap1 A=13.4736p P=49.24u
.ENDS sg13g2_Filler200

.SUBCKT sg13g2_Filler400 \$1 iovss iovss$1 iovss$2 vss
R$1 iovss$1 \$1 ptap1 A=37.5336p P=51.24u
R$2 iovss$2 \$1 ptap1 A=38.298p P=52.22u
R$3 iovss \$1 ptap1 A=38.3136p P=52.24u
R$4 vss \$1 ptap1 A=0.672p P=5.08u
.ENDS sg13g2_Filler400

.SUBCKT sg13g2_Filler1000 \$1 iovss iovss$1 iovss$2 vss
R$1 iovss$1 \$1 ptap1 A=108.27p P=57.12u
R$2 vss \$1 ptap1 A=1.368p P=9.72u
R$3 iovss \$1 ptap1 A=110.52p P=58.12u
R$4 iovss$2 \$1 ptap1 A=110.475p P=58.1u
.ENDS sg13g2_Filler1000

.SUBCKT sg13g2_Filler4000 \$1 iovss iovss$1 iovss$2 vss
R$1 vss \$1 ptap1 A=5.85p P=39.6u
R$2 iovss$2 \$1 ptap1 A=478.725p P=88.1u
R$3 iovss \$1 ptap1 A=478.92p P=88.12u
R$4 iovss$1 \$1 ptap1 A=469.17p P=87.12u
.ENDS sg13g2_Filler4000

.SUBCKT sg13g2_IOPadOut30mA \$1 pad iovss iovdd iovdd$1 vdd vss c2p
X$1 iovdd$1 vdd vss \$27 \$5 c2p \$1 sg13g2_GateLevelUpInv
X$2 \$1 iovss pad pad sg13g2_DCNDiode
X$3 \$1 iovss pad pad pad pad pad pad pad pad \$5 sg13g2_Clamp_N15N15D
X$4 \$1 iovss iovdd pad pad sg13g2_DCPDiode
X$5 \$1 iovss iovdd pad pad pad pad pad pad pad pad \$27 sg13g2_Clamp_P15N15D
R$1 iovss \$1 ptap1 A=4319.178p P=671.66u
R$2 vss \$1 ptap1 A=24p P=160.6u
.ENDS sg13g2_IOPadOut30mA

.SUBCKT sg13g2_IOPadAnalog \$1 pad iovss iovdd iovdd$1 vss padres
X$1 \$1 iovss pad pad sg13g2_DCNDiode
X$2 \$1 iovss pad pad pad pad pad pad pad pad pad pad sg13g2_Clamp_N20N0D
X$3 \$1 iovss iovdd pad pad sg13g2_DCPDiode
X$4 \$1 iovss iovdd pad pad pad pad pad pad pad pad pad pad sg13g2_Clamp_P20N0D
X$5 \$1 iovss padres pad iovdd$1 sg13g2_SecondaryProtection
R$1 iovss \$1 ptap1 A=4273.4p P=593.62u
R$2 vss \$1 ptap1 A=23.85p P=159.6u
.ENDS sg13g2_IOPadAnalog

.SUBCKT sg13g2_LevelDown \$1 iovss pad iovdd vss core vdd
X$1 \$1 iovss \$11 pad iovdd sg13g2_SecondaryProtection
M$1 core \$21 vss \$1 sg13_lv_nmos L=0.13u W=2.75u AS=0.935p AD=0.935p PS=6.18u
+ PD=6.18u rfmode=0
M$2 vss \$8 \$21 \$1 sg13_hv_nmos L=0.45u W=2.65u AS=0.901p AD=0.5035p PS=5.98u
+ PD=3.03u rfmode=0
M$3 \$21 \$7 vdd \$1 sg13_hv_nmos L=0.45u W=2.65u AS=0.5035p AD=0.901p PS=3.03u
+ PD=5.98u rfmode=0
M$4 \$7 \$11 iovss \$1 sg13_hv_nmos L=0.45u W=1.3u AS=0.442p AD=0.247p PS=3.28u
+ PD=1.68u rfmode=0
M$5 iovss \$7 \$8 \$1 sg13_hv_nmos L=0.45u W=1.3u AS=0.247p AD=0.442p PS=1.68u
+ PD=3.28u rfmode=0
M$6 core \$21 vdd vdd sg13_lv_pmos L=0.13u W=4.75u AS=1.615p AD=1.615p
+ PS=10.18u PD=10.18u rfmode=0
M$7 vdd vdd vdd vdd sg13_hv_pmos L=0.45u W=4.65u AS=1.581p AD=1.581p PS=9.98u
+ PD=9.98u rfmode=0
M$8 iovdd \$11 \$7 iovdd sg13_hv_pmos L=0.45u W=4.6u AS=1.219p AD=0.874p
+ PS=7.96u PD=5.36u rfmode=0
M$10 iovdd \$7 \$8 iovdd sg13_hv_pmos L=0.45u W=4.6u AS=0.874p AD=1.219p
+ PS=5.36u PD=7.96u rfmode=0
R$12 vss \$1 ptap1 A=2.019p P=14.06u
R$13 iovss \$1 ptap1 A=0.804p P=5.96u
.ENDS sg13g2_LevelDown

.SUBCKT sg13g2_Clamp_N43N43D4R \$2 iovss pad pad$1 pad$2 pad$3 pad$4 pad$5
+ pad$6 pad$7 pad$8 pad$9 pad$10 pad$11 pad$12 pad$13 pad$14 pad$15 pad$16
+ pad$17 pad$18 pad$19 pad$20 pad$21 gate
M$1 iovss gate pad \$2 sg13_hv_nmos L=0.6u W=35.2u AS=18.656p AD=16.016p
+ PS=61.28u PD=42.48u rfmode=0
M$3 iovss gate pad$1 \$2 sg13_hv_nmos L=0.6u W=35.2u AS=16.016p AD=16.016p
+ PS=42.48u PD=42.48u rfmode=0
M$5 iovss gate pad$2 \$2 sg13_hv_nmos L=0.6u W=35.2u AS=16.016p AD=16.016p
+ PS=42.48u PD=42.48u rfmode=0
M$7 iovss gate pad$3 \$2 sg13_hv_nmos L=0.6u W=35.2u AS=16.016p AD=16.016p
+ PS=42.48u PD=42.48u rfmode=0
M$9 iovss gate pad$4 \$2 sg13_hv_nmos L=0.6u W=35.2u AS=16.016p AD=16.016p
+ PS=42.48u PD=42.48u rfmode=0
M$11 iovss gate pad$5 \$2 sg13_hv_nmos L=0.6u W=35.2u AS=16.016p AD=16.016p
+ PS=42.48u PD=42.48u rfmode=0
M$13 iovss gate pad$6 \$2 sg13_hv_nmos L=0.6u W=35.2u AS=16.016p AD=16.016p
+ PS=42.48u PD=42.48u rfmode=0
M$15 iovss gate pad$7 \$2 sg13_hv_nmos L=0.6u W=35.2u AS=16.016p AD=16.016p
+ PS=42.48u PD=42.48u rfmode=0
M$17 iovss gate pad$8 \$2 sg13_hv_nmos L=0.6u W=35.2u AS=16.016p AD=16.016p
+ PS=42.48u PD=42.48u rfmode=0
M$19 iovss gate pad$9 \$2 sg13_hv_nmos L=0.6u W=35.2u AS=16.016p AD=16.016p
+ PS=42.48u PD=42.48u rfmode=0
M$21 iovss gate pad$10 \$2 sg13_hv_nmos L=0.6u W=35.2u AS=16.016p AD=16.016p
+ PS=42.48u PD=42.48u rfmode=0
M$23 iovss gate pad$11 \$2 sg13_hv_nmos L=0.6u W=35.2u AS=16.016p AD=16.016p
+ PS=42.48u PD=42.48u rfmode=0
M$25 iovss gate pad$12 \$2 sg13_hv_nmos L=0.6u W=35.2u AS=16.016p AD=16.016p
+ PS=42.48u PD=42.48u rfmode=0
M$27 iovss gate pad$13 \$2 sg13_hv_nmos L=0.6u W=35.2u AS=16.016p AD=16.016p
+ PS=42.48u PD=42.48u rfmode=0
M$29 iovss gate pad$14 \$2 sg13_hv_nmos L=0.6u W=35.2u AS=16.016p AD=16.016p
+ PS=42.48u PD=42.48u rfmode=0
M$31 iovss gate pad$15 \$2 sg13_hv_nmos L=0.6u W=35.2u AS=16.016p AD=16.016p
+ PS=42.48u PD=42.48u rfmode=0
M$33 iovss gate pad$16 \$2 sg13_hv_nmos L=0.6u W=35.2u AS=16.016p AD=16.016p
+ PS=42.48u PD=42.48u rfmode=0
M$35 iovss gate pad$17 \$2 sg13_hv_nmos L=0.6u W=35.2u AS=16.016p AD=16.016p
+ PS=42.48u PD=42.48u rfmode=0
M$37 iovss gate pad$18 \$2 sg13_hv_nmos L=0.6u W=35.2u AS=16.016p AD=16.016p
+ PS=42.48u PD=42.48u rfmode=0
M$39 iovss gate pad$19 \$2 sg13_hv_nmos L=0.6u W=35.2u AS=16.016p AD=16.016p
+ PS=42.48u PD=42.48u rfmode=0
M$41 iovss gate pad$20 \$2 sg13_hv_nmos L=0.6u W=35.2u AS=16.016p AD=16.016p
+ PS=42.48u PD=42.48u rfmode=0
M$43 iovss gate pad$21 \$2 sg13_hv_nmos L=0.6u W=17.6u AS=5.632p AD=13.024p
+ PS=20.16u PD=41.12u rfmode=0
D$173 \$2 gate dantenna A=0.2304p P=1.92u m=1
R$174 iovss \$2 ptap1 A=65.6472p P=386.16u
.ENDS sg13g2_Clamp_N43N43D4R

.SUBCKT sg13g2_RCClampInverter \$1 iovss in out supply
M$1 iovss in iovss \$1 sg13_hv_nmos L=9.5u W=126u AS=26.64p AD=23.94p
+ PS=149.92u PD=131.32u rfmode=0
M$8 iovss in out \$1 sg13_hv_nmos L=0.5u W=108u AS=20.52p AD=23.22p PS=112.56u
+ PD=131.16u rfmode=0
M$27 supply in out supply sg13_hv_pmos L=0.5u W=350u AS=67.55p AD=67.55p
+ PS=376.3u PD=376.3u rfmode=0
R$77 iovss \$1 ptap1 A=69.122p P=406.6u
.ENDS sg13g2_RCClampInverter

.SUBCKT sg13g2_GateLevelUpInv iovdd vdd vss pgate ngate core \$7
X$1 iovdd ngate \$7 core vss vdd sg13g2_LevelUpInv
X$2 iovdd pgate \$7 core vss vdd sg13g2_LevelUpInv
.ENDS sg13g2_GateLevelUpInv

.SUBCKT sg13g2_Clamp_N15N15D \$2 iovss pad pad$1 pad$2 pad$3 pad$4 pad$5 pad$6
+ pad$7 gate
M$1 iovss gate pad \$2 sg13_hv_nmos L=0.6u W=8.8u AS=4.664p AD=4.004p PS=15.32u
+ PD=10.62u rfmode=0
M$3 iovss gate pad$1 \$2 sg13_hv_nmos L=0.6u W=8.8u AS=4.004p AD=4.004p
+ PS=10.62u PD=10.62u rfmode=0
M$5 iovss gate pad$2 \$2 sg13_hv_nmos L=0.6u W=8.8u AS=4.004p AD=4.004p
+ PS=10.62u PD=10.62u rfmode=0
M$7 iovss gate pad$3 \$2 sg13_hv_nmos L=0.6u W=8.8u AS=4.004p AD=4.004p
+ PS=10.62u PD=10.62u rfmode=0
M$9 iovss gate pad$4 \$2 sg13_hv_nmos L=0.6u W=8.8u AS=4.004p AD=4.004p
+ PS=10.62u PD=10.62u rfmode=0
M$11 iovss gate pad$5 \$2 sg13_hv_nmos L=0.6u W=8.8u AS=4.004p AD=4.004p
+ PS=10.62u PD=10.62u rfmode=0
M$13 iovss gate pad$6 \$2 sg13_hv_nmos L=0.6u W=8.8u AS=4.004p AD=4.004p
+ PS=10.62u PD=10.62u rfmode=0
M$15 iovss gate pad$7 \$2 sg13_hv_nmos L=0.6u W=4.4u AS=1.408p AD=3.256p
+ PS=5.04u PD=10.28u rfmode=0
D$16 \$2 gate dantenna A=0.6084p P=3.12u m=1
R$17 iovss \$2 ptap1 A=55.7736p P=328.08u
.ENDS sg13g2_Clamp_N15N15D

.SUBCKT sg13g2_Clamp_P15N15D \$1 iovss iovdd pad pad$1 pad$2 pad$3 pad$4 pad$5
+ pad$6 pad$7 gate
M$1 iovdd gate pad iovdd sg13_hv_pmos L=0.6u W=26.64u AS=14.1192p AD=12.1212p
+ PS=44.2u PD=30.28u rfmode=0
M$3 iovdd gate pad$1 iovdd sg13_hv_pmos L=0.6u W=26.64u AS=12.1212p AD=12.1212p
+ PS=30.28u PD=30.28u rfmode=0
M$5 iovdd gate pad$2 iovdd sg13_hv_pmos L=0.6u W=26.64u AS=12.1212p AD=12.1212p
+ PS=30.28u PD=30.28u rfmode=0
M$7 iovdd gate pad$3 iovdd sg13_hv_pmos L=0.6u W=26.64u AS=12.1212p AD=12.1212p
+ PS=30.28u PD=30.28u rfmode=0
M$9 iovdd gate pad$4 iovdd sg13_hv_pmos L=0.6u W=26.64u AS=12.1212p AD=12.1212p
+ PS=30.28u PD=30.28u rfmode=0
M$11 iovdd gate pad$5 iovdd sg13_hv_pmos L=0.6u W=26.64u AS=12.1212p
+ AD=12.1212p PS=30.28u PD=30.28u rfmode=0
M$13 iovdd gate pad$6 iovdd sg13_hv_pmos L=0.6u W=26.64u AS=12.1212p
+ AD=12.1212p PS=30.28u PD=30.28u rfmode=0
M$15 iovdd gate pad$7 iovdd sg13_hv_pmos L=0.6u W=13.32u AS=4.2624p AD=9.8568p
+ PS=14.6u PD=29.6u rfmode=0
D$31 gate iovdd dpantenna A=0.6084p P=3.12u m=1
R$32 iovss \$1 ptap1 A=67.0344p P=394.32u
.ENDS sg13g2_Clamp_P15N15D

.SUBCKT sg13g2_Clamp_N20N0D \$2 iovss pad pad$1 pad$2 pad$3 pad$4 pad$5 pad$6
+ pad$7 pad$8 pad$9
M$1 iovss \$4 pad \$2 sg13_hv_nmos L=0.6u W=8.8u AS=4.664p AD=4.004p PS=15.32u
+ PD=10.62u rfmode=0
M$3 iovss \$4 pad$1 \$2 sg13_hv_nmos L=0.6u W=8.8u AS=4.004p AD=4.004p
+ PS=10.62u PD=10.62u rfmode=0
M$5 iovss \$4 pad$2 \$2 sg13_hv_nmos L=0.6u W=8.8u AS=4.004p AD=4.004p
+ PS=10.62u PD=10.62u rfmode=0
M$7 iovss \$4 pad$3 \$2 sg13_hv_nmos L=0.6u W=8.8u AS=4.004p AD=4.004p
+ PS=10.62u PD=10.62u rfmode=0
M$9 iovss \$4 pad$4 \$2 sg13_hv_nmos L=0.6u W=8.8u AS=4.004p AD=4.004p
+ PS=10.62u PD=10.62u rfmode=0
M$11 iovss \$4 pad$5 \$2 sg13_hv_nmos L=0.6u W=8.8u AS=4.004p AD=4.004p
+ PS=10.62u PD=10.62u rfmode=0
M$13 iovss \$4 pad$6 \$2 sg13_hv_nmos L=0.6u W=8.8u AS=4.004p AD=4.004p
+ PS=10.62u PD=10.62u rfmode=0
M$15 iovss \$4 pad$7 \$2 sg13_hv_nmos L=0.6u W=8.8u AS=4.004p AD=4.004p
+ PS=10.62u PD=10.62u rfmode=0
M$17 iovss \$4 pad$8 \$2 sg13_hv_nmos L=0.6u W=8.8u AS=4.004p AD=4.004p
+ PS=10.62u PD=10.62u rfmode=0
M$19 iovss \$4 pad$9 \$2 sg13_hv_nmos L=0.6u W=8.8u AS=4.004p AD=4.664p
+ PS=10.62u PD=15.32u rfmode=0
R$21 iovss \$4 \$2 rppd w=0.5u l=3.54u ps=0u b=0 m=1
R$22 iovss \$2 ptap1 A=55.7736p P=328.08u
.ENDS sg13g2_Clamp_N20N0D

.SUBCKT sg13g2_Clamp_P20N0D \$1 iovss iovdd pad pad$1 pad$2 pad$3 pad$4 pad$5
+ pad$6 pad$7 pad$8 pad$9
M$1 iovdd \$6 pad iovdd sg13_hv_pmos L=0.6u W=26.64u AS=14.1192p AD=12.1212p
+ PS=44.2u PD=30.28u rfmode=0
M$3 iovdd \$6 pad$1 iovdd sg13_hv_pmos L=0.6u W=26.64u AS=12.1212p AD=12.1212p
+ PS=30.28u PD=30.28u rfmode=0
M$5 iovdd \$6 pad$2 iovdd sg13_hv_pmos L=0.6u W=26.64u AS=12.1212p AD=12.1212p
+ PS=30.28u PD=30.28u rfmode=0
M$7 iovdd \$6 pad$3 iovdd sg13_hv_pmos L=0.6u W=26.64u AS=12.1212p AD=12.1212p
+ PS=30.28u PD=30.28u rfmode=0
M$9 iovdd \$6 pad$4 iovdd sg13_hv_pmos L=0.6u W=26.64u AS=12.1212p AD=12.1212p
+ PS=30.28u PD=30.28u rfmode=0
M$11 iovdd \$6 pad$5 iovdd sg13_hv_pmos L=0.6u W=26.64u AS=12.1212p AD=12.1212p
+ PS=30.28u PD=30.28u rfmode=0
M$13 iovdd \$6 pad$6 iovdd sg13_hv_pmos L=0.6u W=26.64u AS=12.1212p AD=12.1212p
+ PS=30.28u PD=30.28u rfmode=0
M$15 iovdd \$6 pad$7 iovdd sg13_hv_pmos L=0.6u W=26.64u AS=12.1212p AD=12.1212p
+ PS=30.28u PD=30.28u rfmode=0
M$17 iovdd \$6 pad$8 iovdd sg13_hv_pmos L=0.6u W=26.64u AS=12.1212p AD=12.1212p
+ PS=30.28u PD=30.28u rfmode=0
M$19 iovdd \$6 pad$9 iovdd sg13_hv_pmos L=0.6u W=26.64u AS=12.1212p AD=14.1192p
+ PS=30.28u PD=44.2u rfmode=0
R$41 iovdd \$6 iovdd rppd w=0.5u l=12.9u ps=0u b=0 m=1
R$42 iovss \$1 ptap1 A=67.0344p P=394.32u
.ENDS sg13g2_Clamp_P20N0D

.SUBCKT sg13g2_DCNDiode \$2 anode cathode cathode$1
D$1 \$2 cathode$1 dantenna A=35.0028p P=58.08u m=1
D$2 \$2 cathode dantenna A=35.0028p P=58.08u m=1
R$3 anode \$2 ptap1 A=141.2964p P=221.76u
.ENDS sg13g2_DCNDiode

.SUBCKT sg13g2_DCPDiode \$1 guard cathode anode anode$1
D$1 anode$1 cathode dpantenna A=35.0028p P=58.08u m=1
D$2 anode cathode dpantenna A=35.0028p P=58.08u m=1
R$3 guard \$1 ptap1 A=33.5104p P=197.12u
.ENDS sg13g2_DCPDiode

.SUBCKT sg13g2_LevelUpInv iovdd o \$5 i vss vdd
M$1 \$6 i vss \$5 sg13_lv_nmos L=0.13u W=2.75u AS=0.935p AD=0.935p PS=6.18u
+ PD=6.18u rfmode=0
M$2 \$3 i vss \$5 sg13_hv_nmos L=0.45u W=1.9u AS=0.646p AD=0.361p PS=4.48u
+ PD=2.28u rfmode=0
M$3 vss \$6 \$4 \$5 sg13_hv_nmos L=0.45u W=1.9u AS=0.361p AD=0.646p PS=2.28u
+ PD=4.48u rfmode=0
M$4 vss \$4 o \$5 sg13_hv_nmos L=0.45u W=1.9u AS=0.646p AD=0.646p PS=4.48u
+ PD=4.48u rfmode=0
M$5 \$6 i vdd vdd sg13_lv_pmos L=0.13u W=4.75u AS=1.615p AD=1.615p PS=10.18u
+ PD=10.18u rfmode=0
M$6 \$3 \$4 iovdd iovdd sg13_hv_pmos L=0.45u W=0.3u AS=0.102p AD=0.057p
+ PS=1.28u PD=0.68u rfmode=0
M$7 iovdd \$3 \$4 iovdd sg13_hv_pmos L=0.45u W=0.3u AS=0.057p AD=0.102p
+ PS=0.68u PD=1.28u rfmode=0
M$8 iovdd \$4 o iovdd sg13_hv_pmos L=0.45u W=3.9u AS=1.326p AD=1.326p PS=8.48u
+ PD=8.48u rfmode=0
R$9 vss \$5 ptap1 A=1.053p P=7.62u
.ENDS sg13g2_LevelUpInv

.SUBCKT sg13g2_SecondaryProtection \$1 minus core pad plus
D$1 \$1 core dantenna A=1.984p P=7.48u m=1
D$2 core plus dpantenna A=3.1872p P=11.24u m=1
R$3 pad core \$1 rppd w=1u l=2u ps=0u b=0 m=1
R$4 minus \$1 ptap1 A=9.0304p P=53.12u
.ENDS sg13g2_SecondaryProtection
