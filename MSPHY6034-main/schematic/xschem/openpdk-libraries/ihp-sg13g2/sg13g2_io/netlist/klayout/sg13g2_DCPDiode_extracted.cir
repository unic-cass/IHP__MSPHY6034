* Extracted by KLayout with SG13G2 LVS runset on : 13/03/2026 09:19

.SUBCKT sg13g2_DCPDiode guard cathode anode1 anode2
D$1 anode2 cathode dpantenna A=35.0028p P=58.08u m=1
D$2 anode1 cathode dpantenna A=35.0028p P=58.08u m=1
R$3 \$1 guard ptap1 A=33.5104p P=197.12u
.ENDS sg13g2_DCPDiode
