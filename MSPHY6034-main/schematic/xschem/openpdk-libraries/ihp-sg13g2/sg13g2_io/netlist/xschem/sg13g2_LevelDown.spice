** sch_path: /home/designer/shared/ihp2603/openpdk-libraries/ihp-sg13g2/sg13g2_io/xschem/sg13g2_LevelDown.sch
.subckt sg13g2_LevelDown iovdd iovss pad core vdd vss !
*.PININFO iovdd:B vss:B core:B pad:B vdd:B iovss:B !:B
R1 vss ! ptap1 A=2.019p P=14.06u
MM5 net2 net1 vdd vdd sg13_hv_pmos w=4.65u l=0.45u ng=1 m=1
MM6 net2 net1 vss ! sg13_hv_nmos w=2.65u l=0.45u ng=1 m=1
MM7 core net2 vss ! sg13_lv_nmos w=2.75u l=0.13u ng=1 m=1
MM8 core net2 vdd vdd sg13_lv_pmos w=4.75u l=0.13u ng=1 m=1
x1 net1 iovdd iovss pad ! sg13g2_SecondaryProtection
.ends

* expanding   symbol:  sg13g2_SecondaryProtection.sym # of pins=5
** sym_path: /home/designer/shared/ihp2603/openpdk-libraries/ihp-sg13g2/sg13g2_io/xschem/sg13g2_SecondaryProtection.sym
** sch_path: /home/designer/shared/ihp2603/openpdk-libraries/ihp-sg13g2/sg13g2_io/xschem/sg13g2_SecondaryProtection.sch
.subckt sg13g2_SecondaryProtection core iovdd iovss pad !
*.PININFO iovss:B core:B pad:B iovdd:B !:B
R1 iovss ! ptap1 A=9.0304p P=53.12u
DD1 core iovdd dpantenna l=4.98u w=0.64u
DD2 ! core dantenna l=3.1u w=0.64u
RR3 pad core $SUB=sub! $[rppd] w=1e-6 l=2e-6 b=0 m=1
.ends
