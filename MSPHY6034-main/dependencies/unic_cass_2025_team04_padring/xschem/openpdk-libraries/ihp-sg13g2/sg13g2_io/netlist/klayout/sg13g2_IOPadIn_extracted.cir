* Extracted by KLayout with SG13G2 LVS runset on : 13/03/2026 18:41

.SUBCKT sg13g2_IOPadIn pad iovss iovss1 iovdd vdd vss p2c
X$1 \$1 iovss pad pad sg13g2_DCNDiode
X$2 \$1 pad iovdd vss p2c vdd sg13g2_LevelDown_noptap
X$3 iovdd pad pad sg13g2_DCPDiode_noptap
R$1 \$1 vss ptap1 A=24p P=160.6u
R$2 \$1 iovss1 ptap1 A=5416.1304p P=746.28u
.ENDS sg13g2_IOPadIn

.SUBCKT sg13g2_LevelDown_noptap \$1 pad iovdd vss core vdd
X$1 \$1 \$10 pad iovdd sg13g2_SecondaryProtection_noptap
M$1 core \$7 vss \$1 sg13_lv_nmos L=0.13u W=2.75u AS=0.935p AD=0.935p PS=6.18u
+ PD=6.18u
M$2 vss \$10 \$7 \$1 sg13_hv_nmos L=0.45u W=2.65u AS=0.901p AD=0.901p PS=5.98u
+ PD=5.98u
M$3 core \$7 vdd vdd sg13_lv_pmos L=0.13u W=4.75u AS=1.615p AD=1.615p PS=10.18u
+ PD=10.18u
M$4 vdd \$10 \$7 vdd sg13_hv_pmos L=0.45u W=4.65u AS=1.581p AD=1.581p PS=9.98u
+ PD=9.98u
.ENDS sg13g2_LevelDown_noptap

.SUBCKT sg13g2_DCNDiode \$2 anode cathode1 cathode2
D$1 \$2 cathode2 dantenna A=35.0028p P=58.08u m=1
D$2 \$2 cathode1 dantenna A=35.0028p P=58.08u m=1
R$3 \$2 anode ptap1 A=141.2964p P=221.76u
.ENDS sg13g2_DCNDiode

.SUBCKT sg13g2_DCPDiode_noptap cathode anode1 anode2
D$1 anode2 cathode dpantenna A=35.0028p P=58.08u m=1
D$2 anode1 cathode dpantenna A=35.0028p P=58.08u m=1
.ENDS sg13g2_DCPDiode_noptap

.SUBCKT sg13g2_SecondaryProtection_noptap \$1 core pad iovdd
D$1 \$1 core dantenna A=1.984p P=7.48u m=1
D$2 core iovdd dpantenna A=3.1872p P=11.24u m=1
R$3 pad core rppd w=1u l=2u ps=0 b=0 m=1
.ENDS sg13g2_SecondaryProtection_noptap
