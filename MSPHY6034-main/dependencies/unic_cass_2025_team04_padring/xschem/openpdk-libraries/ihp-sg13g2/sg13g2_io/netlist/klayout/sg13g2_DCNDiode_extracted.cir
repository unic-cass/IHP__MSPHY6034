* Extracted by KLayout with SG13G2 LVS runset on : 13/03/2026 09:18

.SUBCKT sg13g2_DCNDiode anode cathode1 cathode2
D$1 \$2 cathode2 dantenna A=35.0028p P=58.08u m=1
D$2 \$2 cathode1 dantenna A=35.0028p P=58.08u m=1
R$3 \$2 anode ptap1 A=141.2964p P=221.76u
.ENDS sg13g2_DCNDiode
