* Extracted by KLayout with SG13G2 LVS runset on : 13/03/2026 08:47

.SUBCKT sg13g2_IOPadOut4mA pad iovss iovdd iovdd1 vdd vss c2p
X$1 iovdd1 vdd vss \$15 \$5 c2p \$1 sg13g2_GateLevelUpInv_noptap
X$2 \$1 iovss pad pad sg13g2_DCNDiode
X$3 \$1 iovss \$5 pad sg13g2_Clamp_N2N2D
X$4 iovdd pad pad sg13g2_DCPDiode_noptap
X$5 iovdd pad \$15 sg13g2_Clamp_P2N2D_noptap
R$1 \$1 iovss ptap1 A=4413.9448p P=953.3u
R$2 \$1 vss ptap1 A=24p P=160.6u
.ENDS sg13g2_IOPadOut4mA

.SUBCKT sg13g2_GateLevelUpInv_noptap iovdd vdd vss pgate ngate core \$7
X$1 iovdd pgate \$7 core vss vdd sg13g2_LevelUpInv_noptap
X$2 iovdd ngate \$7 core vss vdd sg13g2_LevelUpInv_noptap
.ENDS sg13g2_GateLevelUpInv_noptap

.SUBCKT sg13g2_Clamp_N2N2D \$2 iovss gate pad
M$1 iovss gate pad \$2 sg13_hv_nmos L=0.6u W=8.8u AS=4.664p AD=4.664p PS=15.32u
+ PD=15.32u
D$3 \$2 gate dantenna A=0.6084p P=3.12u m=1
R$4 \$2 iovss ptap1 A=55.7736p P=328.08u
.ENDS sg13g2_Clamp_N2N2D

.SUBCKT sg13g2_Clamp_P2N2D_noptap iovdd pad gate
M$1 iovdd gate pad iovdd sg13_hv_pmos L=0.6u W=26.64u AS=14.1192p AD=14.1192p
+ PS=44.2u PD=44.2u
D$5 gate iovdd dpantenna A=0.2304p P=1.92u m=1
.ENDS sg13g2_Clamp_P2N2D_noptap

.SUBCKT sg13g2_DCNDiode \$2 anode cathode1 cathode2
D$1 \$2 cathode2 dantenna A=35.0028p P=58.08u m=1
D$2 \$2 cathode1 dantenna A=35.0028p P=58.08u m=1
R$3 \$2 anode ptap1 A=141.2964p P=221.76u
.ENDS sg13g2_DCNDiode

.SUBCKT sg13g2_DCPDiode_noptap cathode anode1 anode2
D$1 anode2 cathode dpantenna A=35.0028p P=58.08u m=1
D$2 anode1 cathode dpantenna A=35.0028p P=58.08u m=1
.ENDS sg13g2_DCPDiode_noptap

.SUBCKT sg13g2_LevelUpInv_noptap iovdd o \$5 i vss vdd
M$1 \$6 i vss \$5 sg13_lv_nmos L=0.13u W=2.75u AS=0.935p AD=0.935p PS=6.18u
+ PD=6.18u
M$2 vss \$4 o \$5 sg13_hv_nmos L=0.45u W=1.9u AS=0.646p AD=0.646p PS=4.48u
+ PD=4.48u
M$3 \$3 i vss \$5 sg13_hv_nmos L=0.45u W=1.9u AS=0.646p AD=0.361p PS=4.48u
+ PD=2.28u
M$4 vss \$6 \$4 \$5 sg13_hv_nmos L=0.45u W=1.9u AS=0.361p AD=0.646p PS=2.28u
+ PD=4.48u
M$5 \$6 i vdd vdd sg13_lv_pmos L=0.13u W=4.75u AS=1.615p AD=1.615p PS=10.18u
+ PD=10.18u
M$6 iovdd \$4 o iovdd sg13_hv_pmos L=0.45u W=3.9u AS=1.326p AD=1.326p PS=8.48u
+ PD=8.48u
M$7 \$3 \$4 iovdd iovdd sg13_hv_pmos L=0.45u W=0.3u AS=0.102p AD=0.057p
+ PS=1.28u PD=0.68u
M$8 iovdd \$3 \$4 iovdd sg13_hv_pmos L=0.45u W=0.3u AS=0.057p AD=0.102p
+ PS=0.68u PD=1.28u
.ENDS sg13g2_LevelUpInv_noptap
