* Extracted by KLayout with SG13G2 LVS runset on : 13/03/2026 09:09

.SUBCKT sg13g2_Clamp_P20N0D iovss iovdd pad[0] pad[1] pad[2] pad[3] pad[4]
+ pad[5] pad[6] pad[7] pad[8] pad[9]
M$1 iovdd \$5 pad[0] iovdd sg13_hv_pmos L=0.6u W=26.64u AS=14.1192p AD=12.1212p
+ PS=44.2u PD=30.28u
M$3 iovdd \$5 pad[1] iovdd sg13_hv_pmos L=0.6u W=26.64u AS=12.1212p AD=12.1212p
+ PS=30.28u PD=30.28u
M$5 iovdd \$5 pad[2] iovdd sg13_hv_pmos L=0.6u W=26.64u AS=12.1212p AD=12.1212p
+ PS=30.28u PD=30.28u
M$7 iovdd \$5 pad[3] iovdd sg13_hv_pmos L=0.6u W=26.64u AS=12.1212p AD=12.1212p
+ PS=30.28u PD=30.28u
M$9 iovdd \$5 pad[4] iovdd sg13_hv_pmos L=0.6u W=26.64u AS=12.1212p AD=12.1212p
+ PS=30.28u PD=30.28u
M$11 iovdd \$5 pad[5] iovdd sg13_hv_pmos L=0.6u W=26.64u AS=12.1212p
+ AD=12.1212p PS=30.28u PD=30.28u
M$13 iovdd \$5 pad[6] iovdd sg13_hv_pmos L=0.6u W=26.64u AS=12.1212p
+ AD=12.1212p PS=30.28u PD=30.28u
M$15 iovdd \$5 pad[7] iovdd sg13_hv_pmos L=0.6u W=26.64u AS=12.1212p
+ AD=12.1212p PS=30.28u PD=30.28u
M$17 iovdd \$5 pad[8] iovdd sg13_hv_pmos L=0.6u W=26.64u AS=12.1212p
+ AD=12.1212p PS=30.28u PD=30.28u
M$19 iovdd \$5 pad[9] iovdd sg13_hv_pmos L=0.6u W=26.64u AS=12.1212p
+ AD=14.1192p PS=30.28u PD=44.2u
R$41 iovdd \$5 rppd w=0.5u l=12.9u ps=0 b=0 m=1
R$42 \$1 iovss ptap1 A=67.0344p P=394.32u
.ENDS sg13g2_Clamp_P20N0D
