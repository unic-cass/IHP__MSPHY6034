* Extracted by KLayout with SG13G2 LVS runset on : 13/03/2026 08:57

.SUBCKT sg13g2_IOPadIOVss iovss iovdd vss
X$1 \$1 iovss iovss iovss sg13g2_DCNDiode
X$2 iovdd iovss iovss sg13g2_DCPDiode_noptap
R$1 \$1 iovss ptap1 A=5407.1p P=703.48u
R$2 \$1 vss ptap1 A=24p P=160.6u
.ENDS sg13g2_IOPadIOVss

.SUBCKT sg13g2_DCPDiode_noptap cathode anode1 anode2
D$1 anode2 cathode dpantenna A=35.0028p P=58.08u m=1
D$2 anode1 cathode dpantenna A=35.0028p P=58.08u m=1
.ENDS sg13g2_DCPDiode_noptap

.SUBCKT sg13g2_DCNDiode \$2 anode cathode1 cathode2
D$1 \$2 cathode2 dantenna A=35.0028p P=58.08u m=1
D$2 \$2 cathode1 dantenna A=35.0028p P=58.08u m=1
R$3 \$2 anode ptap1 A=141.2964p P=221.76u
.ENDS sg13g2_DCNDiode
