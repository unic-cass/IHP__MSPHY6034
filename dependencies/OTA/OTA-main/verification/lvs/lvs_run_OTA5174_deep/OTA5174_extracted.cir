* Extracted by KLayout with SG13G2 LVS runset on : 21/09/2026 21:59

.SUBCKT OTA5174
X$1 \$1 \$I2 \$I2 digital_pulse_ina_temp_TOP
.ENDS OTA5174

.SUBCKT digital_pulse_ina_temp_TOP \$4 \$26 \$I45
X$7 \$4 \$7 \$2 \$8 \$5 \$I34 \$I35 \$34 \$6 \$33 \$3 \$26 \$19 imp_boost_tech
X$26 \$4 \$8 \$I45 \$19 \$7 vcm_ref_vicm_ref_gen
C$1 \$8 \$4 cap_cmim w=7u l=7u A=49p P=28u m=1
C$2 \$7 \$4 cap_cmim w=7u l=7u A=49p P=28u m=1
C$3 \$I57 \$4 cap_cmim w=7u l=7u A=49p P=28u m=1
C$4 \$I60 \$4 cap_cmim w=7u l=7u A=49p P=28u m=1
C$5 \$I63 \$4 cap_cmim w=7u l=7u A=49p P=28u m=1
M$6 \$I54 \$32 \$4 \$4 sg13_hv_nmos L=0.45u W=0.3u AS=0.102p AD=0.102p PS=1.28u
+ PD=1.28u rfmode=0
M$7 \$I54 \$6 \$4 \$4 sg13_hv_nmos L=0.45u W=0.3u AS=0.102p AD=0.102p PS=1.28u
+ PD=1.28u rfmode=0
M$8 \$I54 \$6 \$I66 DVDD sg13_hv_pmos L=1.8u W=1.2u AS=0.408p AD=0.408p
+ PS=3.08u PD=3.08u rfmode=0
M$9 DVDD \$32 \$I66 DVDD sg13_hv_pmos L=1.8u W=1.2u AS=0.408p AD=0.408p
+ PS=3.08u PD=3.08u rfmode=0
M$10 \$I51 \$5 \$4 \$4 sg13_hv_nmos L=0.45u W=0.3u AS=0.102p AD=0.102p PS=1.28u
+ PD=1.28u rfmode=0
M$11 \$I51 \$I53 \$4 \$4 sg13_hv_nmos L=0.45u W=0.3u AS=0.102p AD=0.102p
+ PS=1.28u PD=1.28u rfmode=0
M$12 \$I51 \$I53 \$I67 DVDD sg13_hv_pmos L=1.8u W=1.2u AS=0.408p AD=0.408p
+ PS=3.08u PD=3.08u rfmode=0
M$13 DVDD \$5 \$I67 DVDD sg13_hv_pmos L=1.8u W=1.2u AS=0.408p AD=0.408p
+ PS=3.08u PD=3.08u rfmode=0
M$14 DVDD \$I56 \$3 DVDD sg13_hv_pmos L=0.9u W=0.6u AS=0.204p AD=0.204p
+ PS=1.88u PD=1.88u rfmode=0
M$15 \$I68 \$I52 \$I56 \$4 sg13_hv_nmos L=0.45u W=0.3u AS=0.102p AD=0.102p
+ PS=1.28u PD=1.28u rfmode=0
M$16 \$4 \$I51 \$I68 \$4 sg13_hv_nmos L=0.45u W=0.3u AS=0.102p AD=0.102p
+ PS=1.28u PD=1.28u rfmode=0
M$17 \$4 \$I56 \$3 \$4 sg13_hv_nmos L=0.45u W=0.3u AS=0.102p AD=0.102p PS=1.28u
+ PD=1.28u rfmode=0
M$18 DVDD \$I51 \$I56 DVDD sg13_hv_pmos L=0.45u W=0.3u AS=0.102p AD=0.102p
+ PS=1.28u PD=1.28u rfmode=0
M$19 \$I56 \$I52 DVDD DVDD sg13_hv_pmos L=0.45u W=0.3u AS=0.102p AD=0.102p
+ PS=1.28u PD=1.28u rfmode=0
M$20 DVDD \$I69 \$2 DVDD sg13_hv_pmos L=0.9u W=0.6u AS=0.204p AD=0.204p
+ PS=1.88u PD=1.88u rfmode=0
M$21 \$I70 \$I55 \$I69 \$4 sg13_hv_nmos L=0.45u W=0.3u AS=0.102p AD=0.102p
+ PS=1.28u PD=1.28u rfmode=0
M$22 \$4 \$I54 \$I70 \$4 sg13_hv_nmos L=0.45u W=0.3u AS=0.102p AD=0.102p
+ PS=1.28u PD=1.28u rfmode=0
M$23 \$4 \$I69 \$2 \$4 sg13_hv_nmos L=0.45u W=0.3u AS=0.102p AD=0.102p PS=1.28u
+ PD=1.28u rfmode=0
M$24 \$I69 \$I55 DVDD DVDD sg13_hv_pmos L=0.45u W=0.3u AS=0.102p AD=0.102p
+ PS=1.28u PD=1.28u rfmode=0
M$25 DVDD \$I54 \$I69 DVDD sg13_hv_pmos L=0.45u W=0.3u AS=0.102p AD=0.102p
+ PS=1.28u PD=1.28u rfmode=0
C$26 \$I71 \$4 cap_cmim w=7u l=7u A=49p P=28u m=1
M$27 \$I53 \$32 \$4 \$4 sg13_hv_nmos L=0.45u W=0.3u AS=0.102p AD=0.102p
+ PS=1.28u PD=1.28u rfmode=0
M$28 DVDD \$32 \$I53 DVDD sg13_hv_pmos L=0.9u W=0.6u AS=0.204p AD=0.204p
+ PS=1.88u PD=1.88u rfmode=0
M$29 \$I55 \$I58 \$4 \$4 sg13_hv_nmos L=0.45u W=0.3u AS=0.102p AD=0.102p
+ PS=1.28u PD=1.28u rfmode=0
M$30 DVDD \$I58 \$I55 DVDD sg13_hv_pmos L=0.9u W=0.6u AS=0.204p AD=0.204p
+ PS=1.88u PD=1.88u rfmode=0
M$31 \$I58 \$I59 \$4 \$4 sg13_hv_nmos L=0.45u W=0.3u AS=0.102p AD=0.102p
+ PS=1.28u PD=1.28u rfmode=0
M$32 DVDD \$I59 \$I58 DVDD sg13_hv_pmos L=0.9u W=0.6u AS=0.204p AD=0.204p
+ PS=1.88u PD=1.88u rfmode=0
M$33 \$I59 \$I57 \$4 \$4 sg13_hv_nmos L=0.45u W=0.3u AS=0.102p AD=0.102p
+ PS=1.28u PD=1.28u rfmode=0
M$34 DVDD \$I57 \$I59 DVDD sg13_hv_pmos L=0.9u W=0.6u AS=0.204p AD=0.204p
+ PS=1.88u PD=1.88u rfmode=0
M$35 \$I57 \$5 \$4 \$4 sg13_hv_nmos L=0.45u W=0.3u AS=0.102p AD=0.102p PS=1.28u
+ PD=1.28u rfmode=0
M$36 DVDD \$5 \$I57 DVDD sg13_hv_pmos L=0.9u W=0.6u AS=0.204p AD=0.204p
+ PS=1.88u PD=1.88u rfmode=0
M$37 \$5 \$I61 \$4 \$4 sg13_hv_nmos L=0.45u W=0.3u AS=0.102p AD=0.102p PS=1.28u
+ PD=1.28u rfmode=0
M$38 DVDD \$I61 \$5 DVDD sg13_hv_pmos L=0.9u W=0.6u AS=0.204p AD=0.204p
+ PS=1.88u PD=1.88u rfmode=0
M$39 \$I61 \$I62 \$4 \$4 sg13_hv_nmos L=0.45u W=0.3u AS=0.102p AD=0.102p
+ PS=1.28u PD=1.28u rfmode=0
M$40 DVDD \$I62 \$I61 DVDD sg13_hv_pmos L=0.9u W=0.6u AS=0.204p AD=0.204p
+ PS=1.88u PD=1.88u rfmode=0
M$41 \$I62 \$I60 \$4 \$4 sg13_hv_nmos L=0.45u W=0.3u AS=0.102p AD=0.102p
+ PS=1.28u PD=1.28u rfmode=0
M$42 DVDD \$I60 \$I62 DVDD sg13_hv_pmos L=0.9u W=0.6u AS=0.204p AD=0.204p
+ PS=1.88u PD=1.88u rfmode=0
M$43 \$I60 \$I54 \$4 \$4 sg13_hv_nmos L=0.45u W=0.3u AS=0.102p AD=0.102p
+ PS=1.28u PD=1.28u rfmode=0
M$44 DVDD \$I54 \$I60 DVDD sg13_hv_pmos L=0.9u W=0.6u AS=0.204p AD=0.204p
+ PS=1.88u PD=1.88u rfmode=0
M$45 \$6 \$I64 \$4 \$4 sg13_hv_nmos L=0.45u W=0.3u AS=0.102p AD=0.102p PS=1.28u
+ PD=1.28u rfmode=0
M$46 DVDD \$I64 \$6 DVDD sg13_hv_pmos L=0.9u W=0.6u AS=0.204p AD=0.204p
+ PS=1.88u PD=1.88u rfmode=0
M$47 \$I64 \$I65 \$4 \$4 sg13_hv_nmos L=0.45u W=0.3u AS=0.102p AD=0.102p
+ PS=1.28u PD=1.28u rfmode=0
M$48 DVDD \$I65 \$I64 DVDD sg13_hv_pmos L=0.9u W=0.6u AS=0.204p AD=0.204p
+ PS=1.88u PD=1.88u rfmode=0
M$49 \$I65 \$I63 \$4 \$4 sg13_hv_nmos L=0.45u W=0.3u AS=0.102p AD=0.102p
+ PS=1.28u PD=1.28u rfmode=0
M$50 DVDD \$I63 \$I65 DVDD sg13_hv_pmos L=0.9u W=0.6u AS=0.204p AD=0.204p
+ PS=1.88u PD=1.88u rfmode=0
M$51 \$I63 \$I51 \$4 \$4 sg13_hv_nmos L=0.45u W=0.3u AS=0.102p AD=0.102p
+ PS=1.28u PD=1.28u rfmode=0
M$52 DVDD \$I51 \$I63 DVDD sg13_hv_pmos L=0.9u W=0.6u AS=0.204p AD=0.204p
+ PS=1.88u PD=1.88u rfmode=0
M$53 \$I52 \$I72 \$4 \$4 sg13_hv_nmos L=0.45u W=0.3u AS=0.102p AD=0.102p
+ PS=1.28u PD=1.28u rfmode=0
M$54 DVDD \$I72 \$I52 DVDD sg13_hv_pmos L=0.9u W=0.6u AS=0.204p AD=0.204p
+ PS=1.88u PD=1.88u rfmode=0
M$55 \$I72 \$I73 \$4 \$4 sg13_hv_nmos L=0.45u W=0.3u AS=0.102p AD=0.102p
+ PS=1.28u PD=1.28u rfmode=0
M$56 DVDD \$I73 \$I72 DVDD sg13_hv_pmos L=0.9u W=0.6u AS=0.204p AD=0.204p
+ PS=1.88u PD=1.88u rfmode=0
M$57 \$I73 \$I71 \$4 \$4 sg13_hv_nmos L=0.45u W=0.3u AS=0.102p AD=0.102p
+ PS=1.28u PD=1.28u rfmode=0
M$58 DVDD \$I71 \$I73 DVDD sg13_hv_pmos L=0.9u W=0.6u AS=0.204p AD=0.204p
+ PS=1.88u PD=1.88u rfmode=0
M$59 \$I71 \$6 \$4 \$4 sg13_hv_nmos L=0.45u W=0.3u AS=0.102p AD=0.102p PS=1.28u
+ PD=1.28u rfmode=0
M$60 DVDD \$6 \$I71 DVDD sg13_hv_pmos L=0.9u W=0.6u AS=0.204p AD=0.204p
+ PS=1.88u PD=1.88u rfmode=0
.ENDS digital_pulse_ina_temp_TOP

.SUBCKT vcm_ref_vicm_ref_gen GND VICM \$7 \$21 VCM
M$1 \$13 \$7 GND GND sg13_hv_nmos L=3.7u W=0.3u AS=0.102p AD=0.102p PS=1.28u
+ PD=1.28u rfmode=0
M$2 \$13 \$7 \$7 GND sg13_hv_nmos L=0.45u W=10u AS=3.4p AD=3.4p PS=20.68u
+ PD=20.68u rfmode=0
M$3 \$7 \$7 \$47 GND sg13_hv_nmos L=0.45u W=0.8u AS=0.272p AD=0.272p PS=2.28u
+ PD=2.28u rfmode=0
M$4 GND \$7 \$47 GND sg13_hv_nmos L=1.4u W=0.3u AS=0.102p AD=0.102p PS=1.28u
+ PD=1.28u rfmode=0
M$5 \$35 \$47 \$39 \$7 sg13_hv_pmos L=0.5u W=4.5u AS=1.53p AD=1.53p PS=10.36u
+ PD=10.36u rfmode=0
M$6 \$35 VCM VCM \$7 sg13_hv_pmos L=0.5u W=4.5u AS=1.53p AD=1.53p PS=10.36u
+ PD=10.36u rfmode=0
M$9 \$4 VICM VICM \$7 sg13_hv_pmos L=0.5u W=4.5u AS=1.53p AD=1.53p PS=10.36u
+ PD=10.36u rfmode=0
M$10 \$4 \$13 \$11 \$7 sg13_hv_pmos L=0.5u W=4.5u AS=1.53p AD=1.53p PS=10.36u
+ PD=10.36u rfmode=0
M$13 GND \$11 VICM GND sg13_hv_nmos L=0.5u W=1u AS=0.34p AD=0.34p PS=2.68u
+ PD=2.68u rfmode=0
M$14 GND \$39 VCM GND sg13_hv_nmos L=0.5u W=1u AS=0.34p AD=0.34p PS=2.68u
+ PD=2.68u rfmode=0
M$15 \$39 \$39 GND GND sg13_hv_nmos L=0.5u W=1u AS=0.34p AD=0.34p PS=2.68u
+ PD=2.68u rfmode=0
M$16 \$11 \$11 GND GND sg13_hv_nmos L=0.5u W=1u AS=0.34p AD=0.34p PS=2.68u
+ PD=2.68u rfmode=0
M$17 \$7 \$21 \$35 \$7 sg13_hv_pmos L=1u W=16u AS=5.44p AD=5.44p PS=34.72u
+ PD=34.72u rfmode=0
M$21 \$7 \$21 \$4 \$7 sg13_hv_pmos L=1u W=16u AS=5.44p AD=5.44p PS=34.72u
+ PD=34.72u rfmode=0
.ENDS vcm_ref_vicm_ref_gen

.SUBCKT imp_boost_tech \$1 VCM_REF \$6 VICM_REF \$10 VOM VOP \$36 \$55 \$58
+ \$81 \$I398 \$I397
X$181 \$1 OTA_VOP OTA_VOM OTA_VINM OTA_VINP \$I398 VCM_REF \$I397 VICM_REF
+ Differntial_ended_symbol_making
M$1 OTA_VOM \$55 VOM \$1 sg13_hv_nmos L=0.45u W=0.3u AS=0.102p AD=0.102p
+ PS=1.28u PD=1.28u rfmode=0
M$2 OTA_VOM \$10 VOP \$1 sg13_hv_nmos L=0.45u W=0.3u AS=0.102p AD=0.102p
+ PS=1.28u PD=1.28u rfmode=0
M$3 OTA_VOP \$10 VOM \$1 sg13_hv_nmos L=0.45u W=0.3u AS=0.102p AD=0.102p
+ PS=1.28u PD=1.28u rfmode=0
M$4 OTA_VOP \$55 VOP \$1 sg13_hv_nmos L=0.45u W=0.3u AS=0.102p AD=0.102p
+ PS=1.28u PD=1.28u rfmode=0
M$5 OTA_VINM \$10 \$45 \$1 sg13_hv_nmos L=0.45u W=0.3u AS=0.102p AD=0.102p
+ PS=1.28u PD=1.28u rfmode=0
M$6 OTA_VINP \$10 \$54 \$1 sg13_hv_nmos L=0.45u W=0.3u AS=0.102p AD=0.102p
+ PS=1.28u PD=1.28u rfmode=0
M$7 OTA_VINM \$55 \$54 \$1 sg13_hv_nmos L=0.45u W=0.3u AS=0.102p AD=0.102p
+ PS=1.28u PD=1.28u rfmode=0
M$8 OTA_VINP \$55 \$45 \$1 sg13_hv_nmos L=0.45u W=0.3u AS=0.102p AD=0.102p
+ PS=1.28u PD=1.28u rfmode=0
M$9 \$17 \$10 OTA_VOP \$1 sg13_hv_nmos L=0.45u W=0.3u AS=0.102p AD=0.102p
+ PS=1.28u PD=1.28u rfmode=0
M$10 \$14 \$10 OTA_VOM \$1 sg13_hv_nmos L=0.45u W=0.3u AS=0.102p AD=0.102p
+ PS=1.28u PD=1.28u rfmode=0
M$11 \$17 \$55 OTA_VOM \$1 sg13_hv_nmos L=0.45u W=0.3u AS=0.102p AD=0.102p
+ PS=1.28u PD=1.28u rfmode=0
M$12 \$14 \$55 OTA_VOP \$1 sg13_hv_nmos L=0.45u W=0.3u AS=0.102p AD=0.102p
+ PS=1.28u PD=1.28u rfmode=0
M$13 \$19 \$6 OTA_VINM \$1 sg13_hv_nmos L=0.45u W=0.3u AS=0.102p AD=0.102p
+ PS=1.28u PD=1.28u rfmode=0
M$14 \$13 \$6 OTA_VINP \$1 sg13_hv_nmos L=0.45u W=0.3u AS=0.102p AD=0.102p
+ PS=1.28u PD=1.28u rfmode=0
M$15 \$19 \$81 OTA_VINP \$1 sg13_hv_nmos L=0.45u W=0.3u AS=0.102p AD=0.102p
+ PS=1.28u PD=1.28u rfmode=0
M$16 \$13 \$81 OTA_VINM \$1 sg13_hv_nmos L=0.45u W=0.3u AS=0.102p AD=0.102p
+ PS=1.28u PD=1.28u rfmode=0
M$17 \$38 \$6 \$39 \$1 sg13_hv_nmos L=0.45u W=0.3u AS=0.102p AD=0.102p PS=1.28u
+ PD=1.28u rfmode=0
M$18 \$37 \$6 \$49 \$1 sg13_hv_nmos L=0.45u W=0.3u AS=0.102p AD=0.102p PS=1.28u
+ PD=1.28u rfmode=0
M$19 \$38 \$81 \$49 \$1 sg13_hv_nmos L=0.45u W=0.3u AS=0.102p AD=0.102p
+ PS=1.28u PD=1.28u rfmode=0
M$20 \$37 \$81 \$39 \$1 sg13_hv_nmos L=0.45u W=0.3u AS=0.102p AD=0.102p
+ PS=1.28u PD=1.28u rfmode=0
M$21 \$36 \$10 \$37 \$1 sg13_hv_nmos L=0.45u W=0.3u AS=0.102p AD=0.102p
+ PS=1.28u PD=1.28u rfmode=0
M$22 \$58 \$10 \$38 \$1 sg13_hv_nmos L=0.45u W=0.3u AS=0.102p AD=0.102p
+ PS=1.28u PD=1.28u rfmode=0
M$23 \$36 \$55 \$38 \$1 sg13_hv_nmos L=0.45u W=0.3u AS=0.102p AD=0.102p
+ PS=1.28u PD=1.28u rfmode=0
M$24 \$58 \$55 \$37 \$1 sg13_hv_nmos L=0.45u W=0.3u AS=0.102p AD=0.102p
+ PS=1.28u PD=1.28u rfmode=0
C$25 \$14 \$45 cap_cmim w=5.7u l=5.7u A=32.49p P=22.8u m=2
C$26 \$17 \$54 cap_cmim w=5.7u l=5.7u A=32.49p P=22.8u m=2
C$29 \$13 \$39 cap_cmim w=26u l=12.8u A=332.8p P=77.6u m=2
C$30 \$19 \$49 cap_cmim w=26u l=12.8u A=332.8p P=77.6u m=2
.ENDS imp_boost_tech

.SUBCKT Differntial_ended_symbol_making \$1 \$2 \$8 \$16 \$17 \$19 \$28 \$51
+ \$59
M$1 \$1 \$1 \$1 \$1 sg13_hv_nmos L=2u W=8u AS=2.72p AD=2.72p PS=18.72u
+ PD=18.72u rfmode=0
M$5 \$2 \$4 \$1 \$1 sg13_hv_nmos L=2u W=4u AS=1.36p AD=1.36p PS=9.36u PD=9.36u
+ rfmode=0
M$6 \$8 \$4 \$1 \$1 sg13_hv_nmos L=2u W=4u AS=1.36p AD=1.36p PS=9.36u PD=9.36u
+ rfmode=0
M$9 \$59 \$16 \$16 \$19 sg13_hv_pmos L=1u W=50u AS=11p AD=11p PS=62.2u PD=62.2u
+ rfmode=0
M$14 \$17 \$17 \$59 \$19 sg13_hv_pmos L=1u W=50u AS=11p AD=11p PS=62.2u
+ PD=62.2u rfmode=0
M$19 \$22 \$22 \$1 \$1 sg13_hv_nmos L=0.5u W=1u AS=0.34p AD=0.34p PS=2.68u
+ PD=2.68u rfmode=0
M$20 \$1 \$22 \$4 \$1 sg13_hv_nmos L=0.5u W=1u AS=0.34p AD=0.34p PS=2.68u
+ PD=2.68u rfmode=0
M$21 \$34 \$28 \$4 \$19 sg13_hv_pmos L=0.5u W=4.5u AS=1.53p AD=1.53p PS=10.36u
+ PD=10.36u rfmode=0
M$22 \$34 \$8 \$22 \$19 sg13_hv_pmos L=0.5u W=2.25u AS=0.765p AD=0.765p
+ PS=5.18u PD=5.18u rfmode=0
M$23 \$22 \$2 \$34 \$19 sg13_hv_pmos L=0.5u W=2.25u AS=0.765p AD=0.765p
+ PS=5.18u PD=5.18u rfmode=0
M$25 \$51 \$51 \$19 \$19 sg13_hv_pmos L=1u W=4u AS=1.36p AD=1.36p PS=8.68u
+ PD=8.68u rfmode=0
M$26 \$34 \$51 \$19 \$19 sg13_hv_pmos L=1u W=16u AS=5.44p AD=5.44p PS=34.72u
+ PD=34.72u rfmode=0
M$30 \$26 \$51 \$19 \$19 sg13_hv_pmos L=1u W=16u AS=5.44p AD=5.44p PS=34.72u
+ PD=34.72u rfmode=0
M$34 \$19 \$19 \$19 \$19 sg13_hv_pmos L=0.4u W=18u AS=6.12p AD=6.12p PS=38.72u
+ PD=38.72u rfmode=0
M$38 \$2 \$17 \$26 \$19 sg13_hv_pmos L=1u W=9u AS=3.06p AD=3.06p PS=19.36u
+ PD=19.36u rfmode=0
M$39 \$26 \$16 \$8 \$19 sg13_hv_pmos L=1u W=9u AS=3.06p AD=3.06p PS=19.36u
+ PD=19.36u rfmode=0
C$42 \$4 \$1 cap_cmim w=14u l=50u A=700p P=128u m=1
.ENDS Differntial_ended_symbol_making
