* Extracted by KLayout with SG13G2 LVS runset on : 21/09/2026 22:07

.SUBCKT CS_DAC_10b VDD VSS VBIAS X10 X8 X9 OUTP OUTN CLK X4 X3 X7 X5 X6 X2 X1
M$1 VSS \$187 \$7 VSS sg13_lv_nmos L=0.13u W=0.55u AS=0.187p AD=0.1045p
+ PS=1.78u PD=0.93u rfmode=0
M$2 \$7 \$320 VSS VSS sg13_lv_nmos L=0.13u W=0.55u AS=0.1045p AD=0.146425p
+ PS=0.93u PD=1.155u rfmode=0
M$3 VSS \$7 \$8 VSS sg13_lv_nmos L=0.13u W=1.48u AS=0.312925p AD=0.4477p
+ PS=2.345u PD=3.43u rfmode=0
M$5 VSS \$190 \$11 VSS sg13_lv_nmos L=0.13u W=0.55u AS=0.187p AD=0.1045p
+ PS=1.78u PD=0.93u rfmode=0
M$6 \$11 \$320 VSS VSS sg13_lv_nmos L=0.13u W=0.55u AS=0.1045p AD=0.146425p
+ PS=0.93u PD=1.155u rfmode=0
M$7 VSS \$11 \$12 VSS sg13_lv_nmos L=0.13u W=1.48u AS=0.312925p AD=0.4477p
+ PS=2.345u PD=3.43u rfmode=0
M$9 VSS \$193 \$15 VSS sg13_lv_nmos L=0.13u W=0.55u AS=0.187p AD=0.1045p
+ PS=1.78u PD=0.93u rfmode=0
M$10 \$15 \$320 VSS VSS sg13_lv_nmos L=0.13u W=0.55u AS=0.1045p AD=0.146425p
+ PS=0.93u PD=1.155u rfmode=0
M$11 VSS \$15 \$16 VSS sg13_lv_nmos L=0.13u W=1.48u AS=0.312925p AD=0.4477p
+ PS=2.345u PD=3.43u rfmode=0
M$13 VSS \$196 \$19 VSS sg13_lv_nmos L=0.13u W=0.55u AS=0.187p AD=0.1045p
+ PS=1.78u PD=0.93u rfmode=0
M$14 \$19 \$320 VSS VSS sg13_lv_nmos L=0.13u W=0.55u AS=0.1045p AD=0.146425p
+ PS=0.93u PD=1.155u rfmode=0
M$15 VSS \$19 \$20 VSS sg13_lv_nmos L=0.13u W=1.48u AS=0.312925p AD=0.4477p
+ PS=2.345u PD=3.43u rfmode=0
M$17 VSS \$199 \$23 VSS sg13_lv_nmos L=0.13u W=0.55u AS=0.187p AD=0.1045p
+ PS=1.78u PD=0.93u rfmode=0
M$18 \$23 \$320 VSS VSS sg13_lv_nmos L=0.13u W=0.55u AS=0.1045p AD=0.146425p
+ PS=0.93u PD=1.155u rfmode=0
M$19 VSS \$23 \$24 VSS sg13_lv_nmos L=0.13u W=1.48u AS=0.312925p AD=0.4477p
+ PS=2.345u PD=3.43u rfmode=0
M$21 VSS \$202 \$27 VSS sg13_lv_nmos L=0.13u W=0.55u AS=0.187p AD=0.1045p
+ PS=1.78u PD=0.93u rfmode=0
M$22 \$27 \$320 VSS VSS sg13_lv_nmos L=0.13u W=0.55u AS=0.1045p AD=0.146425p
+ PS=0.93u PD=1.155u rfmode=0
M$23 VSS \$27 \$28 VSS sg13_lv_nmos L=0.13u W=1.48u AS=0.312925p AD=0.4477p
+ PS=2.345u PD=3.43u rfmode=0
M$25 VSS \$205 \$31 VSS sg13_lv_nmos L=0.13u W=0.55u AS=0.187p AD=0.1045p
+ PS=1.78u PD=0.93u rfmode=0
M$26 \$31 \$320 VSS VSS sg13_lv_nmos L=0.13u W=0.55u AS=0.1045p AD=0.146425p
+ PS=0.93u PD=1.155u rfmode=0
M$27 VSS \$31 \$32 VSS sg13_lv_nmos L=0.13u W=1.48u AS=0.312925p AD=0.4477p
+ PS=2.345u PD=3.43u rfmode=0
M$29 VSS VSS \$35 VSS sg13_lv_nmos L=0.13u W=0.55u AS=0.187p AD=0.1045p
+ PS=1.78u PD=0.93u rfmode=0
M$30 \$35 \$320 VSS VSS sg13_lv_nmos L=0.13u W=0.55u AS=0.1045p AD=0.146425p
+ PS=0.93u PD=1.155u rfmode=0
M$31 VSS \$35 \$36 VSS sg13_lv_nmos L=0.13u W=1.48u AS=0.312925p AD=0.4477p
+ PS=2.345u PD=3.43u rfmode=0
M$33 \$4 X10 VSS VSS sg13_lv_nmos L=0.13u W=0.64u AS=0.2176p AD=0.1371p
+ PS=1.96u PD=1.12u rfmode=0
M$34 VSS \$4 \$5 VSS sg13_lv_nmos L=0.13u W=1.48u AS=0.2777p AD=0.3922p
+ PS=2.24u PD=3.28u rfmode=0
M$36 \$41 \$40 \$122 VSS sg13_lv_nmos L=0.13u W=0.42u AS=0.1428p AD=0.0609p
+ PS=1.52u PD=0.71u rfmode=0
M$37 \$122 VDD VSS VSS sg13_lv_nmos L=0.13u W=0.42u AS=0.0609p AD=0.1626p
+ PS=0.71u PD=1.415u rfmode=0
M$38 VSS \$167 \$9 VSS sg13_lv_nmos L=0.13u W=0.74u AS=0.1626p AD=0.2516p
+ PS=1.415u PD=2.16u rfmode=0
M$39 \$43 \$168 VSS VSS sg13_lv_nmos L=0.13u W=0.42u AS=0.1428p AD=0.0798p
+ PS=1.52u PD=0.8u rfmode=0
M$40 VSS VDD \$125 VSS sg13_lv_nmos L=0.13u W=0.42u AS=0.0798p AD=0.0378p
+ PS=0.8u PD=0.6u rfmode=0
M$41 \$125 \$44 \$168 VSS sg13_lv_nmos L=0.13u W=0.42u AS=0.0378p AD=0.1428p
+ PS=0.6u PD=1.52u rfmode=0
M$42 VSS \$44 \$46 VSS sg13_lv_nmos L=0.13u W=0.64u AS=0.1331p AD=0.2176p
+ PS=1.12u PD=1.96u rfmode=0
M$43 VSS \$44 \$45 VSS sg13_lv_nmos L=0.13u W=1.48u AS=0.3922p AD=0.2737p
+ PS=3.28u PD=2.24u rfmode=0
M$45 VSS \$46 \$47 VSS sg13_lv_nmos L=0.13u W=1.48u AS=0.3922p AD=0.3922p
+ PS=3.28u PD=3.28u rfmode=0
M$47 \$51 \$50 \$132 VSS sg13_lv_nmos L=0.13u W=0.42u AS=0.1428p AD=0.0609p
+ PS=1.52u PD=0.71u rfmode=0
M$48 \$132 VDD VSS VSS sg13_lv_nmos L=0.13u W=0.42u AS=0.0609p AD=0.1626p
+ PS=0.71u PD=1.415u rfmode=0
M$49 VSS \$169 \$13 VSS sg13_lv_nmos L=0.13u W=0.74u AS=0.1626p AD=0.2516p
+ PS=1.415u PD=2.16u rfmode=0
M$50 \$53 \$170 VSS VSS sg13_lv_nmos L=0.13u W=0.42u AS=0.1428p AD=0.0798p
+ PS=1.52u PD=0.8u rfmode=0
M$51 VSS VDD \$137 VSS sg13_lv_nmos L=0.13u W=0.42u AS=0.0798p AD=0.0378p
+ PS=0.8u PD=0.6u rfmode=0
M$52 \$137 \$54 \$170 VSS sg13_lv_nmos L=0.13u W=0.42u AS=0.0378p AD=0.1428p
+ PS=0.6u PD=1.52u rfmode=0
M$53 VSS \$54 \$56 VSS sg13_lv_nmos L=0.13u W=0.64u AS=0.1331p AD=0.2176p
+ PS=1.12u PD=1.96u rfmode=0
M$54 VSS \$54 \$55 VSS sg13_lv_nmos L=0.13u W=1.48u AS=0.3922p AD=0.2737p
+ PS=3.28u PD=2.24u rfmode=0
M$56 VSS \$56 \$57 VSS sg13_lv_nmos L=0.13u W=1.48u AS=0.3922p AD=0.3922p
+ PS=3.28u PD=3.28u rfmode=0
M$58 \$61 \$60 \$144 VSS sg13_lv_nmos L=0.13u W=0.42u AS=0.1428p AD=0.0609p
+ PS=1.52u PD=0.71u rfmode=0
M$59 \$144 VDD VSS VSS sg13_lv_nmos L=0.13u W=0.42u AS=0.0609p AD=0.1626p
+ PS=0.71u PD=1.415u rfmode=0
M$60 VSS \$171 \$17 VSS sg13_lv_nmos L=0.13u W=0.74u AS=0.1626p AD=0.2516p
+ PS=1.415u PD=2.16u rfmode=0
M$61 \$63 \$172 VSS VSS sg13_lv_nmos L=0.13u W=0.42u AS=0.1428p AD=0.0798p
+ PS=1.52u PD=0.8u rfmode=0
M$62 VSS VDD \$148 VSS sg13_lv_nmos L=0.13u W=0.42u AS=0.0798p AD=0.0378p
+ PS=0.8u PD=0.6u rfmode=0
M$63 \$148 \$64 \$172 VSS sg13_lv_nmos L=0.13u W=0.42u AS=0.0378p AD=0.1428p
+ PS=0.6u PD=1.52u rfmode=0
M$64 VSS \$64 \$66 VSS sg13_lv_nmos L=0.13u W=0.64u AS=0.1331p AD=0.2176p
+ PS=1.12u PD=1.96u rfmode=0
M$65 VSS \$64 \$65 VSS sg13_lv_nmos L=0.13u W=1.48u AS=0.3922p AD=0.2737p
+ PS=3.28u PD=2.24u rfmode=0
M$67 VSS \$66 \$67 VSS sg13_lv_nmos L=0.13u W=1.48u AS=0.3922p AD=0.3922p
+ PS=3.28u PD=3.28u rfmode=0
M$69 \$71 \$70 \$155 VSS sg13_lv_nmos L=0.13u W=0.42u AS=0.1428p AD=0.0609p
+ PS=1.52u PD=0.71u rfmode=0
M$70 \$155 VDD VSS VSS sg13_lv_nmos L=0.13u W=0.42u AS=0.0609p AD=0.1626p
+ PS=0.71u PD=1.415u rfmode=0
M$71 VSS \$173 \$21 VSS sg13_lv_nmos L=0.13u W=0.74u AS=0.1626p AD=0.2516p
+ PS=1.415u PD=2.16u rfmode=0
M$72 \$73 \$174 VSS VSS sg13_lv_nmos L=0.13u W=0.42u AS=0.1428p AD=0.0798p
+ PS=1.52u PD=0.8u rfmode=0
M$73 VSS VDD \$160 VSS sg13_lv_nmos L=0.13u W=0.42u AS=0.0798p AD=0.0378p
+ PS=0.8u PD=0.6u rfmode=0
M$74 \$160 \$74 \$174 VSS sg13_lv_nmos L=0.13u W=0.42u AS=0.0378p AD=0.1428p
+ PS=0.6u PD=1.52u rfmode=0
M$75 VSS \$74 \$76 VSS sg13_lv_nmos L=0.13u W=0.64u AS=0.1331p AD=0.2176p
+ PS=1.12u PD=1.96u rfmode=0
M$76 VSS \$74 \$75 VSS sg13_lv_nmos L=0.13u W=1.48u AS=0.3922p AD=0.2737p
+ PS=3.28u PD=2.24u rfmode=0
M$78 VSS \$76 \$77 VSS sg13_lv_nmos L=0.13u W=1.48u AS=0.3922p AD=0.3922p
+ PS=3.28u PD=3.28u rfmode=0
M$80 \$81 \$80 \$166 VSS sg13_lv_nmos L=0.13u W=0.42u AS=0.1428p AD=0.0609p
+ PS=1.52u PD=0.71u rfmode=0
M$81 \$166 VDD VSS VSS sg13_lv_nmos L=0.13u W=0.42u AS=0.0609p AD=0.1626p
+ PS=0.71u PD=1.415u rfmode=0
M$82 VSS \$175 \$25 VSS sg13_lv_nmos L=0.13u W=0.74u AS=0.1626p AD=0.2516p
+ PS=1.415u PD=2.16u rfmode=0
M$83 \$83 \$176 VSS VSS sg13_lv_nmos L=0.13u W=0.42u AS=0.1428p AD=0.0798p
+ PS=1.52u PD=0.8u rfmode=0
M$84 VSS VDD \$163 VSS sg13_lv_nmos L=0.13u W=0.42u AS=0.0798p AD=0.0378p
+ PS=0.8u PD=0.6u rfmode=0
M$85 \$163 \$84 \$176 VSS sg13_lv_nmos L=0.13u W=0.42u AS=0.0378p AD=0.1428p
+ PS=0.6u PD=1.52u rfmode=0
M$86 VSS \$84 \$86 VSS sg13_lv_nmos L=0.13u W=0.64u AS=0.1331p AD=0.2176p
+ PS=1.12u PD=1.96u rfmode=0
M$87 VSS \$84 \$85 VSS sg13_lv_nmos L=0.13u W=1.48u AS=0.3922p AD=0.2737p
+ PS=3.28u PD=2.24u rfmode=0
M$89 VSS \$86 \$87 VSS sg13_lv_nmos L=0.13u W=1.48u AS=0.3922p AD=0.3922p
+ PS=3.28u PD=3.28u rfmode=0
M$91 \$91 \$90 \$153 VSS sg13_lv_nmos L=0.13u W=0.42u AS=0.1428p AD=0.0609p
+ PS=1.52u PD=0.71u rfmode=0
M$92 \$153 VDD VSS VSS sg13_lv_nmos L=0.13u W=0.42u AS=0.0609p AD=0.1626p
+ PS=0.71u PD=1.415u rfmode=0
M$93 VSS \$177 \$29 VSS sg13_lv_nmos L=0.13u W=0.74u AS=0.1626p AD=0.2516p
+ PS=1.415u PD=2.16u rfmode=0
M$94 \$93 \$178 VSS VSS sg13_lv_nmos L=0.13u W=0.42u AS=0.1428p AD=0.0798p
+ PS=1.52u PD=0.8u rfmode=0
M$95 VSS VDD \$149 VSS sg13_lv_nmos L=0.13u W=0.42u AS=0.0798p AD=0.0378p
+ PS=0.8u PD=0.6u rfmode=0
M$96 \$149 \$94 \$178 VSS sg13_lv_nmos L=0.13u W=0.42u AS=0.0378p AD=0.1428p
+ PS=0.6u PD=1.52u rfmode=0
M$97 VSS \$94 \$96 VSS sg13_lv_nmos L=0.13u W=0.64u AS=0.1331p AD=0.2176p
+ PS=1.12u PD=1.96u rfmode=0
M$98 VSS \$94 \$95 VSS sg13_lv_nmos L=0.13u W=1.48u AS=0.3922p AD=0.2737p
+ PS=3.28u PD=2.24u rfmode=0
M$100 VSS \$96 \$97 VSS sg13_lv_nmos L=0.13u W=1.48u AS=0.3922p AD=0.3922p
+ PS=3.28u PD=3.28u rfmode=0
M$102 \$101 \$100 \$141 VSS sg13_lv_nmos L=0.13u W=0.42u AS=0.1428p AD=0.0609p
+ PS=1.52u PD=0.71u rfmode=0
M$103 \$141 VDD VSS VSS sg13_lv_nmos L=0.13u W=0.42u AS=0.0609p AD=0.1626p
+ PS=0.71u PD=1.415u rfmode=0
M$104 VSS \$179 \$33 VSS sg13_lv_nmos L=0.13u W=0.74u AS=0.1626p AD=0.2516p
+ PS=1.415u PD=2.16u rfmode=0
M$105 \$103 \$180 VSS VSS sg13_lv_nmos L=0.13u W=0.42u AS=0.1428p AD=0.0798p
+ PS=1.52u PD=0.8u rfmode=0
M$106 VSS VDD \$136 VSS sg13_lv_nmos L=0.13u W=0.42u AS=0.0798p AD=0.0378p
+ PS=0.8u PD=0.6u rfmode=0
M$107 \$136 \$104 \$180 VSS sg13_lv_nmos L=0.13u W=0.42u AS=0.0378p AD=0.1428p
+ PS=0.6u PD=1.52u rfmode=0
M$108 VSS \$104 \$106 VSS sg13_lv_nmos L=0.13u W=0.64u AS=0.1331p AD=0.2176p
+ PS=1.12u PD=1.96u rfmode=0
M$109 VSS \$104 \$105 VSS sg13_lv_nmos L=0.13u W=1.48u AS=0.3922p AD=0.2737p
+ PS=3.28u PD=2.24u rfmode=0
M$111 VSS \$106 \$107 VSS sg13_lv_nmos L=0.13u W=1.48u AS=0.3922p AD=0.3922p
+ PS=3.28u PD=3.28u rfmode=0
M$113 \$111 \$110 \$127 VSS sg13_lv_nmos L=0.13u W=0.42u AS=0.1428p AD=0.0609p
+ PS=1.52u PD=0.71u rfmode=0
M$114 \$127 VDD VSS VSS sg13_lv_nmos L=0.13u W=0.42u AS=0.0609p AD=0.1626p
+ PS=0.71u PD=1.415u rfmode=0
M$115 VSS \$181 \$37 VSS sg13_lv_nmos L=0.13u W=0.74u AS=0.1626p AD=0.2516p
+ PS=1.415u PD=2.16u rfmode=0
M$116 \$113 \$182 VSS VSS sg13_lv_nmos L=0.13u W=0.42u AS=0.1428p AD=0.0798p
+ PS=1.52u PD=0.8u rfmode=0
M$117 VSS VDD \$124 VSS sg13_lv_nmos L=0.13u W=0.42u AS=0.0798p AD=0.0378p
+ PS=0.8u PD=0.6u rfmode=0
M$118 \$124 \$114 \$182 VSS sg13_lv_nmos L=0.13u W=0.42u AS=0.0378p AD=0.1428p
+ PS=0.6u PD=1.52u rfmode=0
M$119 VSS \$114 \$116 VSS sg13_lv_nmos L=0.13u W=0.64u AS=0.1331p AD=0.2176p
+ PS=1.12u PD=1.96u rfmode=0
M$120 VSS \$114 \$115 VSS sg13_lv_nmos L=0.13u W=1.48u AS=0.3922p AD=0.2737p
+ PS=3.28u PD=2.24u rfmode=0
M$122 VSS \$116 \$117 VSS sg13_lv_nmos L=0.13u W=1.48u AS=0.3922p AD=0.3922p
+ PS=3.28u PD=3.28u rfmode=0
M$124 \$39 \$8 VSS VSS sg13_lv_nmos L=0.13u W=1.44u AS=0.4068p AD=0.2772p
+ PS=3.29u PD=2.21u rfmode=0
M$126 \$39 VDD \$40 VSS sg13_lv_nmos L=0.13u W=1.44u AS=0.2772p AD=0.3816p
+ PS=2.21u PD=3.22u rfmode=0
M$128 VSS VDD \$123 VSS sg13_lv_nmos L=0.13u W=0.42u AS=0.1701p AD=0.03885p
+ PS=1.65u PD=0.605u rfmode=0
M$129 \$123 \$9 \$42 VSS sg13_lv_nmos L=0.13u W=0.42u AS=0.03885p AD=0.1596p
+ PS=0.605u PD=1.6u rfmode=0
M$130 \$41 \$10 \$167 VSS sg13_lv_nmos L=0.13u W=0.42u AS=0.1296p AD=0.081p
+ PS=1.52u PD=0.81u rfmode=0
M$131 \$167 \$188 \$42 VSS sg13_lv_nmos L=0.13u W=0.42u AS=0.081p AD=0.2163p
+ PS=0.81u PD=1.87u rfmode=0
M$132 VSS \$10 \$188 VSS sg13_lv_nmos L=0.13u W=0.74u AS=0.43315p AD=0.2516p
+ PS=2.205u PD=2.16u rfmode=0
M$133 VSS CLK \$10 VSS sg13_lv_nmos L=0.13u W=0.74u AS=0.43315p AD=0.2516p
+ PS=2.205u PD=2.16u rfmode=0
M$134 \$44 \$10 \$43 VSS sg13_lv_nmos L=0.13u W=0.42u AS=0.12665p AD=0.1428p
+ PS=1.145u PD=1.52u rfmode=0
M$135 \$9 \$188 \$44 VSS sg13_lv_nmos L=0.13u W=0.74u AS=0.3473p AD=0.12665p
+ PS=2.71u PD=1.145u rfmode=0
M$136 \$49 \$12 VSS VSS sg13_lv_nmos L=0.13u W=1.44u AS=0.4068p AD=0.2772p
+ PS=3.29u PD=2.21u rfmode=0
M$138 \$49 VDD \$50 VSS sg13_lv_nmos L=0.13u W=1.44u AS=0.2772p AD=0.3816p
+ PS=2.21u PD=3.22u rfmode=0
M$140 VSS VDD \$134 VSS sg13_lv_nmos L=0.13u W=0.42u AS=0.1701p AD=0.03885p
+ PS=1.65u PD=0.605u rfmode=0
M$141 \$134 \$13 \$52 VSS sg13_lv_nmos L=0.13u W=0.42u AS=0.03885p AD=0.1596p
+ PS=0.605u PD=1.6u rfmode=0
M$142 \$51 \$14 \$169 VSS sg13_lv_nmos L=0.13u W=0.42u AS=0.1296p AD=0.081p
+ PS=1.52u PD=0.81u rfmode=0
M$143 \$169 \$191 \$52 VSS sg13_lv_nmos L=0.13u W=0.42u AS=0.081p AD=0.2163p
+ PS=0.81u PD=1.87u rfmode=0
M$144 VSS \$14 \$191 VSS sg13_lv_nmos L=0.13u W=0.74u AS=0.43315p AD=0.2516p
+ PS=2.205u PD=2.16u rfmode=0
M$145 VSS CLK \$14 VSS sg13_lv_nmos L=0.13u W=0.74u AS=0.43315p AD=0.2516p
+ PS=2.205u PD=2.16u rfmode=0
M$146 \$54 \$14 \$53 VSS sg13_lv_nmos L=0.13u W=0.42u AS=0.12665p AD=0.1428p
+ PS=1.145u PD=1.52u rfmode=0
M$147 \$13 \$191 \$54 VSS sg13_lv_nmos L=0.13u W=0.74u AS=0.3473p AD=0.12665p
+ PS=2.71u PD=1.145u rfmode=0
M$148 \$59 \$16 VSS VSS sg13_lv_nmos L=0.13u W=1.44u AS=0.4068p AD=0.2772p
+ PS=3.29u PD=2.21u rfmode=0
M$150 \$59 VDD \$60 VSS sg13_lv_nmos L=0.13u W=1.44u AS=0.2772p AD=0.3816p
+ PS=2.21u PD=3.22u rfmode=0
M$152 VSS VDD \$145 VSS sg13_lv_nmos L=0.13u W=0.42u AS=0.1701p AD=0.03885p
+ PS=1.65u PD=0.605u rfmode=0
M$153 \$145 \$17 \$62 VSS sg13_lv_nmos L=0.13u W=0.42u AS=0.03885p AD=0.1596p
+ PS=0.605u PD=1.6u rfmode=0
M$154 \$61 \$18 \$171 VSS sg13_lv_nmos L=0.13u W=0.42u AS=0.1296p AD=0.081p
+ PS=1.52u PD=0.81u rfmode=0
M$155 \$171 \$194 \$62 VSS sg13_lv_nmos L=0.13u W=0.42u AS=0.081p AD=0.2163p
+ PS=0.81u PD=1.87u rfmode=0
M$156 VSS \$18 \$194 VSS sg13_lv_nmos L=0.13u W=0.74u AS=0.43315p AD=0.2516p
+ PS=2.205u PD=2.16u rfmode=0
M$157 VSS CLK \$18 VSS sg13_lv_nmos L=0.13u W=0.74u AS=0.43315p AD=0.2516p
+ PS=2.205u PD=2.16u rfmode=0
M$158 \$64 \$18 \$63 VSS sg13_lv_nmos L=0.13u W=0.42u AS=0.12665p AD=0.1428p
+ PS=1.145u PD=1.52u rfmode=0
M$159 \$17 \$194 \$64 VSS sg13_lv_nmos L=0.13u W=0.74u AS=0.3473p AD=0.12665p
+ PS=2.71u PD=1.145u rfmode=0
M$160 \$69 \$20 VSS VSS sg13_lv_nmos L=0.13u W=1.44u AS=0.4068p AD=0.2772p
+ PS=3.29u PD=2.21u rfmode=0
M$162 \$69 VDD \$70 VSS sg13_lv_nmos L=0.13u W=1.44u AS=0.2772p AD=0.3816p
+ PS=2.21u PD=3.22u rfmode=0
M$164 VSS VDD \$156 VSS sg13_lv_nmos L=0.13u W=0.42u AS=0.1701p AD=0.03885p
+ PS=1.65u PD=0.605u rfmode=0
M$165 \$156 \$21 \$72 VSS sg13_lv_nmos L=0.13u W=0.42u AS=0.03885p AD=0.1596p
+ PS=0.605u PD=1.6u rfmode=0
M$166 \$71 \$22 \$173 VSS sg13_lv_nmos L=0.13u W=0.42u AS=0.1296p AD=0.081p
+ PS=1.52u PD=0.81u rfmode=0
M$167 \$173 \$197 \$72 VSS sg13_lv_nmos L=0.13u W=0.42u AS=0.081p AD=0.2163p
+ PS=0.81u PD=1.87u rfmode=0
M$168 VSS \$22 \$197 VSS sg13_lv_nmos L=0.13u W=0.74u AS=0.43315p AD=0.2516p
+ PS=2.205u PD=2.16u rfmode=0
M$169 VSS CLK \$22 VSS sg13_lv_nmos L=0.13u W=0.74u AS=0.43315p AD=0.2516p
+ PS=2.205u PD=2.16u rfmode=0
M$170 \$74 \$22 \$73 VSS sg13_lv_nmos L=0.13u W=0.42u AS=0.12665p AD=0.1428p
+ PS=1.145u PD=1.52u rfmode=0
M$171 \$21 \$197 \$74 VSS sg13_lv_nmos L=0.13u W=0.74u AS=0.3473p AD=0.12665p
+ PS=2.71u PD=1.145u rfmode=0
M$172 \$79 \$24 VSS VSS sg13_lv_nmos L=0.13u W=1.44u AS=0.4068p AD=0.2772p
+ PS=3.29u PD=2.21u rfmode=0
M$174 \$79 VDD \$80 VSS sg13_lv_nmos L=0.13u W=1.44u AS=0.2772p AD=0.3816p
+ PS=2.21u PD=3.22u rfmode=0
M$176 VSS VDD \$165 VSS sg13_lv_nmos L=0.13u W=0.42u AS=0.1701p AD=0.03885p
+ PS=1.65u PD=0.605u rfmode=0
M$177 \$165 \$25 \$82 VSS sg13_lv_nmos L=0.13u W=0.42u AS=0.03885p AD=0.1596p
+ PS=0.605u PD=1.6u rfmode=0
M$178 \$81 \$26 \$175 VSS sg13_lv_nmos L=0.13u W=0.42u AS=0.1296p AD=0.081p
+ PS=1.52u PD=0.81u rfmode=0
M$179 \$175 \$200 \$82 VSS sg13_lv_nmos L=0.13u W=0.42u AS=0.081p AD=0.2163p
+ PS=0.81u PD=1.87u rfmode=0
M$180 VSS \$26 \$200 VSS sg13_lv_nmos L=0.13u W=0.74u AS=0.43315p AD=0.2516p
+ PS=2.205u PD=2.16u rfmode=0
M$181 VSS CLK \$26 VSS sg13_lv_nmos L=0.13u W=0.74u AS=0.43315p AD=0.2516p
+ PS=2.205u PD=2.16u rfmode=0
M$182 \$84 \$26 \$83 VSS sg13_lv_nmos L=0.13u W=0.42u AS=0.12665p AD=0.1428p
+ PS=1.145u PD=1.52u rfmode=0
M$183 \$25 \$200 \$84 VSS sg13_lv_nmos L=0.13u W=0.74u AS=0.3473p AD=0.12665p
+ PS=2.71u PD=1.145u rfmode=0
M$184 \$89 \$28 VSS VSS sg13_lv_nmos L=0.13u W=1.44u AS=0.4068p AD=0.2772p
+ PS=3.29u PD=2.21u rfmode=0
M$186 \$89 VDD \$90 VSS sg13_lv_nmos L=0.13u W=1.44u AS=0.2772p AD=0.3816p
+ PS=2.21u PD=3.22u rfmode=0
M$188 VSS VDD \$152 VSS sg13_lv_nmos L=0.13u W=0.42u AS=0.1701p AD=0.03885p
+ PS=1.65u PD=0.605u rfmode=0
M$189 \$152 \$29 \$92 VSS sg13_lv_nmos L=0.13u W=0.42u AS=0.03885p AD=0.1596p
+ PS=0.605u PD=1.6u rfmode=0
M$190 \$91 \$30 \$177 VSS sg13_lv_nmos L=0.13u W=0.42u AS=0.1296p AD=0.081p
+ PS=1.52u PD=0.81u rfmode=0
M$191 \$177 \$203 \$92 VSS sg13_lv_nmos L=0.13u W=0.42u AS=0.081p AD=0.2163p
+ PS=0.81u PD=1.87u rfmode=0
M$192 VSS \$30 \$203 VSS sg13_lv_nmos L=0.13u W=0.74u AS=0.43315p AD=0.2516p
+ PS=2.205u PD=2.16u rfmode=0
M$193 VSS CLK \$30 VSS sg13_lv_nmos L=0.13u W=0.74u AS=0.43315p AD=0.2516p
+ PS=2.205u PD=2.16u rfmode=0
M$194 \$94 \$30 \$93 VSS sg13_lv_nmos L=0.13u W=0.42u AS=0.12665p AD=0.1428p
+ PS=1.145u PD=1.52u rfmode=0
M$195 \$29 \$203 \$94 VSS sg13_lv_nmos L=0.13u W=0.74u AS=0.3473p AD=0.12665p
+ PS=2.71u PD=1.145u rfmode=0
M$196 \$99 \$32 VSS VSS sg13_lv_nmos L=0.13u W=1.44u AS=0.4068p AD=0.2772p
+ PS=3.29u PD=2.21u rfmode=0
M$198 \$99 VDD \$100 VSS sg13_lv_nmos L=0.13u W=1.44u AS=0.2772p AD=0.3816p
+ PS=2.21u PD=3.22u rfmode=0
M$200 VSS VDD \$139 VSS sg13_lv_nmos L=0.13u W=0.42u AS=0.1701p AD=0.03885p
+ PS=1.65u PD=0.605u rfmode=0
M$201 \$139 \$33 \$102 VSS sg13_lv_nmos L=0.13u W=0.42u AS=0.03885p AD=0.1596p
+ PS=0.605u PD=1.6u rfmode=0
M$202 \$101 \$34 \$179 VSS sg13_lv_nmos L=0.13u W=0.42u AS=0.1296p AD=0.081p
+ PS=1.52u PD=0.81u rfmode=0
M$203 \$179 \$206 \$102 VSS sg13_lv_nmos L=0.13u W=0.42u AS=0.081p AD=0.2163p
+ PS=0.81u PD=1.87u rfmode=0
M$204 VSS \$34 \$206 VSS sg13_lv_nmos L=0.13u W=0.74u AS=0.43315p AD=0.2516p
+ PS=2.205u PD=2.16u rfmode=0
M$205 VSS CLK \$34 VSS sg13_lv_nmos L=0.13u W=0.74u AS=0.43315p AD=0.2516p
+ PS=2.205u PD=2.16u rfmode=0
M$206 \$104 \$34 \$103 VSS sg13_lv_nmos L=0.13u W=0.42u AS=0.12665p AD=0.1428p
+ PS=1.145u PD=1.52u rfmode=0
M$207 \$33 \$206 \$104 VSS sg13_lv_nmos L=0.13u W=0.74u AS=0.3473p AD=0.12665p
+ PS=2.71u PD=1.145u rfmode=0
M$208 \$109 \$36 VSS VSS sg13_lv_nmos L=0.13u W=1.44u AS=0.4068p AD=0.2772p
+ PS=3.29u PD=2.21u rfmode=0
M$210 \$109 VDD \$110 VSS sg13_lv_nmos L=0.13u W=1.44u AS=0.2772p AD=0.3816p
+ PS=2.21u PD=3.22u rfmode=0
M$212 VSS VDD \$126 VSS sg13_lv_nmos L=0.13u W=0.42u AS=0.1701p AD=0.03885p
+ PS=1.65u PD=0.605u rfmode=0
M$213 \$126 \$37 \$112 VSS sg13_lv_nmos L=0.13u W=0.42u AS=0.03885p AD=0.1596p
+ PS=0.605u PD=1.6u rfmode=0
M$214 \$111 \$38 \$181 VSS sg13_lv_nmos L=0.13u W=0.42u AS=0.1296p AD=0.081p
+ PS=1.52u PD=0.81u rfmode=0
M$215 \$181 \$208 \$112 VSS sg13_lv_nmos L=0.13u W=0.42u AS=0.081p AD=0.2163p
+ PS=0.81u PD=1.87u rfmode=0
M$216 VSS \$38 \$208 VSS sg13_lv_nmos L=0.13u W=0.74u AS=0.43315p AD=0.2516p
+ PS=2.205u PD=2.16u rfmode=0
M$217 VSS CLK \$38 VSS sg13_lv_nmos L=0.13u W=0.74u AS=0.43315p AD=0.2516p
+ PS=2.205u PD=2.16u rfmode=0
M$218 \$114 \$38 \$113 VSS sg13_lv_nmos L=0.13u W=0.42u AS=0.12665p AD=0.1428p
+ PS=1.145u PD=1.52u rfmode=0
M$219 \$37 \$208 \$114 VSS sg13_lv_nmos L=0.13u W=0.74u AS=0.3473p AD=0.12665p
+ PS=2.71u PD=1.145u rfmode=0
M$220 \$251 X8 \$253 VSS sg13_lv_nmos L=0.13u W=0.64u AS=0.2176p AD=0.1216p
+ PS=1.96u PD=1.02u rfmode=0
M$221 VSS X9 \$253 VSS sg13_lv_nmos L=0.13u W=0.64u AS=0.1331p AD=0.1216p
+ PS=1.12u PD=1.02u rfmode=0
M$222 VSS \$251 \$184 VSS sg13_lv_nmos L=0.13u W=1.48u AS=0.2737p AD=0.4218p
+ PS=2.24u PD=3.36u rfmode=0
M$224 VSS X10 \$185 VSS sg13_lv_nmos L=0.13u W=0.55u AS=0.187p AD=0.1045p
+ PS=1.78u PD=0.93u rfmode=0
M$225 \$185 \$184 VSS VSS sg13_lv_nmos L=0.13u W=0.55u AS=0.1045p AD=0.146425p
+ PS=0.93u PD=1.155u rfmode=0
M$226 VSS \$185 \$186 VSS sg13_lv_nmos L=0.13u W=1.48u AS=0.312925p AD=0.4477p
+ PS=2.345u PD=3.43u rfmode=0
M$228 VSS VSS \$189 VSS sg13_lv_nmos L=0.13u W=1u AS=0.265p AD=0.265p PS=2.56u
+ PD=2.56u rfmode=0
M$229 \$189 \$45 OUTP VSS sg13_lv_nmos L=0.13u W=2u AS=0.38p AD=0.38p PS=3.52u
+ PD=3.52u rfmode=0
M$231 \$189 \$47 OUTN VSS sg13_lv_nmos L=0.13u W=2u AS=0.38p AD=0.38p PS=3.52u
+ PD=3.52u rfmode=0
M$238 VSS VSS \$192 VSS sg13_lv_nmos L=0.13u W=1u AS=0.265p AD=0.265p PS=2.56u
+ PD=2.56u rfmode=0
M$239 \$192 \$55 OUTP VSS sg13_lv_nmos L=0.13u W=2u AS=0.38p AD=0.38p PS=3.52u
+ PD=3.52u rfmode=0
M$241 \$192 \$57 OUTN VSS sg13_lv_nmos L=0.13u W=2u AS=0.38p AD=0.38p PS=3.52u
+ PD=3.52u rfmode=0
M$248 VSS VSS \$195 VSS sg13_lv_nmos L=0.13u W=1u AS=0.265p AD=0.265p PS=2.56u
+ PD=2.56u rfmode=0
M$249 \$195 \$65 OUTP VSS sg13_lv_nmos L=0.13u W=2u AS=0.38p AD=0.38p PS=3.52u
+ PD=3.52u rfmode=0
M$251 \$195 \$67 OUTN VSS sg13_lv_nmos L=0.13u W=2u AS=0.38p AD=0.38p PS=3.52u
+ PD=3.52u rfmode=0
M$258 VSS VSS \$198 VSS sg13_lv_nmos L=0.13u W=1u AS=0.265p AD=0.265p PS=2.56u
+ PD=2.56u rfmode=0
M$259 \$198 \$75 OUTP VSS sg13_lv_nmos L=0.13u W=2u AS=0.38p AD=0.38p PS=3.52u
+ PD=3.52u rfmode=0
M$261 \$198 \$77 OUTN VSS sg13_lv_nmos L=0.13u W=2u AS=0.38p AD=0.38p PS=3.52u
+ PD=3.52u rfmode=0
M$268 VSS VSS \$201 VSS sg13_lv_nmos L=0.13u W=1u AS=0.265p AD=0.265p PS=2.56u
+ PD=2.56u rfmode=0
M$269 \$201 \$85 OUTP VSS sg13_lv_nmos L=0.13u W=2u AS=0.38p AD=0.38p PS=3.52u
+ PD=3.52u rfmode=0
M$271 \$201 \$87 OUTN VSS sg13_lv_nmos L=0.13u W=2u AS=0.38p AD=0.38p PS=3.52u
+ PD=3.52u rfmode=0
M$278 VSS VSS \$204 VSS sg13_lv_nmos L=0.13u W=1u AS=0.265p AD=0.265p PS=2.56u
+ PD=2.56u rfmode=0
M$279 \$204 \$95 OUTP VSS sg13_lv_nmos L=0.13u W=2u AS=0.38p AD=0.38p PS=3.52u
+ PD=3.52u rfmode=0
M$281 \$204 \$97 OUTN VSS sg13_lv_nmos L=0.13u W=2u AS=0.38p AD=0.38p PS=3.52u
+ PD=3.52u rfmode=0
M$288 VSS VSS \$207 VSS sg13_lv_nmos L=0.13u W=1u AS=0.265p AD=0.265p PS=2.56u
+ PD=2.56u rfmode=0
M$289 \$207 \$105 OUTP VSS sg13_lv_nmos L=0.13u W=2u AS=0.38p AD=0.38p PS=3.52u
+ PD=3.52u rfmode=0
M$291 \$207 \$107 OUTN VSS sg13_lv_nmos L=0.13u W=2u AS=0.38p AD=0.38p PS=3.52u
+ PD=3.52u rfmode=0
M$298 VSS VSS \$209 VSS sg13_lv_nmos L=0.13u W=1u AS=0.265p AD=0.265p PS=2.56u
+ PD=2.56u rfmode=0
M$299 \$209 \$115 OUTP VSS sg13_lv_nmos L=0.13u W=2u AS=0.38p AD=0.38p PS=3.52u
+ PD=3.52u rfmode=0
M$301 \$209 \$117 OUTN VSS sg13_lv_nmos L=0.13u W=2u AS=0.38p AD=0.38p PS=3.52u
+ PD=3.52u rfmode=0
M$308 VSS X9 \$317 VSS sg13_lv_nmos L=0.13u W=0.55u AS=0.187p AD=0.1045p
+ PS=1.78u PD=0.93u rfmode=0
M$309 \$317 X10 VSS VSS sg13_lv_nmos L=0.13u W=0.55u AS=0.1045p AD=0.146425p
+ PS=0.93u PD=1.155u rfmode=0
M$310 VSS \$317 \$318 VSS sg13_lv_nmos L=0.13u W=1.48u AS=0.312925p AD=0.4477p
+ PS=2.345u PD=3.43u rfmode=0
M$312 VSS X9 \$263 VSS sg13_lv_nmos L=0.13u W=0.55u AS=0.187p AD=0.1045p
+ PS=1.78u PD=0.93u rfmode=0
M$313 VSS X8 \$263 VSS sg13_lv_nmos L=0.13u W=0.55u AS=0.146425p AD=0.1045p
+ PS=1.155u PD=0.93u rfmode=0
M$314 VSS \$263 \$264 VSS sg13_lv_nmos L=0.13u W=1.48u AS=0.312925p AD=0.4477p
+ PS=2.345u PD=3.43u rfmode=0
M$316 VSS X8 \$319 VSS sg13_lv_nmos L=0.13u W=0.55u AS=0.187p AD=0.1045p
+ PS=1.78u PD=0.93u rfmode=0
M$317 \$319 \$318 VSS VSS sg13_lv_nmos L=0.13u W=0.55u AS=0.1045p AD=0.146425p
+ PS=0.93u PD=1.155u rfmode=0
M$318 VSS \$319 \$320 VSS sg13_lv_nmos L=0.13u W=1.48u AS=0.312925p AD=0.4477p
+ PS=2.345u PD=3.43u rfmode=0
M$320 \$265 X10 \$321 VSS sg13_lv_nmos L=0.13u W=0.64u AS=0.2176p AD=0.1216p
+ PS=1.96u PD=1.02u rfmode=0
M$321 \$321 \$264 VSS VSS sg13_lv_nmos L=0.13u W=0.64u AS=0.1216p AD=0.1331p
+ PS=1.02u PD=1.12u rfmode=0
M$322 VSS \$265 \$266 VSS sg13_lv_nmos L=0.13u W=1.48u AS=0.2737p AD=0.4218p
+ PS=2.24u PD=3.36u rfmode=0
M$324 VSS \$187 \$327 VSS sg13_lv_nmos L=0.13u W=0.55u AS=0.187p AD=0.1045p
+ PS=1.78u PD=0.93u rfmode=0
M$325 \$327 \$318 VSS VSS sg13_lv_nmos L=0.13u W=0.55u AS=0.1045p AD=0.146425p
+ PS=0.93u PD=1.155u rfmode=0
M$326 VSS \$327 \$328 VSS sg13_lv_nmos L=0.13u W=1.48u AS=0.312925p AD=0.4477p
+ PS=2.345u PD=3.43u rfmode=0
M$328 \$377 \$376 \$449 VSS sg13_lv_nmos L=0.13u W=0.42u AS=0.1428p AD=0.0609p
+ PS=1.52u PD=0.71u rfmode=0
M$329 \$449 VDD VSS VSS sg13_lv_nmos L=0.13u W=0.42u AS=0.0609p AD=0.1626p
+ PS=0.71u PD=1.415u rfmode=0
M$330 VSS \$494 \$329 VSS sg13_lv_nmos L=0.13u W=0.74u AS=0.1626p AD=0.2516p
+ PS=1.415u PD=2.16u rfmode=0
M$331 \$380 \$495 VSS VSS sg13_lv_nmos L=0.13u W=0.42u AS=0.1428p AD=0.0798p
+ PS=1.52u PD=0.8u rfmode=0
M$332 VSS VDD \$452 VSS sg13_lv_nmos L=0.13u W=0.42u AS=0.0798p AD=0.0378p
+ PS=0.8u PD=0.6u rfmode=0
M$333 \$452 \$381 \$495 VSS sg13_lv_nmos L=0.13u W=0.42u AS=0.0378p AD=0.1428p
+ PS=0.6u PD=1.52u rfmode=0
M$334 VSS \$381 \$332 VSS sg13_lv_nmos L=0.13u W=0.64u AS=0.1331p AD=0.2176p
+ PS=1.12u PD=1.96u rfmode=0
M$335 VSS \$381 \$331 VSS sg13_lv_nmos L=0.13u W=1.48u AS=0.3922p AD=0.2737p
+ PS=3.28u PD=2.24u rfmode=0
M$337 VSS \$332 \$382 VSS sg13_lv_nmos L=0.13u W=1.48u AS=0.3922p AD=0.3922p
+ PS=3.28u PD=3.28u rfmode=0
M$339 VSS \$190 \$333 VSS sg13_lv_nmos L=0.13u W=0.55u AS=0.187p AD=0.1045p
+ PS=1.78u PD=0.93u rfmode=0
M$340 \$333 \$318 VSS VSS sg13_lv_nmos L=0.13u W=0.55u AS=0.1045p AD=0.146425p
+ PS=0.93u PD=1.155u rfmode=0
M$341 VSS \$333 \$334 VSS sg13_lv_nmos L=0.13u W=1.48u AS=0.312925p AD=0.4477p
+ PS=2.345u PD=3.43u rfmode=0
M$343 \$386 \$385 \$459 VSS sg13_lv_nmos L=0.13u W=0.42u AS=0.1428p AD=0.0609p
+ PS=1.52u PD=0.71u rfmode=0
M$344 \$459 VDD VSS VSS sg13_lv_nmos L=0.13u W=0.42u AS=0.0609p AD=0.1626p
+ PS=0.71u PD=1.415u rfmode=0
M$345 VSS \$496 \$335 VSS sg13_lv_nmos L=0.13u W=0.74u AS=0.1626p AD=0.2516p
+ PS=1.415u PD=2.16u rfmode=0
M$346 \$389 \$497 VSS VSS sg13_lv_nmos L=0.13u W=0.42u AS=0.1428p AD=0.0798p
+ PS=1.52u PD=0.8u rfmode=0
M$347 VSS VDD \$463 VSS sg13_lv_nmos L=0.13u W=0.42u AS=0.0798p AD=0.0378p
+ PS=0.8u PD=0.6u rfmode=0
M$348 \$463 \$390 \$497 VSS sg13_lv_nmos L=0.13u W=0.42u AS=0.0378p AD=0.1428p
+ PS=0.6u PD=1.52u rfmode=0
M$349 VSS \$390 \$338 VSS sg13_lv_nmos L=0.13u W=0.64u AS=0.1331p AD=0.2176p
+ PS=1.12u PD=1.96u rfmode=0
M$350 VSS \$390 \$337 VSS sg13_lv_nmos L=0.13u W=1.48u AS=0.3922p AD=0.2737p
+ PS=3.28u PD=2.24u rfmode=0
M$352 VSS \$338 \$391 VSS sg13_lv_nmos L=0.13u W=1.48u AS=0.3922p AD=0.3922p
+ PS=3.28u PD=3.28u rfmode=0
M$354 VSS \$193 \$339 VSS sg13_lv_nmos L=0.13u W=0.55u AS=0.187p AD=0.1045p
+ PS=1.78u PD=0.93u rfmode=0
M$355 \$339 \$318 VSS VSS sg13_lv_nmos L=0.13u W=0.55u AS=0.1045p AD=0.146425p
+ PS=0.93u PD=1.155u rfmode=0
M$356 VSS \$339 \$340 VSS sg13_lv_nmos L=0.13u W=1.48u AS=0.312925p AD=0.4477p
+ PS=2.345u PD=3.43u rfmode=0
M$358 \$395 \$394 \$470 VSS sg13_lv_nmos L=0.13u W=0.42u AS=0.1428p AD=0.0609p
+ PS=1.52u PD=0.71u rfmode=0
M$359 \$470 VDD VSS VSS sg13_lv_nmos L=0.13u W=0.42u AS=0.0609p AD=0.1626p
+ PS=0.71u PD=1.415u rfmode=0
M$360 VSS \$498 \$341 VSS sg13_lv_nmos L=0.13u W=0.74u AS=0.1626p AD=0.2516p
+ PS=1.415u PD=2.16u rfmode=0
M$361 \$398 \$499 VSS VSS sg13_lv_nmos L=0.13u W=0.42u AS=0.1428p AD=0.0798p
+ PS=1.52u PD=0.8u rfmode=0
M$362 VSS VDD \$474 VSS sg13_lv_nmos L=0.13u W=0.42u AS=0.0798p AD=0.0378p
+ PS=0.8u PD=0.6u rfmode=0
M$363 \$474 \$399 \$499 VSS sg13_lv_nmos L=0.13u W=0.42u AS=0.0378p AD=0.1428p
+ PS=0.6u PD=1.52u rfmode=0
M$364 VSS \$399 \$344 VSS sg13_lv_nmos L=0.13u W=0.64u AS=0.1331p AD=0.2176p
+ PS=1.12u PD=1.96u rfmode=0
M$365 VSS \$399 \$343 VSS sg13_lv_nmos L=0.13u W=1.48u AS=0.3922p AD=0.2737p
+ PS=3.28u PD=2.24u rfmode=0
M$367 VSS \$344 \$400 VSS sg13_lv_nmos L=0.13u W=1.48u AS=0.3922p AD=0.3922p
+ PS=3.28u PD=3.28u rfmode=0
M$369 VSS \$196 \$345 VSS sg13_lv_nmos L=0.13u W=0.55u AS=0.187p AD=0.1045p
+ PS=1.78u PD=0.93u rfmode=0
M$370 \$345 \$318 VSS VSS sg13_lv_nmos L=0.13u W=0.55u AS=0.1045p AD=0.146425p
+ PS=0.93u PD=1.155u rfmode=0
M$371 VSS \$345 \$346 VSS sg13_lv_nmos L=0.13u W=1.48u AS=0.312925p AD=0.4477p
+ PS=2.345u PD=3.43u rfmode=0
M$373 \$404 \$403 \$482 VSS sg13_lv_nmos L=0.13u W=0.42u AS=0.1428p AD=0.0609p
+ PS=1.52u PD=0.71u rfmode=0
M$374 \$482 VDD VSS VSS sg13_lv_nmos L=0.13u W=0.42u AS=0.0609p AD=0.1626p
+ PS=0.71u PD=1.415u rfmode=0
M$375 VSS \$500 \$347 VSS sg13_lv_nmos L=0.13u W=0.74u AS=0.1626p AD=0.2516p
+ PS=1.415u PD=2.16u rfmode=0
M$376 \$407 \$501 VSS VSS sg13_lv_nmos L=0.13u W=0.42u AS=0.1428p AD=0.0798p
+ PS=1.52u PD=0.8u rfmode=0
M$377 VSS VDD \$485 VSS sg13_lv_nmos L=0.13u W=0.42u AS=0.0798p AD=0.0378p
+ PS=0.8u PD=0.6u rfmode=0
M$378 \$485 \$408 \$501 VSS sg13_lv_nmos L=0.13u W=0.42u AS=0.0378p AD=0.1428p
+ PS=0.6u PD=1.52u rfmode=0
M$379 VSS \$408 \$350 VSS sg13_lv_nmos L=0.13u W=0.64u AS=0.1331p AD=0.2176p
+ PS=1.12u PD=1.96u rfmode=0
M$380 VSS \$408 \$349 VSS sg13_lv_nmos L=0.13u W=1.48u AS=0.3922p AD=0.2737p
+ PS=3.28u PD=2.24u rfmode=0
M$382 VSS \$350 \$409 VSS sg13_lv_nmos L=0.13u W=1.48u AS=0.3922p AD=0.3922p
+ PS=3.28u PD=3.28u rfmode=0
M$384 VSS \$199 \$351 VSS sg13_lv_nmos L=0.13u W=0.55u AS=0.187p AD=0.1045p
+ PS=1.78u PD=0.93u rfmode=0
M$385 \$351 \$318 VSS VSS sg13_lv_nmos L=0.13u W=0.55u AS=0.1045p AD=0.146425p
+ PS=0.93u PD=1.155u rfmode=0
M$386 VSS \$351 \$352 VSS sg13_lv_nmos L=0.13u W=1.48u AS=0.312925p AD=0.4477p
+ PS=2.345u PD=3.43u rfmode=0
M$388 \$413 \$412 \$493 VSS sg13_lv_nmos L=0.13u W=0.42u AS=0.1428p AD=0.0609p
+ PS=1.52u PD=0.71u rfmode=0
M$389 \$493 VDD VSS VSS sg13_lv_nmos L=0.13u W=0.42u AS=0.0609p AD=0.1626p
+ PS=0.71u PD=1.415u rfmode=0
M$390 VSS \$502 \$353 VSS sg13_lv_nmos L=0.13u W=0.74u AS=0.1626p AD=0.2516p
+ PS=1.415u PD=2.16u rfmode=0
M$391 \$416 \$503 VSS VSS sg13_lv_nmos L=0.13u W=0.42u AS=0.1428p AD=0.0798p
+ PS=1.52u PD=0.8u rfmode=0
M$392 VSS VDD \$491 VSS sg13_lv_nmos L=0.13u W=0.42u AS=0.0798p AD=0.0378p
+ PS=0.8u PD=0.6u rfmode=0
M$393 \$491 \$417 \$503 VSS sg13_lv_nmos L=0.13u W=0.42u AS=0.0378p AD=0.1428p
+ PS=0.6u PD=1.52u rfmode=0
M$394 VSS \$417 \$356 VSS sg13_lv_nmos L=0.13u W=0.64u AS=0.1331p AD=0.2176p
+ PS=1.12u PD=1.96u rfmode=0
M$395 VSS \$417 \$355 VSS sg13_lv_nmos L=0.13u W=1.48u AS=0.3922p AD=0.2737p
+ PS=3.28u PD=2.24u rfmode=0
M$397 VSS \$356 \$418 VSS sg13_lv_nmos L=0.13u W=1.48u AS=0.3922p AD=0.3922p
+ PS=3.28u PD=3.28u rfmode=0
M$399 VSS \$202 \$357 VSS sg13_lv_nmos L=0.13u W=0.55u AS=0.187p AD=0.1045p
+ PS=1.78u PD=0.93u rfmode=0
M$400 \$357 \$318 VSS VSS sg13_lv_nmos L=0.13u W=0.55u AS=0.1045p AD=0.146425p
+ PS=0.93u PD=1.155u rfmode=0
M$401 VSS \$357 \$358 VSS sg13_lv_nmos L=0.13u W=1.48u AS=0.312925p AD=0.4477p
+ PS=2.345u PD=3.43u rfmode=0
M$403 \$422 \$421 \$481 VSS sg13_lv_nmos L=0.13u W=0.42u AS=0.1428p AD=0.0609p
+ PS=1.52u PD=0.71u rfmode=0
M$404 \$481 VDD VSS VSS sg13_lv_nmos L=0.13u W=0.42u AS=0.0609p AD=0.1626p
+ PS=0.71u PD=1.415u rfmode=0
M$405 VSS \$504 \$359 VSS sg13_lv_nmos L=0.13u W=0.74u AS=0.1626p AD=0.2516p
+ PS=1.415u PD=2.16u rfmode=0
M$406 \$425 \$505 VSS VSS sg13_lv_nmos L=0.13u W=0.42u AS=0.1428p AD=0.0798p
+ PS=1.52u PD=0.8u rfmode=0
M$407 VSS VDD \$478 VSS sg13_lv_nmos L=0.13u W=0.42u AS=0.0798p AD=0.0378p
+ PS=0.8u PD=0.6u rfmode=0
M$408 \$478 \$426 \$505 VSS sg13_lv_nmos L=0.13u W=0.42u AS=0.0378p AD=0.1428p
+ PS=0.6u PD=1.52u rfmode=0
M$409 VSS \$426 \$362 VSS sg13_lv_nmos L=0.13u W=0.64u AS=0.1331p AD=0.2176p
+ PS=1.12u PD=1.96u rfmode=0
M$410 VSS \$426 \$361 VSS sg13_lv_nmos L=0.13u W=1.48u AS=0.3922p AD=0.2737p
+ PS=3.28u PD=2.24u rfmode=0
M$412 VSS \$362 \$427 VSS sg13_lv_nmos L=0.13u W=1.48u AS=0.3922p AD=0.3922p
+ PS=3.28u PD=3.28u rfmode=0
M$414 VSS \$205 \$363 VSS sg13_lv_nmos L=0.13u W=0.55u AS=0.187p AD=0.1045p
+ PS=1.78u PD=0.93u rfmode=0
M$415 \$363 \$318 VSS VSS sg13_lv_nmos L=0.13u W=0.55u AS=0.1045p AD=0.146425p
+ PS=0.93u PD=1.155u rfmode=0
M$416 VSS \$363 \$364 VSS sg13_lv_nmos L=0.13u W=1.48u AS=0.312925p AD=0.4477p
+ PS=2.345u PD=3.43u rfmode=0
M$418 \$517 \$430 \$468 VSS sg13_lv_nmos L=0.13u W=0.42u AS=0.1428p AD=0.0609p
+ PS=1.52u PD=0.71u rfmode=0
M$419 \$468 VDD VSS VSS sg13_lv_nmos L=0.13u W=0.42u AS=0.0609p AD=0.1626p
+ PS=0.71u PD=1.415u rfmode=0
M$420 VSS \$506 \$365 VSS sg13_lv_nmos L=0.13u W=0.74u AS=0.1626p AD=0.2516p
+ PS=1.415u PD=2.16u rfmode=0
M$421 \$433 \$507 VSS VSS sg13_lv_nmos L=0.13u W=0.42u AS=0.1428p AD=0.0798p
+ PS=1.52u PD=0.8u rfmode=0
M$422 VSS VDD \$464 VSS sg13_lv_nmos L=0.13u W=0.42u AS=0.0798p AD=0.0378p
+ PS=0.8u PD=0.6u rfmode=0
M$423 \$464 \$434 \$507 VSS sg13_lv_nmos L=0.13u W=0.42u AS=0.0378p AD=0.1428p
+ PS=0.6u PD=1.52u rfmode=0
M$424 VSS \$434 \$368 VSS sg13_lv_nmos L=0.13u W=0.64u AS=0.1331p AD=0.2176p
+ PS=1.12u PD=1.96u rfmode=0
M$425 VSS \$434 \$367 VSS sg13_lv_nmos L=0.13u W=1.48u AS=0.3922p AD=0.2737p
+ PS=3.28u PD=2.24u rfmode=0
M$427 VSS \$368 \$435 VSS sg13_lv_nmos L=0.13u W=1.48u AS=0.3922p AD=0.3922p
+ PS=3.28u PD=3.28u rfmode=0
M$429 VSS VSS \$369 VSS sg13_lv_nmos L=0.13u W=0.55u AS=0.187p AD=0.1045p
+ PS=1.78u PD=0.93u rfmode=0
M$430 \$369 \$318 VSS VSS sg13_lv_nmos L=0.13u W=0.55u AS=0.1045p AD=0.146425p
+ PS=0.93u PD=1.155u rfmode=0
M$431 VSS \$369 \$370 VSS sg13_lv_nmos L=0.13u W=1.48u AS=0.312925p AD=0.4477p
+ PS=2.345u PD=3.43u rfmode=0
M$433 \$439 \$438 \$454 VSS sg13_lv_nmos L=0.13u W=0.42u AS=0.1428p AD=0.0609p
+ PS=1.52u PD=0.71u rfmode=0
M$434 \$454 VDD VSS VSS sg13_lv_nmos L=0.13u W=0.42u AS=0.0609p AD=0.1626p
+ PS=0.71u PD=1.415u rfmode=0
M$435 VSS \$508 \$371 VSS sg13_lv_nmos L=0.13u W=0.74u AS=0.1626p AD=0.2516p
+ PS=1.415u PD=2.16u rfmode=0
M$436 \$442 \$509 VSS VSS sg13_lv_nmos L=0.13u W=0.42u AS=0.1428p AD=0.0798p
+ PS=1.52u PD=0.8u rfmode=0
M$437 VSS VDD \$451 VSS sg13_lv_nmos L=0.13u W=0.42u AS=0.0798p AD=0.0378p
+ PS=0.8u PD=0.6u rfmode=0
M$438 \$451 \$443 \$509 VSS sg13_lv_nmos L=0.13u W=0.42u AS=0.0378p AD=0.1428p
+ PS=0.6u PD=1.52u rfmode=0
M$439 VSS \$443 \$374 VSS sg13_lv_nmos L=0.13u W=0.64u AS=0.1331p AD=0.2176p
+ PS=1.12u PD=1.96u rfmode=0
M$440 VSS \$443 \$373 VSS sg13_lv_nmos L=0.13u W=1.48u AS=0.3922p AD=0.2737p
+ PS=3.28u PD=2.24u rfmode=0
M$442 VSS \$374 \$444 VSS sg13_lv_nmos L=0.13u W=1.48u AS=0.3922p AD=0.3922p
+ PS=3.28u PD=3.28u rfmode=0
M$444 \$375 \$328 VSS VSS sg13_lv_nmos L=0.13u W=1.44u AS=0.4068p AD=0.2772p
+ PS=3.29u PD=2.21u rfmode=0
M$446 \$375 \$320 \$376 VSS sg13_lv_nmos L=0.13u W=1.44u AS=0.2772p AD=0.3816p
+ PS=2.21u PD=3.22u rfmode=0
M$448 VSS VDD \$450 VSS sg13_lv_nmos L=0.13u W=0.42u AS=0.1701p AD=0.03885p
+ PS=1.65u PD=0.605u rfmode=0
M$449 \$450 \$329 \$378 VSS sg13_lv_nmos L=0.13u W=0.42u AS=0.03885p AD=0.1596p
+ PS=0.605u PD=1.6u rfmode=0
M$450 VSS \$330 \$379 VSS sg13_lv_nmos L=0.13u W=0.74u AS=0.43315p AD=0.2516p
+ PS=2.205u PD=2.16u rfmode=0
M$451 VSS CLK \$330 VSS sg13_lv_nmos L=0.13u W=0.74u AS=0.43315p AD=0.2516p
+ PS=2.205u PD=2.16u rfmode=0
M$452 \$381 \$330 \$380 VSS sg13_lv_nmos L=0.13u W=0.42u AS=0.12665p AD=0.1428p
+ PS=1.145u PD=1.52u rfmode=0
M$453 \$329 \$379 \$381 VSS sg13_lv_nmos L=0.13u W=0.74u AS=0.3473p AD=0.12665p
+ PS=2.71u PD=1.145u rfmode=0
M$454 \$384 \$334 VSS VSS sg13_lv_nmos L=0.13u W=1.44u AS=0.4068p AD=0.2772p
+ PS=3.29u PD=2.21u rfmode=0
M$456 \$384 \$320 \$385 VSS sg13_lv_nmos L=0.13u W=1.44u AS=0.2772p AD=0.3816p
+ PS=2.21u PD=3.22u rfmode=0
M$458 VSS VDD \$460 VSS sg13_lv_nmos L=0.13u W=0.42u AS=0.1701p AD=0.03885p
+ PS=1.65u PD=0.605u rfmode=0
M$459 \$460 \$335 \$387 VSS sg13_lv_nmos L=0.13u W=0.42u AS=0.03885p AD=0.1596p
+ PS=0.605u PD=1.6u rfmode=0
M$460 VSS \$336 \$388 VSS sg13_lv_nmos L=0.13u W=0.74u AS=0.43315p AD=0.2516p
+ PS=2.205u PD=2.16u rfmode=0
M$461 VSS CLK \$336 VSS sg13_lv_nmos L=0.13u W=0.74u AS=0.43315p AD=0.2516p
+ PS=2.205u PD=2.16u rfmode=0
M$462 \$390 \$336 \$389 VSS sg13_lv_nmos L=0.13u W=0.42u AS=0.12665p AD=0.1428p
+ PS=1.145u PD=1.52u rfmode=0
M$463 \$335 \$388 \$390 VSS sg13_lv_nmos L=0.13u W=0.74u AS=0.3473p AD=0.12665p
+ PS=2.71u PD=1.145u rfmode=0
M$464 \$393 \$340 VSS VSS sg13_lv_nmos L=0.13u W=1.44u AS=0.4068p AD=0.2772p
+ PS=3.29u PD=2.21u rfmode=0
M$466 \$393 \$320 \$394 VSS sg13_lv_nmos L=0.13u W=1.44u AS=0.2772p AD=0.3816p
+ PS=2.21u PD=3.22u rfmode=0
M$468 VSS VDD \$471 VSS sg13_lv_nmos L=0.13u W=0.42u AS=0.1701p AD=0.03885p
+ PS=1.65u PD=0.605u rfmode=0
M$469 \$471 \$341 \$396 VSS sg13_lv_nmos L=0.13u W=0.42u AS=0.03885p AD=0.1596p
+ PS=0.605u PD=1.6u rfmode=0
M$470 VSS \$342 \$397 VSS sg13_lv_nmos L=0.13u W=0.74u AS=0.43315p AD=0.2516p
+ PS=2.205u PD=2.16u rfmode=0
M$471 VSS CLK \$342 VSS sg13_lv_nmos L=0.13u W=0.74u AS=0.43315p AD=0.2516p
+ PS=2.205u PD=2.16u rfmode=0
M$472 \$399 \$342 \$398 VSS sg13_lv_nmos L=0.13u W=0.42u AS=0.12665p AD=0.1428p
+ PS=1.145u PD=1.52u rfmode=0
M$473 \$341 \$397 \$399 VSS sg13_lv_nmos L=0.13u W=0.74u AS=0.3473p AD=0.12665p
+ PS=2.71u PD=1.145u rfmode=0
M$474 \$402 \$346 VSS VSS sg13_lv_nmos L=0.13u W=1.44u AS=0.4068p AD=0.2772p
+ PS=3.29u PD=2.21u rfmode=0
M$476 \$402 \$320 \$403 VSS sg13_lv_nmos L=0.13u W=1.44u AS=0.2772p AD=0.3816p
+ PS=2.21u PD=3.22u rfmode=0
M$478 VSS VDD \$483 VSS sg13_lv_nmos L=0.13u W=0.42u AS=0.1701p AD=0.03885p
+ PS=1.65u PD=0.605u rfmode=0
M$479 \$483 \$347 \$405 VSS sg13_lv_nmos L=0.13u W=0.42u AS=0.03885p AD=0.1596p
+ PS=0.605u PD=1.6u rfmode=0
M$480 VSS \$348 \$406 VSS sg13_lv_nmos L=0.13u W=0.74u AS=0.43315p AD=0.2516p
+ PS=2.205u PD=2.16u rfmode=0
M$481 VSS CLK \$348 VSS sg13_lv_nmos L=0.13u W=0.74u AS=0.43315p AD=0.2516p
+ PS=2.205u PD=2.16u rfmode=0
M$482 \$408 \$348 \$407 VSS sg13_lv_nmos L=0.13u W=0.42u AS=0.12665p AD=0.1428p
+ PS=1.145u PD=1.52u rfmode=0
M$483 \$347 \$406 \$408 VSS sg13_lv_nmos L=0.13u W=0.74u AS=0.3473p AD=0.12665p
+ PS=2.71u PD=1.145u rfmode=0
M$484 \$411 \$352 VSS VSS sg13_lv_nmos L=0.13u W=1.44u AS=0.4068p AD=0.2772p
+ PS=3.29u PD=2.21u rfmode=0
M$486 \$411 \$320 \$412 VSS sg13_lv_nmos L=0.13u W=1.44u AS=0.2772p AD=0.3816p
+ PS=2.21u PD=3.22u rfmode=0
M$488 VSS VDD \$492 VSS sg13_lv_nmos L=0.13u W=0.42u AS=0.1701p AD=0.03885p
+ PS=1.65u PD=0.605u rfmode=0
M$489 \$492 \$353 \$414 VSS sg13_lv_nmos L=0.13u W=0.42u AS=0.03885p AD=0.1596p
+ PS=0.605u PD=1.6u rfmode=0
M$490 VSS \$354 \$415 VSS sg13_lv_nmos L=0.13u W=0.74u AS=0.43315p AD=0.2516p
+ PS=2.205u PD=2.16u rfmode=0
M$491 VSS CLK \$354 VSS sg13_lv_nmos L=0.13u W=0.74u AS=0.43315p AD=0.2516p
+ PS=2.205u PD=2.16u rfmode=0
M$492 \$417 \$354 \$416 VSS sg13_lv_nmos L=0.13u W=0.42u AS=0.12665p AD=0.1428p
+ PS=1.145u PD=1.52u rfmode=0
M$493 \$353 \$415 \$417 VSS sg13_lv_nmos L=0.13u W=0.74u AS=0.3473p AD=0.12665p
+ PS=2.71u PD=1.145u rfmode=0
M$494 \$420 \$358 VSS VSS sg13_lv_nmos L=0.13u W=1.44u AS=0.4068p AD=0.2772p
+ PS=3.29u PD=2.21u rfmode=0
M$496 \$420 \$320 \$421 VSS sg13_lv_nmos L=0.13u W=1.44u AS=0.2772p AD=0.3816p
+ PS=2.21u PD=3.22u rfmode=0
M$498 VSS VDD \$480 VSS sg13_lv_nmos L=0.13u W=0.42u AS=0.1701p AD=0.03885p
+ PS=1.65u PD=0.605u rfmode=0
M$499 \$480 \$359 \$423 VSS sg13_lv_nmos L=0.13u W=0.42u AS=0.03885p AD=0.1596p
+ PS=0.605u PD=1.6u rfmode=0
M$500 VSS \$360 \$424 VSS sg13_lv_nmos L=0.13u W=0.74u AS=0.43315p AD=0.2516p
+ PS=2.205u PD=2.16u rfmode=0
M$501 VSS CLK \$360 VSS sg13_lv_nmos L=0.13u W=0.74u AS=0.43315p AD=0.2516p
+ PS=2.205u PD=2.16u rfmode=0
M$502 \$426 \$360 \$425 VSS sg13_lv_nmos L=0.13u W=0.42u AS=0.12665p AD=0.1428p
+ PS=1.145u PD=1.52u rfmode=0
M$503 \$359 \$424 \$426 VSS sg13_lv_nmos L=0.13u W=0.74u AS=0.3473p AD=0.12665p
+ PS=2.71u PD=1.145u rfmode=0
M$504 \$429 \$364 VSS VSS sg13_lv_nmos L=0.13u W=1.44u AS=0.4068p AD=0.2772p
+ PS=3.29u PD=2.21u rfmode=0
M$506 \$429 \$320 \$430 VSS sg13_lv_nmos L=0.13u W=1.44u AS=0.2772p AD=0.3816p
+ PS=2.21u PD=3.22u rfmode=0
M$508 VSS VDD \$467 VSS sg13_lv_nmos L=0.13u W=0.42u AS=0.1701p AD=0.03885p
+ PS=1.65u PD=0.605u rfmode=0
M$509 \$467 \$365 \$431 VSS sg13_lv_nmos L=0.13u W=0.42u AS=0.03885p AD=0.1596p
+ PS=0.605u PD=1.6u rfmode=0
M$510 VSS \$366 \$432 VSS sg13_lv_nmos L=0.13u W=0.74u AS=0.43315p AD=0.2516p
+ PS=2.205u PD=2.16u rfmode=0
M$511 VSS CLK \$366 VSS sg13_lv_nmos L=0.13u W=0.74u AS=0.43315p AD=0.2516p
+ PS=2.205u PD=2.16u rfmode=0
M$512 \$434 \$366 \$433 VSS sg13_lv_nmos L=0.13u W=0.42u AS=0.12665p AD=0.1428p
+ PS=1.145u PD=1.52u rfmode=0
M$513 \$365 \$432 \$434 VSS sg13_lv_nmos L=0.13u W=0.74u AS=0.3473p AD=0.12665p
+ PS=2.71u PD=1.145u rfmode=0
M$514 \$437 \$370 VSS VSS sg13_lv_nmos L=0.13u W=1.44u AS=0.4068p AD=0.2772p
+ PS=3.29u PD=2.21u rfmode=0
M$516 \$437 \$320 \$438 VSS sg13_lv_nmos L=0.13u W=1.44u AS=0.2772p AD=0.3816p
+ PS=2.21u PD=3.22u rfmode=0
M$518 VSS VDD \$453 VSS sg13_lv_nmos L=0.13u W=0.42u AS=0.1701p AD=0.03885p
+ PS=1.65u PD=0.605u rfmode=0
M$519 \$453 \$371 \$440 VSS sg13_lv_nmos L=0.13u W=0.42u AS=0.03885p AD=0.1596p
+ PS=0.605u PD=1.6u rfmode=0
M$520 VSS \$372 \$441 VSS sg13_lv_nmos L=0.13u W=0.74u AS=0.43315p AD=0.2516p
+ PS=2.205u PD=2.16u rfmode=0
M$521 VSS CLK \$372 VSS sg13_lv_nmos L=0.13u W=0.74u AS=0.43315p AD=0.2516p
+ PS=2.205u PD=2.16u rfmode=0
M$522 \$443 \$372 \$442 VSS sg13_lv_nmos L=0.13u W=0.42u AS=0.12665p AD=0.1428p
+ PS=1.145u PD=1.52u rfmode=0
M$523 \$371 \$441 \$443 VSS sg13_lv_nmos L=0.13u W=0.74u AS=0.3473p AD=0.12665p
+ PS=2.71u PD=1.145u rfmode=0
M$524 \$568 X8 \$572 VSS sg13_lv_nmos L=0.13u W=0.64u AS=0.2176p AD=0.1216p
+ PS=1.96u PD=1.02u rfmode=0
M$525 VSS X9 \$572 VSS sg13_lv_nmos L=0.13u W=0.64u AS=0.1331p AD=0.1216p
+ PS=1.12u PD=1.02u rfmode=0
M$526 VSS \$568 \$569 VSS sg13_lv_nmos L=0.13u W=1.48u AS=0.2737p AD=0.4218p
+ PS=2.24u PD=3.36u rfmode=0
M$528 \$325 X9 \$510 VSS sg13_lv_nmos L=0.13u W=0.64u AS=0.2176p AD=0.1216p
+ PS=1.96u PD=1.02u rfmode=0
M$529 \$510 X10 VSS VSS sg13_lv_nmos L=0.13u W=0.64u AS=0.1216p AD=0.1331p
+ PS=1.02u PD=1.12u rfmode=0
M$530 VSS \$325 \$326 VSS sg13_lv_nmos L=0.13u W=1.48u AS=0.2737p AD=0.4218p
+ PS=2.24u PD=3.36u rfmode=0
M$532 \$570 X10 \$573 VSS sg13_lv_nmos L=0.13u W=0.64u AS=0.2176p AD=0.1216p
+ PS=1.96u PD=1.02u rfmode=0
M$533 VSS \$569 \$573 VSS sg13_lv_nmos L=0.13u W=0.64u AS=0.1331p AD=0.1216p
+ PS=1.12u PD=1.02u rfmode=0
M$534 VSS \$570 \$571 VSS sg13_lv_nmos L=0.13u W=1.48u AS=0.2737p AD=0.4218p
+ PS=2.24u PD=3.36u rfmode=0
M$536 VSS \$187 \$622 VSS sg13_lv_nmos L=0.13u W=0.55u AS=0.187p AD=0.1045p
+ PS=1.78u PD=0.93u rfmode=0
M$537 \$622 \$186 VSS VSS sg13_lv_nmos L=0.13u W=0.55u AS=0.1045p AD=0.146425p
+ PS=0.93u PD=1.155u rfmode=0
M$538 VSS \$622 \$623 VSS sg13_lv_nmos L=0.13u W=1.48u AS=0.312925p AD=0.4477p
+ PS=2.345u PD=3.43u rfmode=0
M$540 \$656 \$655 \$735 VSS sg13_lv_nmos L=0.13u W=0.42u AS=0.1428p AD=0.0609p
+ PS=1.52u PD=0.71u rfmode=0
M$541 \$735 VDD VSS VSS sg13_lv_nmos L=0.13u W=0.42u AS=0.0609p AD=0.1626p
+ PS=0.71u PD=1.415u rfmode=0
M$542 VSS \$782 \$624 VSS sg13_lv_nmos L=0.13u W=0.74u AS=0.1626p AD=0.2516p
+ PS=1.415u PD=2.16u rfmode=0
M$543 \$377 \$330 \$494 VSS sg13_lv_nmos L=0.13u W=0.42u AS=0.1296p AD=0.081p
+ PS=1.52u PD=0.81u rfmode=0
M$544 \$494 \$379 \$378 VSS sg13_lv_nmos L=0.13u W=0.42u AS=0.081p AD=0.2163p
+ PS=0.81u PD=1.87u rfmode=0
M$545 \$658 \$783 VSS VSS sg13_lv_nmos L=0.13u W=0.42u AS=0.1428p AD=0.0798p
+ PS=1.52u PD=0.8u rfmode=0
M$546 VSS VDD \$740 VSS sg13_lv_nmos L=0.13u W=0.42u AS=0.0798p AD=0.0378p
+ PS=0.8u PD=0.6u rfmode=0
M$547 \$740 \$659 \$783 VSS sg13_lv_nmos L=0.13u W=0.42u AS=0.0378p AD=0.1428p
+ PS=0.6u PD=1.52u rfmode=0
M$548 VSS \$659 \$661 VSS sg13_lv_nmos L=0.13u W=0.64u AS=0.1331p AD=0.2176p
+ PS=1.12u PD=1.96u rfmode=0
M$549 VSS \$659 \$660 VSS sg13_lv_nmos L=0.13u W=1.48u AS=0.3922p AD=0.2737p
+ PS=3.28u PD=2.24u rfmode=0
M$551 VSS \$661 \$662 VSS sg13_lv_nmos L=0.13u W=1.48u AS=0.3922p AD=0.3922p
+ PS=3.28u PD=3.28u rfmode=0
M$553 VSS VSS \$511 VSS sg13_lv_nmos L=0.13u W=1u AS=0.265p AD=0.265p PS=2.56u
+ PD=2.56u rfmode=0
M$554 \$511 \$331 OUTP VSS sg13_lv_nmos L=0.13u W=2u AS=0.38p AD=0.38p PS=3.52u
+ PD=3.52u rfmode=0
M$556 \$511 \$382 OUTN VSS sg13_lv_nmos L=0.13u W=2u AS=0.38p AD=0.38p PS=3.52u
+ PD=3.52u rfmode=0
M$563 VSS \$190 \$626 VSS sg13_lv_nmos L=0.13u W=0.55u AS=0.187p AD=0.1045p
+ PS=1.78u PD=0.93u rfmode=0
M$564 \$626 \$186 VSS VSS sg13_lv_nmos L=0.13u W=0.55u AS=0.1045p AD=0.146425p
+ PS=0.93u PD=1.155u rfmode=0
M$565 VSS \$626 \$627 VSS sg13_lv_nmos L=0.13u W=1.48u AS=0.312925p AD=0.4477p
+ PS=2.345u PD=3.43u rfmode=0
M$567 \$666 \$665 \$747 VSS sg13_lv_nmos L=0.13u W=0.42u AS=0.1428p AD=0.0609p
+ PS=1.52u PD=0.71u rfmode=0
M$568 \$747 VDD VSS VSS sg13_lv_nmos L=0.13u W=0.42u AS=0.0609p AD=0.1626p
+ PS=0.71u PD=1.415u rfmode=0
M$569 VSS \$784 \$628 VSS sg13_lv_nmos L=0.13u W=0.74u AS=0.1626p AD=0.2516p
+ PS=1.415u PD=2.16u rfmode=0
M$570 \$386 \$336 \$496 VSS sg13_lv_nmos L=0.13u W=0.42u AS=0.1296p AD=0.081p
+ PS=1.52u PD=0.81u rfmode=0
M$571 \$496 \$388 \$387 VSS sg13_lv_nmos L=0.13u W=0.42u AS=0.081p AD=0.2163p
+ PS=0.81u PD=1.87u rfmode=0
M$572 \$668 \$785 VSS VSS sg13_lv_nmos L=0.13u W=0.42u AS=0.1428p AD=0.0798p
+ PS=1.52u PD=0.8u rfmode=0
M$573 VSS VDD \$751 VSS sg13_lv_nmos L=0.13u W=0.42u AS=0.0798p AD=0.0378p
+ PS=0.8u PD=0.6u rfmode=0
M$574 \$751 \$669 \$785 VSS sg13_lv_nmos L=0.13u W=0.42u AS=0.0378p AD=0.1428p
+ PS=0.6u PD=1.52u rfmode=0
M$575 VSS \$669 \$671 VSS sg13_lv_nmos L=0.13u W=0.64u AS=0.1331p AD=0.2176p
+ PS=1.12u PD=1.96u rfmode=0
M$576 VSS \$669 \$670 VSS sg13_lv_nmos L=0.13u W=1.48u AS=0.3922p AD=0.2737p
+ PS=3.28u PD=2.24u rfmode=0
M$578 VSS \$671 \$672 VSS sg13_lv_nmos L=0.13u W=1.48u AS=0.3922p AD=0.3922p
+ PS=3.28u PD=3.28u rfmode=0
M$580 VSS VSS \$512 VSS sg13_lv_nmos L=0.13u W=1u AS=0.265p AD=0.265p PS=2.56u
+ PD=2.56u rfmode=0
M$581 \$512 \$337 OUTP VSS sg13_lv_nmos L=0.13u W=2u AS=0.38p AD=0.38p PS=3.52u
+ PD=3.52u rfmode=0
M$583 \$512 \$391 OUTN VSS sg13_lv_nmos L=0.13u W=2u AS=0.38p AD=0.38p PS=3.52u
+ PD=3.52u rfmode=0
M$590 VSS \$193 \$630 VSS sg13_lv_nmos L=0.13u W=0.55u AS=0.187p AD=0.1045p
+ PS=1.78u PD=0.93u rfmode=0
M$591 \$630 \$186 VSS VSS sg13_lv_nmos L=0.13u W=0.55u AS=0.1045p AD=0.146425p
+ PS=0.93u PD=1.155u rfmode=0
M$592 VSS \$630 \$631 VSS sg13_lv_nmos L=0.13u W=1.48u AS=0.312925p AD=0.4477p
+ PS=2.345u PD=3.43u rfmode=0
M$594 \$676 \$675 \$758 VSS sg13_lv_nmos L=0.13u W=0.42u AS=0.1428p AD=0.0609p
+ PS=1.52u PD=0.71u rfmode=0
M$595 \$758 VDD VSS VSS sg13_lv_nmos L=0.13u W=0.42u AS=0.0609p AD=0.1626p
+ PS=0.71u PD=1.415u rfmode=0
M$596 VSS \$786 \$632 VSS sg13_lv_nmos L=0.13u W=0.74u AS=0.1626p AD=0.2516p
+ PS=1.415u PD=2.16u rfmode=0
M$597 \$395 \$342 \$498 VSS sg13_lv_nmos L=0.13u W=0.42u AS=0.1296p AD=0.081p
+ PS=1.52u PD=0.81u rfmode=0
M$598 \$498 \$397 \$396 VSS sg13_lv_nmos L=0.13u W=0.42u AS=0.081p AD=0.2163p
+ PS=0.81u PD=1.87u rfmode=0
M$599 \$678 \$787 VSS VSS sg13_lv_nmos L=0.13u W=0.42u AS=0.1428p AD=0.0798p
+ PS=1.52u PD=0.8u rfmode=0
M$600 VSS VDD \$763 VSS sg13_lv_nmos L=0.13u W=0.42u AS=0.0798p AD=0.0378p
+ PS=0.8u PD=0.6u rfmode=0
M$601 \$763 \$679 \$787 VSS sg13_lv_nmos L=0.13u W=0.42u AS=0.0378p AD=0.1428p
+ PS=0.6u PD=1.52u rfmode=0
M$602 VSS \$679 \$681 VSS sg13_lv_nmos L=0.13u W=0.64u AS=0.1331p AD=0.2176p
+ PS=1.12u PD=1.96u rfmode=0
M$603 VSS \$679 \$680 VSS sg13_lv_nmos L=0.13u W=1.48u AS=0.3922p AD=0.2737p
+ PS=3.28u PD=2.24u rfmode=0
M$605 VSS \$681 \$682 VSS sg13_lv_nmos L=0.13u W=1.48u AS=0.3922p AD=0.3922p
+ PS=3.28u PD=3.28u rfmode=0
M$607 VSS VSS \$513 VSS sg13_lv_nmos L=0.13u W=1u AS=0.265p AD=0.265p PS=2.56u
+ PD=2.56u rfmode=0
M$608 \$513 \$343 OUTP VSS sg13_lv_nmos L=0.13u W=2u AS=0.38p AD=0.38p PS=3.52u
+ PD=3.52u rfmode=0
M$610 \$513 \$400 OUTN VSS sg13_lv_nmos L=0.13u W=2u AS=0.38p AD=0.38p PS=3.52u
+ PD=3.52u rfmode=0
M$617 VSS \$196 \$634 VSS sg13_lv_nmos L=0.13u W=0.55u AS=0.187p AD=0.1045p
+ PS=1.78u PD=0.93u rfmode=0
M$618 \$634 \$186 VSS VSS sg13_lv_nmos L=0.13u W=0.55u AS=0.1045p AD=0.146425p
+ PS=0.93u PD=1.155u rfmode=0
M$619 VSS \$634 \$635 VSS sg13_lv_nmos L=0.13u W=1.48u AS=0.312925p AD=0.4477p
+ PS=2.345u PD=3.43u rfmode=0
M$621 \$686 \$685 \$770 VSS sg13_lv_nmos L=0.13u W=0.42u AS=0.1428p AD=0.0609p
+ PS=1.52u PD=0.71u rfmode=0
M$622 \$770 VDD VSS VSS sg13_lv_nmos L=0.13u W=0.42u AS=0.0609p AD=0.1626p
+ PS=0.71u PD=1.415u rfmode=0
M$623 VSS \$788 \$636 VSS sg13_lv_nmos L=0.13u W=0.74u AS=0.1626p AD=0.2516p
+ PS=1.415u PD=2.16u rfmode=0
M$624 \$404 \$348 \$500 VSS sg13_lv_nmos L=0.13u W=0.42u AS=0.1296p AD=0.081p
+ PS=1.52u PD=0.81u rfmode=0
M$625 \$500 \$406 \$405 VSS sg13_lv_nmos L=0.13u W=0.42u AS=0.081p AD=0.2163p
+ PS=0.81u PD=1.87u rfmode=0
M$626 \$688 \$789 VSS VSS sg13_lv_nmos L=0.13u W=0.42u AS=0.1428p AD=0.0798p
+ PS=1.52u PD=0.8u rfmode=0
M$627 VSS VDD \$773 VSS sg13_lv_nmos L=0.13u W=0.42u AS=0.0798p AD=0.0378p
+ PS=0.8u PD=0.6u rfmode=0
M$628 \$773 \$689 \$789 VSS sg13_lv_nmos L=0.13u W=0.42u AS=0.0378p AD=0.1428p
+ PS=0.6u PD=1.52u rfmode=0
M$629 VSS \$689 \$691 VSS sg13_lv_nmos L=0.13u W=0.64u AS=0.1331p AD=0.2176p
+ PS=1.12u PD=1.96u rfmode=0
M$630 VSS \$689 \$690 VSS sg13_lv_nmos L=0.13u W=1.48u AS=0.3922p AD=0.2737p
+ PS=3.28u PD=2.24u rfmode=0
M$632 VSS \$691 \$692 VSS sg13_lv_nmos L=0.13u W=1.48u AS=0.3922p AD=0.3922p
+ PS=3.28u PD=3.28u rfmode=0
M$634 VSS VSS \$514 VSS sg13_lv_nmos L=0.13u W=1u AS=0.265p AD=0.265p PS=2.56u
+ PD=2.56u rfmode=0
M$635 \$514 \$349 OUTP VSS sg13_lv_nmos L=0.13u W=2u AS=0.38p AD=0.38p PS=3.52u
+ PD=3.52u rfmode=0
M$637 \$514 \$409 OUTN VSS sg13_lv_nmos L=0.13u W=2u AS=0.38p AD=0.38p PS=3.52u
+ PD=3.52u rfmode=0
M$644 VSS \$199 \$638 VSS sg13_lv_nmos L=0.13u W=0.55u AS=0.187p AD=0.1045p
+ PS=1.78u PD=0.93u rfmode=0
M$645 \$638 \$186 VSS VSS sg13_lv_nmos L=0.13u W=0.55u AS=0.1045p AD=0.146425p
+ PS=0.93u PD=1.155u rfmode=0
M$646 VSS \$638 \$639 VSS sg13_lv_nmos L=0.13u W=1.48u AS=0.312925p AD=0.4477p
+ PS=2.345u PD=3.43u rfmode=0
M$648 \$696 \$695 \$781 VSS sg13_lv_nmos L=0.13u W=0.42u AS=0.1428p AD=0.0609p
+ PS=1.52u PD=0.71u rfmode=0
M$649 \$781 VDD VSS VSS sg13_lv_nmos L=0.13u W=0.42u AS=0.0609p AD=0.1626p
+ PS=0.71u PD=1.415u rfmode=0
M$650 VSS \$790 \$640 VSS sg13_lv_nmos L=0.13u W=0.74u AS=0.1626p AD=0.2516p
+ PS=1.415u PD=2.16u rfmode=0
M$651 \$413 \$354 \$502 VSS sg13_lv_nmos L=0.13u W=0.42u AS=0.1296p AD=0.081p
+ PS=1.52u PD=0.81u rfmode=0
M$652 \$502 \$415 \$414 VSS sg13_lv_nmos L=0.13u W=0.42u AS=0.081p AD=0.2163p
+ PS=0.81u PD=1.87u rfmode=0
M$653 \$698 \$791 VSS VSS sg13_lv_nmos L=0.13u W=0.42u AS=0.1428p AD=0.0798p
+ PS=1.52u PD=0.8u rfmode=0
M$654 VSS VDD \$778 VSS sg13_lv_nmos L=0.13u W=0.42u AS=0.0798p AD=0.0378p
+ PS=0.8u PD=0.6u rfmode=0
M$655 \$778 \$699 \$791 VSS sg13_lv_nmos L=0.13u W=0.42u AS=0.0378p AD=0.1428p
+ PS=0.6u PD=1.52u rfmode=0
M$656 VSS \$699 \$701 VSS sg13_lv_nmos L=0.13u W=0.64u AS=0.1331p AD=0.2176p
+ PS=1.12u PD=1.96u rfmode=0
M$657 VSS \$699 \$700 VSS sg13_lv_nmos L=0.13u W=1.48u AS=0.3922p AD=0.2737p
+ PS=3.28u PD=2.24u rfmode=0
M$659 VSS \$701 \$702 VSS sg13_lv_nmos L=0.13u W=1.48u AS=0.3922p AD=0.3922p
+ PS=3.28u PD=3.28u rfmode=0
M$661 VSS VSS \$515 VSS sg13_lv_nmos L=0.13u W=1u AS=0.265p AD=0.265p PS=2.56u
+ PD=2.56u rfmode=0
M$662 \$515 \$355 OUTP VSS sg13_lv_nmos L=0.13u W=2u AS=0.38p AD=0.38p PS=3.52u
+ PD=3.52u rfmode=0
M$664 \$515 \$418 OUTN VSS sg13_lv_nmos L=0.13u W=2u AS=0.38p AD=0.38p PS=3.52u
+ PD=3.52u rfmode=0
M$671 VSS \$202 \$642 VSS sg13_lv_nmos L=0.13u W=0.55u AS=0.187p AD=0.1045p
+ PS=1.78u PD=0.93u rfmode=0
M$672 \$642 \$186 VSS VSS sg13_lv_nmos L=0.13u W=0.55u AS=0.1045p AD=0.146425p
+ PS=0.93u PD=1.155u rfmode=0
M$673 VSS \$642 \$643 VSS sg13_lv_nmos L=0.13u W=1.48u AS=0.312925p AD=0.4477p
+ PS=2.345u PD=3.43u rfmode=0
M$675 \$706 \$705 \$769 VSS sg13_lv_nmos L=0.13u W=0.42u AS=0.1428p AD=0.0609p
+ PS=1.52u PD=0.71u rfmode=0
M$676 \$769 VDD VSS VSS sg13_lv_nmos L=0.13u W=0.42u AS=0.0609p AD=0.1626p
+ PS=0.71u PD=1.415u rfmode=0
M$677 VSS \$792 \$644 VSS sg13_lv_nmos L=0.13u W=0.74u AS=0.1626p AD=0.2516p
+ PS=1.415u PD=2.16u rfmode=0
M$678 \$422 \$360 \$504 VSS sg13_lv_nmos L=0.13u W=0.42u AS=0.1296p AD=0.081p
+ PS=1.52u PD=0.81u rfmode=0
M$679 \$504 \$424 \$423 VSS sg13_lv_nmos L=0.13u W=0.42u AS=0.081p AD=0.2163p
+ PS=0.81u PD=1.87u rfmode=0
M$680 \$708 \$793 VSS VSS sg13_lv_nmos L=0.13u W=0.42u AS=0.1428p AD=0.0798p
+ PS=1.52u PD=0.8u rfmode=0
M$681 VSS VDD \$766 VSS sg13_lv_nmos L=0.13u W=0.42u AS=0.0798p AD=0.0378p
+ PS=0.8u PD=0.6u rfmode=0
M$682 \$766 \$709 \$793 VSS sg13_lv_nmos L=0.13u W=0.42u AS=0.0378p AD=0.1428p
+ PS=0.6u PD=1.52u rfmode=0
M$683 VSS \$709 \$711 VSS sg13_lv_nmos L=0.13u W=0.64u AS=0.1331p AD=0.2176p
+ PS=1.12u PD=1.96u rfmode=0
M$684 VSS \$709 \$710 VSS sg13_lv_nmos L=0.13u W=1.48u AS=0.3922p AD=0.2737p
+ PS=3.28u PD=2.24u rfmode=0
M$686 VSS \$711 \$712 VSS sg13_lv_nmos L=0.13u W=1.48u AS=0.3922p AD=0.3922p
+ PS=3.28u PD=3.28u rfmode=0
M$688 VSS VSS \$516 VSS sg13_lv_nmos L=0.13u W=1u AS=0.265p AD=0.265p PS=2.56u
+ PD=2.56u rfmode=0
M$689 \$516 \$361 OUTP VSS sg13_lv_nmos L=0.13u W=2u AS=0.38p AD=0.38p PS=3.52u
+ PD=3.52u rfmode=0
M$691 \$516 \$427 OUTN VSS sg13_lv_nmos L=0.13u W=2u AS=0.38p AD=0.38p PS=3.52u
+ PD=3.52u rfmode=0
M$698 VSS \$205 \$646 VSS sg13_lv_nmos L=0.13u W=0.55u AS=0.187p AD=0.1045p
+ PS=1.78u PD=0.93u rfmode=0
M$699 \$646 \$186 VSS VSS sg13_lv_nmos L=0.13u W=0.55u AS=0.1045p AD=0.146425p
+ PS=0.93u PD=1.155u rfmode=0
M$700 VSS \$646 \$647 VSS sg13_lv_nmos L=0.13u W=1.48u AS=0.312925p AD=0.4477p
+ PS=2.345u PD=3.43u rfmode=0
M$702 \$716 \$715 \$756 VSS sg13_lv_nmos L=0.13u W=0.42u AS=0.1428p AD=0.0609p
+ PS=1.52u PD=0.71u rfmode=0
M$703 \$756 VDD VSS VSS sg13_lv_nmos L=0.13u W=0.42u AS=0.0609p AD=0.1626p
+ PS=0.71u PD=1.415u rfmode=0
M$704 VSS \$794 \$648 VSS sg13_lv_nmos L=0.13u W=0.74u AS=0.1626p AD=0.2516p
+ PS=1.415u PD=2.16u rfmode=0
M$705 \$517 \$366 \$506 VSS sg13_lv_nmos L=0.13u W=0.42u AS=0.1296p AD=0.081p
+ PS=1.52u PD=0.81u rfmode=0
M$706 \$506 \$432 \$431 VSS sg13_lv_nmos L=0.13u W=0.42u AS=0.081p AD=0.2163p
+ PS=0.81u PD=1.87u rfmode=0
M$707 \$718 \$795 VSS VSS sg13_lv_nmos L=0.13u W=0.42u AS=0.1428p AD=0.0798p
+ PS=1.52u PD=0.8u rfmode=0
M$708 VSS VDD \$752 VSS sg13_lv_nmos L=0.13u W=0.42u AS=0.0798p AD=0.0378p
+ PS=0.8u PD=0.6u rfmode=0
M$709 \$752 \$719 \$795 VSS sg13_lv_nmos L=0.13u W=0.42u AS=0.0378p AD=0.1428p
+ PS=0.6u PD=1.52u rfmode=0
M$710 VSS \$719 \$721 VSS sg13_lv_nmos L=0.13u W=0.64u AS=0.1331p AD=0.2176p
+ PS=1.12u PD=1.96u rfmode=0
M$711 VSS \$719 \$720 VSS sg13_lv_nmos L=0.13u W=1.48u AS=0.3922p AD=0.2737p
+ PS=3.28u PD=2.24u rfmode=0
M$713 VSS \$721 \$722 VSS sg13_lv_nmos L=0.13u W=1.48u AS=0.3922p AD=0.3922p
+ PS=3.28u PD=3.28u rfmode=0
M$715 VSS VSS \$518 VSS sg13_lv_nmos L=0.13u W=1u AS=0.265p AD=0.265p PS=2.56u
+ PD=2.56u rfmode=0
M$716 \$518 \$367 OUTP VSS sg13_lv_nmos L=0.13u W=2u AS=0.38p AD=0.38p PS=3.52u
+ PD=3.52u rfmode=0
M$718 \$518 \$435 OUTN VSS sg13_lv_nmos L=0.13u W=2u AS=0.38p AD=0.38p PS=3.52u
+ PD=3.52u rfmode=0
M$725 VSS VSS \$650 VSS sg13_lv_nmos L=0.13u W=0.55u AS=0.187p AD=0.1045p
+ PS=1.78u PD=0.93u rfmode=0
M$726 \$650 \$186 VSS VSS sg13_lv_nmos L=0.13u W=0.55u AS=0.1045p AD=0.146425p
+ PS=0.93u PD=1.155u rfmode=0
M$727 VSS \$650 \$651 VSS sg13_lv_nmos L=0.13u W=1.48u AS=0.312925p AD=0.4477p
+ PS=2.345u PD=3.43u rfmode=0
M$729 \$726 \$725 \$744 VSS sg13_lv_nmos L=0.13u W=0.42u AS=0.1428p AD=0.0609p
+ PS=1.52u PD=0.71u rfmode=0
M$730 \$744 VDD VSS VSS sg13_lv_nmos L=0.13u W=0.42u AS=0.0609p AD=0.1626p
+ PS=0.71u PD=1.415u rfmode=0
M$731 VSS \$796 \$652 VSS sg13_lv_nmos L=0.13u W=0.74u AS=0.1626p AD=0.2516p
+ PS=1.415u PD=2.16u rfmode=0
M$732 \$439 \$372 \$508 VSS sg13_lv_nmos L=0.13u W=0.42u AS=0.1296p AD=0.081p
+ PS=1.52u PD=0.81u rfmode=0
M$733 \$508 \$441 \$440 VSS sg13_lv_nmos L=0.13u W=0.42u AS=0.081p AD=0.2163p
+ PS=0.81u PD=1.87u rfmode=0
M$734 \$728 \$797 VSS VSS sg13_lv_nmos L=0.13u W=0.42u AS=0.1428p AD=0.0798p
+ PS=1.52u PD=0.8u rfmode=0
M$735 VSS VDD \$739 VSS sg13_lv_nmos L=0.13u W=0.42u AS=0.0798p AD=0.0378p
+ PS=0.8u PD=0.6u rfmode=0
M$736 \$739 \$729 \$797 VSS sg13_lv_nmos L=0.13u W=0.42u AS=0.0378p AD=0.1428p
+ PS=0.6u PD=1.52u rfmode=0
M$737 VSS \$729 \$731 VSS sg13_lv_nmos L=0.13u W=0.64u AS=0.1331p AD=0.2176p
+ PS=1.12u PD=1.96u rfmode=0
M$738 VSS \$729 \$730 VSS sg13_lv_nmos L=0.13u W=1.48u AS=0.3922p AD=0.2737p
+ PS=3.28u PD=2.24u rfmode=0
M$740 VSS \$731 \$732 VSS sg13_lv_nmos L=0.13u W=1.48u AS=0.3922p AD=0.3922p
+ PS=3.28u PD=3.28u rfmode=0
M$742 VSS VSS \$519 VSS sg13_lv_nmos L=0.13u W=1u AS=0.265p AD=0.265p PS=2.56u
+ PD=2.56u rfmode=0
M$743 \$519 \$373 OUTP VSS sg13_lv_nmos L=0.13u W=2u AS=0.38p AD=0.38p PS=3.52u
+ PD=3.52u rfmode=0
M$745 \$519 \$444 OUTN VSS sg13_lv_nmos L=0.13u W=2u AS=0.38p AD=0.38p PS=3.52u
+ PD=3.52u rfmode=0
M$752 \$654 \$623 VSS VSS sg13_lv_nmos L=0.13u W=1.44u AS=0.4068p AD=0.2772p
+ PS=3.29u PD=2.21u rfmode=0
M$754 \$654 \$318 \$655 VSS sg13_lv_nmos L=0.13u W=1.44u AS=0.2772p AD=0.3816p
+ PS=2.21u PD=3.22u rfmode=0
M$756 VSS VDD \$737 VSS sg13_lv_nmos L=0.13u W=0.42u AS=0.1701p AD=0.03885p
+ PS=1.65u PD=0.605u rfmode=0
M$757 \$737 \$624 \$657 VSS sg13_lv_nmos L=0.13u W=0.42u AS=0.03885p AD=0.1596p
+ PS=0.605u PD=1.6u rfmode=0
M$758 VSS \$625 \$798 VSS sg13_lv_nmos L=0.13u W=0.74u AS=0.43315p AD=0.2516p
+ PS=2.205u PD=2.16u rfmode=0
M$759 VSS CLK \$625 VSS sg13_lv_nmos L=0.13u W=0.74u AS=0.43315p AD=0.2516p
+ PS=2.205u PD=2.16u rfmode=0
M$760 \$659 \$625 \$658 VSS sg13_lv_nmos L=0.13u W=0.42u AS=0.12665p AD=0.1428p
+ PS=1.145u PD=1.52u rfmode=0
M$761 \$624 \$798 \$659 VSS sg13_lv_nmos L=0.13u W=0.74u AS=0.3473p AD=0.12665p
+ PS=2.71u PD=1.145u rfmode=0
M$762 \$664 \$627 VSS VSS sg13_lv_nmos L=0.13u W=1.44u AS=0.4068p AD=0.2772p
+ PS=3.29u PD=2.21u rfmode=0
M$764 \$664 \$318 \$665 VSS sg13_lv_nmos L=0.13u W=1.44u AS=0.2772p AD=0.3816p
+ PS=2.21u PD=3.22u rfmode=0
M$766 VSS VDD \$748 VSS sg13_lv_nmos L=0.13u W=0.42u AS=0.1701p AD=0.03885p
+ PS=1.65u PD=0.605u rfmode=0
M$767 \$748 \$628 \$667 VSS sg13_lv_nmos L=0.13u W=0.42u AS=0.03885p AD=0.1596p
+ PS=0.605u PD=1.6u rfmode=0
M$768 VSS \$629 \$800 VSS sg13_lv_nmos L=0.13u W=0.74u AS=0.43315p AD=0.2516p
+ PS=2.205u PD=2.16u rfmode=0
M$769 VSS CLK \$629 VSS sg13_lv_nmos L=0.13u W=0.74u AS=0.43315p AD=0.2516p
+ PS=2.205u PD=2.16u rfmode=0
M$770 \$669 \$629 \$668 VSS sg13_lv_nmos L=0.13u W=0.42u AS=0.12665p AD=0.1428p
+ PS=1.145u PD=1.52u rfmode=0
M$771 \$628 \$800 \$669 VSS sg13_lv_nmos L=0.13u W=0.74u AS=0.3473p AD=0.12665p
+ PS=2.71u PD=1.145u rfmode=0
M$772 \$674 \$631 VSS VSS sg13_lv_nmos L=0.13u W=1.44u AS=0.4068p AD=0.2772p
+ PS=3.29u PD=2.21u rfmode=0
M$774 \$674 \$318 \$675 VSS sg13_lv_nmos L=0.13u W=1.44u AS=0.2772p AD=0.3816p
+ PS=2.21u PD=3.22u rfmode=0
M$776 VSS VDD \$759 VSS sg13_lv_nmos L=0.13u W=0.42u AS=0.1701p AD=0.03885p
+ PS=1.65u PD=0.605u rfmode=0
M$777 \$759 \$632 \$677 VSS sg13_lv_nmos L=0.13u W=0.42u AS=0.03885p AD=0.1596p
+ PS=0.605u PD=1.6u rfmode=0
M$778 VSS \$633 \$802 VSS sg13_lv_nmos L=0.13u W=0.74u AS=0.43315p AD=0.2516p
+ PS=2.205u PD=2.16u rfmode=0
M$779 VSS CLK \$633 VSS sg13_lv_nmos L=0.13u W=0.74u AS=0.43315p AD=0.2516p
+ PS=2.205u PD=2.16u rfmode=0
M$780 \$679 \$633 \$678 VSS sg13_lv_nmos L=0.13u W=0.42u AS=0.12665p AD=0.1428p
+ PS=1.145u PD=1.52u rfmode=0
M$781 \$632 \$802 \$679 VSS sg13_lv_nmos L=0.13u W=0.74u AS=0.3473p AD=0.12665p
+ PS=2.71u PD=1.145u rfmode=0
M$782 \$684 \$635 VSS VSS sg13_lv_nmos L=0.13u W=1.44u AS=0.4068p AD=0.2772p
+ PS=3.29u PD=2.21u rfmode=0
M$784 \$684 \$318 \$685 VSS sg13_lv_nmos L=0.13u W=1.44u AS=0.2772p AD=0.3816p
+ PS=2.21u PD=3.22u rfmode=0
M$786 VSS VDD \$771 VSS sg13_lv_nmos L=0.13u W=0.42u AS=0.1701p AD=0.03885p
+ PS=1.65u PD=0.605u rfmode=0
M$787 \$771 \$636 \$687 VSS sg13_lv_nmos L=0.13u W=0.42u AS=0.03885p AD=0.1596p
+ PS=0.605u PD=1.6u rfmode=0
M$788 VSS \$637 \$804 VSS sg13_lv_nmos L=0.13u W=0.74u AS=0.43315p AD=0.2516p
+ PS=2.205u PD=2.16u rfmode=0
M$789 VSS CLK \$637 VSS sg13_lv_nmos L=0.13u W=0.74u AS=0.43315p AD=0.2516p
+ PS=2.205u PD=2.16u rfmode=0
M$790 \$689 \$637 \$688 VSS sg13_lv_nmos L=0.13u W=0.42u AS=0.12665p AD=0.1428p
+ PS=1.145u PD=1.52u rfmode=0
M$791 \$636 \$804 \$689 VSS sg13_lv_nmos L=0.13u W=0.74u AS=0.3473p AD=0.12665p
+ PS=2.71u PD=1.145u rfmode=0
M$792 \$694 \$639 VSS VSS sg13_lv_nmos L=0.13u W=1.44u AS=0.4068p AD=0.2772p
+ PS=3.29u PD=2.21u rfmode=0
M$794 \$694 \$318 \$695 VSS sg13_lv_nmos L=0.13u W=1.44u AS=0.2772p AD=0.3816p
+ PS=2.21u PD=3.22u rfmode=0
M$796 VSS VDD \$780 VSS sg13_lv_nmos L=0.13u W=0.42u AS=0.1701p AD=0.03885p
+ PS=1.65u PD=0.605u rfmode=0
M$797 \$780 \$640 \$697 VSS sg13_lv_nmos L=0.13u W=0.42u AS=0.03885p AD=0.1596p
+ PS=0.605u PD=1.6u rfmode=0
M$798 VSS \$641 \$806 VSS sg13_lv_nmos L=0.13u W=0.74u AS=0.43315p AD=0.2516p
+ PS=2.205u PD=2.16u rfmode=0
M$799 VSS CLK \$641 VSS sg13_lv_nmos L=0.13u W=0.74u AS=0.43315p AD=0.2516p
+ PS=2.205u PD=2.16u rfmode=0
M$800 \$699 \$641 \$698 VSS sg13_lv_nmos L=0.13u W=0.42u AS=0.12665p AD=0.1428p
+ PS=1.145u PD=1.52u rfmode=0
M$801 \$640 \$806 \$699 VSS sg13_lv_nmos L=0.13u W=0.74u AS=0.3473p AD=0.12665p
+ PS=2.71u PD=1.145u rfmode=0
M$802 \$704 \$643 VSS VSS sg13_lv_nmos L=0.13u W=1.44u AS=0.4068p AD=0.2772p
+ PS=3.29u PD=2.21u rfmode=0
M$804 \$704 \$318 \$705 VSS sg13_lv_nmos L=0.13u W=1.44u AS=0.2772p AD=0.3816p
+ PS=2.21u PD=3.22u rfmode=0
M$806 VSS VDD \$767 VSS sg13_lv_nmos L=0.13u W=0.42u AS=0.1701p AD=0.03885p
+ PS=1.65u PD=0.605u rfmode=0
M$807 \$767 \$644 \$707 VSS sg13_lv_nmos L=0.13u W=0.42u AS=0.03885p AD=0.1596p
+ PS=0.605u PD=1.6u rfmode=0
M$808 VSS \$645 \$808 VSS sg13_lv_nmos L=0.13u W=0.74u AS=0.43315p AD=0.2516p
+ PS=2.205u PD=2.16u rfmode=0
M$809 VSS CLK \$645 VSS sg13_lv_nmos L=0.13u W=0.74u AS=0.43315p AD=0.2516p
+ PS=2.205u PD=2.16u rfmode=0
M$810 \$709 \$645 \$708 VSS sg13_lv_nmos L=0.13u W=0.42u AS=0.12665p AD=0.1428p
+ PS=1.145u PD=1.52u rfmode=0
M$811 \$644 \$808 \$709 VSS sg13_lv_nmos L=0.13u W=0.74u AS=0.3473p AD=0.12665p
+ PS=2.71u PD=1.145u rfmode=0
M$812 \$714 \$647 VSS VSS sg13_lv_nmos L=0.13u W=1.44u AS=0.4068p AD=0.2772p
+ PS=3.29u PD=2.21u rfmode=0
M$814 \$714 \$318 \$715 VSS sg13_lv_nmos L=0.13u W=1.44u AS=0.2772p AD=0.3816p
+ PS=2.21u PD=3.22u rfmode=0
M$816 VSS VDD \$755 VSS sg13_lv_nmos L=0.13u W=0.42u AS=0.1701p AD=0.03885p
+ PS=1.65u PD=0.605u rfmode=0
M$817 \$755 \$648 \$717 VSS sg13_lv_nmos L=0.13u W=0.42u AS=0.03885p AD=0.1596p
+ PS=0.605u PD=1.6u rfmode=0
M$818 VSS \$649 \$810 VSS sg13_lv_nmos L=0.13u W=0.74u AS=0.43315p AD=0.2516p
+ PS=2.205u PD=2.16u rfmode=0
M$819 VSS CLK \$649 VSS sg13_lv_nmos L=0.13u W=0.74u AS=0.43315p AD=0.2516p
+ PS=2.205u PD=2.16u rfmode=0
M$820 \$719 \$649 \$718 VSS sg13_lv_nmos L=0.13u W=0.42u AS=0.12665p AD=0.1428p
+ PS=1.145u PD=1.52u rfmode=0
M$821 \$648 \$810 \$719 VSS sg13_lv_nmos L=0.13u W=0.74u AS=0.3473p AD=0.12665p
+ PS=2.71u PD=1.145u rfmode=0
M$822 \$724 \$651 VSS VSS sg13_lv_nmos L=0.13u W=1.44u AS=0.4068p AD=0.2772p
+ PS=3.29u PD=2.21u rfmode=0
M$824 \$724 \$318 \$725 VSS sg13_lv_nmos L=0.13u W=1.44u AS=0.2772p AD=0.3816p
+ PS=2.21u PD=3.22u rfmode=0
M$826 VSS VDD \$742 VSS sg13_lv_nmos L=0.13u W=0.42u AS=0.1701p AD=0.03885p
+ PS=1.65u PD=0.605u rfmode=0
M$827 \$742 \$652 \$727 VSS sg13_lv_nmos L=0.13u W=0.42u AS=0.03885p AD=0.1596p
+ PS=0.605u PD=1.6u rfmode=0
M$828 VSS \$653 \$812 VSS sg13_lv_nmos L=0.13u W=0.74u AS=0.43315p AD=0.2516p
+ PS=2.205u PD=2.16u rfmode=0
M$829 VSS CLK \$653 VSS sg13_lv_nmos L=0.13u W=0.74u AS=0.43315p AD=0.2516p
+ PS=2.205u PD=2.16u rfmode=0
M$830 \$729 \$653 \$728 VSS sg13_lv_nmos L=0.13u W=0.42u AS=0.12665p AD=0.1428p
+ PS=1.145u PD=1.52u rfmode=0
M$831 \$652 \$812 \$729 VSS sg13_lv_nmos L=0.13u W=0.74u AS=0.3473p AD=0.12665p
+ PS=2.71u PD=1.145u rfmode=0
M$832 VSS \$187 \$910 VSS sg13_lv_nmos L=0.13u W=0.55u AS=0.187p AD=0.1045p
+ PS=1.78u PD=0.93u rfmode=0
M$833 \$910 \$5 VSS VSS sg13_lv_nmos L=0.13u W=0.55u AS=0.1045p AD=0.146425p
+ PS=0.93u PD=1.155u rfmode=0
M$834 VSS \$910 \$911 VSS sg13_lv_nmos L=0.13u W=1.48u AS=0.312925p AD=0.4477p
+ PS=2.345u PD=3.43u rfmode=0
M$836 \$944 \$943 \$1023 VSS sg13_lv_nmos L=0.13u W=0.42u AS=0.1428p AD=0.0609p
+ PS=1.52u PD=0.71u rfmode=0
M$837 \$1023 VDD VSS VSS sg13_lv_nmos L=0.13u W=0.42u AS=0.0609p AD=0.1626p
+ PS=0.71u PD=1.415u rfmode=0
M$838 VSS \$1070 \$912 VSS sg13_lv_nmos L=0.13u W=0.74u AS=0.1626p AD=0.2516p
+ PS=1.415u PD=2.16u rfmode=0
M$839 \$656 \$625 \$782 VSS sg13_lv_nmos L=0.13u W=0.42u AS=0.1296p AD=0.081p
+ PS=1.52u PD=0.81u rfmode=0
M$840 \$782 \$798 \$657 VSS sg13_lv_nmos L=0.13u W=0.42u AS=0.081p AD=0.2163p
+ PS=0.81u PD=1.87u rfmode=0
M$841 \$946 \$1071 VSS VSS sg13_lv_nmos L=0.13u W=0.42u AS=0.1428p AD=0.0798p
+ PS=1.52u PD=0.8u rfmode=0
M$842 VSS VDD \$1027 VSS sg13_lv_nmos L=0.13u W=0.42u AS=0.0798p AD=0.0378p
+ PS=0.8u PD=0.6u rfmode=0
M$843 \$1027 \$947 \$1071 VSS sg13_lv_nmos L=0.13u W=0.42u AS=0.0378p
+ AD=0.1428p PS=0.6u PD=1.52u rfmode=0
M$844 VSS \$947 \$949 VSS sg13_lv_nmos L=0.13u W=0.64u AS=0.1331p AD=0.2176p
+ PS=1.12u PD=1.96u rfmode=0
M$845 VSS \$947 \$948 VSS sg13_lv_nmos L=0.13u W=1.48u AS=0.3922p AD=0.2737p
+ PS=3.28u PD=2.24u rfmode=0
M$847 VSS \$949 \$950 VSS sg13_lv_nmos L=0.13u W=1.48u AS=0.3922p AD=0.3922p
+ PS=3.28u PD=3.28u rfmode=0
M$849 VSS VSS \$799 VSS sg13_lv_nmos L=0.13u W=1u AS=0.265p AD=0.265p PS=2.56u
+ PD=2.56u rfmode=0
M$850 \$799 \$660 OUTP VSS sg13_lv_nmos L=0.13u W=2u AS=0.38p AD=0.38p PS=3.52u
+ PD=3.52u rfmode=0
M$852 \$799 \$662 OUTN VSS sg13_lv_nmos L=0.13u W=2u AS=0.38p AD=0.38p PS=3.52u
+ PD=3.52u rfmode=0
M$859 VSS \$190 \$914 VSS sg13_lv_nmos L=0.13u W=0.55u AS=0.187p AD=0.1045p
+ PS=1.78u PD=0.93u rfmode=0
M$860 \$914 \$5 VSS VSS sg13_lv_nmos L=0.13u W=0.55u AS=0.1045p AD=0.146425p
+ PS=0.93u PD=1.155u rfmode=0
M$861 VSS \$914 \$915 VSS sg13_lv_nmos L=0.13u W=1.48u AS=0.312925p AD=0.4477p
+ PS=2.345u PD=3.43u rfmode=0
M$863 \$954 \$953 \$1035 VSS sg13_lv_nmos L=0.13u W=0.42u AS=0.1428p AD=0.0609p
+ PS=1.52u PD=0.71u rfmode=0
M$864 \$1035 VDD VSS VSS sg13_lv_nmos L=0.13u W=0.42u AS=0.0609p AD=0.1626p
+ PS=0.71u PD=1.415u rfmode=0
M$865 VSS \$1072 \$916 VSS sg13_lv_nmos L=0.13u W=0.74u AS=0.1626p AD=0.2516p
+ PS=1.415u PD=2.16u rfmode=0
M$866 \$666 \$629 \$784 VSS sg13_lv_nmos L=0.13u W=0.42u AS=0.1296p AD=0.081p
+ PS=1.52u PD=0.81u rfmode=0
M$867 \$784 \$800 \$667 VSS sg13_lv_nmos L=0.13u W=0.42u AS=0.081p AD=0.2163p
+ PS=0.81u PD=1.87u rfmode=0
M$868 \$956 \$1073 VSS VSS sg13_lv_nmos L=0.13u W=0.42u AS=0.1428p AD=0.0798p
+ PS=1.52u PD=0.8u rfmode=0
M$869 VSS VDD \$1039 VSS sg13_lv_nmos L=0.13u W=0.42u AS=0.0798p AD=0.0378p
+ PS=0.8u PD=0.6u rfmode=0
M$870 \$1039 \$957 \$1073 VSS sg13_lv_nmos L=0.13u W=0.42u AS=0.0378p
+ AD=0.1428p PS=0.6u PD=1.52u rfmode=0
M$871 VSS \$957 \$959 VSS sg13_lv_nmos L=0.13u W=0.64u AS=0.1331p AD=0.2176p
+ PS=1.12u PD=1.96u rfmode=0
M$872 VSS \$957 \$958 VSS sg13_lv_nmos L=0.13u W=1.48u AS=0.3922p AD=0.2737p
+ PS=3.28u PD=2.24u rfmode=0
M$874 VSS \$959 \$960 VSS sg13_lv_nmos L=0.13u W=1.48u AS=0.3922p AD=0.3922p
+ PS=3.28u PD=3.28u rfmode=0
M$876 VSS VSS \$801 VSS sg13_lv_nmos L=0.13u W=1u AS=0.265p AD=0.265p PS=2.56u
+ PD=2.56u rfmode=0
M$877 \$801 \$670 OUTP VSS sg13_lv_nmos L=0.13u W=2u AS=0.38p AD=0.38p PS=3.52u
+ PD=3.52u rfmode=0
M$879 \$801 \$672 OUTN VSS sg13_lv_nmos L=0.13u W=2u AS=0.38p AD=0.38p PS=3.52u
+ PD=3.52u rfmode=0
M$886 VSS \$193 \$918 VSS sg13_lv_nmos L=0.13u W=0.55u AS=0.187p AD=0.1045p
+ PS=1.78u PD=0.93u rfmode=0
M$887 \$918 \$5 VSS VSS sg13_lv_nmos L=0.13u W=0.55u AS=0.1045p AD=0.146425p
+ PS=0.93u PD=1.155u rfmode=0
M$888 VSS \$918 \$919 VSS sg13_lv_nmos L=0.13u W=1.48u AS=0.312925p AD=0.4477p
+ PS=2.345u PD=3.43u rfmode=0
M$890 \$964 \$963 \$1046 VSS sg13_lv_nmos L=0.13u W=0.42u AS=0.1428p AD=0.0609p
+ PS=1.52u PD=0.71u rfmode=0
M$891 \$1046 VDD VSS VSS sg13_lv_nmos L=0.13u W=0.42u AS=0.0609p AD=0.1626p
+ PS=0.71u PD=1.415u rfmode=0
M$892 VSS \$1074 \$920 VSS sg13_lv_nmos L=0.13u W=0.74u AS=0.1626p AD=0.2516p
+ PS=1.415u PD=2.16u rfmode=0
M$893 \$676 \$633 \$786 VSS sg13_lv_nmos L=0.13u W=0.42u AS=0.1296p AD=0.081p
+ PS=1.52u PD=0.81u rfmode=0
M$894 \$786 \$802 \$677 VSS sg13_lv_nmos L=0.13u W=0.42u AS=0.081p AD=0.2163p
+ PS=0.81u PD=1.87u rfmode=0
M$895 \$966 \$1075 VSS VSS sg13_lv_nmos L=0.13u W=0.42u AS=0.1428p AD=0.0798p
+ PS=1.52u PD=0.8u rfmode=0
M$896 VSS VDD \$1051 VSS sg13_lv_nmos L=0.13u W=0.42u AS=0.0798p AD=0.0378p
+ PS=0.8u PD=0.6u rfmode=0
M$897 \$1051 \$967 \$1075 VSS sg13_lv_nmos L=0.13u W=0.42u AS=0.0378p
+ AD=0.1428p PS=0.6u PD=1.52u rfmode=0
M$898 VSS \$967 \$969 VSS sg13_lv_nmos L=0.13u W=0.64u AS=0.1331p AD=0.2176p
+ PS=1.12u PD=1.96u rfmode=0
M$899 VSS \$967 \$968 VSS sg13_lv_nmos L=0.13u W=1.48u AS=0.3922p AD=0.2737p
+ PS=3.28u PD=2.24u rfmode=0
M$901 VSS \$969 \$970 VSS sg13_lv_nmos L=0.13u W=1.48u AS=0.3922p AD=0.3922p
+ PS=3.28u PD=3.28u rfmode=0
M$903 VSS VSS \$803 VSS sg13_lv_nmos L=0.13u W=1u AS=0.265p AD=0.265p PS=2.56u
+ PD=2.56u rfmode=0
M$904 \$803 \$680 OUTP VSS sg13_lv_nmos L=0.13u W=2u AS=0.38p AD=0.38p PS=3.52u
+ PD=3.52u rfmode=0
M$906 \$803 \$682 OUTN VSS sg13_lv_nmos L=0.13u W=2u AS=0.38p AD=0.38p PS=3.52u
+ PD=3.52u rfmode=0
M$913 VSS \$196 \$922 VSS sg13_lv_nmos L=0.13u W=0.55u AS=0.187p AD=0.1045p
+ PS=1.78u PD=0.93u rfmode=0
M$914 \$922 \$5 VSS VSS sg13_lv_nmos L=0.13u W=0.55u AS=0.1045p AD=0.146425p
+ PS=0.93u PD=1.155u rfmode=0
M$915 VSS \$922 \$923 VSS sg13_lv_nmos L=0.13u W=1.48u AS=0.312925p AD=0.4477p
+ PS=2.345u PD=3.43u rfmode=0
M$917 \$974 \$973 \$1058 VSS sg13_lv_nmos L=0.13u W=0.42u AS=0.1428p AD=0.0609p
+ PS=1.52u PD=0.71u rfmode=0
M$918 \$1058 VDD VSS VSS sg13_lv_nmos L=0.13u W=0.42u AS=0.0609p AD=0.1626p
+ PS=0.71u PD=1.415u rfmode=0
M$919 VSS \$1076 \$924 VSS sg13_lv_nmos L=0.13u W=0.74u AS=0.1626p AD=0.2516p
+ PS=1.415u PD=2.16u rfmode=0
M$920 \$686 \$637 \$788 VSS sg13_lv_nmos L=0.13u W=0.42u AS=0.1296p AD=0.081p
+ PS=1.52u PD=0.81u rfmode=0
M$921 \$788 \$804 \$687 VSS sg13_lv_nmos L=0.13u W=0.42u AS=0.081p AD=0.2163p
+ PS=0.81u PD=1.87u rfmode=0
M$922 \$976 \$1077 VSS VSS sg13_lv_nmos L=0.13u W=0.42u AS=0.1428p AD=0.0798p
+ PS=1.52u PD=0.8u rfmode=0
M$923 VSS VDD \$1061 VSS sg13_lv_nmos L=0.13u W=0.42u AS=0.0798p AD=0.0378p
+ PS=0.8u PD=0.6u rfmode=0
M$924 \$1061 \$977 \$1077 VSS sg13_lv_nmos L=0.13u W=0.42u AS=0.0378p
+ AD=0.1428p PS=0.6u PD=1.52u rfmode=0
M$925 VSS \$977 \$979 VSS sg13_lv_nmos L=0.13u W=0.64u AS=0.1331p AD=0.2176p
+ PS=1.12u PD=1.96u rfmode=0
M$926 VSS \$977 \$978 VSS sg13_lv_nmos L=0.13u W=1.48u AS=0.3922p AD=0.2737p
+ PS=3.28u PD=2.24u rfmode=0
M$928 VSS \$979 \$980 VSS sg13_lv_nmos L=0.13u W=1.48u AS=0.3922p AD=0.3922p
+ PS=3.28u PD=3.28u rfmode=0
M$930 VSS VSS \$805 VSS sg13_lv_nmos L=0.13u W=1u AS=0.265p AD=0.265p PS=2.56u
+ PD=2.56u rfmode=0
M$931 \$805 \$690 OUTP VSS sg13_lv_nmos L=0.13u W=2u AS=0.38p AD=0.38p PS=3.52u
+ PD=3.52u rfmode=0
M$933 \$805 \$692 OUTN VSS sg13_lv_nmos L=0.13u W=2u AS=0.38p AD=0.38p PS=3.52u
+ PD=3.52u rfmode=0
M$940 VSS \$199 \$926 VSS sg13_lv_nmos L=0.13u W=0.55u AS=0.187p AD=0.1045p
+ PS=1.78u PD=0.93u rfmode=0
M$941 \$926 \$5 VSS VSS sg13_lv_nmos L=0.13u W=0.55u AS=0.1045p AD=0.146425p
+ PS=0.93u PD=1.155u rfmode=0
M$942 VSS \$926 \$927 VSS sg13_lv_nmos L=0.13u W=1.48u AS=0.312925p AD=0.4477p
+ PS=2.345u PD=3.43u rfmode=0
M$944 \$984 \$983 \$1069 VSS sg13_lv_nmos L=0.13u W=0.42u AS=0.1428p AD=0.0609p
+ PS=1.52u PD=0.71u rfmode=0
M$945 \$1069 VDD VSS VSS sg13_lv_nmos L=0.13u W=0.42u AS=0.0609p AD=0.1626p
+ PS=0.71u PD=1.415u rfmode=0
M$946 VSS \$1078 \$928 VSS sg13_lv_nmos L=0.13u W=0.74u AS=0.1626p AD=0.2516p
+ PS=1.415u PD=2.16u rfmode=0
M$947 \$696 \$641 \$790 VSS sg13_lv_nmos L=0.13u W=0.42u AS=0.1296p AD=0.081p
+ PS=1.52u PD=0.81u rfmode=0
M$948 \$790 \$806 \$697 VSS sg13_lv_nmos L=0.13u W=0.42u AS=0.081p AD=0.2163p
+ PS=0.81u PD=1.87u rfmode=0
M$949 \$986 \$1079 VSS VSS sg13_lv_nmos L=0.13u W=0.42u AS=0.1428p AD=0.0798p
+ PS=1.52u PD=0.8u rfmode=0
M$950 VSS VDD \$1066 VSS sg13_lv_nmos L=0.13u W=0.42u AS=0.0798p AD=0.0378p
+ PS=0.8u PD=0.6u rfmode=0
M$951 \$1066 \$987 \$1079 VSS sg13_lv_nmos L=0.13u W=0.42u AS=0.0378p
+ AD=0.1428p PS=0.6u PD=1.52u rfmode=0
M$952 VSS \$987 \$989 VSS sg13_lv_nmos L=0.13u W=0.64u AS=0.1331p AD=0.2176p
+ PS=1.12u PD=1.96u rfmode=0
M$953 VSS \$987 \$988 VSS sg13_lv_nmos L=0.13u W=1.48u AS=0.3922p AD=0.2737p
+ PS=3.28u PD=2.24u rfmode=0
M$955 VSS \$989 \$990 VSS sg13_lv_nmos L=0.13u W=1.48u AS=0.3922p AD=0.3922p
+ PS=3.28u PD=3.28u rfmode=0
M$957 VSS VSS \$807 VSS sg13_lv_nmos L=0.13u W=1u AS=0.265p AD=0.265p PS=2.56u
+ PD=2.56u rfmode=0
M$958 \$807 \$700 OUTP VSS sg13_lv_nmos L=0.13u W=2u AS=0.38p AD=0.38p PS=3.52u
+ PD=3.52u rfmode=0
M$960 \$807 \$702 OUTN VSS sg13_lv_nmos L=0.13u W=2u AS=0.38p AD=0.38p PS=3.52u
+ PD=3.52u rfmode=0
M$967 VSS \$202 \$930 VSS sg13_lv_nmos L=0.13u W=0.55u AS=0.187p AD=0.1045p
+ PS=1.78u PD=0.93u rfmode=0
M$968 \$930 \$5 VSS VSS sg13_lv_nmos L=0.13u W=0.55u AS=0.1045p AD=0.146425p
+ PS=0.93u PD=1.155u rfmode=0
M$969 VSS \$930 \$931 VSS sg13_lv_nmos L=0.13u W=1.48u AS=0.312925p AD=0.4477p
+ PS=2.345u PD=3.43u rfmode=0
M$971 \$994 \$993 \$1057 VSS sg13_lv_nmos L=0.13u W=0.42u AS=0.1428p AD=0.0609p
+ PS=1.52u PD=0.71u rfmode=0
M$972 \$1057 VDD VSS VSS sg13_lv_nmos L=0.13u W=0.42u AS=0.0609p AD=0.1626p
+ PS=0.71u PD=1.415u rfmode=0
M$973 VSS \$1080 \$932 VSS sg13_lv_nmos L=0.13u W=0.74u AS=0.1626p AD=0.2516p
+ PS=1.415u PD=2.16u rfmode=0
M$974 \$706 \$645 \$792 VSS sg13_lv_nmos L=0.13u W=0.42u AS=0.1296p AD=0.081p
+ PS=1.52u PD=0.81u rfmode=0
M$975 \$792 \$808 \$707 VSS sg13_lv_nmos L=0.13u W=0.42u AS=0.081p AD=0.2163p
+ PS=0.81u PD=1.87u rfmode=0
M$976 \$996 \$1081 VSS VSS sg13_lv_nmos L=0.13u W=0.42u AS=0.1428p AD=0.0798p
+ PS=1.52u PD=0.8u rfmode=0
M$977 VSS VDD \$1054 VSS sg13_lv_nmos L=0.13u W=0.42u AS=0.0798p AD=0.0378p
+ PS=0.8u PD=0.6u rfmode=0
M$978 \$1054 \$997 \$1081 VSS sg13_lv_nmos L=0.13u W=0.42u AS=0.0378p
+ AD=0.1428p PS=0.6u PD=1.52u rfmode=0
M$979 VSS \$997 \$999 VSS sg13_lv_nmos L=0.13u W=0.64u AS=0.1331p AD=0.2176p
+ PS=1.12u PD=1.96u rfmode=0
M$980 VSS \$997 \$998 VSS sg13_lv_nmos L=0.13u W=1.48u AS=0.3922p AD=0.2737p
+ PS=3.28u PD=2.24u rfmode=0
M$982 VSS \$999 \$1000 VSS sg13_lv_nmos L=0.13u W=1.48u AS=0.3922p AD=0.3922p
+ PS=3.28u PD=3.28u rfmode=0
M$984 VSS VSS \$809 VSS sg13_lv_nmos L=0.13u W=1u AS=0.265p AD=0.265p PS=2.56u
+ PD=2.56u rfmode=0
M$985 \$809 \$710 OUTP VSS sg13_lv_nmos L=0.13u W=2u AS=0.38p AD=0.38p PS=3.52u
+ PD=3.52u rfmode=0
M$987 \$809 \$712 OUTN VSS sg13_lv_nmos L=0.13u W=2u AS=0.38p AD=0.38p PS=3.52u
+ PD=3.52u rfmode=0
M$994 VSS \$205 \$934 VSS sg13_lv_nmos L=0.13u W=0.55u AS=0.187p AD=0.1045p
+ PS=1.78u PD=0.93u rfmode=0
M$995 \$934 \$5 VSS VSS sg13_lv_nmos L=0.13u W=0.55u AS=0.1045p AD=0.146425p
+ PS=0.93u PD=1.155u rfmode=0
M$996 VSS \$934 \$935 VSS sg13_lv_nmos L=0.13u W=1.48u AS=0.312925p AD=0.4477p
+ PS=2.345u PD=3.43u rfmode=0
M$998 \$1004 \$1003 \$1044 VSS sg13_lv_nmos L=0.13u W=0.42u AS=0.1428p
+ AD=0.0609p PS=1.52u PD=0.71u rfmode=0
M$999 \$1044 VDD VSS VSS sg13_lv_nmos L=0.13u W=0.42u AS=0.0609p AD=0.1626p
+ PS=0.71u PD=1.415u rfmode=0
M$1000 VSS \$1082 \$936 VSS sg13_lv_nmos L=0.13u W=0.74u AS=0.1626p AD=0.2516p
+ PS=1.415u PD=2.16u rfmode=0
M$1001 \$716 \$649 \$794 VSS sg13_lv_nmos L=0.13u W=0.42u AS=0.1296p AD=0.081p
+ PS=1.52u PD=0.81u rfmode=0
M$1002 \$794 \$810 \$717 VSS sg13_lv_nmos L=0.13u W=0.42u AS=0.081p AD=0.2163p
+ PS=0.81u PD=1.87u rfmode=0
M$1003 \$1006 \$1083 VSS VSS sg13_lv_nmos L=0.13u W=0.42u AS=0.1428p AD=0.0798p
+ PS=1.52u PD=0.8u rfmode=0
M$1004 VSS VDD \$1040 VSS sg13_lv_nmos L=0.13u W=0.42u AS=0.0798p AD=0.0378p
+ PS=0.8u PD=0.6u rfmode=0
M$1005 \$1040 \$1007 \$1083 VSS sg13_lv_nmos L=0.13u W=0.42u AS=0.0378p
+ AD=0.1428p PS=0.6u PD=1.52u rfmode=0
M$1006 VSS \$1007 \$1009 VSS sg13_lv_nmos L=0.13u W=0.64u AS=0.1331p AD=0.2176p
+ PS=1.12u PD=1.96u rfmode=0
M$1007 VSS \$1007 \$1008 VSS sg13_lv_nmos L=0.13u W=1.48u AS=0.3922p AD=0.2737p
+ PS=3.28u PD=2.24u rfmode=0
M$1009 VSS \$1009 \$1010 VSS sg13_lv_nmos L=0.13u W=1.48u AS=0.3922p AD=0.3922p
+ PS=3.28u PD=3.28u rfmode=0
M$1011 VSS VSS \$811 VSS sg13_lv_nmos L=0.13u W=1u AS=0.265p AD=0.265p PS=2.56u
+ PD=2.56u rfmode=0
M$1012 \$811 \$720 OUTP VSS sg13_lv_nmos L=0.13u W=2u AS=0.38p AD=0.38p
+ PS=3.52u PD=3.52u rfmode=0
M$1014 \$811 \$722 OUTN VSS sg13_lv_nmos L=0.13u W=2u AS=0.38p AD=0.38p
+ PS=3.52u PD=3.52u rfmode=0
M$1021 VSS VSS \$938 VSS sg13_lv_nmos L=0.13u W=0.55u AS=0.187p AD=0.1045p
+ PS=1.78u PD=0.93u rfmode=0
M$1022 \$938 \$5 VSS VSS sg13_lv_nmos L=0.13u W=0.55u AS=0.1045p AD=0.146425p
+ PS=0.93u PD=1.155u rfmode=0
M$1023 VSS \$938 \$939 VSS sg13_lv_nmos L=0.13u W=1.48u AS=0.312925p AD=0.4477p
+ PS=2.345u PD=3.43u rfmode=0
M$1025 \$1014 \$1013 \$1032 VSS sg13_lv_nmos L=0.13u W=0.42u AS=0.1428p
+ AD=0.0609p PS=1.52u PD=0.71u rfmode=0
M$1026 \$1032 VDD VSS VSS sg13_lv_nmos L=0.13u W=0.42u AS=0.0609p AD=0.1626p
+ PS=0.71u PD=1.415u rfmode=0
M$1027 VSS \$1084 \$940 VSS sg13_lv_nmos L=0.13u W=0.74u AS=0.1626p AD=0.2516p
+ PS=1.415u PD=2.16u rfmode=0
M$1028 \$726 \$653 \$796 VSS sg13_lv_nmos L=0.13u W=0.42u AS=0.1296p AD=0.081p
+ PS=1.52u PD=0.81u rfmode=0
M$1029 \$796 \$812 \$727 VSS sg13_lv_nmos L=0.13u W=0.42u AS=0.081p AD=0.2163p
+ PS=0.81u PD=1.87u rfmode=0
M$1030 \$1016 \$1085 VSS VSS sg13_lv_nmos L=0.13u W=0.42u AS=0.1428p AD=0.0798p
+ PS=1.52u PD=0.8u rfmode=0
M$1031 VSS VDD \$1028 VSS sg13_lv_nmos L=0.13u W=0.42u AS=0.0798p AD=0.0378p
+ PS=0.8u PD=0.6u rfmode=0
M$1032 \$1028 \$1017 \$1085 VSS sg13_lv_nmos L=0.13u W=0.42u AS=0.0378p
+ AD=0.1428p PS=0.6u PD=1.52u rfmode=0
M$1033 VSS \$1017 \$1019 VSS sg13_lv_nmos L=0.13u W=0.64u AS=0.1331p AD=0.2176p
+ PS=1.12u PD=1.96u rfmode=0
M$1034 VSS \$1017 \$1018 VSS sg13_lv_nmos L=0.13u W=1.48u AS=0.3922p AD=0.2737p
+ PS=3.28u PD=2.24u rfmode=0
M$1036 VSS \$1019 \$1020 VSS sg13_lv_nmos L=0.13u W=1.48u AS=0.3922p AD=0.3922p
+ PS=3.28u PD=3.28u rfmode=0
M$1038 VSS VSS \$813 VSS sg13_lv_nmos L=0.13u W=1u AS=0.265p AD=0.265p PS=2.56u
+ PD=2.56u rfmode=0
M$1039 \$813 \$730 OUTP VSS sg13_lv_nmos L=0.13u W=2u AS=0.38p AD=0.38p
+ PS=3.52u PD=3.52u rfmode=0
M$1041 \$813 \$732 OUTN VSS sg13_lv_nmos L=0.13u W=2u AS=0.38p AD=0.38p
+ PS=3.52u PD=3.52u rfmode=0
M$1048 \$942 \$911 VSS VSS sg13_lv_nmos L=0.13u W=1.44u AS=0.4068p AD=0.2772p
+ PS=3.29u PD=2.21u rfmode=0
M$1050 \$942 \$186 \$943 VSS sg13_lv_nmos L=0.13u W=1.44u AS=0.2772p AD=0.3816p
+ PS=2.21u PD=3.22u rfmode=0
M$1052 VSS VDD \$1024 VSS sg13_lv_nmos L=0.13u W=0.42u AS=0.1701p AD=0.03885p
+ PS=1.65u PD=0.605u rfmode=0
M$1053 \$1024 \$912 \$945 VSS sg13_lv_nmos L=0.13u W=0.42u AS=0.03885p
+ AD=0.1596p PS=0.605u PD=1.6u rfmode=0
M$1054 VSS \$913 \$1086 VSS sg13_lv_nmos L=0.13u W=0.74u AS=0.43315p AD=0.2516p
+ PS=2.205u PD=2.16u rfmode=0
M$1055 VSS CLK \$913 VSS sg13_lv_nmos L=0.13u W=0.74u AS=0.43315p AD=0.2516p
+ PS=2.205u PD=2.16u rfmode=0
M$1056 \$947 \$913 \$946 VSS sg13_lv_nmos L=0.13u W=0.42u AS=0.12665p
+ AD=0.1428p PS=1.145u PD=1.52u rfmode=0
M$1057 \$912 \$1086 \$947 VSS sg13_lv_nmos L=0.13u W=0.74u AS=0.3473p
+ AD=0.12665p PS=2.71u PD=1.145u rfmode=0
M$1058 \$952 \$915 VSS VSS sg13_lv_nmos L=0.13u W=1.44u AS=0.4068p AD=0.2772p
+ PS=3.29u PD=2.21u rfmode=0
M$1060 \$952 \$186 \$953 VSS sg13_lv_nmos L=0.13u W=1.44u AS=0.2772p AD=0.3816p
+ PS=2.21u PD=3.22u rfmode=0
M$1062 VSS VDD \$1036 VSS sg13_lv_nmos L=0.13u W=0.42u AS=0.1701p AD=0.03885p
+ PS=1.65u PD=0.605u rfmode=0
M$1063 \$1036 \$916 \$955 VSS sg13_lv_nmos L=0.13u W=0.42u AS=0.03885p
+ AD=0.1596p PS=0.605u PD=1.6u rfmode=0
M$1064 VSS \$917 \$1088 VSS sg13_lv_nmos L=0.13u W=0.74u AS=0.43315p AD=0.2516p
+ PS=2.205u PD=2.16u rfmode=0
M$1065 VSS CLK \$917 VSS sg13_lv_nmos L=0.13u W=0.74u AS=0.43315p AD=0.2516p
+ PS=2.205u PD=2.16u rfmode=0
M$1066 \$957 \$917 \$956 VSS sg13_lv_nmos L=0.13u W=0.42u AS=0.12665p
+ AD=0.1428p PS=1.145u PD=1.52u rfmode=0
M$1067 \$916 \$1088 \$957 VSS sg13_lv_nmos L=0.13u W=0.74u AS=0.3473p
+ AD=0.12665p PS=2.71u PD=1.145u rfmode=0
M$1068 \$962 \$919 VSS VSS sg13_lv_nmos L=0.13u W=1.44u AS=0.4068p AD=0.2772p
+ PS=3.29u PD=2.21u rfmode=0
M$1070 \$962 \$186 \$963 VSS sg13_lv_nmos L=0.13u W=1.44u AS=0.2772p AD=0.3816p
+ PS=2.21u PD=3.22u rfmode=0
M$1072 VSS VDD \$1047 VSS sg13_lv_nmos L=0.13u W=0.42u AS=0.1701p AD=0.03885p
+ PS=1.65u PD=0.605u rfmode=0
M$1073 \$1047 \$920 \$965 VSS sg13_lv_nmos L=0.13u W=0.42u AS=0.03885p
+ AD=0.1596p PS=0.605u PD=1.6u rfmode=0
M$1074 VSS \$921 \$1090 VSS sg13_lv_nmos L=0.13u W=0.74u AS=0.43315p AD=0.2516p
+ PS=2.205u PD=2.16u rfmode=0
M$1075 VSS CLK \$921 VSS sg13_lv_nmos L=0.13u W=0.74u AS=0.43315p AD=0.2516p
+ PS=2.205u PD=2.16u rfmode=0
M$1076 \$967 \$921 \$966 VSS sg13_lv_nmos L=0.13u W=0.42u AS=0.12665p
+ AD=0.1428p PS=1.145u PD=1.52u rfmode=0
M$1077 \$920 \$1090 \$967 VSS sg13_lv_nmos L=0.13u W=0.74u AS=0.3473p
+ AD=0.12665p PS=2.71u PD=1.145u rfmode=0
M$1078 \$972 \$923 VSS VSS sg13_lv_nmos L=0.13u W=1.44u AS=0.4068p AD=0.2772p
+ PS=3.29u PD=2.21u rfmode=0
M$1080 \$972 \$186 \$973 VSS sg13_lv_nmos L=0.13u W=1.44u AS=0.2772p AD=0.3816p
+ PS=2.21u PD=3.22u rfmode=0
M$1082 VSS VDD \$1059 VSS sg13_lv_nmos L=0.13u W=0.42u AS=0.1701p AD=0.03885p
+ PS=1.65u PD=0.605u rfmode=0
M$1083 \$1059 \$924 \$975 VSS sg13_lv_nmos L=0.13u W=0.42u AS=0.03885p
+ AD=0.1596p PS=0.605u PD=1.6u rfmode=0
M$1084 VSS \$925 \$1092 VSS sg13_lv_nmos L=0.13u W=0.74u AS=0.43315p AD=0.2516p
+ PS=2.205u PD=2.16u rfmode=0
M$1085 VSS CLK \$925 VSS sg13_lv_nmos L=0.13u W=0.74u AS=0.43315p AD=0.2516p
+ PS=2.205u PD=2.16u rfmode=0
M$1086 \$977 \$925 \$976 VSS sg13_lv_nmos L=0.13u W=0.42u AS=0.12665p
+ AD=0.1428p PS=1.145u PD=1.52u rfmode=0
M$1087 \$924 \$1092 \$977 VSS sg13_lv_nmos L=0.13u W=0.74u AS=0.3473p
+ AD=0.12665p PS=2.71u PD=1.145u rfmode=0
M$1088 \$982 \$927 VSS VSS sg13_lv_nmos L=0.13u W=1.44u AS=0.4068p AD=0.2772p
+ PS=3.29u PD=2.21u rfmode=0
M$1090 \$982 \$186 \$983 VSS sg13_lv_nmos L=0.13u W=1.44u AS=0.2772p AD=0.3816p
+ PS=2.21u PD=3.22u rfmode=0
M$1092 VSS VDD \$1068 VSS sg13_lv_nmos L=0.13u W=0.42u AS=0.1701p AD=0.03885p
+ PS=1.65u PD=0.605u rfmode=0
M$1093 \$1068 \$928 \$985 VSS sg13_lv_nmos L=0.13u W=0.42u AS=0.03885p
+ AD=0.1596p PS=0.605u PD=1.6u rfmode=0
M$1094 VSS \$929 \$1094 VSS sg13_lv_nmos L=0.13u W=0.74u AS=0.43315p AD=0.2516p
+ PS=2.205u PD=2.16u rfmode=0
M$1095 VSS CLK \$929 VSS sg13_lv_nmos L=0.13u W=0.74u AS=0.43315p AD=0.2516p
+ PS=2.205u PD=2.16u rfmode=0
M$1096 \$987 \$929 \$986 VSS sg13_lv_nmos L=0.13u W=0.42u AS=0.12665p
+ AD=0.1428p PS=1.145u PD=1.52u rfmode=0
M$1097 \$928 \$1094 \$987 VSS sg13_lv_nmos L=0.13u W=0.74u AS=0.3473p
+ AD=0.12665p PS=2.71u PD=1.145u rfmode=0
M$1098 \$992 \$931 VSS VSS sg13_lv_nmos L=0.13u W=1.44u AS=0.4068p AD=0.2772p
+ PS=3.29u PD=2.21u rfmode=0
M$1100 \$992 \$186 \$993 VSS sg13_lv_nmos L=0.13u W=1.44u AS=0.2772p AD=0.3816p
+ PS=2.21u PD=3.22u rfmode=0
M$1102 VSS VDD \$1056 VSS sg13_lv_nmos L=0.13u W=0.42u AS=0.1701p AD=0.03885p
+ PS=1.65u PD=0.605u rfmode=0
M$1103 \$1056 \$932 \$995 VSS sg13_lv_nmos L=0.13u W=0.42u AS=0.03885p
+ AD=0.1596p PS=0.605u PD=1.6u rfmode=0
M$1104 VSS \$933 \$1096 VSS sg13_lv_nmos L=0.13u W=0.74u AS=0.43315p AD=0.2516p
+ PS=2.205u PD=2.16u rfmode=0
M$1105 VSS CLK \$933 VSS sg13_lv_nmos L=0.13u W=0.74u AS=0.43315p AD=0.2516p
+ PS=2.205u PD=2.16u rfmode=0
M$1106 \$997 \$933 \$996 VSS sg13_lv_nmos L=0.13u W=0.42u AS=0.12665p
+ AD=0.1428p PS=1.145u PD=1.52u rfmode=0
M$1107 \$932 \$1096 \$997 VSS sg13_lv_nmos L=0.13u W=0.74u AS=0.3473p
+ AD=0.12665p PS=2.71u PD=1.145u rfmode=0
M$1108 \$1002 \$935 VSS VSS sg13_lv_nmos L=0.13u W=1.44u AS=0.4068p AD=0.2772p
+ PS=3.29u PD=2.21u rfmode=0
M$1110 \$1002 \$186 \$1003 VSS sg13_lv_nmos L=0.13u W=1.44u AS=0.2772p
+ AD=0.3816p PS=2.21u PD=3.22u rfmode=0
M$1112 VSS VDD \$1043 VSS sg13_lv_nmos L=0.13u W=0.42u AS=0.1701p AD=0.03885p
+ PS=1.65u PD=0.605u rfmode=0
M$1113 \$1043 \$936 \$1005 VSS sg13_lv_nmos L=0.13u W=0.42u AS=0.03885p
+ AD=0.1596p PS=0.605u PD=1.6u rfmode=0
M$1114 VSS \$937 \$1098 VSS sg13_lv_nmos L=0.13u W=0.74u AS=0.43315p AD=0.2516p
+ PS=2.205u PD=2.16u rfmode=0
M$1115 VSS CLK \$937 VSS sg13_lv_nmos L=0.13u W=0.74u AS=0.43315p AD=0.2516p
+ PS=2.205u PD=2.16u rfmode=0
M$1116 \$1007 \$937 \$1006 VSS sg13_lv_nmos L=0.13u W=0.42u AS=0.12665p
+ AD=0.1428p PS=1.145u PD=1.52u rfmode=0
M$1117 \$936 \$1098 \$1007 VSS sg13_lv_nmos L=0.13u W=0.74u AS=0.3473p
+ AD=0.12665p PS=2.71u PD=1.145u rfmode=0
M$1118 \$1012 \$939 VSS VSS sg13_lv_nmos L=0.13u W=1.44u AS=0.4068p AD=0.2772p
+ PS=3.29u PD=2.21u rfmode=0
M$1120 \$1012 \$186 \$1013 VSS sg13_lv_nmos L=0.13u W=1.44u AS=0.2772p
+ AD=0.3816p PS=2.21u PD=3.22u rfmode=0
M$1122 VSS VDD \$1031 VSS sg13_lv_nmos L=0.13u W=0.42u AS=0.1701p AD=0.03885p
+ PS=1.65u PD=0.605u rfmode=0
M$1123 \$1031 \$940 \$1015 VSS sg13_lv_nmos L=0.13u W=0.42u AS=0.03885p
+ AD=0.1596p PS=0.605u PD=1.6u rfmode=0
M$1124 VSS \$941 \$1100 VSS sg13_lv_nmos L=0.13u W=0.74u AS=0.43315p AD=0.2516p
+ PS=2.205u PD=2.16u rfmode=0
M$1125 VSS CLK \$941 VSS sg13_lv_nmos L=0.13u W=0.74u AS=0.43315p AD=0.2516p
+ PS=2.205u PD=2.16u rfmode=0
M$1126 \$1017 \$941 \$1016 VSS sg13_lv_nmos L=0.13u W=0.42u AS=0.12665p
+ AD=0.1428p PS=1.145u PD=1.52u rfmode=0
M$1127 \$940 \$1100 \$1017 VSS sg13_lv_nmos L=0.13u W=0.74u AS=0.3473p
+ AD=0.12665p PS=2.71u PD=1.145u rfmode=0
M$1128 VSS \$187 \$1198 VSS sg13_lv_nmos L=0.13u W=0.55u AS=0.187p AD=0.1045p
+ PS=1.78u PD=0.93u rfmode=0
M$1129 \$1198 \$266 VSS VSS sg13_lv_nmos L=0.13u W=0.55u AS=0.1045p
+ AD=0.146425p PS=0.93u PD=1.155u rfmode=0
M$1130 VSS \$1198 \$1199 VSS sg13_lv_nmos L=0.13u W=1.48u AS=0.312925p
+ AD=0.4477p PS=2.345u PD=3.43u rfmode=0
M$1132 \$1232 \$1231 \$1311 VSS sg13_lv_nmos L=0.13u W=0.42u AS=0.1428p
+ AD=0.0609p PS=1.52u PD=0.71u rfmode=0
M$1133 \$1311 VDD VSS VSS sg13_lv_nmos L=0.13u W=0.42u AS=0.0609p AD=0.1626p
+ PS=0.71u PD=1.415u rfmode=0
M$1134 VSS \$1358 \$1200 VSS sg13_lv_nmos L=0.13u W=0.74u AS=0.1626p AD=0.2516p
+ PS=1.415u PD=2.16u rfmode=0
M$1135 \$944 \$913 \$1070 VSS sg13_lv_nmos L=0.13u W=0.42u AS=0.1296p AD=0.081p
+ PS=1.52u PD=0.81u rfmode=0
M$1136 \$1070 \$1086 \$945 VSS sg13_lv_nmos L=0.13u W=0.42u AS=0.081p
+ AD=0.2163p PS=0.81u PD=1.87u rfmode=0
M$1137 \$1234 \$1359 VSS VSS sg13_lv_nmos L=0.13u W=0.42u AS=0.1428p AD=0.0798p
+ PS=1.52u PD=0.8u rfmode=0
M$1138 VSS VDD \$1315 VSS sg13_lv_nmos L=0.13u W=0.42u AS=0.0798p AD=0.0378p
+ PS=0.8u PD=0.6u rfmode=0
M$1139 \$1315 \$1235 \$1359 VSS sg13_lv_nmos L=0.13u W=0.42u AS=0.0378p
+ AD=0.1428p PS=0.6u PD=1.52u rfmode=0
M$1140 VSS \$1235 \$1237 VSS sg13_lv_nmos L=0.13u W=0.64u AS=0.1331p AD=0.2176p
+ PS=1.12u PD=1.96u rfmode=0
M$1141 VSS \$1235 \$1236 VSS sg13_lv_nmos L=0.13u W=1.48u AS=0.3922p AD=0.2737p
+ PS=3.28u PD=2.24u rfmode=0
M$1143 VSS \$1237 \$1238 VSS sg13_lv_nmos L=0.13u W=1.48u AS=0.3922p AD=0.3922p
+ PS=3.28u PD=3.28u rfmode=0
M$1145 VSS VSS \$1087 VSS sg13_lv_nmos L=0.13u W=1u AS=0.265p AD=0.265p
+ PS=2.56u PD=2.56u rfmode=0
M$1146 \$1087 \$948 OUTP VSS sg13_lv_nmos L=0.13u W=2u AS=0.38p AD=0.38p
+ PS=3.52u PD=3.52u rfmode=0
M$1148 \$1087 \$950 OUTN VSS sg13_lv_nmos L=0.13u W=2u AS=0.38p AD=0.38p
+ PS=3.52u PD=3.52u rfmode=0
M$1155 VSS \$190 \$1202 VSS sg13_lv_nmos L=0.13u W=0.55u AS=0.187p AD=0.1045p
+ PS=1.78u PD=0.93u rfmode=0
M$1156 \$1202 \$266 VSS VSS sg13_lv_nmos L=0.13u W=0.55u AS=0.1045p
+ AD=0.146425p PS=0.93u PD=1.155u rfmode=0
M$1157 VSS \$1202 \$1203 VSS sg13_lv_nmos L=0.13u W=1.48u AS=0.312925p
+ AD=0.4477p PS=2.345u PD=3.43u rfmode=0
M$1159 \$1242 \$1241 \$1323 VSS sg13_lv_nmos L=0.13u W=0.42u AS=0.1428p
+ AD=0.0609p PS=1.52u PD=0.71u rfmode=0
M$1160 \$1323 VDD VSS VSS sg13_lv_nmos L=0.13u W=0.42u AS=0.0609p AD=0.1626p
+ PS=0.71u PD=1.415u rfmode=0
M$1161 VSS \$1360 \$1204 VSS sg13_lv_nmos L=0.13u W=0.74u AS=0.1626p AD=0.2516p
+ PS=1.415u PD=2.16u rfmode=0
M$1162 \$954 \$917 \$1072 VSS sg13_lv_nmos L=0.13u W=0.42u AS=0.1296p AD=0.081p
+ PS=1.52u PD=0.81u rfmode=0
M$1163 \$1072 \$1088 \$955 VSS sg13_lv_nmos L=0.13u W=0.42u AS=0.081p
+ AD=0.2163p PS=0.81u PD=1.87u rfmode=0
M$1164 \$1244 \$1361 VSS VSS sg13_lv_nmos L=0.13u W=0.42u AS=0.1428p AD=0.0798p
+ PS=1.52u PD=0.8u rfmode=0
M$1165 VSS VDD \$1327 VSS sg13_lv_nmos L=0.13u W=0.42u AS=0.0798p AD=0.0378p
+ PS=0.8u PD=0.6u rfmode=0
M$1166 \$1327 \$1245 \$1361 VSS sg13_lv_nmos L=0.13u W=0.42u AS=0.0378p
+ AD=0.1428p PS=0.6u PD=1.52u rfmode=0
M$1167 VSS \$1245 \$1247 VSS sg13_lv_nmos L=0.13u W=0.64u AS=0.1331p AD=0.2176p
+ PS=1.12u PD=1.96u rfmode=0
M$1168 VSS \$1245 \$1246 VSS sg13_lv_nmos L=0.13u W=1.48u AS=0.3922p AD=0.2737p
+ PS=3.28u PD=2.24u rfmode=0
M$1170 VSS \$1247 \$1248 VSS sg13_lv_nmos L=0.13u W=1.48u AS=0.3922p AD=0.3922p
+ PS=3.28u PD=3.28u rfmode=0
M$1172 VSS VSS \$1089 VSS sg13_lv_nmos L=0.13u W=1u AS=0.265p AD=0.265p
+ PS=2.56u PD=2.56u rfmode=0
M$1173 \$1089 \$958 OUTP VSS sg13_lv_nmos L=0.13u W=2u AS=0.38p AD=0.38p
+ PS=3.52u PD=3.52u rfmode=0
M$1175 \$1089 \$960 OUTN VSS sg13_lv_nmos L=0.13u W=2u AS=0.38p AD=0.38p
+ PS=3.52u PD=3.52u rfmode=0
M$1182 VSS \$193 \$1206 VSS sg13_lv_nmos L=0.13u W=0.55u AS=0.187p AD=0.1045p
+ PS=1.78u PD=0.93u rfmode=0
M$1183 \$1206 \$266 VSS VSS sg13_lv_nmos L=0.13u W=0.55u AS=0.1045p
+ AD=0.146425p PS=0.93u PD=1.155u rfmode=0
M$1184 VSS \$1206 \$1207 VSS sg13_lv_nmos L=0.13u W=1.48u AS=0.312925p
+ AD=0.4477p PS=2.345u PD=3.43u rfmode=0
M$1186 \$1252 \$1251 \$1334 VSS sg13_lv_nmos L=0.13u W=0.42u AS=0.1428p
+ AD=0.0609p PS=1.52u PD=0.71u rfmode=0
M$1187 \$1334 VDD VSS VSS sg13_lv_nmos L=0.13u W=0.42u AS=0.0609p AD=0.1626p
+ PS=0.71u PD=1.415u rfmode=0
M$1188 VSS \$1362 \$1208 VSS sg13_lv_nmos L=0.13u W=0.74u AS=0.1626p AD=0.2516p
+ PS=1.415u PD=2.16u rfmode=0
M$1189 \$964 \$921 \$1074 VSS sg13_lv_nmos L=0.13u W=0.42u AS=0.1296p AD=0.081p
+ PS=1.52u PD=0.81u rfmode=0
M$1190 \$1074 \$1090 \$965 VSS sg13_lv_nmos L=0.13u W=0.42u AS=0.081p
+ AD=0.2163p PS=0.81u PD=1.87u rfmode=0
M$1191 \$1254 \$1363 VSS VSS sg13_lv_nmos L=0.13u W=0.42u AS=0.1428p AD=0.0798p
+ PS=1.52u PD=0.8u rfmode=0
M$1192 VSS VDD \$1339 VSS sg13_lv_nmos L=0.13u W=0.42u AS=0.0798p AD=0.0378p
+ PS=0.8u PD=0.6u rfmode=0
M$1193 \$1339 \$1255 \$1363 VSS sg13_lv_nmos L=0.13u W=0.42u AS=0.0378p
+ AD=0.1428p PS=0.6u PD=1.52u rfmode=0
M$1194 VSS \$1255 \$1257 VSS sg13_lv_nmos L=0.13u W=0.64u AS=0.1331p AD=0.2176p
+ PS=1.12u PD=1.96u rfmode=0
M$1195 VSS \$1255 \$1256 VSS sg13_lv_nmos L=0.13u W=1.48u AS=0.3922p AD=0.2737p
+ PS=3.28u PD=2.24u rfmode=0
M$1197 VSS \$1257 \$1258 VSS sg13_lv_nmos L=0.13u W=1.48u AS=0.3922p AD=0.3922p
+ PS=3.28u PD=3.28u rfmode=0
M$1199 VSS VSS \$1091 VSS sg13_lv_nmos L=0.13u W=1u AS=0.265p AD=0.265p
+ PS=2.56u PD=2.56u rfmode=0
M$1200 \$1091 \$968 OUTP VSS sg13_lv_nmos L=0.13u W=2u AS=0.38p AD=0.38p
+ PS=3.52u PD=3.52u rfmode=0
M$1202 \$1091 \$970 OUTN VSS sg13_lv_nmos L=0.13u W=2u AS=0.38p AD=0.38p
+ PS=3.52u PD=3.52u rfmode=0
M$1209 VSS \$196 \$1210 VSS sg13_lv_nmos L=0.13u W=0.55u AS=0.187p AD=0.1045p
+ PS=1.78u PD=0.93u rfmode=0
M$1210 \$1210 \$266 VSS VSS sg13_lv_nmos L=0.13u W=0.55u AS=0.1045p
+ AD=0.146425p PS=0.93u PD=1.155u rfmode=0
M$1211 VSS \$1210 \$1211 VSS sg13_lv_nmos L=0.13u W=1.48u AS=0.312925p
+ AD=0.4477p PS=2.345u PD=3.43u rfmode=0
M$1213 \$1262 \$1261 \$1346 VSS sg13_lv_nmos L=0.13u W=0.42u AS=0.1428p
+ AD=0.0609p PS=1.52u PD=0.71u rfmode=0
M$1214 \$1346 VDD VSS VSS sg13_lv_nmos L=0.13u W=0.42u AS=0.0609p AD=0.1626p
+ PS=0.71u PD=1.415u rfmode=0
M$1215 VSS \$1364 \$1212 VSS sg13_lv_nmos L=0.13u W=0.74u AS=0.1626p AD=0.2516p
+ PS=1.415u PD=2.16u rfmode=0
M$1216 \$974 \$925 \$1076 VSS sg13_lv_nmos L=0.13u W=0.42u AS=0.1296p AD=0.081p
+ PS=1.52u PD=0.81u rfmode=0
M$1217 \$1076 \$1092 \$975 VSS sg13_lv_nmos L=0.13u W=0.42u AS=0.081p
+ AD=0.2163p PS=0.81u PD=1.87u rfmode=0
M$1218 \$1264 \$1365 VSS VSS sg13_lv_nmos L=0.13u W=0.42u AS=0.1428p AD=0.0798p
+ PS=1.52u PD=0.8u rfmode=0
M$1219 VSS VDD \$1349 VSS sg13_lv_nmos L=0.13u W=0.42u AS=0.0798p AD=0.0378p
+ PS=0.8u PD=0.6u rfmode=0
M$1220 \$1349 \$1265 \$1365 VSS sg13_lv_nmos L=0.13u W=0.42u AS=0.0378p
+ AD=0.1428p PS=0.6u PD=1.52u rfmode=0
M$1221 VSS \$1265 \$1267 VSS sg13_lv_nmos L=0.13u W=0.64u AS=0.1331p AD=0.2176p
+ PS=1.12u PD=1.96u rfmode=0
M$1222 VSS \$1265 \$1266 VSS sg13_lv_nmos L=0.13u W=1.48u AS=0.3922p AD=0.2737p
+ PS=3.28u PD=2.24u rfmode=0
M$1224 VSS \$1267 \$1268 VSS sg13_lv_nmos L=0.13u W=1.48u AS=0.3922p AD=0.3922p
+ PS=3.28u PD=3.28u rfmode=0
M$1226 VSS VSS \$1093 VSS sg13_lv_nmos L=0.13u W=1u AS=0.265p AD=0.265p
+ PS=2.56u PD=2.56u rfmode=0
M$1227 \$1093 \$978 OUTP VSS sg13_lv_nmos L=0.13u W=2u AS=0.38p AD=0.38p
+ PS=3.52u PD=3.52u rfmode=0
M$1229 \$1093 \$980 OUTN VSS sg13_lv_nmos L=0.13u W=2u AS=0.38p AD=0.38p
+ PS=3.52u PD=3.52u rfmode=0
M$1236 VSS \$199 \$1214 VSS sg13_lv_nmos L=0.13u W=0.55u AS=0.187p AD=0.1045p
+ PS=1.78u PD=0.93u rfmode=0
M$1237 \$1214 \$266 VSS VSS sg13_lv_nmos L=0.13u W=0.55u AS=0.1045p
+ AD=0.146425p PS=0.93u PD=1.155u rfmode=0
M$1238 VSS \$1214 \$1215 VSS sg13_lv_nmos L=0.13u W=1.48u AS=0.312925p
+ AD=0.4477p PS=2.345u PD=3.43u rfmode=0
M$1240 \$1272 \$1271 \$1357 VSS sg13_lv_nmos L=0.13u W=0.42u AS=0.1428p
+ AD=0.0609p PS=1.52u PD=0.71u rfmode=0
M$1241 \$1357 VDD VSS VSS sg13_lv_nmos L=0.13u W=0.42u AS=0.0609p AD=0.1626p
+ PS=0.71u PD=1.415u rfmode=0
M$1242 VSS \$1366 \$1216 VSS sg13_lv_nmos L=0.13u W=0.74u AS=0.1626p AD=0.2516p
+ PS=1.415u PD=2.16u rfmode=0
M$1243 \$984 \$929 \$1078 VSS sg13_lv_nmos L=0.13u W=0.42u AS=0.1296p AD=0.081p
+ PS=1.52u PD=0.81u rfmode=0
M$1244 \$1078 \$1094 \$985 VSS sg13_lv_nmos L=0.13u W=0.42u AS=0.081p
+ AD=0.2163p PS=0.81u PD=1.87u rfmode=0
M$1245 \$1274 \$1367 VSS VSS sg13_lv_nmos L=0.13u W=0.42u AS=0.1428p AD=0.0798p
+ PS=1.52u PD=0.8u rfmode=0
M$1246 VSS VDD \$1354 VSS sg13_lv_nmos L=0.13u W=0.42u AS=0.0798p AD=0.0378p
+ PS=0.8u PD=0.6u rfmode=0
M$1247 \$1354 \$1275 \$1367 VSS sg13_lv_nmos L=0.13u W=0.42u AS=0.0378p
+ AD=0.1428p PS=0.6u PD=1.52u rfmode=0
M$1248 VSS \$1275 \$1277 VSS sg13_lv_nmos L=0.13u W=0.64u AS=0.1331p AD=0.2176p
+ PS=1.12u PD=1.96u rfmode=0
M$1249 VSS \$1275 \$1276 VSS sg13_lv_nmos L=0.13u W=1.48u AS=0.3922p AD=0.2737p
+ PS=3.28u PD=2.24u rfmode=0
M$1251 VSS \$1277 \$1278 VSS sg13_lv_nmos L=0.13u W=1.48u AS=0.3922p AD=0.3922p
+ PS=3.28u PD=3.28u rfmode=0
M$1253 VSS VSS \$1095 VSS sg13_lv_nmos L=0.13u W=1u AS=0.265p AD=0.265p
+ PS=2.56u PD=2.56u rfmode=0
M$1254 \$1095 \$988 OUTP VSS sg13_lv_nmos L=0.13u W=2u AS=0.38p AD=0.38p
+ PS=3.52u PD=3.52u rfmode=0
M$1256 \$1095 \$990 OUTN VSS sg13_lv_nmos L=0.13u W=2u AS=0.38p AD=0.38p
+ PS=3.52u PD=3.52u rfmode=0
M$1263 VSS \$202 \$1218 VSS sg13_lv_nmos L=0.13u W=0.55u AS=0.187p AD=0.1045p
+ PS=1.78u PD=0.93u rfmode=0
M$1264 \$1218 \$266 VSS VSS sg13_lv_nmos L=0.13u W=0.55u AS=0.1045p
+ AD=0.146425p PS=0.93u PD=1.155u rfmode=0
M$1265 VSS \$1218 \$1219 VSS sg13_lv_nmos L=0.13u W=1.48u AS=0.312925p
+ AD=0.4477p PS=2.345u PD=3.43u rfmode=0
M$1267 \$1282 \$1281 \$1345 VSS sg13_lv_nmos L=0.13u W=0.42u AS=0.1428p
+ AD=0.0609p PS=1.52u PD=0.71u rfmode=0
M$1268 \$1345 VDD VSS VSS sg13_lv_nmos L=0.13u W=0.42u AS=0.0609p AD=0.1626p
+ PS=0.71u PD=1.415u rfmode=0
M$1269 VSS \$1368 \$1220 VSS sg13_lv_nmos L=0.13u W=0.74u AS=0.1626p AD=0.2516p
+ PS=1.415u PD=2.16u rfmode=0
M$1270 \$994 \$933 \$1080 VSS sg13_lv_nmos L=0.13u W=0.42u AS=0.1296p AD=0.081p
+ PS=1.52u PD=0.81u rfmode=0
M$1271 \$1080 \$1096 \$995 VSS sg13_lv_nmos L=0.13u W=0.42u AS=0.081p
+ AD=0.2163p PS=0.81u PD=1.87u rfmode=0
M$1272 \$1284 \$1369 VSS VSS sg13_lv_nmos L=0.13u W=0.42u AS=0.1428p AD=0.0798p
+ PS=1.52u PD=0.8u rfmode=0
M$1273 VSS VDD \$1342 VSS sg13_lv_nmos L=0.13u W=0.42u AS=0.0798p AD=0.0378p
+ PS=0.8u PD=0.6u rfmode=0
M$1274 \$1342 \$1285 \$1369 VSS sg13_lv_nmos L=0.13u W=0.42u AS=0.0378p
+ AD=0.1428p PS=0.6u PD=1.52u rfmode=0
M$1275 VSS \$1285 \$1287 VSS sg13_lv_nmos L=0.13u W=0.64u AS=0.1331p AD=0.2176p
+ PS=1.12u PD=1.96u rfmode=0
M$1276 VSS \$1285 \$1286 VSS sg13_lv_nmos L=0.13u W=1.48u AS=0.3922p AD=0.2737p
+ PS=3.28u PD=2.24u rfmode=0
M$1278 VSS \$1287 \$1288 VSS sg13_lv_nmos L=0.13u W=1.48u AS=0.3922p AD=0.3922p
+ PS=3.28u PD=3.28u rfmode=0
M$1280 VSS VSS \$1097 VSS sg13_lv_nmos L=0.13u W=1u AS=0.265p AD=0.265p
+ PS=2.56u PD=2.56u rfmode=0
M$1281 \$1097 \$998 OUTP VSS sg13_lv_nmos L=0.13u W=2u AS=0.38p AD=0.38p
+ PS=3.52u PD=3.52u rfmode=0
M$1283 \$1097 \$1000 OUTN VSS sg13_lv_nmos L=0.13u W=2u AS=0.38p AD=0.38p
+ PS=3.52u PD=3.52u rfmode=0
M$1290 VSS \$205 \$1222 VSS sg13_lv_nmos L=0.13u W=0.55u AS=0.187p AD=0.1045p
+ PS=1.78u PD=0.93u rfmode=0
M$1291 \$1222 \$266 VSS VSS sg13_lv_nmos L=0.13u W=0.55u AS=0.1045p
+ AD=0.146425p PS=0.93u PD=1.155u rfmode=0
M$1292 VSS \$1222 \$1223 VSS sg13_lv_nmos L=0.13u W=1.48u AS=0.312925p
+ AD=0.4477p PS=2.345u PD=3.43u rfmode=0
M$1294 \$1292 \$1291 \$1332 VSS sg13_lv_nmos L=0.13u W=0.42u AS=0.1428p
+ AD=0.0609p PS=1.52u PD=0.71u rfmode=0
M$1295 \$1332 VDD VSS VSS sg13_lv_nmos L=0.13u W=0.42u AS=0.0609p AD=0.1626p
+ PS=0.71u PD=1.415u rfmode=0
M$1296 VSS \$1370 \$1224 VSS sg13_lv_nmos L=0.13u W=0.74u AS=0.1626p AD=0.2516p
+ PS=1.415u PD=2.16u rfmode=0
M$1297 \$1004 \$937 \$1082 VSS sg13_lv_nmos L=0.13u W=0.42u AS=0.1296p
+ AD=0.081p PS=1.52u PD=0.81u rfmode=0
M$1298 \$1082 \$1098 \$1005 VSS sg13_lv_nmos L=0.13u W=0.42u AS=0.081p
+ AD=0.2163p PS=0.81u PD=1.87u rfmode=0
M$1299 \$1294 \$1371 VSS VSS sg13_lv_nmos L=0.13u W=0.42u AS=0.1428p AD=0.0798p
+ PS=1.52u PD=0.8u rfmode=0
M$1300 VSS VDD \$1328 VSS sg13_lv_nmos L=0.13u W=0.42u AS=0.0798p AD=0.0378p
+ PS=0.8u PD=0.6u rfmode=0
M$1301 \$1328 \$1295 \$1371 VSS sg13_lv_nmos L=0.13u W=0.42u AS=0.0378p
+ AD=0.1428p PS=0.6u PD=1.52u rfmode=0
M$1302 VSS \$1295 \$1297 VSS sg13_lv_nmos L=0.13u W=0.64u AS=0.1331p AD=0.2176p
+ PS=1.12u PD=1.96u rfmode=0
M$1303 VSS \$1295 \$1296 VSS sg13_lv_nmos L=0.13u W=1.48u AS=0.3922p AD=0.2737p
+ PS=3.28u PD=2.24u rfmode=0
M$1305 VSS \$1297 \$1298 VSS sg13_lv_nmos L=0.13u W=1.48u AS=0.3922p AD=0.3922p
+ PS=3.28u PD=3.28u rfmode=0
M$1307 VSS VSS \$1099 VSS sg13_lv_nmos L=0.13u W=1u AS=0.265p AD=0.265p
+ PS=2.56u PD=2.56u rfmode=0
M$1308 \$1099 \$1008 OUTP VSS sg13_lv_nmos L=0.13u W=2u AS=0.38p AD=0.38p
+ PS=3.52u PD=3.52u rfmode=0
M$1310 \$1099 \$1010 OUTN VSS sg13_lv_nmos L=0.13u W=2u AS=0.38p AD=0.38p
+ PS=3.52u PD=3.52u rfmode=0
M$1317 VSS VSS \$1226 VSS sg13_lv_nmos L=0.13u W=0.55u AS=0.187p AD=0.1045p
+ PS=1.78u PD=0.93u rfmode=0
M$1318 \$1226 \$266 VSS VSS sg13_lv_nmos L=0.13u W=0.55u AS=0.1045p
+ AD=0.146425p PS=0.93u PD=1.155u rfmode=0
M$1319 VSS \$1226 \$1227 VSS sg13_lv_nmos L=0.13u W=1.48u AS=0.312925p
+ AD=0.4477p PS=2.345u PD=3.43u rfmode=0
M$1321 \$1302 \$1301 \$1320 VSS sg13_lv_nmos L=0.13u W=0.42u AS=0.1428p
+ AD=0.0609p PS=1.52u PD=0.71u rfmode=0
M$1322 \$1320 VDD VSS VSS sg13_lv_nmos L=0.13u W=0.42u AS=0.0609p AD=0.1626p
+ PS=0.71u PD=1.415u rfmode=0
M$1323 VSS \$1372 \$1228 VSS sg13_lv_nmos L=0.13u W=0.74u AS=0.1626p AD=0.2516p
+ PS=1.415u PD=2.16u rfmode=0
M$1324 \$1014 \$941 \$1084 VSS sg13_lv_nmos L=0.13u W=0.42u AS=0.1296p
+ AD=0.081p PS=1.52u PD=0.81u rfmode=0
M$1325 \$1084 \$1100 \$1015 VSS sg13_lv_nmos L=0.13u W=0.42u AS=0.081p
+ AD=0.2163p PS=0.81u PD=1.87u rfmode=0
M$1326 \$1304 \$1373 VSS VSS sg13_lv_nmos L=0.13u W=0.42u AS=0.1428p AD=0.0798p
+ PS=1.52u PD=0.8u rfmode=0
M$1327 VSS VDD \$1316 VSS sg13_lv_nmos L=0.13u W=0.42u AS=0.0798p AD=0.0378p
+ PS=0.8u PD=0.6u rfmode=0
M$1328 \$1316 \$1305 \$1373 VSS sg13_lv_nmos L=0.13u W=0.42u AS=0.0378p
+ AD=0.1428p PS=0.6u PD=1.52u rfmode=0
M$1329 VSS \$1305 \$1307 VSS sg13_lv_nmos L=0.13u W=0.64u AS=0.1331p AD=0.2176p
+ PS=1.12u PD=1.96u rfmode=0
M$1330 VSS \$1305 \$1306 VSS sg13_lv_nmos L=0.13u W=1.48u AS=0.3922p AD=0.2737p
+ PS=3.28u PD=2.24u rfmode=0
M$1332 VSS \$1307 \$1308 VSS sg13_lv_nmos L=0.13u W=1.48u AS=0.3922p AD=0.3922p
+ PS=3.28u PD=3.28u rfmode=0
M$1334 VSS VSS \$1101 VSS sg13_lv_nmos L=0.13u W=1u AS=0.265p AD=0.265p
+ PS=2.56u PD=2.56u rfmode=0
M$1335 \$1101 \$1018 OUTP VSS sg13_lv_nmos L=0.13u W=2u AS=0.38p AD=0.38p
+ PS=3.52u PD=3.52u rfmode=0
M$1337 \$1101 \$1020 OUTN VSS sg13_lv_nmos L=0.13u W=2u AS=0.38p AD=0.38p
+ PS=3.52u PD=3.52u rfmode=0
M$1344 \$1230 \$1199 VSS VSS sg13_lv_nmos L=0.13u W=1.44u AS=0.4068p AD=0.2772p
+ PS=3.29u PD=2.21u rfmode=0
M$1346 \$1230 \$5 \$1231 VSS sg13_lv_nmos L=0.13u W=1.44u AS=0.2772p AD=0.3816p
+ PS=2.21u PD=3.22u rfmode=0
M$1348 VSS VDD \$1312 VSS sg13_lv_nmos L=0.13u W=0.42u AS=0.1701p AD=0.03885p
+ PS=1.65u PD=0.605u rfmode=0
M$1349 \$1312 \$1200 \$1233 VSS sg13_lv_nmos L=0.13u W=0.42u AS=0.03885p
+ AD=0.1596p PS=0.605u PD=1.6u rfmode=0
M$1350 VSS \$1201 \$1374 VSS sg13_lv_nmos L=0.13u W=0.74u AS=0.43315p
+ AD=0.2516p PS=2.205u PD=2.16u rfmode=0
M$1351 VSS CLK \$1201 VSS sg13_lv_nmos L=0.13u W=0.74u AS=0.43315p AD=0.2516p
+ PS=2.205u PD=2.16u rfmode=0
M$1352 \$1235 \$1201 \$1234 VSS sg13_lv_nmos L=0.13u W=0.42u AS=0.12665p
+ AD=0.1428p PS=1.145u PD=1.52u rfmode=0
M$1353 \$1200 \$1374 \$1235 VSS sg13_lv_nmos L=0.13u W=0.74u AS=0.3473p
+ AD=0.12665p PS=2.71u PD=1.145u rfmode=0
M$1354 \$1240 \$1203 VSS VSS sg13_lv_nmos L=0.13u W=1.44u AS=0.4068p AD=0.2772p
+ PS=3.29u PD=2.21u rfmode=0
M$1356 \$1240 \$5 \$1241 VSS sg13_lv_nmos L=0.13u W=1.44u AS=0.2772p AD=0.3816p
+ PS=2.21u PD=3.22u rfmode=0
M$1358 VSS VDD \$1324 VSS sg13_lv_nmos L=0.13u W=0.42u AS=0.1701p AD=0.03885p
+ PS=1.65u PD=0.605u rfmode=0
M$1359 \$1324 \$1204 \$1243 VSS sg13_lv_nmos L=0.13u W=0.42u AS=0.03885p
+ AD=0.1596p PS=0.605u PD=1.6u rfmode=0
M$1360 VSS \$1205 \$1376 VSS sg13_lv_nmos L=0.13u W=0.74u AS=0.43315p
+ AD=0.2516p PS=2.205u PD=2.16u rfmode=0
M$1361 VSS CLK \$1205 VSS sg13_lv_nmos L=0.13u W=0.74u AS=0.43315p AD=0.2516p
+ PS=2.205u PD=2.16u rfmode=0
M$1362 \$1245 \$1205 \$1244 VSS sg13_lv_nmos L=0.13u W=0.42u AS=0.12665p
+ AD=0.1428p PS=1.145u PD=1.52u rfmode=0
M$1363 \$1204 \$1376 \$1245 VSS sg13_lv_nmos L=0.13u W=0.74u AS=0.3473p
+ AD=0.12665p PS=2.71u PD=1.145u rfmode=0
M$1364 \$1250 \$1207 VSS VSS sg13_lv_nmos L=0.13u W=1.44u AS=0.4068p AD=0.2772p
+ PS=3.29u PD=2.21u rfmode=0
M$1366 \$1250 \$5 \$1251 VSS sg13_lv_nmos L=0.13u W=1.44u AS=0.2772p AD=0.3816p
+ PS=2.21u PD=3.22u rfmode=0
M$1368 VSS VDD \$1335 VSS sg13_lv_nmos L=0.13u W=0.42u AS=0.1701p AD=0.03885p
+ PS=1.65u PD=0.605u rfmode=0
M$1369 \$1335 \$1208 \$1253 VSS sg13_lv_nmos L=0.13u W=0.42u AS=0.03885p
+ AD=0.1596p PS=0.605u PD=1.6u rfmode=0
M$1370 VSS \$1209 \$1378 VSS sg13_lv_nmos L=0.13u W=0.74u AS=0.43315p
+ AD=0.2516p PS=2.205u PD=2.16u rfmode=0
M$1371 VSS CLK \$1209 VSS sg13_lv_nmos L=0.13u W=0.74u AS=0.43315p AD=0.2516p
+ PS=2.205u PD=2.16u rfmode=0
M$1372 \$1255 \$1209 \$1254 VSS sg13_lv_nmos L=0.13u W=0.42u AS=0.12665p
+ AD=0.1428p PS=1.145u PD=1.52u rfmode=0
M$1373 \$1208 \$1378 \$1255 VSS sg13_lv_nmos L=0.13u W=0.74u AS=0.3473p
+ AD=0.12665p PS=2.71u PD=1.145u rfmode=0
M$1374 \$1260 \$1211 VSS VSS sg13_lv_nmos L=0.13u W=1.44u AS=0.4068p AD=0.2772p
+ PS=3.29u PD=2.21u rfmode=0
M$1376 \$1260 \$5 \$1261 VSS sg13_lv_nmos L=0.13u W=1.44u AS=0.2772p AD=0.3816p
+ PS=2.21u PD=3.22u rfmode=0
M$1378 VSS VDD \$1347 VSS sg13_lv_nmos L=0.13u W=0.42u AS=0.1701p AD=0.03885p
+ PS=1.65u PD=0.605u rfmode=0
M$1379 \$1347 \$1212 \$1263 VSS sg13_lv_nmos L=0.13u W=0.42u AS=0.03885p
+ AD=0.1596p PS=0.605u PD=1.6u rfmode=0
M$1380 VSS \$1213 \$1380 VSS sg13_lv_nmos L=0.13u W=0.74u AS=0.43315p
+ AD=0.2516p PS=2.205u PD=2.16u rfmode=0
M$1381 VSS CLK \$1213 VSS sg13_lv_nmos L=0.13u W=0.74u AS=0.43315p AD=0.2516p
+ PS=2.205u PD=2.16u rfmode=0
M$1382 \$1265 \$1213 \$1264 VSS sg13_lv_nmos L=0.13u W=0.42u AS=0.12665p
+ AD=0.1428p PS=1.145u PD=1.52u rfmode=0
M$1383 \$1212 \$1380 \$1265 VSS sg13_lv_nmos L=0.13u W=0.74u AS=0.3473p
+ AD=0.12665p PS=2.71u PD=1.145u rfmode=0
M$1384 \$1270 \$1215 VSS VSS sg13_lv_nmos L=0.13u W=1.44u AS=0.4068p AD=0.2772p
+ PS=3.29u PD=2.21u rfmode=0
M$1386 \$1270 \$5 \$1271 VSS sg13_lv_nmos L=0.13u W=1.44u AS=0.2772p AD=0.3816p
+ PS=2.21u PD=3.22u rfmode=0
M$1388 VSS VDD \$1356 VSS sg13_lv_nmos L=0.13u W=0.42u AS=0.1701p AD=0.03885p
+ PS=1.65u PD=0.605u rfmode=0
M$1389 \$1356 \$1216 \$1273 VSS sg13_lv_nmos L=0.13u W=0.42u AS=0.03885p
+ AD=0.1596p PS=0.605u PD=1.6u rfmode=0
M$1390 VSS \$1217 \$1382 VSS sg13_lv_nmos L=0.13u W=0.74u AS=0.43315p
+ AD=0.2516p PS=2.205u PD=2.16u rfmode=0
M$1391 VSS CLK \$1217 VSS sg13_lv_nmos L=0.13u W=0.74u AS=0.43315p AD=0.2516p
+ PS=2.205u PD=2.16u rfmode=0
M$1392 \$1275 \$1217 \$1274 VSS sg13_lv_nmos L=0.13u W=0.42u AS=0.12665p
+ AD=0.1428p PS=1.145u PD=1.52u rfmode=0
M$1393 \$1216 \$1382 \$1275 VSS sg13_lv_nmos L=0.13u W=0.74u AS=0.3473p
+ AD=0.12665p PS=2.71u PD=1.145u rfmode=0
M$1394 \$1280 \$1219 VSS VSS sg13_lv_nmos L=0.13u W=1.44u AS=0.4068p AD=0.2772p
+ PS=3.29u PD=2.21u rfmode=0
M$1396 \$1280 \$5 \$1281 VSS sg13_lv_nmos L=0.13u W=1.44u AS=0.2772p AD=0.3816p
+ PS=2.21u PD=3.22u rfmode=0
M$1398 VSS VDD \$1344 VSS sg13_lv_nmos L=0.13u W=0.42u AS=0.1701p AD=0.03885p
+ PS=1.65u PD=0.605u rfmode=0
M$1399 \$1344 \$1220 \$1283 VSS sg13_lv_nmos L=0.13u W=0.42u AS=0.03885p
+ AD=0.1596p PS=0.605u PD=1.6u rfmode=0
M$1400 VSS \$1221 \$1384 VSS sg13_lv_nmos L=0.13u W=0.74u AS=0.43315p
+ AD=0.2516p PS=2.205u PD=2.16u rfmode=0
M$1401 VSS CLK \$1221 VSS sg13_lv_nmos L=0.13u W=0.74u AS=0.43315p AD=0.2516p
+ PS=2.205u PD=2.16u rfmode=0
M$1402 \$1285 \$1221 \$1284 VSS sg13_lv_nmos L=0.13u W=0.42u AS=0.12665p
+ AD=0.1428p PS=1.145u PD=1.52u rfmode=0
M$1403 \$1220 \$1384 \$1285 VSS sg13_lv_nmos L=0.13u W=0.74u AS=0.3473p
+ AD=0.12665p PS=2.71u PD=1.145u rfmode=0
M$1404 \$1290 \$1223 VSS VSS sg13_lv_nmos L=0.13u W=1.44u AS=0.4068p AD=0.2772p
+ PS=3.29u PD=2.21u rfmode=0
M$1406 \$1290 \$5 \$1291 VSS sg13_lv_nmos L=0.13u W=1.44u AS=0.2772p AD=0.3816p
+ PS=2.21u PD=3.22u rfmode=0
M$1408 VSS VDD \$1331 VSS sg13_lv_nmos L=0.13u W=0.42u AS=0.1701p AD=0.03885p
+ PS=1.65u PD=0.605u rfmode=0
M$1409 \$1331 \$1224 \$1293 VSS sg13_lv_nmos L=0.13u W=0.42u AS=0.03885p
+ AD=0.1596p PS=0.605u PD=1.6u rfmode=0
M$1410 VSS \$1225 \$1386 VSS sg13_lv_nmos L=0.13u W=0.74u AS=0.43315p
+ AD=0.2516p PS=2.205u PD=2.16u rfmode=0
M$1411 VSS CLK \$1225 VSS sg13_lv_nmos L=0.13u W=0.74u AS=0.43315p AD=0.2516p
+ PS=2.205u PD=2.16u rfmode=0
M$1412 \$1295 \$1225 \$1294 VSS sg13_lv_nmos L=0.13u W=0.42u AS=0.12665p
+ AD=0.1428p PS=1.145u PD=1.52u rfmode=0
M$1413 \$1224 \$1386 \$1295 VSS sg13_lv_nmos L=0.13u W=0.74u AS=0.3473p
+ AD=0.12665p PS=2.71u PD=1.145u rfmode=0
M$1414 \$1300 \$1227 VSS VSS sg13_lv_nmos L=0.13u W=1.44u AS=0.4068p AD=0.2772p
+ PS=3.29u PD=2.21u rfmode=0
M$1416 \$1300 \$5 \$1301 VSS sg13_lv_nmos L=0.13u W=1.44u AS=0.2772p AD=0.3816p
+ PS=2.21u PD=3.22u rfmode=0
M$1418 VSS VDD \$1319 VSS sg13_lv_nmos L=0.13u W=0.42u AS=0.1701p AD=0.03885p
+ PS=1.65u PD=0.605u rfmode=0
M$1419 \$1319 \$1228 \$1303 VSS sg13_lv_nmos L=0.13u W=0.42u AS=0.03885p
+ AD=0.1596p PS=0.605u PD=1.6u rfmode=0
M$1420 VSS \$1229 \$1388 VSS sg13_lv_nmos L=0.13u W=0.74u AS=0.43315p
+ AD=0.2516p PS=2.205u PD=2.16u rfmode=0
M$1421 VSS CLK \$1229 VSS sg13_lv_nmos L=0.13u W=0.74u AS=0.43315p AD=0.2516p
+ PS=2.205u PD=2.16u rfmode=0
M$1422 \$1305 \$1229 \$1304 VSS sg13_lv_nmos L=0.13u W=0.42u AS=0.12665p
+ AD=0.1428p PS=1.145u PD=1.52u rfmode=0
M$1423 \$1228 \$1388 \$1305 VSS sg13_lv_nmos L=0.13u W=0.74u AS=0.3473p
+ AD=0.12665p PS=2.71u PD=1.145u rfmode=0
M$1424 VSS \$187 \$1486 VSS sg13_lv_nmos L=0.13u W=0.55u AS=0.187p AD=0.1045p
+ PS=1.78u PD=0.93u rfmode=0
M$1425 \$1486 \$326 VSS VSS sg13_lv_nmos L=0.13u W=0.55u AS=0.1045p
+ AD=0.146425p PS=0.93u PD=1.155u rfmode=0
M$1426 VSS \$1486 \$1487 VSS sg13_lv_nmos L=0.13u W=1.48u AS=0.312925p
+ AD=0.4477p PS=2.345u PD=3.43u rfmode=0
M$1428 \$1520 \$1519 \$1599 VSS sg13_lv_nmos L=0.13u W=0.42u AS=0.1428p
+ AD=0.0609p PS=1.52u PD=0.71u rfmode=0
M$1429 \$1599 VDD VSS VSS sg13_lv_nmos L=0.13u W=0.42u AS=0.0609p AD=0.1626p
+ PS=0.71u PD=1.415u rfmode=0
M$1430 VSS \$1646 \$1488 VSS sg13_lv_nmos L=0.13u W=0.74u AS=0.1626p AD=0.2516p
+ PS=1.415u PD=2.16u rfmode=0
M$1431 \$1232 \$1201 \$1358 VSS sg13_lv_nmos L=0.13u W=0.42u AS=0.1296p
+ AD=0.081p PS=1.52u PD=0.81u rfmode=0
M$1432 \$1358 \$1374 \$1233 VSS sg13_lv_nmos L=0.13u W=0.42u AS=0.081p
+ AD=0.2163p PS=0.81u PD=1.87u rfmode=0
M$1433 \$1522 \$1647 VSS VSS sg13_lv_nmos L=0.13u W=0.42u AS=0.1428p AD=0.0798p
+ PS=1.52u PD=0.8u rfmode=0
M$1434 VSS VDD \$1603 VSS sg13_lv_nmos L=0.13u W=0.42u AS=0.0798p AD=0.0378p
+ PS=0.8u PD=0.6u rfmode=0
M$1435 \$1603 \$1523 \$1647 VSS sg13_lv_nmos L=0.13u W=0.42u AS=0.0378p
+ AD=0.1428p PS=0.6u PD=1.52u rfmode=0
M$1436 VSS \$1523 \$1525 VSS sg13_lv_nmos L=0.13u W=0.64u AS=0.1331p AD=0.2176p
+ PS=1.12u PD=1.96u rfmode=0
M$1437 VSS \$1523 \$1524 VSS sg13_lv_nmos L=0.13u W=1.48u AS=0.3922p AD=0.2737p
+ PS=3.28u PD=2.24u rfmode=0
M$1439 VSS \$1525 \$1526 VSS sg13_lv_nmos L=0.13u W=1.48u AS=0.3922p AD=0.3922p
+ PS=3.28u PD=3.28u rfmode=0
M$1441 VSS VSS \$1375 VSS sg13_lv_nmos L=0.13u W=1u AS=0.265p AD=0.265p
+ PS=2.56u PD=2.56u rfmode=0
M$1442 \$1375 \$1236 OUTP VSS sg13_lv_nmos L=0.13u W=2u AS=0.38p AD=0.38p
+ PS=3.52u PD=3.52u rfmode=0
M$1444 \$1375 \$1238 OUTN VSS sg13_lv_nmos L=0.13u W=2u AS=0.38p AD=0.38p
+ PS=3.52u PD=3.52u rfmode=0
M$1451 VSS \$190 \$1490 VSS sg13_lv_nmos L=0.13u W=0.55u AS=0.187p AD=0.1045p
+ PS=1.78u PD=0.93u rfmode=0
M$1452 \$1490 \$326 VSS VSS sg13_lv_nmos L=0.13u W=0.55u AS=0.1045p
+ AD=0.146425p PS=0.93u PD=1.155u rfmode=0
M$1453 VSS \$1490 \$1491 VSS sg13_lv_nmos L=0.13u W=1.48u AS=0.312925p
+ AD=0.4477p PS=2.345u PD=3.43u rfmode=0
M$1455 \$1530 \$1529 \$1611 VSS sg13_lv_nmos L=0.13u W=0.42u AS=0.1428p
+ AD=0.0609p PS=1.52u PD=0.71u rfmode=0
M$1456 \$1611 VDD VSS VSS sg13_lv_nmos L=0.13u W=0.42u AS=0.0609p AD=0.1626p
+ PS=0.71u PD=1.415u rfmode=0
M$1457 VSS \$1648 \$1492 VSS sg13_lv_nmos L=0.13u W=0.74u AS=0.1626p AD=0.2516p
+ PS=1.415u PD=2.16u rfmode=0
M$1458 \$1242 \$1205 \$1360 VSS sg13_lv_nmos L=0.13u W=0.42u AS=0.1296p
+ AD=0.081p PS=1.52u PD=0.81u rfmode=0
M$1459 \$1360 \$1376 \$1243 VSS sg13_lv_nmos L=0.13u W=0.42u AS=0.081p
+ AD=0.2163p PS=0.81u PD=1.87u rfmode=0
M$1460 \$1532 \$1649 VSS VSS sg13_lv_nmos L=0.13u W=0.42u AS=0.1428p AD=0.0798p
+ PS=1.52u PD=0.8u rfmode=0
M$1461 VSS VDD \$1615 VSS sg13_lv_nmos L=0.13u W=0.42u AS=0.0798p AD=0.0378p
+ PS=0.8u PD=0.6u rfmode=0
M$1462 \$1615 \$1533 \$1649 VSS sg13_lv_nmos L=0.13u W=0.42u AS=0.0378p
+ AD=0.1428p PS=0.6u PD=1.52u rfmode=0
M$1463 VSS \$1533 \$1535 VSS sg13_lv_nmos L=0.13u W=0.64u AS=0.1331p AD=0.2176p
+ PS=1.12u PD=1.96u rfmode=0
M$1464 VSS \$1533 \$1534 VSS sg13_lv_nmos L=0.13u W=1.48u AS=0.3922p AD=0.2737p
+ PS=3.28u PD=2.24u rfmode=0
M$1466 VSS \$1535 \$1536 VSS sg13_lv_nmos L=0.13u W=1.48u AS=0.3922p AD=0.3922p
+ PS=3.28u PD=3.28u rfmode=0
M$1468 VSS VSS \$1377 VSS sg13_lv_nmos L=0.13u W=1u AS=0.265p AD=0.265p
+ PS=2.56u PD=2.56u rfmode=0
M$1469 \$1377 \$1246 OUTP VSS sg13_lv_nmos L=0.13u W=2u AS=0.38p AD=0.38p
+ PS=3.52u PD=3.52u rfmode=0
M$1471 \$1377 \$1248 OUTN VSS sg13_lv_nmos L=0.13u W=2u AS=0.38p AD=0.38p
+ PS=3.52u PD=3.52u rfmode=0
M$1478 VSS \$193 \$1494 VSS sg13_lv_nmos L=0.13u W=0.55u AS=0.187p AD=0.1045p
+ PS=1.78u PD=0.93u rfmode=0
M$1479 \$1494 \$326 VSS VSS sg13_lv_nmos L=0.13u W=0.55u AS=0.1045p
+ AD=0.146425p PS=0.93u PD=1.155u rfmode=0
M$1480 VSS \$1494 \$1495 VSS sg13_lv_nmos L=0.13u W=1.48u AS=0.312925p
+ AD=0.4477p PS=2.345u PD=3.43u rfmode=0
M$1482 \$1540 \$1539 \$1622 VSS sg13_lv_nmos L=0.13u W=0.42u AS=0.1428p
+ AD=0.0609p PS=1.52u PD=0.71u rfmode=0
M$1483 \$1622 VDD VSS VSS sg13_lv_nmos L=0.13u W=0.42u AS=0.0609p AD=0.1626p
+ PS=0.71u PD=1.415u rfmode=0
M$1484 VSS \$1650 \$1496 VSS sg13_lv_nmos L=0.13u W=0.74u AS=0.1626p AD=0.2516p
+ PS=1.415u PD=2.16u rfmode=0
M$1485 \$1252 \$1209 \$1362 VSS sg13_lv_nmos L=0.13u W=0.42u AS=0.1296p
+ AD=0.081p PS=1.52u PD=0.81u rfmode=0
M$1486 \$1362 \$1378 \$1253 VSS sg13_lv_nmos L=0.13u W=0.42u AS=0.081p
+ AD=0.2163p PS=0.81u PD=1.87u rfmode=0
M$1487 \$1542 \$1651 VSS VSS sg13_lv_nmos L=0.13u W=0.42u AS=0.1428p AD=0.0798p
+ PS=1.52u PD=0.8u rfmode=0
M$1488 VSS VDD \$1627 VSS sg13_lv_nmos L=0.13u W=0.42u AS=0.0798p AD=0.0378p
+ PS=0.8u PD=0.6u rfmode=0
M$1489 \$1627 \$1543 \$1651 VSS sg13_lv_nmos L=0.13u W=0.42u AS=0.0378p
+ AD=0.1428p PS=0.6u PD=1.52u rfmode=0
M$1490 VSS \$1543 \$1545 VSS sg13_lv_nmos L=0.13u W=0.64u AS=0.1331p AD=0.2176p
+ PS=1.12u PD=1.96u rfmode=0
M$1491 VSS \$1543 \$1544 VSS sg13_lv_nmos L=0.13u W=1.48u AS=0.3922p AD=0.2737p
+ PS=3.28u PD=2.24u rfmode=0
M$1493 VSS \$1545 \$1546 VSS sg13_lv_nmos L=0.13u W=1.48u AS=0.3922p AD=0.3922p
+ PS=3.28u PD=3.28u rfmode=0
M$1495 VSS VSS \$1379 VSS sg13_lv_nmos L=0.13u W=1u AS=0.265p AD=0.265p
+ PS=2.56u PD=2.56u rfmode=0
M$1496 \$1379 \$1256 OUTP VSS sg13_lv_nmos L=0.13u W=2u AS=0.38p AD=0.38p
+ PS=3.52u PD=3.52u rfmode=0
M$1498 \$1379 \$1258 OUTN VSS sg13_lv_nmos L=0.13u W=2u AS=0.38p AD=0.38p
+ PS=3.52u PD=3.52u rfmode=0
M$1505 VSS \$196 \$1498 VSS sg13_lv_nmos L=0.13u W=0.55u AS=0.187p AD=0.1045p
+ PS=1.78u PD=0.93u rfmode=0
M$1506 \$1498 \$326 VSS VSS sg13_lv_nmos L=0.13u W=0.55u AS=0.1045p
+ AD=0.146425p PS=0.93u PD=1.155u rfmode=0
M$1507 VSS \$1498 \$1499 VSS sg13_lv_nmos L=0.13u W=1.48u AS=0.312925p
+ AD=0.4477p PS=2.345u PD=3.43u rfmode=0
M$1509 \$1550 \$1549 \$1634 VSS sg13_lv_nmos L=0.13u W=0.42u AS=0.1428p
+ AD=0.0609p PS=1.52u PD=0.71u rfmode=0
M$1510 \$1634 VDD VSS VSS sg13_lv_nmos L=0.13u W=0.42u AS=0.0609p AD=0.1626p
+ PS=0.71u PD=1.415u rfmode=0
M$1511 VSS \$1652 \$1500 VSS sg13_lv_nmos L=0.13u W=0.74u AS=0.1626p AD=0.2516p
+ PS=1.415u PD=2.16u rfmode=0
M$1512 \$1262 \$1213 \$1364 VSS sg13_lv_nmos L=0.13u W=0.42u AS=0.1296p
+ AD=0.081p PS=1.52u PD=0.81u rfmode=0
M$1513 \$1364 \$1380 \$1263 VSS sg13_lv_nmos L=0.13u W=0.42u AS=0.081p
+ AD=0.2163p PS=0.81u PD=1.87u rfmode=0
M$1514 \$1552 \$1653 VSS VSS sg13_lv_nmos L=0.13u W=0.42u AS=0.1428p AD=0.0798p
+ PS=1.52u PD=0.8u rfmode=0
M$1515 VSS VDD \$1637 VSS sg13_lv_nmos L=0.13u W=0.42u AS=0.0798p AD=0.0378p
+ PS=0.8u PD=0.6u rfmode=0
M$1516 \$1637 \$1553 \$1653 VSS sg13_lv_nmos L=0.13u W=0.42u AS=0.0378p
+ AD=0.1428p PS=0.6u PD=1.52u rfmode=0
M$1517 VSS \$1553 \$1555 VSS sg13_lv_nmos L=0.13u W=0.64u AS=0.1331p AD=0.2176p
+ PS=1.12u PD=1.96u rfmode=0
M$1518 VSS \$1553 \$1554 VSS sg13_lv_nmos L=0.13u W=1.48u AS=0.3922p AD=0.2737p
+ PS=3.28u PD=2.24u rfmode=0
M$1520 VSS \$1555 \$1556 VSS sg13_lv_nmos L=0.13u W=1.48u AS=0.3922p AD=0.3922p
+ PS=3.28u PD=3.28u rfmode=0
M$1522 VSS VSS \$1381 VSS sg13_lv_nmos L=0.13u W=1u AS=0.265p AD=0.265p
+ PS=2.56u PD=2.56u rfmode=0
M$1523 \$1381 \$1266 OUTP VSS sg13_lv_nmos L=0.13u W=2u AS=0.38p AD=0.38p
+ PS=3.52u PD=3.52u rfmode=0
M$1525 \$1381 \$1268 OUTN VSS sg13_lv_nmos L=0.13u W=2u AS=0.38p AD=0.38p
+ PS=3.52u PD=3.52u rfmode=0
M$1532 VSS \$199 \$1502 VSS sg13_lv_nmos L=0.13u W=0.55u AS=0.187p AD=0.1045p
+ PS=1.78u PD=0.93u rfmode=0
M$1533 \$1502 \$326 VSS VSS sg13_lv_nmos L=0.13u W=0.55u AS=0.1045p
+ AD=0.146425p PS=0.93u PD=1.155u rfmode=0
M$1534 VSS \$1502 \$1503 VSS sg13_lv_nmos L=0.13u W=1.48u AS=0.312925p
+ AD=0.4477p PS=2.345u PD=3.43u rfmode=0
M$1536 \$1560 \$1559 \$1645 VSS sg13_lv_nmos L=0.13u W=0.42u AS=0.1428p
+ AD=0.0609p PS=1.52u PD=0.71u rfmode=0
M$1537 \$1645 VDD VSS VSS sg13_lv_nmos L=0.13u W=0.42u AS=0.0609p AD=0.1626p
+ PS=0.71u PD=1.415u rfmode=0
M$1538 VSS \$1654 \$1504 VSS sg13_lv_nmos L=0.13u W=0.74u AS=0.1626p AD=0.2516p
+ PS=1.415u PD=2.16u rfmode=0
M$1539 \$1272 \$1217 \$1366 VSS sg13_lv_nmos L=0.13u W=0.42u AS=0.1296p
+ AD=0.081p PS=1.52u PD=0.81u rfmode=0
M$1540 \$1366 \$1382 \$1273 VSS sg13_lv_nmos L=0.13u W=0.42u AS=0.081p
+ AD=0.2163p PS=0.81u PD=1.87u rfmode=0
M$1541 \$1562 \$1655 VSS VSS sg13_lv_nmos L=0.13u W=0.42u AS=0.1428p AD=0.0798p
+ PS=1.52u PD=0.8u rfmode=0
M$1542 VSS VDD \$1642 VSS sg13_lv_nmos L=0.13u W=0.42u AS=0.0798p AD=0.0378p
+ PS=0.8u PD=0.6u rfmode=0
M$1543 \$1642 \$1563 \$1655 VSS sg13_lv_nmos L=0.13u W=0.42u AS=0.0378p
+ AD=0.1428p PS=0.6u PD=1.52u rfmode=0
M$1544 VSS \$1563 \$1565 VSS sg13_lv_nmos L=0.13u W=0.64u AS=0.1331p AD=0.2176p
+ PS=1.12u PD=1.96u rfmode=0
M$1545 VSS \$1563 \$1564 VSS sg13_lv_nmos L=0.13u W=1.48u AS=0.3922p AD=0.2737p
+ PS=3.28u PD=2.24u rfmode=0
M$1547 VSS \$1565 \$1566 VSS sg13_lv_nmos L=0.13u W=1.48u AS=0.3922p AD=0.3922p
+ PS=3.28u PD=3.28u rfmode=0
M$1549 VSS VSS \$1383 VSS sg13_lv_nmos L=0.13u W=1u AS=0.265p AD=0.265p
+ PS=2.56u PD=2.56u rfmode=0
M$1550 \$1383 \$1276 OUTP VSS sg13_lv_nmos L=0.13u W=2u AS=0.38p AD=0.38p
+ PS=3.52u PD=3.52u rfmode=0
M$1552 \$1383 \$1278 OUTN VSS sg13_lv_nmos L=0.13u W=2u AS=0.38p AD=0.38p
+ PS=3.52u PD=3.52u rfmode=0
M$1559 VSS \$202 \$1506 VSS sg13_lv_nmos L=0.13u W=0.55u AS=0.187p AD=0.1045p
+ PS=1.78u PD=0.93u rfmode=0
M$1560 \$1506 \$326 VSS VSS sg13_lv_nmos L=0.13u W=0.55u AS=0.1045p
+ AD=0.146425p PS=0.93u PD=1.155u rfmode=0
M$1561 VSS \$1506 \$1507 VSS sg13_lv_nmos L=0.13u W=1.48u AS=0.312925p
+ AD=0.4477p PS=2.345u PD=3.43u rfmode=0
M$1563 \$1570 \$1569 \$1633 VSS sg13_lv_nmos L=0.13u W=0.42u AS=0.1428p
+ AD=0.0609p PS=1.52u PD=0.71u rfmode=0
M$1564 \$1633 VDD VSS VSS sg13_lv_nmos L=0.13u W=0.42u AS=0.0609p AD=0.1626p
+ PS=0.71u PD=1.415u rfmode=0
M$1565 VSS \$1656 \$1508 VSS sg13_lv_nmos L=0.13u W=0.74u AS=0.1626p AD=0.2516p
+ PS=1.415u PD=2.16u rfmode=0
M$1566 \$1282 \$1221 \$1368 VSS sg13_lv_nmos L=0.13u W=0.42u AS=0.1296p
+ AD=0.081p PS=1.52u PD=0.81u rfmode=0
M$1567 \$1368 \$1384 \$1283 VSS sg13_lv_nmos L=0.13u W=0.42u AS=0.081p
+ AD=0.2163p PS=0.81u PD=1.87u rfmode=0
M$1568 \$1572 \$1657 VSS VSS sg13_lv_nmos L=0.13u W=0.42u AS=0.1428p AD=0.0798p
+ PS=1.52u PD=0.8u rfmode=0
M$1569 VSS VDD \$1630 VSS sg13_lv_nmos L=0.13u W=0.42u AS=0.0798p AD=0.0378p
+ PS=0.8u PD=0.6u rfmode=0
M$1570 \$1630 \$1573 \$1657 VSS sg13_lv_nmos L=0.13u W=0.42u AS=0.0378p
+ AD=0.1428p PS=0.6u PD=1.52u rfmode=0
M$1571 VSS \$1573 \$1575 VSS sg13_lv_nmos L=0.13u W=0.64u AS=0.1331p AD=0.2176p
+ PS=1.12u PD=1.96u rfmode=0
M$1572 VSS \$1573 \$1574 VSS sg13_lv_nmos L=0.13u W=1.48u AS=0.3922p AD=0.2737p
+ PS=3.28u PD=2.24u rfmode=0
M$1574 VSS \$1575 \$1576 VSS sg13_lv_nmos L=0.13u W=1.48u AS=0.3922p AD=0.3922p
+ PS=3.28u PD=3.28u rfmode=0
M$1576 VSS VSS \$1385 VSS sg13_lv_nmos L=0.13u W=1u AS=0.265p AD=0.265p
+ PS=2.56u PD=2.56u rfmode=0
M$1577 \$1385 \$1286 OUTP VSS sg13_lv_nmos L=0.13u W=2u AS=0.38p AD=0.38p
+ PS=3.52u PD=3.52u rfmode=0
M$1579 \$1385 \$1288 OUTN VSS sg13_lv_nmos L=0.13u W=2u AS=0.38p AD=0.38p
+ PS=3.52u PD=3.52u rfmode=0
M$1586 VSS \$205 \$1510 VSS sg13_lv_nmos L=0.13u W=0.55u AS=0.187p AD=0.1045p
+ PS=1.78u PD=0.93u rfmode=0
M$1587 \$1510 \$326 VSS VSS sg13_lv_nmos L=0.13u W=0.55u AS=0.1045p
+ AD=0.146425p PS=0.93u PD=1.155u rfmode=0
M$1588 VSS \$1510 \$1511 VSS sg13_lv_nmos L=0.13u W=1.48u AS=0.312925p
+ AD=0.4477p PS=2.345u PD=3.43u rfmode=0
M$1590 \$1580 \$1579 \$1620 VSS sg13_lv_nmos L=0.13u W=0.42u AS=0.1428p
+ AD=0.0609p PS=1.52u PD=0.71u rfmode=0
M$1591 \$1620 VDD VSS VSS sg13_lv_nmos L=0.13u W=0.42u AS=0.0609p AD=0.1626p
+ PS=0.71u PD=1.415u rfmode=0
M$1592 VSS \$1658 \$1512 VSS sg13_lv_nmos L=0.13u W=0.74u AS=0.1626p AD=0.2516p
+ PS=1.415u PD=2.16u rfmode=0
M$1593 \$1292 \$1225 \$1370 VSS sg13_lv_nmos L=0.13u W=0.42u AS=0.1296p
+ AD=0.081p PS=1.52u PD=0.81u rfmode=0
M$1594 \$1370 \$1386 \$1293 VSS sg13_lv_nmos L=0.13u W=0.42u AS=0.081p
+ AD=0.2163p PS=0.81u PD=1.87u rfmode=0
M$1595 \$1582 \$1659 VSS VSS sg13_lv_nmos L=0.13u W=0.42u AS=0.1428p AD=0.0798p
+ PS=1.52u PD=0.8u rfmode=0
M$1596 VSS VDD \$1616 VSS sg13_lv_nmos L=0.13u W=0.42u AS=0.0798p AD=0.0378p
+ PS=0.8u PD=0.6u rfmode=0
M$1597 \$1616 \$1583 \$1659 VSS sg13_lv_nmos L=0.13u W=0.42u AS=0.0378p
+ AD=0.1428p PS=0.6u PD=1.52u rfmode=0
M$1598 VSS \$1583 \$1585 VSS sg13_lv_nmos L=0.13u W=0.64u AS=0.1331p AD=0.2176p
+ PS=1.12u PD=1.96u rfmode=0
M$1599 VSS \$1583 \$1584 VSS sg13_lv_nmos L=0.13u W=1.48u AS=0.3922p AD=0.2737p
+ PS=3.28u PD=2.24u rfmode=0
M$1601 VSS \$1585 \$1586 VSS sg13_lv_nmos L=0.13u W=1.48u AS=0.3922p AD=0.3922p
+ PS=3.28u PD=3.28u rfmode=0
M$1603 VSS VSS \$1387 VSS sg13_lv_nmos L=0.13u W=1u AS=0.265p AD=0.265p
+ PS=2.56u PD=2.56u rfmode=0
M$1604 \$1387 \$1296 OUTP VSS sg13_lv_nmos L=0.13u W=2u AS=0.38p AD=0.38p
+ PS=3.52u PD=3.52u rfmode=0
M$1606 \$1387 \$1298 OUTN VSS sg13_lv_nmos L=0.13u W=2u AS=0.38p AD=0.38p
+ PS=3.52u PD=3.52u rfmode=0
M$1613 VSS VSS \$1514 VSS sg13_lv_nmos L=0.13u W=0.55u AS=0.187p AD=0.1045p
+ PS=1.78u PD=0.93u rfmode=0
M$1614 \$1514 \$326 VSS VSS sg13_lv_nmos L=0.13u W=0.55u AS=0.1045p
+ AD=0.146425p PS=0.93u PD=1.155u rfmode=0
M$1615 VSS \$1514 \$1515 VSS sg13_lv_nmos L=0.13u W=1.48u AS=0.312925p
+ AD=0.4477p PS=2.345u PD=3.43u rfmode=0
M$1617 \$1590 \$1589 \$1608 VSS sg13_lv_nmos L=0.13u W=0.42u AS=0.1428p
+ AD=0.0609p PS=1.52u PD=0.71u rfmode=0
M$1618 \$1608 VDD VSS VSS sg13_lv_nmos L=0.13u W=0.42u AS=0.0609p AD=0.1626p
+ PS=0.71u PD=1.415u rfmode=0
M$1619 VSS \$1660 \$1516 VSS sg13_lv_nmos L=0.13u W=0.74u AS=0.1626p AD=0.2516p
+ PS=1.415u PD=2.16u rfmode=0
M$1620 \$1302 \$1229 \$1372 VSS sg13_lv_nmos L=0.13u W=0.42u AS=0.1296p
+ AD=0.081p PS=1.52u PD=0.81u rfmode=0
M$1621 \$1372 \$1388 \$1303 VSS sg13_lv_nmos L=0.13u W=0.42u AS=0.081p
+ AD=0.2163p PS=0.81u PD=1.87u rfmode=0
M$1622 \$1592 \$1661 VSS VSS sg13_lv_nmos L=0.13u W=0.42u AS=0.1428p AD=0.0798p
+ PS=1.52u PD=0.8u rfmode=0
M$1623 VSS VDD \$1604 VSS sg13_lv_nmos L=0.13u W=0.42u AS=0.0798p AD=0.0378p
+ PS=0.8u PD=0.6u rfmode=0
M$1624 \$1604 \$1593 \$1661 VSS sg13_lv_nmos L=0.13u W=0.42u AS=0.0378p
+ AD=0.1428p PS=0.6u PD=1.52u rfmode=0
M$1625 VSS \$1593 \$1595 VSS sg13_lv_nmos L=0.13u W=0.64u AS=0.1331p AD=0.2176p
+ PS=1.12u PD=1.96u rfmode=0
M$1626 VSS \$1593 \$1594 VSS sg13_lv_nmos L=0.13u W=1.48u AS=0.3922p AD=0.2737p
+ PS=3.28u PD=2.24u rfmode=0
M$1628 VSS \$1595 \$1596 VSS sg13_lv_nmos L=0.13u W=1.48u AS=0.3922p AD=0.3922p
+ PS=3.28u PD=3.28u rfmode=0
M$1630 VSS VSS \$1389 VSS sg13_lv_nmos L=0.13u W=1u AS=0.265p AD=0.265p
+ PS=2.56u PD=2.56u rfmode=0
M$1631 \$1389 \$1306 OUTP VSS sg13_lv_nmos L=0.13u W=2u AS=0.38p AD=0.38p
+ PS=3.52u PD=3.52u rfmode=0
M$1633 \$1389 \$1308 OUTN VSS sg13_lv_nmos L=0.13u W=2u AS=0.38p AD=0.38p
+ PS=3.52u PD=3.52u rfmode=0
M$1640 \$1518 \$1487 VSS VSS sg13_lv_nmos L=0.13u W=1.44u AS=0.4068p AD=0.2772p
+ PS=3.29u PD=2.21u rfmode=0
M$1642 \$1518 \$266 \$1519 VSS sg13_lv_nmos L=0.13u W=1.44u AS=0.2772p
+ AD=0.3816p PS=2.21u PD=3.22u rfmode=0
M$1644 VSS VDD \$1600 VSS sg13_lv_nmos L=0.13u W=0.42u AS=0.1701p AD=0.03885p
+ PS=1.65u PD=0.605u rfmode=0
M$1645 \$1600 \$1488 \$1521 VSS sg13_lv_nmos L=0.13u W=0.42u AS=0.03885p
+ AD=0.1596p PS=0.605u PD=1.6u rfmode=0
M$1646 VSS \$1489 \$1662 VSS sg13_lv_nmos L=0.13u W=0.74u AS=0.43315p
+ AD=0.2516p PS=2.205u PD=2.16u rfmode=0
M$1647 VSS CLK \$1489 VSS sg13_lv_nmos L=0.13u W=0.74u AS=0.43315p AD=0.2516p
+ PS=2.205u PD=2.16u rfmode=0
M$1648 \$1523 \$1489 \$1522 VSS sg13_lv_nmos L=0.13u W=0.42u AS=0.12665p
+ AD=0.1428p PS=1.145u PD=1.52u rfmode=0
M$1649 \$1488 \$1662 \$1523 VSS sg13_lv_nmos L=0.13u W=0.74u AS=0.3473p
+ AD=0.12665p PS=2.71u PD=1.145u rfmode=0
M$1650 \$1528 \$1491 VSS VSS sg13_lv_nmos L=0.13u W=1.44u AS=0.4068p AD=0.2772p
+ PS=3.29u PD=2.21u rfmode=0
M$1652 \$1528 \$266 \$1529 VSS sg13_lv_nmos L=0.13u W=1.44u AS=0.2772p
+ AD=0.3816p PS=2.21u PD=3.22u rfmode=0
M$1654 VSS VDD \$1612 VSS sg13_lv_nmos L=0.13u W=0.42u AS=0.1701p AD=0.03885p
+ PS=1.65u PD=0.605u rfmode=0
M$1655 \$1612 \$1492 \$1531 VSS sg13_lv_nmos L=0.13u W=0.42u AS=0.03885p
+ AD=0.1596p PS=0.605u PD=1.6u rfmode=0
M$1656 VSS \$1493 \$1664 VSS sg13_lv_nmos L=0.13u W=0.74u AS=0.43315p
+ AD=0.2516p PS=2.205u PD=2.16u rfmode=0
M$1657 VSS CLK \$1493 VSS sg13_lv_nmos L=0.13u W=0.74u AS=0.43315p AD=0.2516p
+ PS=2.205u PD=2.16u rfmode=0
M$1658 \$1533 \$1493 \$1532 VSS sg13_lv_nmos L=0.13u W=0.42u AS=0.12665p
+ AD=0.1428p PS=1.145u PD=1.52u rfmode=0
M$1659 \$1492 \$1664 \$1533 VSS sg13_lv_nmos L=0.13u W=0.74u AS=0.3473p
+ AD=0.12665p PS=2.71u PD=1.145u rfmode=0
M$1660 \$1538 \$1495 VSS VSS sg13_lv_nmos L=0.13u W=1.44u AS=0.4068p AD=0.2772p
+ PS=3.29u PD=2.21u rfmode=0
M$1662 \$1538 \$266 \$1539 VSS sg13_lv_nmos L=0.13u W=1.44u AS=0.2772p
+ AD=0.3816p PS=2.21u PD=3.22u rfmode=0
M$1664 VSS VDD \$1623 VSS sg13_lv_nmos L=0.13u W=0.42u AS=0.1701p AD=0.03885p
+ PS=1.65u PD=0.605u rfmode=0
M$1665 \$1623 \$1496 \$1541 VSS sg13_lv_nmos L=0.13u W=0.42u AS=0.03885p
+ AD=0.1596p PS=0.605u PD=1.6u rfmode=0
M$1666 VSS \$1497 \$1666 VSS sg13_lv_nmos L=0.13u W=0.74u AS=0.43315p
+ AD=0.2516p PS=2.205u PD=2.16u rfmode=0
M$1667 VSS CLK \$1497 VSS sg13_lv_nmos L=0.13u W=0.74u AS=0.43315p AD=0.2516p
+ PS=2.205u PD=2.16u rfmode=0
M$1668 \$1543 \$1497 \$1542 VSS sg13_lv_nmos L=0.13u W=0.42u AS=0.12665p
+ AD=0.1428p PS=1.145u PD=1.52u rfmode=0
M$1669 \$1496 \$1666 \$1543 VSS sg13_lv_nmos L=0.13u W=0.74u AS=0.3473p
+ AD=0.12665p PS=2.71u PD=1.145u rfmode=0
M$1670 \$1548 \$1499 VSS VSS sg13_lv_nmos L=0.13u W=1.44u AS=0.4068p AD=0.2772p
+ PS=3.29u PD=2.21u rfmode=0
M$1672 \$1548 \$266 \$1549 VSS sg13_lv_nmos L=0.13u W=1.44u AS=0.2772p
+ AD=0.3816p PS=2.21u PD=3.22u rfmode=0
M$1674 VSS VDD \$1635 VSS sg13_lv_nmos L=0.13u W=0.42u AS=0.1701p AD=0.03885p
+ PS=1.65u PD=0.605u rfmode=0
M$1675 \$1635 \$1500 \$1551 VSS sg13_lv_nmos L=0.13u W=0.42u AS=0.03885p
+ AD=0.1596p PS=0.605u PD=1.6u rfmode=0
M$1676 VSS \$1501 \$1668 VSS sg13_lv_nmos L=0.13u W=0.74u AS=0.43315p
+ AD=0.2516p PS=2.205u PD=2.16u rfmode=0
M$1677 VSS CLK \$1501 VSS sg13_lv_nmos L=0.13u W=0.74u AS=0.43315p AD=0.2516p
+ PS=2.205u PD=2.16u rfmode=0
M$1678 \$1553 \$1501 \$1552 VSS sg13_lv_nmos L=0.13u W=0.42u AS=0.12665p
+ AD=0.1428p PS=1.145u PD=1.52u rfmode=0
M$1679 \$1500 \$1668 \$1553 VSS sg13_lv_nmos L=0.13u W=0.74u AS=0.3473p
+ AD=0.12665p PS=2.71u PD=1.145u rfmode=0
M$1680 \$1558 \$1503 VSS VSS sg13_lv_nmos L=0.13u W=1.44u AS=0.4068p AD=0.2772p
+ PS=3.29u PD=2.21u rfmode=0
M$1682 \$1558 \$266 \$1559 VSS sg13_lv_nmos L=0.13u W=1.44u AS=0.2772p
+ AD=0.3816p PS=2.21u PD=3.22u rfmode=0
M$1684 VSS VDD \$1644 VSS sg13_lv_nmos L=0.13u W=0.42u AS=0.1701p AD=0.03885p
+ PS=1.65u PD=0.605u rfmode=0
M$1685 \$1644 \$1504 \$1561 VSS sg13_lv_nmos L=0.13u W=0.42u AS=0.03885p
+ AD=0.1596p PS=0.605u PD=1.6u rfmode=0
M$1686 VSS \$1505 \$1670 VSS sg13_lv_nmos L=0.13u W=0.74u AS=0.43315p
+ AD=0.2516p PS=2.205u PD=2.16u rfmode=0
M$1687 VSS CLK \$1505 VSS sg13_lv_nmos L=0.13u W=0.74u AS=0.43315p AD=0.2516p
+ PS=2.205u PD=2.16u rfmode=0
M$1688 \$1563 \$1505 \$1562 VSS sg13_lv_nmos L=0.13u W=0.42u AS=0.12665p
+ AD=0.1428p PS=1.145u PD=1.52u rfmode=0
M$1689 \$1504 \$1670 \$1563 VSS sg13_lv_nmos L=0.13u W=0.74u AS=0.3473p
+ AD=0.12665p PS=2.71u PD=1.145u rfmode=0
M$1690 \$1568 \$1507 VSS VSS sg13_lv_nmos L=0.13u W=1.44u AS=0.4068p AD=0.2772p
+ PS=3.29u PD=2.21u rfmode=0
M$1692 \$1568 \$266 \$1569 VSS sg13_lv_nmos L=0.13u W=1.44u AS=0.2772p
+ AD=0.3816p PS=2.21u PD=3.22u rfmode=0
M$1694 VSS VDD \$1632 VSS sg13_lv_nmos L=0.13u W=0.42u AS=0.1701p AD=0.03885p
+ PS=1.65u PD=0.605u rfmode=0
M$1695 \$1632 \$1508 \$1571 VSS sg13_lv_nmos L=0.13u W=0.42u AS=0.03885p
+ AD=0.1596p PS=0.605u PD=1.6u rfmode=0
M$1696 VSS \$1509 \$1672 VSS sg13_lv_nmos L=0.13u W=0.74u AS=0.43315p
+ AD=0.2516p PS=2.205u PD=2.16u rfmode=0
M$1697 VSS CLK \$1509 VSS sg13_lv_nmos L=0.13u W=0.74u AS=0.43315p AD=0.2516p
+ PS=2.205u PD=2.16u rfmode=0
M$1698 \$1573 \$1509 \$1572 VSS sg13_lv_nmos L=0.13u W=0.42u AS=0.12665p
+ AD=0.1428p PS=1.145u PD=1.52u rfmode=0
M$1699 \$1508 \$1672 \$1573 VSS sg13_lv_nmos L=0.13u W=0.74u AS=0.3473p
+ AD=0.12665p PS=2.71u PD=1.145u rfmode=0
M$1700 \$1578 \$1511 VSS VSS sg13_lv_nmos L=0.13u W=1.44u AS=0.4068p AD=0.2772p
+ PS=3.29u PD=2.21u rfmode=0
M$1702 \$1578 \$266 \$1579 VSS sg13_lv_nmos L=0.13u W=1.44u AS=0.2772p
+ AD=0.3816p PS=2.21u PD=3.22u rfmode=0
M$1704 VSS VDD \$1619 VSS sg13_lv_nmos L=0.13u W=0.42u AS=0.1701p AD=0.03885p
+ PS=1.65u PD=0.605u rfmode=0
M$1705 \$1619 \$1512 \$1581 VSS sg13_lv_nmos L=0.13u W=0.42u AS=0.03885p
+ AD=0.1596p PS=0.605u PD=1.6u rfmode=0
M$1706 VSS \$1513 \$1674 VSS sg13_lv_nmos L=0.13u W=0.74u AS=0.43315p
+ AD=0.2516p PS=2.205u PD=2.16u rfmode=0
M$1707 VSS CLK \$1513 VSS sg13_lv_nmos L=0.13u W=0.74u AS=0.43315p AD=0.2516p
+ PS=2.205u PD=2.16u rfmode=0
M$1708 \$1583 \$1513 \$1582 VSS sg13_lv_nmos L=0.13u W=0.42u AS=0.12665p
+ AD=0.1428p PS=1.145u PD=1.52u rfmode=0
M$1709 \$1512 \$1674 \$1583 VSS sg13_lv_nmos L=0.13u W=0.74u AS=0.3473p
+ AD=0.12665p PS=2.71u PD=1.145u rfmode=0
M$1710 \$1588 \$1515 VSS VSS sg13_lv_nmos L=0.13u W=1.44u AS=0.4068p AD=0.2772p
+ PS=3.29u PD=2.21u rfmode=0
M$1712 \$1588 \$266 \$1589 VSS sg13_lv_nmos L=0.13u W=1.44u AS=0.2772p
+ AD=0.3816p PS=2.21u PD=3.22u rfmode=0
M$1714 VSS VDD \$1607 VSS sg13_lv_nmos L=0.13u W=0.42u AS=0.1701p AD=0.03885p
+ PS=1.65u PD=0.605u rfmode=0
M$1715 \$1607 \$1516 \$1591 VSS sg13_lv_nmos L=0.13u W=0.42u AS=0.03885p
+ AD=0.1596p PS=0.605u PD=1.6u rfmode=0
M$1716 VSS \$1517 \$1676 VSS sg13_lv_nmos L=0.13u W=0.74u AS=0.43315p
+ AD=0.2516p PS=2.205u PD=2.16u rfmode=0
M$1717 VSS CLK \$1517 VSS sg13_lv_nmos L=0.13u W=0.74u AS=0.43315p AD=0.2516p
+ PS=2.205u PD=2.16u rfmode=0
M$1718 \$1593 \$1517 \$1592 VSS sg13_lv_nmos L=0.13u W=0.42u AS=0.12665p
+ AD=0.1428p PS=1.145u PD=1.52u rfmode=0
M$1719 \$1516 \$1676 \$1593 VSS sg13_lv_nmos L=0.13u W=0.74u AS=0.3473p
+ AD=0.12665p PS=2.71u PD=1.145u rfmode=0
M$1720 VSS \$187 \$1774 VSS sg13_lv_nmos L=0.13u W=0.55u AS=0.187p AD=0.1045p
+ PS=1.78u PD=0.93u rfmode=0
M$1721 \$1774 \$571 VSS VSS sg13_lv_nmos L=0.13u W=0.55u AS=0.1045p
+ AD=0.146425p PS=0.93u PD=1.155u rfmode=0
M$1722 VSS \$1774 \$1775 VSS sg13_lv_nmos L=0.13u W=1.48u AS=0.312925p
+ AD=0.4477p PS=2.345u PD=3.43u rfmode=0
M$1724 \$1808 \$1807 \$1887 VSS sg13_lv_nmos L=0.13u W=0.42u AS=0.1428p
+ AD=0.0609p PS=1.52u PD=0.71u rfmode=0
M$1725 \$1887 VDD VSS VSS sg13_lv_nmos L=0.13u W=0.42u AS=0.0609p AD=0.1626p
+ PS=0.71u PD=1.415u rfmode=0
M$1726 VSS \$1934 \$1776 VSS sg13_lv_nmos L=0.13u W=0.74u AS=0.1626p AD=0.2516p
+ PS=1.415u PD=2.16u rfmode=0
M$1727 \$1520 \$1489 \$1646 VSS sg13_lv_nmos L=0.13u W=0.42u AS=0.1296p
+ AD=0.081p PS=1.52u PD=0.81u rfmode=0
M$1728 \$1646 \$1662 \$1521 VSS sg13_lv_nmos L=0.13u W=0.42u AS=0.081p
+ AD=0.2163p PS=0.81u PD=1.87u rfmode=0
M$1729 \$1810 \$1935 VSS VSS sg13_lv_nmos L=0.13u W=0.42u AS=0.1428p AD=0.0798p
+ PS=1.52u PD=0.8u rfmode=0
M$1730 VSS VDD \$1891 VSS sg13_lv_nmos L=0.13u W=0.42u AS=0.0798p AD=0.0378p
+ PS=0.8u PD=0.6u rfmode=0
M$1731 \$1891 \$1811 \$1935 VSS sg13_lv_nmos L=0.13u W=0.42u AS=0.0378p
+ AD=0.1428p PS=0.6u PD=1.52u rfmode=0
M$1732 VSS \$1811 \$1813 VSS sg13_lv_nmos L=0.13u W=0.64u AS=0.1331p AD=0.2176p
+ PS=1.12u PD=1.96u rfmode=0
M$1733 VSS \$1811 \$1812 VSS sg13_lv_nmos L=0.13u W=1.48u AS=0.3922p AD=0.2737p
+ PS=3.28u PD=2.24u rfmode=0
M$1735 VSS \$1813 \$1814 VSS sg13_lv_nmos L=0.13u W=1.48u AS=0.3922p AD=0.3922p
+ PS=3.28u PD=3.28u rfmode=0
M$1737 VSS VSS \$1663 VSS sg13_lv_nmos L=0.13u W=1u AS=0.265p AD=0.265p
+ PS=2.56u PD=2.56u rfmode=0
M$1738 \$1663 \$1524 OUTP VSS sg13_lv_nmos L=0.13u W=2u AS=0.38p AD=0.38p
+ PS=3.52u PD=3.52u rfmode=0
M$1740 \$1663 \$1526 OUTN VSS sg13_lv_nmos L=0.13u W=2u AS=0.38p AD=0.38p
+ PS=3.52u PD=3.52u rfmode=0
M$1747 VSS \$190 \$1778 VSS sg13_lv_nmos L=0.13u W=0.55u AS=0.187p AD=0.1045p
+ PS=1.78u PD=0.93u rfmode=0
M$1748 \$1778 \$571 VSS VSS sg13_lv_nmos L=0.13u W=0.55u AS=0.1045p
+ AD=0.146425p PS=0.93u PD=1.155u rfmode=0
M$1749 VSS \$1778 \$1779 VSS sg13_lv_nmos L=0.13u W=1.48u AS=0.312925p
+ AD=0.4477p PS=2.345u PD=3.43u rfmode=0
M$1751 \$1818 \$1817 \$1899 VSS sg13_lv_nmos L=0.13u W=0.42u AS=0.1428p
+ AD=0.0609p PS=1.52u PD=0.71u rfmode=0
M$1752 \$1899 VDD VSS VSS sg13_lv_nmos L=0.13u W=0.42u AS=0.0609p AD=0.1626p
+ PS=0.71u PD=1.415u rfmode=0
M$1753 VSS \$1936 \$1780 VSS sg13_lv_nmos L=0.13u W=0.74u AS=0.1626p AD=0.2516p
+ PS=1.415u PD=2.16u rfmode=0
M$1754 \$1530 \$1493 \$1648 VSS sg13_lv_nmos L=0.13u W=0.42u AS=0.1296p
+ AD=0.081p PS=1.52u PD=0.81u rfmode=0
M$1755 \$1648 \$1664 \$1531 VSS sg13_lv_nmos L=0.13u W=0.42u AS=0.081p
+ AD=0.2163p PS=0.81u PD=1.87u rfmode=0
M$1756 \$1820 \$1937 VSS VSS sg13_lv_nmos L=0.13u W=0.42u AS=0.1428p AD=0.0798p
+ PS=1.52u PD=0.8u rfmode=0
M$1757 VSS VDD \$1903 VSS sg13_lv_nmos L=0.13u W=0.42u AS=0.0798p AD=0.0378p
+ PS=0.8u PD=0.6u rfmode=0
M$1758 \$1903 \$1821 \$1937 VSS sg13_lv_nmos L=0.13u W=0.42u AS=0.0378p
+ AD=0.1428p PS=0.6u PD=1.52u rfmode=0
M$1759 VSS \$1821 \$1823 VSS sg13_lv_nmos L=0.13u W=0.64u AS=0.1331p AD=0.2176p
+ PS=1.12u PD=1.96u rfmode=0
M$1760 VSS \$1821 \$1822 VSS sg13_lv_nmos L=0.13u W=1.48u AS=0.3922p AD=0.2737p
+ PS=3.28u PD=2.24u rfmode=0
M$1762 VSS \$1823 \$1824 VSS sg13_lv_nmos L=0.13u W=1.48u AS=0.3922p AD=0.3922p
+ PS=3.28u PD=3.28u rfmode=0
M$1764 VSS VSS \$1665 VSS sg13_lv_nmos L=0.13u W=1u AS=0.265p AD=0.265p
+ PS=2.56u PD=2.56u rfmode=0
M$1765 \$1665 \$1534 OUTP VSS sg13_lv_nmos L=0.13u W=2u AS=0.38p AD=0.38p
+ PS=3.52u PD=3.52u rfmode=0
M$1767 \$1665 \$1536 OUTN VSS sg13_lv_nmos L=0.13u W=2u AS=0.38p AD=0.38p
+ PS=3.52u PD=3.52u rfmode=0
M$1774 VSS \$193 \$1782 VSS sg13_lv_nmos L=0.13u W=0.55u AS=0.187p AD=0.1045p
+ PS=1.78u PD=0.93u rfmode=0
M$1775 \$1782 \$571 VSS VSS sg13_lv_nmos L=0.13u W=0.55u AS=0.1045p
+ AD=0.146425p PS=0.93u PD=1.155u rfmode=0
M$1776 VSS \$1782 \$1783 VSS sg13_lv_nmos L=0.13u W=1.48u AS=0.312925p
+ AD=0.4477p PS=2.345u PD=3.43u rfmode=0
M$1778 \$1828 \$1827 \$1910 VSS sg13_lv_nmos L=0.13u W=0.42u AS=0.1428p
+ AD=0.0609p PS=1.52u PD=0.71u rfmode=0
M$1779 \$1910 VDD VSS VSS sg13_lv_nmos L=0.13u W=0.42u AS=0.0609p AD=0.1626p
+ PS=0.71u PD=1.415u rfmode=0
M$1780 VSS \$1938 \$1784 VSS sg13_lv_nmos L=0.13u W=0.74u AS=0.1626p AD=0.2516p
+ PS=1.415u PD=2.16u rfmode=0
M$1781 \$1540 \$1497 \$1650 VSS sg13_lv_nmos L=0.13u W=0.42u AS=0.1296p
+ AD=0.081p PS=1.52u PD=0.81u rfmode=0
M$1782 \$1650 \$1666 \$1541 VSS sg13_lv_nmos L=0.13u W=0.42u AS=0.081p
+ AD=0.2163p PS=0.81u PD=1.87u rfmode=0
M$1783 \$1830 \$1939 VSS VSS sg13_lv_nmos L=0.13u W=0.42u AS=0.1428p AD=0.0798p
+ PS=1.52u PD=0.8u rfmode=0
M$1784 VSS VDD \$1915 VSS sg13_lv_nmos L=0.13u W=0.42u AS=0.0798p AD=0.0378p
+ PS=0.8u PD=0.6u rfmode=0
M$1785 \$1915 \$1831 \$1939 VSS sg13_lv_nmos L=0.13u W=0.42u AS=0.0378p
+ AD=0.1428p PS=0.6u PD=1.52u rfmode=0
M$1786 VSS \$1831 \$1833 VSS sg13_lv_nmos L=0.13u W=0.64u AS=0.1331p AD=0.2176p
+ PS=1.12u PD=1.96u rfmode=0
M$1787 VSS \$1831 \$1832 VSS sg13_lv_nmos L=0.13u W=1.48u AS=0.3922p AD=0.2737p
+ PS=3.28u PD=2.24u rfmode=0
M$1789 VSS \$1833 \$1834 VSS sg13_lv_nmos L=0.13u W=1.48u AS=0.3922p AD=0.3922p
+ PS=3.28u PD=3.28u rfmode=0
M$1791 VSS VSS \$1667 VSS sg13_lv_nmos L=0.13u W=1u AS=0.265p AD=0.265p
+ PS=2.56u PD=2.56u rfmode=0
M$1792 \$1667 \$1544 OUTP VSS sg13_lv_nmos L=0.13u W=2u AS=0.38p AD=0.38p
+ PS=3.52u PD=3.52u rfmode=0
M$1794 \$1667 \$1546 OUTN VSS sg13_lv_nmos L=0.13u W=2u AS=0.38p AD=0.38p
+ PS=3.52u PD=3.52u rfmode=0
M$1801 VSS \$196 \$1786 VSS sg13_lv_nmos L=0.13u W=0.55u AS=0.187p AD=0.1045p
+ PS=1.78u PD=0.93u rfmode=0
M$1802 \$1786 \$571 VSS VSS sg13_lv_nmos L=0.13u W=0.55u AS=0.1045p
+ AD=0.146425p PS=0.93u PD=1.155u rfmode=0
M$1803 VSS \$1786 \$1787 VSS sg13_lv_nmos L=0.13u W=1.48u AS=0.312925p
+ AD=0.4477p PS=2.345u PD=3.43u rfmode=0
M$1805 \$1838 \$1837 \$1922 VSS sg13_lv_nmos L=0.13u W=0.42u AS=0.1428p
+ AD=0.0609p PS=1.52u PD=0.71u rfmode=0
M$1806 \$1922 VDD VSS VSS sg13_lv_nmos L=0.13u W=0.42u AS=0.0609p AD=0.1626p
+ PS=0.71u PD=1.415u rfmode=0
M$1807 VSS \$1940 \$1788 VSS sg13_lv_nmos L=0.13u W=0.74u AS=0.1626p AD=0.2516p
+ PS=1.415u PD=2.16u rfmode=0
M$1808 \$1550 \$1501 \$1652 VSS sg13_lv_nmos L=0.13u W=0.42u AS=0.1296p
+ AD=0.081p PS=1.52u PD=0.81u rfmode=0
M$1809 \$1652 \$1668 \$1551 VSS sg13_lv_nmos L=0.13u W=0.42u AS=0.081p
+ AD=0.2163p PS=0.81u PD=1.87u rfmode=0
M$1810 \$1840 \$1941 VSS VSS sg13_lv_nmos L=0.13u W=0.42u AS=0.1428p AD=0.0798p
+ PS=1.52u PD=0.8u rfmode=0
M$1811 VSS VDD \$1925 VSS sg13_lv_nmos L=0.13u W=0.42u AS=0.0798p AD=0.0378p
+ PS=0.8u PD=0.6u rfmode=0
M$1812 \$1925 \$1841 \$1941 VSS sg13_lv_nmos L=0.13u W=0.42u AS=0.0378p
+ AD=0.1428p PS=0.6u PD=1.52u rfmode=0
M$1813 VSS \$1841 \$1843 VSS sg13_lv_nmos L=0.13u W=0.64u AS=0.1331p AD=0.2176p
+ PS=1.12u PD=1.96u rfmode=0
M$1814 VSS \$1841 \$1842 VSS sg13_lv_nmos L=0.13u W=1.48u AS=0.3922p AD=0.2737p
+ PS=3.28u PD=2.24u rfmode=0
M$1816 VSS \$1843 \$1844 VSS sg13_lv_nmos L=0.13u W=1.48u AS=0.3922p AD=0.3922p
+ PS=3.28u PD=3.28u rfmode=0
M$1818 VSS VSS \$1669 VSS sg13_lv_nmos L=0.13u W=1u AS=0.265p AD=0.265p
+ PS=2.56u PD=2.56u rfmode=0
M$1819 \$1669 \$1554 OUTP VSS sg13_lv_nmos L=0.13u W=2u AS=0.38p AD=0.38p
+ PS=3.52u PD=3.52u rfmode=0
M$1821 \$1669 \$1556 OUTN VSS sg13_lv_nmos L=0.13u W=2u AS=0.38p AD=0.38p
+ PS=3.52u PD=3.52u rfmode=0
M$1828 VSS \$199 \$1790 VSS sg13_lv_nmos L=0.13u W=0.55u AS=0.187p AD=0.1045p
+ PS=1.78u PD=0.93u rfmode=0
M$1829 \$1790 \$571 VSS VSS sg13_lv_nmos L=0.13u W=0.55u AS=0.1045p
+ AD=0.146425p PS=0.93u PD=1.155u rfmode=0
M$1830 VSS \$1790 \$1791 VSS sg13_lv_nmos L=0.13u W=1.48u AS=0.312925p
+ AD=0.4477p PS=2.345u PD=3.43u rfmode=0
M$1832 \$1848 \$1847 \$1933 VSS sg13_lv_nmos L=0.13u W=0.42u AS=0.1428p
+ AD=0.0609p PS=1.52u PD=0.71u rfmode=0
M$1833 \$1933 VDD VSS VSS sg13_lv_nmos L=0.13u W=0.42u AS=0.0609p AD=0.1626p
+ PS=0.71u PD=1.415u rfmode=0
M$1834 VSS \$1942 \$1792 VSS sg13_lv_nmos L=0.13u W=0.74u AS=0.1626p AD=0.2516p
+ PS=1.415u PD=2.16u rfmode=0
M$1835 \$1560 \$1505 \$1654 VSS sg13_lv_nmos L=0.13u W=0.42u AS=0.1296p
+ AD=0.081p PS=1.52u PD=0.81u rfmode=0
M$1836 \$1654 \$1670 \$1561 VSS sg13_lv_nmos L=0.13u W=0.42u AS=0.081p
+ AD=0.2163p PS=0.81u PD=1.87u rfmode=0
M$1837 \$1850 \$1943 VSS VSS sg13_lv_nmos L=0.13u W=0.42u AS=0.1428p AD=0.0798p
+ PS=1.52u PD=0.8u rfmode=0
M$1838 VSS VDD \$1930 VSS sg13_lv_nmos L=0.13u W=0.42u AS=0.0798p AD=0.0378p
+ PS=0.8u PD=0.6u rfmode=0
M$1839 \$1930 \$1851 \$1943 VSS sg13_lv_nmos L=0.13u W=0.42u AS=0.0378p
+ AD=0.1428p PS=0.6u PD=1.52u rfmode=0
M$1840 VSS \$1851 \$1853 VSS sg13_lv_nmos L=0.13u W=0.64u AS=0.1331p AD=0.2176p
+ PS=1.12u PD=1.96u rfmode=0
M$1841 VSS \$1851 \$1852 VSS sg13_lv_nmos L=0.13u W=1.48u AS=0.3922p AD=0.2737p
+ PS=3.28u PD=2.24u rfmode=0
M$1843 VSS \$1853 \$1854 VSS sg13_lv_nmos L=0.13u W=1.48u AS=0.3922p AD=0.3922p
+ PS=3.28u PD=3.28u rfmode=0
M$1845 VSS VSS \$1671 VSS sg13_lv_nmos L=0.13u W=1u AS=0.265p AD=0.265p
+ PS=2.56u PD=2.56u rfmode=0
M$1846 \$1671 \$1564 OUTP VSS sg13_lv_nmos L=0.13u W=2u AS=0.38p AD=0.38p
+ PS=3.52u PD=3.52u rfmode=0
M$1848 \$1671 \$1566 OUTN VSS sg13_lv_nmos L=0.13u W=2u AS=0.38p AD=0.38p
+ PS=3.52u PD=3.52u rfmode=0
M$1855 VSS \$202 \$1794 VSS sg13_lv_nmos L=0.13u W=0.55u AS=0.187p AD=0.1045p
+ PS=1.78u PD=0.93u rfmode=0
M$1856 \$1794 \$571 VSS VSS sg13_lv_nmos L=0.13u W=0.55u AS=0.1045p
+ AD=0.146425p PS=0.93u PD=1.155u rfmode=0
M$1857 VSS \$1794 \$1795 VSS sg13_lv_nmos L=0.13u W=1.48u AS=0.312925p
+ AD=0.4477p PS=2.345u PD=3.43u rfmode=0
M$1859 \$1858 \$1857 \$1921 VSS sg13_lv_nmos L=0.13u W=0.42u AS=0.1428p
+ AD=0.0609p PS=1.52u PD=0.71u rfmode=0
M$1860 \$1921 VDD VSS VSS sg13_lv_nmos L=0.13u W=0.42u AS=0.0609p AD=0.1626p
+ PS=0.71u PD=1.415u rfmode=0
M$1861 VSS \$1944 \$1796 VSS sg13_lv_nmos L=0.13u W=0.74u AS=0.1626p AD=0.2516p
+ PS=1.415u PD=2.16u rfmode=0
M$1862 \$1570 \$1509 \$1656 VSS sg13_lv_nmos L=0.13u W=0.42u AS=0.1296p
+ AD=0.081p PS=1.52u PD=0.81u rfmode=0
M$1863 \$1656 \$1672 \$1571 VSS sg13_lv_nmos L=0.13u W=0.42u AS=0.081p
+ AD=0.2163p PS=0.81u PD=1.87u rfmode=0
M$1864 \$1860 \$1945 VSS VSS sg13_lv_nmos L=0.13u W=0.42u AS=0.1428p AD=0.0798p
+ PS=1.52u PD=0.8u rfmode=0
M$1865 VSS VDD \$1918 VSS sg13_lv_nmos L=0.13u W=0.42u AS=0.0798p AD=0.0378p
+ PS=0.8u PD=0.6u rfmode=0
M$1866 \$1918 \$1861 \$1945 VSS sg13_lv_nmos L=0.13u W=0.42u AS=0.0378p
+ AD=0.1428p PS=0.6u PD=1.52u rfmode=0
M$1867 VSS \$1861 \$1863 VSS sg13_lv_nmos L=0.13u W=0.64u AS=0.1331p AD=0.2176p
+ PS=1.12u PD=1.96u rfmode=0
M$1868 VSS \$1861 \$1862 VSS sg13_lv_nmos L=0.13u W=1.48u AS=0.3922p AD=0.2737p
+ PS=3.28u PD=2.24u rfmode=0
M$1870 VSS \$1863 \$1864 VSS sg13_lv_nmos L=0.13u W=1.48u AS=0.3922p AD=0.3922p
+ PS=3.28u PD=3.28u rfmode=0
M$1872 VSS VSS \$1673 VSS sg13_lv_nmos L=0.13u W=1u AS=0.265p AD=0.265p
+ PS=2.56u PD=2.56u rfmode=0
M$1873 \$1673 \$1574 OUTP VSS sg13_lv_nmos L=0.13u W=2u AS=0.38p AD=0.38p
+ PS=3.52u PD=3.52u rfmode=0
M$1875 \$1673 \$1576 OUTN VSS sg13_lv_nmos L=0.13u W=2u AS=0.38p AD=0.38p
+ PS=3.52u PD=3.52u rfmode=0
M$1882 VSS \$205 \$1798 VSS sg13_lv_nmos L=0.13u W=0.55u AS=0.187p AD=0.1045p
+ PS=1.78u PD=0.93u rfmode=0
M$1883 \$1798 \$571 VSS VSS sg13_lv_nmos L=0.13u W=0.55u AS=0.1045p
+ AD=0.146425p PS=0.93u PD=1.155u rfmode=0
M$1884 VSS \$1798 \$1799 VSS sg13_lv_nmos L=0.13u W=1.48u AS=0.312925p
+ AD=0.4477p PS=2.345u PD=3.43u rfmode=0
M$1886 \$1868 \$1867 \$1908 VSS sg13_lv_nmos L=0.13u W=0.42u AS=0.1428p
+ AD=0.0609p PS=1.52u PD=0.71u rfmode=0
M$1887 \$1908 VDD VSS VSS sg13_lv_nmos L=0.13u W=0.42u AS=0.0609p AD=0.1626p
+ PS=0.71u PD=1.415u rfmode=0
M$1888 VSS \$1946 \$1800 VSS sg13_lv_nmos L=0.13u W=0.74u AS=0.1626p AD=0.2516p
+ PS=1.415u PD=2.16u rfmode=0
M$1889 \$1580 \$1513 \$1658 VSS sg13_lv_nmos L=0.13u W=0.42u AS=0.1296p
+ AD=0.081p PS=1.52u PD=0.81u rfmode=0
M$1890 \$1658 \$1674 \$1581 VSS sg13_lv_nmos L=0.13u W=0.42u AS=0.081p
+ AD=0.2163p PS=0.81u PD=1.87u rfmode=0
M$1891 \$1870 \$1947 VSS VSS sg13_lv_nmos L=0.13u W=0.42u AS=0.1428p AD=0.0798p
+ PS=1.52u PD=0.8u rfmode=0
M$1892 VSS VDD \$1905 VSS sg13_lv_nmos L=0.13u W=0.42u AS=0.0798p AD=0.0378p
+ PS=0.8u PD=0.6u rfmode=0
M$1893 \$1905 \$1871 \$1947 VSS sg13_lv_nmos L=0.13u W=0.42u AS=0.0378p
+ AD=0.1428p PS=0.6u PD=1.52u rfmode=0
M$1894 VSS \$1871 \$1873 VSS sg13_lv_nmos L=0.13u W=0.64u AS=0.1331p AD=0.2176p
+ PS=1.12u PD=1.96u rfmode=0
M$1895 VSS \$1871 \$1872 VSS sg13_lv_nmos L=0.13u W=1.48u AS=0.3922p AD=0.2737p
+ PS=3.28u PD=2.24u rfmode=0
M$1897 VSS \$1873 \$1874 VSS sg13_lv_nmos L=0.13u W=1.48u AS=0.3922p AD=0.3922p
+ PS=3.28u PD=3.28u rfmode=0
M$1899 VSS VSS \$1675 VSS sg13_lv_nmos L=0.13u W=1u AS=0.265p AD=0.265p
+ PS=2.56u PD=2.56u rfmode=0
M$1900 \$1675 \$1584 OUTP VSS sg13_lv_nmos L=0.13u W=2u AS=0.38p AD=0.38p
+ PS=3.52u PD=3.52u rfmode=0
M$1902 \$1675 \$1586 OUTN VSS sg13_lv_nmos L=0.13u W=2u AS=0.38p AD=0.38p
+ PS=3.52u PD=3.52u rfmode=0
M$1909 VSS VSS \$1802 VSS sg13_lv_nmos L=0.13u W=0.55u AS=0.187p AD=0.1045p
+ PS=1.78u PD=0.93u rfmode=0
M$1910 \$1802 \$571 VSS VSS sg13_lv_nmos L=0.13u W=0.55u AS=0.1045p
+ AD=0.146425p PS=0.93u PD=1.155u rfmode=0
M$1911 VSS \$1802 \$1803 VSS sg13_lv_nmos L=0.13u W=1.48u AS=0.312925p
+ AD=0.4477p PS=2.345u PD=3.43u rfmode=0
M$1913 \$1878 \$1877 \$1896 VSS sg13_lv_nmos L=0.13u W=0.42u AS=0.1428p
+ AD=0.0609p PS=1.52u PD=0.71u rfmode=0
M$1914 \$1896 VDD VSS VSS sg13_lv_nmos L=0.13u W=0.42u AS=0.0609p AD=0.1626p
+ PS=0.71u PD=1.415u rfmode=0
M$1915 VSS \$1948 \$1804 VSS sg13_lv_nmos L=0.13u W=0.74u AS=0.1626p AD=0.2516p
+ PS=1.415u PD=2.16u rfmode=0
M$1916 \$1590 \$1517 \$1660 VSS sg13_lv_nmos L=0.13u W=0.42u AS=0.1296p
+ AD=0.081p PS=1.52u PD=0.81u rfmode=0
M$1917 \$1660 \$1676 \$1591 VSS sg13_lv_nmos L=0.13u W=0.42u AS=0.081p
+ AD=0.2163p PS=0.81u PD=1.87u rfmode=0
M$1918 \$1880 \$1949 VSS VSS sg13_lv_nmos L=0.13u W=0.42u AS=0.1428p AD=0.0798p
+ PS=1.52u PD=0.8u rfmode=0
M$1919 VSS VDD \$1892 VSS sg13_lv_nmos L=0.13u W=0.42u AS=0.0798p AD=0.0378p
+ PS=0.8u PD=0.6u rfmode=0
M$1920 \$1892 \$1881 \$1949 VSS sg13_lv_nmos L=0.13u W=0.42u AS=0.0378p
+ AD=0.1428p PS=0.6u PD=1.52u rfmode=0
M$1921 VSS \$1881 \$1883 VSS sg13_lv_nmos L=0.13u W=0.64u AS=0.1331p AD=0.2176p
+ PS=1.12u PD=1.96u rfmode=0
M$1922 VSS \$1881 \$1882 VSS sg13_lv_nmos L=0.13u W=1.48u AS=0.3922p AD=0.2737p
+ PS=3.28u PD=2.24u rfmode=0
M$1924 VSS \$1883 \$1884 VSS sg13_lv_nmos L=0.13u W=1.48u AS=0.3922p AD=0.3922p
+ PS=3.28u PD=3.28u rfmode=0
M$1926 VSS VSS \$1677 VSS sg13_lv_nmos L=0.13u W=1u AS=0.265p AD=0.265p
+ PS=2.56u PD=2.56u rfmode=0
M$1927 \$1677 \$1594 OUTP VSS sg13_lv_nmos L=0.13u W=2u AS=0.38p AD=0.38p
+ PS=3.52u PD=3.52u rfmode=0
M$1929 \$1677 \$1596 OUTN VSS sg13_lv_nmos L=0.13u W=2u AS=0.38p AD=0.38p
+ PS=3.52u PD=3.52u rfmode=0
M$1936 \$1806 \$1775 VSS VSS sg13_lv_nmos L=0.13u W=1.44u AS=0.4068p AD=0.2772p
+ PS=3.29u PD=2.21u rfmode=0
M$1938 \$1806 \$326 \$1807 VSS sg13_lv_nmos L=0.13u W=1.44u AS=0.2772p
+ AD=0.3816p PS=2.21u PD=3.22u rfmode=0
M$1940 VSS VDD \$1888 VSS sg13_lv_nmos L=0.13u W=0.42u AS=0.1701p AD=0.03885p
+ PS=1.65u PD=0.605u rfmode=0
M$1941 \$1888 \$1776 \$1809 VSS sg13_lv_nmos L=0.13u W=0.42u AS=0.03885p
+ AD=0.1596p PS=0.605u PD=1.6u rfmode=0
M$1942 VSS \$1777 \$1950 VSS sg13_lv_nmos L=0.13u W=0.74u AS=0.43315p
+ AD=0.2516p PS=2.205u PD=2.16u rfmode=0
M$1943 VSS CLK \$1777 VSS sg13_lv_nmos L=0.13u W=0.74u AS=0.43315p AD=0.2516p
+ PS=2.205u PD=2.16u rfmode=0
M$1944 \$1811 \$1777 \$1810 VSS sg13_lv_nmos L=0.13u W=0.42u AS=0.12665p
+ AD=0.1428p PS=1.145u PD=1.52u rfmode=0
M$1945 \$1776 \$1950 \$1811 VSS sg13_lv_nmos L=0.13u W=0.74u AS=0.3473p
+ AD=0.12665p PS=2.71u PD=1.145u rfmode=0
M$1946 \$1816 \$1779 VSS VSS sg13_lv_nmos L=0.13u W=1.44u AS=0.4068p AD=0.2772p
+ PS=3.29u PD=2.21u rfmode=0
M$1948 \$1816 \$326 \$1817 VSS sg13_lv_nmos L=0.13u W=1.44u AS=0.2772p
+ AD=0.3816p PS=2.21u PD=3.22u rfmode=0
M$1950 VSS VDD \$1900 VSS sg13_lv_nmos L=0.13u W=0.42u AS=0.1701p AD=0.03885p
+ PS=1.65u PD=0.605u rfmode=0
M$1951 \$1900 \$1780 \$1819 VSS sg13_lv_nmos L=0.13u W=0.42u AS=0.03885p
+ AD=0.1596p PS=0.605u PD=1.6u rfmode=0
M$1952 VSS \$1781 \$1952 VSS sg13_lv_nmos L=0.13u W=0.74u AS=0.43315p
+ AD=0.2516p PS=2.205u PD=2.16u rfmode=0
M$1953 VSS CLK \$1781 VSS sg13_lv_nmos L=0.13u W=0.74u AS=0.43315p AD=0.2516p
+ PS=2.205u PD=2.16u rfmode=0
M$1954 \$1821 \$1781 \$1820 VSS sg13_lv_nmos L=0.13u W=0.42u AS=0.12665p
+ AD=0.1428p PS=1.145u PD=1.52u rfmode=0
M$1955 \$1780 \$1952 \$1821 VSS sg13_lv_nmos L=0.13u W=0.74u AS=0.3473p
+ AD=0.12665p PS=2.71u PD=1.145u rfmode=0
M$1956 \$1826 \$1783 VSS VSS sg13_lv_nmos L=0.13u W=1.44u AS=0.4068p AD=0.2772p
+ PS=3.29u PD=2.21u rfmode=0
M$1958 \$1826 \$326 \$1827 VSS sg13_lv_nmos L=0.13u W=1.44u AS=0.2772p
+ AD=0.3816p PS=2.21u PD=3.22u rfmode=0
M$1960 VSS VDD \$1911 VSS sg13_lv_nmos L=0.13u W=0.42u AS=0.1701p AD=0.03885p
+ PS=1.65u PD=0.605u rfmode=0
M$1961 \$1911 \$1784 \$1829 VSS sg13_lv_nmos L=0.13u W=0.42u AS=0.03885p
+ AD=0.1596p PS=0.605u PD=1.6u rfmode=0
M$1962 VSS \$1785 \$1954 VSS sg13_lv_nmos L=0.13u W=0.74u AS=0.43315p
+ AD=0.2516p PS=2.205u PD=2.16u rfmode=0
M$1963 VSS CLK \$1785 VSS sg13_lv_nmos L=0.13u W=0.74u AS=0.43315p AD=0.2516p
+ PS=2.205u PD=2.16u rfmode=0
M$1964 \$1831 \$1785 \$1830 VSS sg13_lv_nmos L=0.13u W=0.42u AS=0.12665p
+ AD=0.1428p PS=1.145u PD=1.52u rfmode=0
M$1965 \$1784 \$1954 \$1831 VSS sg13_lv_nmos L=0.13u W=0.74u AS=0.3473p
+ AD=0.12665p PS=2.71u PD=1.145u rfmode=0
M$1966 \$1836 \$1787 VSS VSS sg13_lv_nmos L=0.13u W=1.44u AS=0.4068p AD=0.2772p
+ PS=3.29u PD=2.21u rfmode=0
M$1968 \$1836 \$326 \$1837 VSS sg13_lv_nmos L=0.13u W=1.44u AS=0.2772p
+ AD=0.3816p PS=2.21u PD=3.22u rfmode=0
M$1970 VSS VDD \$1923 VSS sg13_lv_nmos L=0.13u W=0.42u AS=0.1701p AD=0.03885p
+ PS=1.65u PD=0.605u rfmode=0
M$1971 \$1923 \$1788 \$1839 VSS sg13_lv_nmos L=0.13u W=0.42u AS=0.03885p
+ AD=0.1596p PS=0.605u PD=1.6u rfmode=0
M$1972 VSS \$1789 \$1956 VSS sg13_lv_nmos L=0.13u W=0.74u AS=0.43315p
+ AD=0.2516p PS=2.205u PD=2.16u rfmode=0
M$1973 VSS CLK \$1789 VSS sg13_lv_nmos L=0.13u W=0.74u AS=0.43315p AD=0.2516p
+ PS=2.205u PD=2.16u rfmode=0
M$1974 \$1841 \$1789 \$1840 VSS sg13_lv_nmos L=0.13u W=0.42u AS=0.12665p
+ AD=0.1428p PS=1.145u PD=1.52u rfmode=0
M$1975 \$1788 \$1956 \$1841 VSS sg13_lv_nmos L=0.13u W=0.74u AS=0.3473p
+ AD=0.12665p PS=2.71u PD=1.145u rfmode=0
M$1976 \$1846 \$1791 VSS VSS sg13_lv_nmos L=0.13u W=1.44u AS=0.4068p AD=0.2772p
+ PS=3.29u PD=2.21u rfmode=0
M$1978 \$1846 \$326 \$1847 VSS sg13_lv_nmos L=0.13u W=1.44u AS=0.2772p
+ AD=0.3816p PS=2.21u PD=3.22u rfmode=0
M$1980 VSS VDD \$1932 VSS sg13_lv_nmos L=0.13u W=0.42u AS=0.1701p AD=0.03885p
+ PS=1.65u PD=0.605u rfmode=0
M$1981 \$1932 \$1792 \$1849 VSS sg13_lv_nmos L=0.13u W=0.42u AS=0.03885p
+ AD=0.1596p PS=0.605u PD=1.6u rfmode=0
M$1982 VSS \$1793 \$1958 VSS sg13_lv_nmos L=0.13u W=0.74u AS=0.43315p
+ AD=0.2516p PS=2.205u PD=2.16u rfmode=0
M$1983 VSS CLK \$1793 VSS sg13_lv_nmos L=0.13u W=0.74u AS=0.43315p AD=0.2516p
+ PS=2.205u PD=2.16u rfmode=0
M$1984 \$1851 \$1793 \$1850 VSS sg13_lv_nmos L=0.13u W=0.42u AS=0.12665p
+ AD=0.1428p PS=1.145u PD=1.52u rfmode=0
M$1985 \$1792 \$1958 \$1851 VSS sg13_lv_nmos L=0.13u W=0.74u AS=0.3473p
+ AD=0.12665p PS=2.71u PD=1.145u rfmode=0
M$1986 \$1856 \$1795 VSS VSS sg13_lv_nmos L=0.13u W=1.44u AS=0.4068p AD=0.2772p
+ PS=3.29u PD=2.21u rfmode=0
M$1988 \$1856 \$326 \$1857 VSS sg13_lv_nmos L=0.13u W=1.44u AS=0.2772p
+ AD=0.3816p PS=2.21u PD=3.22u rfmode=0
M$1990 VSS VDD \$1920 VSS sg13_lv_nmos L=0.13u W=0.42u AS=0.1701p AD=0.03885p
+ PS=1.65u PD=0.605u rfmode=0
M$1991 \$1920 \$1796 \$1859 VSS sg13_lv_nmos L=0.13u W=0.42u AS=0.03885p
+ AD=0.1596p PS=0.605u PD=1.6u rfmode=0
M$1992 VSS \$1797 \$1960 VSS sg13_lv_nmos L=0.13u W=0.74u AS=0.43315p
+ AD=0.2516p PS=2.205u PD=2.16u rfmode=0
M$1993 VSS CLK \$1797 VSS sg13_lv_nmos L=0.13u W=0.74u AS=0.43315p AD=0.2516p
+ PS=2.205u PD=2.16u rfmode=0
M$1994 \$1861 \$1797 \$1860 VSS sg13_lv_nmos L=0.13u W=0.42u AS=0.12665p
+ AD=0.1428p PS=1.145u PD=1.52u rfmode=0
M$1995 \$1796 \$1960 \$1861 VSS sg13_lv_nmos L=0.13u W=0.74u AS=0.3473p
+ AD=0.12665p PS=2.71u PD=1.145u rfmode=0
M$1996 \$1866 \$1799 VSS VSS sg13_lv_nmos L=0.13u W=1.44u AS=0.4068p AD=0.2772p
+ PS=3.29u PD=2.21u rfmode=0
M$1998 \$1866 \$326 \$1867 VSS sg13_lv_nmos L=0.13u W=1.44u AS=0.2772p
+ AD=0.3816p PS=2.21u PD=3.22u rfmode=0
M$2000 VSS VDD \$1907 VSS sg13_lv_nmos L=0.13u W=0.42u AS=0.1701p AD=0.03885p
+ PS=1.65u PD=0.605u rfmode=0
M$2001 \$1907 \$1800 \$1869 VSS sg13_lv_nmos L=0.13u W=0.42u AS=0.03885p
+ AD=0.1596p PS=0.605u PD=1.6u rfmode=0
M$2002 VSS \$1801 \$1962 VSS sg13_lv_nmos L=0.13u W=0.74u AS=0.43315p
+ AD=0.2516p PS=2.205u PD=2.16u rfmode=0
M$2003 VSS CLK \$1801 VSS sg13_lv_nmos L=0.13u W=0.74u AS=0.43315p AD=0.2516p
+ PS=2.205u PD=2.16u rfmode=0
M$2004 \$1871 \$1801 \$1870 VSS sg13_lv_nmos L=0.13u W=0.42u AS=0.12665p
+ AD=0.1428p PS=1.145u PD=1.52u rfmode=0
M$2005 \$1800 \$1962 \$1871 VSS sg13_lv_nmos L=0.13u W=0.74u AS=0.3473p
+ AD=0.12665p PS=2.71u PD=1.145u rfmode=0
M$2006 \$1876 \$1803 VSS VSS sg13_lv_nmos L=0.13u W=1.44u AS=0.4068p AD=0.2772p
+ PS=3.29u PD=2.21u rfmode=0
M$2008 \$1876 \$326 \$1877 VSS sg13_lv_nmos L=0.13u W=1.44u AS=0.2772p
+ AD=0.3816p PS=2.21u PD=3.22u rfmode=0
M$2010 VSS VDD \$1895 VSS sg13_lv_nmos L=0.13u W=0.42u AS=0.1701p AD=0.03885p
+ PS=1.65u PD=0.605u rfmode=0
M$2011 \$1895 \$1804 \$1879 VSS sg13_lv_nmos L=0.13u W=0.42u AS=0.03885p
+ AD=0.1596p PS=0.605u PD=1.6u rfmode=0
M$2012 VSS \$1805 \$1964 VSS sg13_lv_nmos L=0.13u W=0.74u AS=0.43315p
+ AD=0.2516p PS=2.205u PD=2.16u rfmode=0
M$2013 VSS CLK \$1805 VSS sg13_lv_nmos L=0.13u W=0.74u AS=0.43315p AD=0.2516p
+ PS=2.205u PD=2.16u rfmode=0
M$2014 \$1881 \$1805 \$1880 VSS sg13_lv_nmos L=0.13u W=0.42u AS=0.12665p
+ AD=0.1428p PS=1.145u PD=1.52u rfmode=0
M$2015 \$1804 \$1964 \$1881 VSS sg13_lv_nmos L=0.13u W=0.74u AS=0.3473p
+ AD=0.12665p PS=2.71u PD=1.145u rfmode=0
M$2016 VSS \$187 \$2062 VSS sg13_lv_nmos L=0.13u W=0.55u AS=0.187p AD=0.1045p
+ PS=1.78u PD=0.93u rfmode=0
M$2017 \$2062 VSS VSS VSS sg13_lv_nmos L=0.13u W=0.55u AS=0.1045p AD=0.146425p
+ PS=0.93u PD=1.155u rfmode=0
M$2018 VSS \$2062 \$2063 VSS sg13_lv_nmos L=0.13u W=1.48u AS=0.312925p
+ AD=0.4477p PS=2.345u PD=3.43u rfmode=0
M$2020 \$2090 \$2063 VSS VSS sg13_lv_nmos L=0.13u W=1.44u AS=0.4068p AD=0.2772p
+ PS=3.29u PD=2.21u rfmode=0
M$2022 \$2090 \$571 \$2091 VSS sg13_lv_nmos L=0.13u W=1.44u AS=0.2772p
+ AD=0.3816p PS=2.21u PD=3.22u rfmode=0
M$2024 \$2092 \$2091 \$2161 VSS sg13_lv_nmos L=0.13u W=0.42u AS=0.1428p
+ AD=0.0609p PS=1.52u PD=0.71u rfmode=0
M$2025 \$2161 VDD VSS VSS sg13_lv_nmos L=0.13u W=0.42u AS=0.0609p AD=0.1626p
+ PS=0.71u PD=1.415u rfmode=0
M$2026 VSS \$2202 \$2064 VSS sg13_lv_nmos L=0.13u W=0.74u AS=0.1626p AD=0.2516p
+ PS=1.415u PD=2.16u rfmode=0
M$2027 \$1808 \$1777 \$1934 VSS sg13_lv_nmos L=0.13u W=0.42u AS=0.1296p
+ AD=0.081p PS=1.52u PD=0.81u rfmode=0
M$2028 \$1934 \$1950 \$1809 VSS sg13_lv_nmos L=0.13u W=0.42u AS=0.081p
+ AD=0.2163p PS=0.81u PD=1.87u rfmode=0
M$2029 \$2094 \$2203 VSS VSS sg13_lv_nmos L=0.13u W=0.42u AS=0.1428p AD=0.0798p
+ PS=1.52u PD=0.8u rfmode=0
M$2030 VSS VDD \$2166 VSS sg13_lv_nmos L=0.13u W=0.42u AS=0.0798p AD=0.0378p
+ PS=0.8u PD=0.6u rfmode=0
M$2031 \$2166 \$2095 \$2203 VSS sg13_lv_nmos L=0.13u W=0.42u AS=0.0378p
+ AD=0.1428p PS=0.6u PD=1.52u rfmode=0
M$2032 VSS \$2095 \$2097 VSS sg13_lv_nmos L=0.13u W=0.64u AS=0.1331p AD=0.2176p
+ PS=1.12u PD=1.96u rfmode=0
M$2033 VSS \$2095 \$2096 VSS sg13_lv_nmos L=0.13u W=1.48u AS=0.3922p AD=0.2737p
+ PS=3.28u PD=2.24u rfmode=0
M$2035 VSS \$2097 \$2098 VSS sg13_lv_nmos L=0.13u W=1.48u AS=0.3922p AD=0.3922p
+ PS=3.28u PD=3.28u rfmode=0
M$2037 VSS VSS \$1951 VSS sg13_lv_nmos L=0.13u W=1u AS=0.265p AD=0.265p
+ PS=2.56u PD=2.56u rfmode=0
M$2038 \$1951 \$1812 OUTP VSS sg13_lv_nmos L=0.13u W=2u AS=0.38p AD=0.38p
+ PS=3.52u PD=3.52u rfmode=0
M$2040 \$1951 \$1814 OUTN VSS sg13_lv_nmos L=0.13u W=2u AS=0.38p AD=0.38p
+ PS=3.52u PD=3.52u rfmode=0
M$2047 VSS \$190 \$2066 VSS sg13_lv_nmos L=0.13u W=0.55u AS=0.187p AD=0.1045p
+ PS=1.78u PD=0.93u rfmode=0
M$2048 \$2066 VSS VSS VSS sg13_lv_nmos L=0.13u W=0.55u AS=0.1045p AD=0.146425p
+ PS=0.93u PD=1.155u rfmode=0
M$2049 VSS \$2066 \$2067 VSS sg13_lv_nmos L=0.13u W=1.48u AS=0.312925p
+ AD=0.4477p PS=2.345u PD=3.43u rfmode=0
M$2051 \$2100 \$2067 VSS VSS sg13_lv_nmos L=0.13u W=1.44u AS=0.4068p AD=0.2772p
+ PS=3.29u PD=2.21u rfmode=0
M$2053 \$2100 \$571 \$2101 VSS sg13_lv_nmos L=0.13u W=1.44u AS=0.2772p
+ AD=0.3816p PS=2.21u PD=3.22u rfmode=0
M$2055 \$2102 \$2101 \$2173 VSS sg13_lv_nmos L=0.13u W=0.42u AS=0.1428p
+ AD=0.0609p PS=1.52u PD=0.71u rfmode=0
M$2056 \$2173 VDD VSS VSS sg13_lv_nmos L=0.13u W=0.42u AS=0.0609p AD=0.1626p
+ PS=0.71u PD=1.415u rfmode=0
M$2057 VSS \$2204 \$2068 VSS sg13_lv_nmos L=0.13u W=0.74u AS=0.1626p AD=0.2516p
+ PS=1.415u PD=2.16u rfmode=0
M$2058 \$1818 \$1781 \$1936 VSS sg13_lv_nmos L=0.13u W=0.42u AS=0.1296p
+ AD=0.081p PS=1.52u PD=0.81u rfmode=0
M$2059 \$1936 \$1952 \$1819 VSS sg13_lv_nmos L=0.13u W=0.42u AS=0.081p
+ AD=0.2163p PS=0.81u PD=1.87u rfmode=0
M$2060 \$2104 \$2205 VSS VSS sg13_lv_nmos L=0.13u W=0.42u AS=0.1428p AD=0.0798p
+ PS=1.52u PD=0.8u rfmode=0
M$2061 VSS VDD \$2177 VSS sg13_lv_nmos L=0.13u W=0.42u AS=0.0798p AD=0.0378p
+ PS=0.8u PD=0.6u rfmode=0
M$2062 \$2177 \$2105 \$2205 VSS sg13_lv_nmos L=0.13u W=0.42u AS=0.0378p
+ AD=0.1428p PS=0.6u PD=1.52u rfmode=0
M$2063 VSS \$2105 \$2107 VSS sg13_lv_nmos L=0.13u W=0.64u AS=0.1331p AD=0.2176p
+ PS=1.12u PD=1.96u rfmode=0
M$2064 VSS \$2105 \$2106 VSS sg13_lv_nmos L=0.13u W=1.48u AS=0.3922p AD=0.2737p
+ PS=3.28u PD=2.24u rfmode=0
M$2066 VSS \$2107 \$2108 VSS sg13_lv_nmos L=0.13u W=1.48u AS=0.3922p AD=0.3922p
+ PS=3.28u PD=3.28u rfmode=0
M$2068 VSS VSS \$1953 VSS sg13_lv_nmos L=0.13u W=1u AS=0.265p AD=0.265p
+ PS=2.56u PD=2.56u rfmode=0
M$2069 \$1953 \$1822 OUTP VSS sg13_lv_nmos L=0.13u W=2u AS=0.38p AD=0.38p
+ PS=3.52u PD=3.52u rfmode=0
M$2071 \$1953 \$1824 OUTN VSS sg13_lv_nmos L=0.13u W=2u AS=0.38p AD=0.38p
+ PS=3.52u PD=3.52u rfmode=0
M$2078 VSS \$193 \$2070 VSS sg13_lv_nmos L=0.13u W=0.55u AS=0.187p AD=0.1045p
+ PS=1.78u PD=0.93u rfmode=0
M$2079 \$2070 VSS VSS VSS sg13_lv_nmos L=0.13u W=0.55u AS=0.1045p AD=0.146425p
+ PS=0.93u PD=1.155u rfmode=0
M$2080 VSS \$2070 \$2071 VSS sg13_lv_nmos L=0.13u W=1.48u AS=0.312925p
+ AD=0.4477p PS=2.345u PD=3.43u rfmode=0
M$2082 \$2110 \$2071 VSS VSS sg13_lv_nmos L=0.13u W=1.44u AS=0.4068p AD=0.2772p
+ PS=3.29u PD=2.21u rfmode=0
M$2084 \$2110 \$571 \$2111 VSS sg13_lv_nmos L=0.13u W=1.44u AS=0.2772p
+ AD=0.3816p PS=2.21u PD=3.22u rfmode=0
M$2086 \$2112 \$2111 \$2184 VSS sg13_lv_nmos L=0.13u W=0.42u AS=0.1428p
+ AD=0.0609p PS=1.52u PD=0.71u rfmode=0
M$2087 \$2184 VDD VSS VSS sg13_lv_nmos L=0.13u W=0.42u AS=0.0609p AD=0.1626p
+ PS=0.71u PD=1.415u rfmode=0
M$2088 VSS \$2206 \$2072 VSS sg13_lv_nmos L=0.13u W=0.74u AS=0.1626p AD=0.2516p
+ PS=1.415u PD=2.16u rfmode=0
M$2089 \$1828 \$1785 \$1938 VSS sg13_lv_nmos L=0.13u W=0.42u AS=0.1296p
+ AD=0.081p PS=1.52u PD=0.81u rfmode=0
M$2090 \$1938 \$1954 \$1829 VSS sg13_lv_nmos L=0.13u W=0.42u AS=0.081p
+ AD=0.2163p PS=0.81u PD=1.87u rfmode=0
M$2091 \$2114 \$2207 VSS VSS sg13_lv_nmos L=0.13u W=0.42u AS=0.1428p AD=0.0798p
+ PS=1.52u PD=0.8u rfmode=0
M$2092 VSS VDD \$2189 VSS sg13_lv_nmos L=0.13u W=0.42u AS=0.0798p AD=0.0378p
+ PS=0.8u PD=0.6u rfmode=0
M$2093 \$2189 \$2115 \$2207 VSS sg13_lv_nmos L=0.13u W=0.42u AS=0.0378p
+ AD=0.1428p PS=0.6u PD=1.52u rfmode=0
M$2094 VSS \$2115 \$2117 VSS sg13_lv_nmos L=0.13u W=0.64u AS=0.1331p AD=0.2176p
+ PS=1.12u PD=1.96u rfmode=0
M$2095 VSS \$2115 \$2116 VSS sg13_lv_nmos L=0.13u W=1.48u AS=0.3922p AD=0.2737p
+ PS=3.28u PD=2.24u rfmode=0
M$2097 VSS \$2117 \$2118 VSS sg13_lv_nmos L=0.13u W=1.48u AS=0.3922p AD=0.3922p
+ PS=3.28u PD=3.28u rfmode=0
M$2099 VSS VSS \$1955 VSS sg13_lv_nmos L=0.13u W=1u AS=0.265p AD=0.265p
+ PS=2.56u PD=2.56u rfmode=0
M$2100 \$1955 \$1832 OUTP VSS sg13_lv_nmos L=0.13u W=2u AS=0.38p AD=0.38p
+ PS=3.52u PD=3.52u rfmode=0
M$2102 \$1955 \$1834 OUTN VSS sg13_lv_nmos L=0.13u W=2u AS=0.38p AD=0.38p
+ PS=3.52u PD=3.52u rfmode=0
M$2109 VSS \$196 \$2074 VSS sg13_lv_nmos L=0.13u W=0.55u AS=0.187p AD=0.1045p
+ PS=1.78u PD=0.93u rfmode=0
M$2110 \$2074 VSS VSS VSS sg13_lv_nmos L=0.13u W=0.55u AS=0.1045p AD=0.146425p
+ PS=0.93u PD=1.155u rfmode=0
M$2111 VSS \$2074 \$2075 VSS sg13_lv_nmos L=0.13u W=1.48u AS=0.312925p
+ AD=0.4477p PS=2.345u PD=3.43u rfmode=0
M$2113 \$2120 \$2075 VSS VSS sg13_lv_nmos L=0.13u W=1.44u AS=0.4068p AD=0.2772p
+ PS=3.29u PD=2.21u rfmode=0
M$2115 \$2120 \$571 \$2121 VSS sg13_lv_nmos L=0.13u W=1.44u AS=0.2772p
+ AD=0.3816p PS=2.21u PD=3.22u rfmode=0
M$2117 \$2122 \$2121 \$2196 VSS sg13_lv_nmos L=0.13u W=0.42u AS=0.1428p
+ AD=0.0609p PS=1.52u PD=0.71u rfmode=0
M$2118 \$2196 VDD VSS VSS sg13_lv_nmos L=0.13u W=0.42u AS=0.0609p AD=0.1626p
+ PS=0.71u PD=1.415u rfmode=0
M$2119 VSS \$2208 \$2076 VSS sg13_lv_nmos L=0.13u W=0.74u AS=0.1626p AD=0.2516p
+ PS=1.415u PD=2.16u rfmode=0
M$2120 \$1838 \$1789 \$1940 VSS sg13_lv_nmos L=0.13u W=0.42u AS=0.1296p
+ AD=0.081p PS=1.52u PD=0.81u rfmode=0
M$2121 \$1940 \$1956 \$1839 VSS sg13_lv_nmos L=0.13u W=0.42u AS=0.081p
+ AD=0.2163p PS=0.81u PD=1.87u rfmode=0
M$2122 \$2124 \$2209 VSS VSS sg13_lv_nmos L=0.13u W=0.42u AS=0.1428p AD=0.0798p
+ PS=1.52u PD=0.8u rfmode=0
M$2123 VSS VDD \$2199 VSS sg13_lv_nmos L=0.13u W=0.42u AS=0.0798p AD=0.0378p
+ PS=0.8u PD=0.6u rfmode=0
M$2124 \$2199 \$2125 \$2209 VSS sg13_lv_nmos L=0.13u W=0.42u AS=0.0378p
+ AD=0.1428p PS=0.6u PD=1.52u rfmode=0
M$2125 VSS \$2125 \$2127 VSS sg13_lv_nmos L=0.13u W=0.64u AS=0.1331p AD=0.2176p
+ PS=1.12u PD=1.96u rfmode=0
M$2126 VSS \$2125 \$2126 VSS sg13_lv_nmos L=0.13u W=1.48u AS=0.3922p AD=0.2737p
+ PS=3.28u PD=2.24u rfmode=0
M$2128 VSS \$2127 \$2128 VSS sg13_lv_nmos L=0.13u W=1.48u AS=0.3922p AD=0.3922p
+ PS=3.28u PD=3.28u rfmode=0
M$2130 VSS VSS \$1957 VSS sg13_lv_nmos L=0.13u W=1u AS=0.265p AD=0.265p
+ PS=2.56u PD=2.56u rfmode=0
M$2131 \$1957 \$1842 OUTP VSS sg13_lv_nmos L=0.13u W=2u AS=0.38p AD=0.38p
+ PS=3.52u PD=3.52u rfmode=0
M$2133 \$1957 \$1844 OUTN VSS sg13_lv_nmos L=0.13u W=2u AS=0.38p AD=0.38p
+ PS=3.52u PD=3.52u rfmode=0
M$2140 VSS \$199 \$2078 VSS sg13_lv_nmos L=0.13u W=0.55u AS=0.187p AD=0.1045p
+ PS=1.78u PD=0.93u rfmode=0
M$2141 \$2078 VSS VSS VSS sg13_lv_nmos L=0.13u W=0.55u AS=0.1045p AD=0.146425p
+ PS=0.93u PD=1.155u rfmode=0
M$2142 VSS \$2078 \$2079 VSS sg13_lv_nmos L=0.13u W=1.48u AS=0.312925p
+ AD=0.4477p PS=2.345u PD=3.43u rfmode=0
M$2144 \$2130 \$2079 VSS VSS sg13_lv_nmos L=0.13u W=1.44u AS=0.4068p AD=0.2772p
+ PS=3.29u PD=2.21u rfmode=0
M$2146 \$2130 \$571 \$2131 VSS sg13_lv_nmos L=0.13u W=1.44u AS=0.2772p
+ AD=0.3816p PS=2.21u PD=3.22u rfmode=0
M$2148 \$2132 \$2131 \$2195 VSS sg13_lv_nmos L=0.13u W=0.42u AS=0.1428p
+ AD=0.0609p PS=1.52u PD=0.71u rfmode=0
M$2149 \$2195 VDD VSS VSS sg13_lv_nmos L=0.13u W=0.42u AS=0.0609p AD=0.1626p
+ PS=0.71u PD=1.415u rfmode=0
M$2150 VSS \$2210 \$2080 VSS sg13_lv_nmos L=0.13u W=0.74u AS=0.1626p AD=0.2516p
+ PS=1.415u PD=2.16u rfmode=0
M$2151 \$1848 \$1793 \$1942 VSS sg13_lv_nmos L=0.13u W=0.42u AS=0.1296p
+ AD=0.081p PS=1.52u PD=0.81u rfmode=0
M$2152 \$1942 \$1958 \$1849 VSS sg13_lv_nmos L=0.13u W=0.42u AS=0.081p
+ AD=0.2163p PS=0.81u PD=1.87u rfmode=0
M$2153 \$2134 \$2211 VSS VSS sg13_lv_nmos L=0.13u W=0.42u AS=0.1428p AD=0.0798p
+ PS=1.52u PD=0.8u rfmode=0
M$2154 VSS VDD \$2192 VSS sg13_lv_nmos L=0.13u W=0.42u AS=0.0798p AD=0.0378p
+ PS=0.8u PD=0.6u rfmode=0
M$2155 \$2192 \$2135 \$2211 VSS sg13_lv_nmos L=0.13u W=0.42u AS=0.0378p
+ AD=0.1428p PS=0.6u PD=1.52u rfmode=0
M$2156 VSS \$2135 \$2137 VSS sg13_lv_nmos L=0.13u W=0.64u AS=0.1331p AD=0.2176p
+ PS=1.12u PD=1.96u rfmode=0
M$2157 VSS \$2135 \$2136 VSS sg13_lv_nmos L=0.13u W=1.48u AS=0.3922p AD=0.2737p
+ PS=3.28u PD=2.24u rfmode=0
M$2159 VSS \$2137 \$2138 VSS sg13_lv_nmos L=0.13u W=1.48u AS=0.3922p AD=0.3922p
+ PS=3.28u PD=3.28u rfmode=0
M$2161 VSS VSS \$1959 VSS sg13_lv_nmos L=0.13u W=1u AS=0.265p AD=0.265p
+ PS=2.56u PD=2.56u rfmode=0
M$2162 \$1959 \$1852 OUTP VSS sg13_lv_nmos L=0.13u W=2u AS=0.38p AD=0.38p
+ PS=3.52u PD=3.52u rfmode=0
M$2164 \$1959 \$1854 OUTN VSS sg13_lv_nmos L=0.13u W=2u AS=0.38p AD=0.38p
+ PS=3.52u PD=3.52u rfmode=0
M$2171 VSS \$202 \$2082 VSS sg13_lv_nmos L=0.13u W=0.55u AS=0.187p AD=0.1045p
+ PS=1.78u PD=0.93u rfmode=0
M$2172 \$2082 VSS VSS VSS sg13_lv_nmos L=0.13u W=0.55u AS=0.1045p AD=0.146425p
+ PS=0.93u PD=1.155u rfmode=0
M$2173 VSS \$2082 \$2083 VSS sg13_lv_nmos L=0.13u W=1.48u AS=0.312925p
+ AD=0.4477p PS=2.345u PD=3.43u rfmode=0
M$2175 \$2140 \$2083 VSS VSS sg13_lv_nmos L=0.13u W=1.44u AS=0.4068p AD=0.2772p
+ PS=3.29u PD=2.21u rfmode=0
M$2177 \$2140 \$571 \$2141 VSS sg13_lv_nmos L=0.13u W=1.44u AS=0.2772p
+ AD=0.3816p PS=2.21u PD=3.22u rfmode=0
M$2179 \$2142 \$2141 \$2182 VSS sg13_lv_nmos L=0.13u W=0.42u AS=0.1428p
+ AD=0.0609p PS=1.52u PD=0.71u rfmode=0
M$2180 \$2182 VDD VSS VSS sg13_lv_nmos L=0.13u W=0.42u AS=0.0609p AD=0.1626p
+ PS=0.71u PD=1.415u rfmode=0
M$2181 VSS \$2212 \$2084 VSS sg13_lv_nmos L=0.13u W=0.74u AS=0.1626p AD=0.2516p
+ PS=1.415u PD=2.16u rfmode=0
M$2182 \$1858 \$1797 \$1944 VSS sg13_lv_nmos L=0.13u W=0.42u AS=0.1296p
+ AD=0.081p PS=1.52u PD=0.81u rfmode=0
M$2183 \$1944 \$1960 \$1859 VSS sg13_lv_nmos L=0.13u W=0.42u AS=0.081p
+ AD=0.2163p PS=0.81u PD=1.87u rfmode=0
M$2184 \$2144 \$2213 VSS VSS sg13_lv_nmos L=0.13u W=0.42u AS=0.1428p AD=0.0798p
+ PS=1.52u PD=0.8u rfmode=0
M$2185 VSS VDD \$2179 VSS sg13_lv_nmos L=0.13u W=0.42u AS=0.0798p AD=0.0378p
+ PS=0.8u PD=0.6u rfmode=0
M$2186 \$2179 \$2145 \$2213 VSS sg13_lv_nmos L=0.13u W=0.42u AS=0.0378p
+ AD=0.1428p PS=0.6u PD=1.52u rfmode=0
M$2187 VSS \$2145 \$2147 VSS sg13_lv_nmos L=0.13u W=0.64u AS=0.1331p AD=0.2176p
+ PS=1.12u PD=1.96u rfmode=0
M$2188 VSS \$2145 \$2146 VSS sg13_lv_nmos L=0.13u W=1.48u AS=0.3922p AD=0.2737p
+ PS=3.28u PD=2.24u rfmode=0
M$2190 VSS \$2147 \$2148 VSS sg13_lv_nmos L=0.13u W=1.48u AS=0.3922p AD=0.3922p
+ PS=3.28u PD=3.28u rfmode=0
M$2192 VSS VSS \$1961 VSS sg13_lv_nmos L=0.13u W=1u AS=0.265p AD=0.265p
+ PS=2.56u PD=2.56u rfmode=0
M$2193 \$1961 \$1862 OUTP VSS sg13_lv_nmos L=0.13u W=2u AS=0.38p AD=0.38p
+ PS=3.52u PD=3.52u rfmode=0
M$2195 \$1961 \$1864 OUTN VSS sg13_lv_nmos L=0.13u W=2u AS=0.38p AD=0.38p
+ PS=3.52u PD=3.52u rfmode=0
M$2202 VSS \$205 \$2086 VSS sg13_lv_nmos L=0.13u W=0.55u AS=0.187p AD=0.1045p
+ PS=1.78u PD=0.93u rfmode=0
M$2203 \$2086 VSS VSS VSS sg13_lv_nmos L=0.13u W=0.55u AS=0.1045p AD=0.146425p
+ PS=0.93u PD=1.155u rfmode=0
M$2204 VSS \$2086 \$2087 VSS sg13_lv_nmos L=0.13u W=1.48u AS=0.312925p
+ AD=0.4477p PS=2.345u PD=3.43u rfmode=0
M$2206 \$2150 \$2087 VSS VSS sg13_lv_nmos L=0.13u W=1.44u AS=0.4068p AD=0.2772p
+ PS=3.29u PD=2.21u rfmode=0
M$2208 \$2150 \$571 \$2151 VSS sg13_lv_nmos L=0.13u W=1.44u AS=0.2772p
+ AD=0.3816p PS=2.21u PD=3.22u rfmode=0
M$2210 \$2152 \$2151 \$2170 VSS sg13_lv_nmos L=0.13u W=0.42u AS=0.1428p
+ AD=0.0609p PS=1.52u PD=0.71u rfmode=0
M$2211 \$2170 VDD VSS VSS sg13_lv_nmos L=0.13u W=0.42u AS=0.0609p AD=0.1626p
+ PS=0.71u PD=1.415u rfmode=0
M$2212 VSS \$2214 \$2088 VSS sg13_lv_nmos L=0.13u W=0.74u AS=0.1626p AD=0.2516p
+ PS=1.415u PD=2.16u rfmode=0
M$2213 \$1868 \$1801 \$1946 VSS sg13_lv_nmos L=0.13u W=0.42u AS=0.1296p
+ AD=0.081p PS=1.52u PD=0.81u rfmode=0
M$2214 \$1946 \$1962 \$1869 VSS sg13_lv_nmos L=0.13u W=0.42u AS=0.081p
+ AD=0.2163p PS=0.81u PD=1.87u rfmode=0
M$2215 \$2154 \$2215 VSS VSS sg13_lv_nmos L=0.13u W=0.42u AS=0.1428p AD=0.0798p
+ PS=1.52u PD=0.8u rfmode=0
M$2216 VSS VDD \$2165 VSS sg13_lv_nmos L=0.13u W=0.42u AS=0.0798p AD=0.0378p
+ PS=0.8u PD=0.6u rfmode=0
M$2217 \$2165 \$2155 \$2215 VSS sg13_lv_nmos L=0.13u W=0.42u AS=0.0378p
+ AD=0.1428p PS=0.6u PD=1.52u rfmode=0
M$2218 VSS \$2155 \$2157 VSS sg13_lv_nmos L=0.13u W=0.64u AS=0.1331p AD=0.2176p
+ PS=1.12u PD=1.96u rfmode=0
M$2219 VSS \$2155 \$2156 VSS sg13_lv_nmos L=0.13u W=1.48u AS=0.3922p AD=0.2737p
+ PS=3.28u PD=2.24u rfmode=0
M$2221 VSS \$2157 \$2158 VSS sg13_lv_nmos L=0.13u W=1.48u AS=0.3922p AD=0.3922p
+ PS=3.28u PD=3.28u rfmode=0
M$2223 VSS VSS \$1963 VSS sg13_lv_nmos L=0.13u W=1u AS=0.265p AD=0.265p
+ PS=2.56u PD=2.56u rfmode=0
M$2224 \$1963 \$1872 OUTP VSS sg13_lv_nmos L=0.13u W=2u AS=0.38p AD=0.38p
+ PS=3.52u PD=3.52u rfmode=0
M$2226 \$1963 \$1874 OUTN VSS sg13_lv_nmos L=0.13u W=2u AS=0.38p AD=0.38p
+ PS=3.52u PD=3.52u rfmode=0
M$2233 \$1878 \$1805 \$1948 VSS sg13_lv_nmos L=0.13u W=0.42u AS=0.1296p
+ AD=0.081p PS=1.52u PD=0.81u rfmode=0
M$2234 \$1948 \$1964 \$1879 VSS sg13_lv_nmos L=0.13u W=0.42u AS=0.081p
+ AD=0.2163p PS=0.81u PD=1.87u rfmode=0
M$2235 VSS VSS \$1965 VSS sg13_lv_nmos L=0.13u W=1u AS=0.265p AD=0.265p
+ PS=2.56u PD=2.56u rfmode=0
M$2236 \$1965 \$1882 OUTP VSS sg13_lv_nmos L=0.13u W=2u AS=0.38p AD=0.38p
+ PS=3.52u PD=3.52u rfmode=0
M$2238 \$1965 \$1884 OUTN VSS sg13_lv_nmos L=0.13u W=2u AS=0.38p AD=0.38p
+ PS=3.52u PD=3.52u rfmode=0
M$2245 VSS VDD \$2162 VSS sg13_lv_nmos L=0.13u W=0.42u AS=0.1701p AD=0.03885p
+ PS=1.65u PD=0.605u rfmode=0
M$2246 \$2162 \$2064 \$2093 VSS sg13_lv_nmos L=0.13u W=0.42u AS=0.03885p
+ AD=0.1596p PS=0.605u PD=1.6u rfmode=0
M$2247 \$2092 \$2065 \$2202 VSS sg13_lv_nmos L=0.13u W=0.42u AS=0.1296p
+ AD=0.081p PS=1.52u PD=0.81u rfmode=0
M$2248 \$2202 \$2216 \$2093 VSS sg13_lv_nmos L=0.13u W=0.42u AS=0.081p
+ AD=0.2163p PS=0.81u PD=1.87u rfmode=0
M$2249 VSS \$2065 \$2216 VSS sg13_lv_nmos L=0.13u W=0.74u AS=0.43315p
+ AD=0.2516p PS=2.205u PD=2.16u rfmode=0
M$2250 VSS CLK \$2065 VSS sg13_lv_nmos L=0.13u W=0.74u AS=0.43315p AD=0.2516p
+ PS=2.205u PD=2.16u rfmode=0
M$2251 \$2095 \$2065 \$2094 VSS sg13_lv_nmos L=0.13u W=0.42u AS=0.12665p
+ AD=0.1428p PS=1.145u PD=1.52u rfmode=0
M$2252 \$2064 \$2216 \$2095 VSS sg13_lv_nmos L=0.13u W=0.74u AS=0.3473p
+ AD=0.12665p PS=2.71u PD=1.145u rfmode=0
M$2253 VSS VSS \$2217 VSS sg13_lv_nmos L=0.13u W=1u AS=0.265p AD=0.265p
+ PS=2.56u PD=2.56u rfmode=0
M$2254 \$2217 \$2096 OUTP VSS sg13_lv_nmos L=0.13u W=2u AS=0.38p AD=0.38p
+ PS=3.52u PD=3.52u rfmode=0
M$2256 \$2217 \$2098 OUTN VSS sg13_lv_nmos L=0.13u W=2u AS=0.38p AD=0.38p
+ PS=3.52u PD=3.52u rfmode=0
M$2263 VSS VDD \$2174 VSS sg13_lv_nmos L=0.13u W=0.42u AS=0.1701p AD=0.03885p
+ PS=1.65u PD=0.605u rfmode=0
M$2264 \$2174 \$2068 \$2103 VSS sg13_lv_nmos L=0.13u W=0.42u AS=0.03885p
+ AD=0.1596p PS=0.605u PD=1.6u rfmode=0
M$2265 \$2102 \$2069 \$2204 VSS sg13_lv_nmos L=0.13u W=0.42u AS=0.1296p
+ AD=0.081p PS=1.52u PD=0.81u rfmode=0
M$2266 \$2204 \$2218 \$2103 VSS sg13_lv_nmos L=0.13u W=0.42u AS=0.081p
+ AD=0.2163p PS=0.81u PD=1.87u rfmode=0
M$2267 VSS \$2069 \$2218 VSS sg13_lv_nmos L=0.13u W=0.74u AS=0.43315p
+ AD=0.2516p PS=2.205u PD=2.16u rfmode=0
M$2268 VSS CLK \$2069 VSS sg13_lv_nmos L=0.13u W=0.74u AS=0.43315p AD=0.2516p
+ PS=2.205u PD=2.16u rfmode=0
M$2269 \$2105 \$2069 \$2104 VSS sg13_lv_nmos L=0.13u W=0.42u AS=0.12665p
+ AD=0.1428p PS=1.145u PD=1.52u rfmode=0
M$2270 \$2068 \$2218 \$2105 VSS sg13_lv_nmos L=0.13u W=0.74u AS=0.3473p
+ AD=0.12665p PS=2.71u PD=1.145u rfmode=0
M$2271 VSS VSS \$2219 VSS sg13_lv_nmos L=0.13u W=1u AS=0.265p AD=0.265p
+ PS=2.56u PD=2.56u rfmode=0
M$2272 \$2219 \$2106 OUTP VSS sg13_lv_nmos L=0.13u W=2u AS=0.38p AD=0.38p
+ PS=3.52u PD=3.52u rfmode=0
M$2274 \$2219 \$2108 OUTN VSS sg13_lv_nmos L=0.13u W=2u AS=0.38p AD=0.38p
+ PS=3.52u PD=3.52u rfmode=0
M$2281 VSS VDD \$2185 VSS sg13_lv_nmos L=0.13u W=0.42u AS=0.1701p AD=0.03885p
+ PS=1.65u PD=0.605u rfmode=0
M$2282 \$2185 \$2072 \$2113 VSS sg13_lv_nmos L=0.13u W=0.42u AS=0.03885p
+ AD=0.1596p PS=0.605u PD=1.6u rfmode=0
M$2283 \$2112 \$2073 \$2206 VSS sg13_lv_nmos L=0.13u W=0.42u AS=0.1296p
+ AD=0.081p PS=1.52u PD=0.81u rfmode=0
M$2284 \$2206 \$2220 \$2113 VSS sg13_lv_nmos L=0.13u W=0.42u AS=0.081p
+ AD=0.2163p PS=0.81u PD=1.87u rfmode=0
M$2285 VSS \$2073 \$2220 VSS sg13_lv_nmos L=0.13u W=0.74u AS=0.43315p
+ AD=0.2516p PS=2.205u PD=2.16u rfmode=0
M$2286 VSS CLK \$2073 VSS sg13_lv_nmos L=0.13u W=0.74u AS=0.43315p AD=0.2516p
+ PS=2.205u PD=2.16u rfmode=0
M$2287 \$2115 \$2073 \$2114 VSS sg13_lv_nmos L=0.13u W=0.42u AS=0.12665p
+ AD=0.1428p PS=1.145u PD=1.52u rfmode=0
M$2288 \$2072 \$2220 \$2115 VSS sg13_lv_nmos L=0.13u W=0.74u AS=0.3473p
+ AD=0.12665p PS=2.71u PD=1.145u rfmode=0
M$2289 VSS VSS \$2221 VSS sg13_lv_nmos L=0.13u W=1u AS=0.265p AD=0.265p
+ PS=2.56u PD=2.56u rfmode=0
M$2290 \$2221 \$2116 OUTP VSS sg13_lv_nmos L=0.13u W=2u AS=0.38p AD=0.38p
+ PS=3.52u PD=3.52u rfmode=0
M$2292 \$2221 \$2118 OUTN VSS sg13_lv_nmos L=0.13u W=2u AS=0.38p AD=0.38p
+ PS=3.52u PD=3.52u rfmode=0
M$2299 VSS VDD \$2197 VSS sg13_lv_nmos L=0.13u W=0.42u AS=0.1701p AD=0.03885p
+ PS=1.65u PD=0.605u rfmode=0
M$2300 \$2197 \$2076 \$2123 VSS sg13_lv_nmos L=0.13u W=0.42u AS=0.03885p
+ AD=0.1596p PS=0.605u PD=1.6u rfmode=0
M$2301 \$2122 \$2077 \$2208 VSS sg13_lv_nmos L=0.13u W=0.42u AS=0.1296p
+ AD=0.081p PS=1.52u PD=0.81u rfmode=0
M$2302 \$2208 \$2222 \$2123 VSS sg13_lv_nmos L=0.13u W=0.42u AS=0.081p
+ AD=0.2163p PS=0.81u PD=1.87u rfmode=0
M$2303 VSS \$2077 \$2222 VSS sg13_lv_nmos L=0.13u W=0.74u AS=0.43315p
+ AD=0.2516p PS=2.205u PD=2.16u rfmode=0
M$2304 VSS CLK \$2077 VSS sg13_lv_nmos L=0.13u W=0.74u AS=0.43315p AD=0.2516p
+ PS=2.205u PD=2.16u rfmode=0
M$2305 \$2125 \$2077 \$2124 VSS sg13_lv_nmos L=0.13u W=0.42u AS=0.12665p
+ AD=0.1428p PS=1.145u PD=1.52u rfmode=0
M$2306 \$2076 \$2222 \$2125 VSS sg13_lv_nmos L=0.13u W=0.74u AS=0.3473p
+ AD=0.12665p PS=2.71u PD=1.145u rfmode=0
M$2307 VSS VSS \$2223 VSS sg13_lv_nmos L=0.13u W=1u AS=0.265p AD=0.265p
+ PS=2.56u PD=2.56u rfmode=0
M$2308 \$2223 \$2126 OUTP VSS sg13_lv_nmos L=0.13u W=2u AS=0.38p AD=0.38p
+ PS=3.52u PD=3.52u rfmode=0
M$2310 \$2223 \$2128 OUTN VSS sg13_lv_nmos L=0.13u W=2u AS=0.38p AD=0.38p
+ PS=3.52u PD=3.52u rfmode=0
M$2317 VSS VDD \$2194 VSS sg13_lv_nmos L=0.13u W=0.42u AS=0.1701p AD=0.03885p
+ PS=1.65u PD=0.605u rfmode=0
M$2318 \$2194 \$2080 \$2133 VSS sg13_lv_nmos L=0.13u W=0.42u AS=0.03885p
+ AD=0.1596p PS=0.605u PD=1.6u rfmode=0
M$2319 \$2132 \$2081 \$2210 VSS sg13_lv_nmos L=0.13u W=0.42u AS=0.1296p
+ AD=0.081p PS=1.52u PD=0.81u rfmode=0
M$2320 \$2210 \$2224 \$2133 VSS sg13_lv_nmos L=0.13u W=0.42u AS=0.081p
+ AD=0.2163p PS=0.81u PD=1.87u rfmode=0
M$2321 VSS \$2081 \$2224 VSS sg13_lv_nmos L=0.13u W=0.74u AS=0.43315p
+ AD=0.2516p PS=2.205u PD=2.16u rfmode=0
M$2322 VSS CLK \$2081 VSS sg13_lv_nmos L=0.13u W=0.74u AS=0.43315p AD=0.2516p
+ PS=2.205u PD=2.16u rfmode=0
M$2323 \$2135 \$2081 \$2134 VSS sg13_lv_nmos L=0.13u W=0.42u AS=0.12665p
+ AD=0.1428p PS=1.145u PD=1.52u rfmode=0
M$2324 \$2080 \$2224 \$2135 VSS sg13_lv_nmos L=0.13u W=0.74u AS=0.3473p
+ AD=0.12665p PS=2.71u PD=1.145u rfmode=0
M$2325 VSS VSS \$2225 VSS sg13_lv_nmos L=0.13u W=1u AS=0.265p AD=0.265p
+ PS=2.56u PD=2.56u rfmode=0
M$2326 \$2225 \$2136 OUTP VSS sg13_lv_nmos L=0.13u W=2u AS=0.38p AD=0.38p
+ PS=3.52u PD=3.52u rfmode=0
M$2328 \$2225 \$2138 OUTN VSS sg13_lv_nmos L=0.13u W=2u AS=0.38p AD=0.38p
+ PS=3.52u PD=3.52u rfmode=0
M$2335 VSS VDD \$2181 VSS sg13_lv_nmos L=0.13u W=0.42u AS=0.1701p AD=0.03885p
+ PS=1.65u PD=0.605u rfmode=0
M$2336 \$2181 \$2084 \$2143 VSS sg13_lv_nmos L=0.13u W=0.42u AS=0.03885p
+ AD=0.1596p PS=0.605u PD=1.6u rfmode=0
M$2337 \$2142 \$2085 \$2212 VSS sg13_lv_nmos L=0.13u W=0.42u AS=0.1296p
+ AD=0.081p PS=1.52u PD=0.81u rfmode=0
M$2338 \$2212 \$2226 \$2143 VSS sg13_lv_nmos L=0.13u W=0.42u AS=0.081p
+ AD=0.2163p PS=0.81u PD=1.87u rfmode=0
M$2339 VSS \$2085 \$2226 VSS sg13_lv_nmos L=0.13u W=0.74u AS=0.43315p
+ AD=0.2516p PS=2.205u PD=2.16u rfmode=0
M$2340 VSS CLK \$2085 VSS sg13_lv_nmos L=0.13u W=0.74u AS=0.43315p AD=0.2516p
+ PS=2.205u PD=2.16u rfmode=0
M$2341 \$2145 \$2085 \$2144 VSS sg13_lv_nmos L=0.13u W=0.42u AS=0.12665p
+ AD=0.1428p PS=1.145u PD=1.52u rfmode=0
M$2342 \$2084 \$2226 \$2145 VSS sg13_lv_nmos L=0.13u W=0.74u AS=0.3473p
+ AD=0.12665p PS=2.71u PD=1.145u rfmode=0
M$2343 VSS VSS \$2227 VSS sg13_lv_nmos L=0.13u W=1u AS=0.265p AD=0.265p
+ PS=2.56u PD=2.56u rfmode=0
M$2344 \$2227 \$2146 OUTP VSS sg13_lv_nmos L=0.13u W=2u AS=0.38p AD=0.38p
+ PS=3.52u PD=3.52u rfmode=0
M$2346 \$2227 \$2148 OUTN VSS sg13_lv_nmos L=0.13u W=2u AS=0.38p AD=0.38p
+ PS=3.52u PD=3.52u rfmode=0
M$2353 VSS VDD \$2169 VSS sg13_lv_nmos L=0.13u W=0.42u AS=0.1701p AD=0.03885p
+ PS=1.65u PD=0.605u rfmode=0
M$2354 \$2169 \$2088 \$2153 VSS sg13_lv_nmos L=0.13u W=0.42u AS=0.03885p
+ AD=0.1596p PS=0.605u PD=1.6u rfmode=0
M$2355 \$2152 \$2089 \$2214 VSS sg13_lv_nmos L=0.13u W=0.42u AS=0.1296p
+ AD=0.081p PS=1.52u PD=0.81u rfmode=0
M$2356 \$2214 \$2228 \$2153 VSS sg13_lv_nmos L=0.13u W=0.42u AS=0.081p
+ AD=0.2163p PS=0.81u PD=1.87u rfmode=0
M$2357 VSS \$2089 \$2228 VSS sg13_lv_nmos L=0.13u W=0.74u AS=0.43315p
+ AD=0.2516p PS=2.205u PD=2.16u rfmode=0
M$2358 VSS CLK \$2089 VSS sg13_lv_nmos L=0.13u W=0.74u AS=0.43315p AD=0.2516p
+ PS=2.205u PD=2.16u rfmode=0
M$2359 \$2155 \$2089 \$2154 VSS sg13_lv_nmos L=0.13u W=0.42u AS=0.12665p
+ AD=0.1428p PS=1.145u PD=1.52u rfmode=0
M$2360 \$2088 \$2228 \$2155 VSS sg13_lv_nmos L=0.13u W=0.74u AS=0.3473p
+ AD=0.12665p PS=2.71u PD=1.145u rfmode=0
M$2361 VSS VSS \$2229 VSS sg13_lv_nmos L=0.13u W=1u AS=0.265p AD=0.265p
+ PS=2.56u PD=2.56u rfmode=0
M$2362 \$2229 \$2156 OUTP VSS sg13_lv_nmos L=0.13u W=2u AS=0.38p AD=0.38p
+ PS=3.52u PD=3.52u rfmode=0
M$2364 \$2229 \$2158 OUTN VSS sg13_lv_nmos L=0.13u W=2u AS=0.38p AD=0.38p
+ PS=3.52u PD=3.52u rfmode=0
M$2371 VSS \$2366 \$193 VSS sg13_lv_nmos L=0.13u W=1.48u AS=0.4477p
+ AD=0.312925p PS=3.43u PD=2.345u rfmode=0
M$2373 VSS \$2355 \$2366 VSS sg13_lv_nmos L=0.13u W=0.55u AS=0.146425p
+ AD=0.1045p PS=1.155u PD=0.93u rfmode=0
M$2374 \$2366 X7 VSS VSS sg13_lv_nmos L=0.13u W=0.55u AS=0.1045p AD=0.187p
+ PS=0.93u PD=1.78u rfmode=0
M$2375 VSS \$2367 \$199 VSS sg13_lv_nmos L=0.13u W=1.48u AS=0.4218p AD=0.2737p
+ PS=3.36u PD=2.24u rfmode=0
M$2377 VSS \$2382 \$2372 VSS sg13_lv_nmos L=0.13u W=0.64u AS=0.1331p AD=0.1216p
+ PS=1.12u PD=1.02u rfmode=0
M$2378 \$2372 X7 \$2367 VSS sg13_lv_nmos L=0.13u W=0.64u AS=0.1216p AD=0.2176p
+ PS=1.02u PD=1.96u rfmode=0
M$2379 VSS \$2356 \$187 VSS sg13_lv_nmos L=0.13u W=1.48u AS=0.4477p
+ AD=0.312925p PS=3.43u PD=2.345u rfmode=0
M$2381 VSS \$190 \$2356 VSS sg13_lv_nmos L=0.13u W=0.55u AS=0.146425p
+ AD=0.1045p PS=1.155u PD=0.93u rfmode=0
M$2382 \$2356 X5 VSS VSS sg13_lv_nmos L=0.13u W=0.55u AS=0.1045p AD=0.187p
+ PS=0.93u PD=1.78u rfmode=0
M$2383 VSS \$2357 \$205 VSS sg13_lv_nmos L=0.13u W=1.48u AS=0.4218p AD=0.2737p
+ PS=3.36u PD=2.24u rfmode=0
M$2385 VSS \$2383 \$2377 VSS sg13_lv_nmos L=0.13u W=0.64u AS=0.1331p AD=0.1216p
+ PS=1.12u PD=1.02u rfmode=0
M$2386 \$2377 X7 \$2357 VSS sg13_lv_nmos L=0.13u W=0.64u AS=0.1216p AD=0.2176p
+ PS=1.02u PD=1.96u rfmode=0
M$2387 \$2348 X3 \$2364 VSS sg13_lv_nmos L=0.13u W=0.42u AS=0.1428p AD=0.0609p
+ PS=1.52u PD=0.71u rfmode=0
M$2388 \$2364 VDD VSS VSS sg13_lv_nmos L=0.13u W=0.42u AS=0.0609p AD=0.1626p
+ PS=0.71u PD=1.415u rfmode=0
M$2389 VSS \$2368 \$2346 VSS sg13_lv_nmos L=0.13u W=0.74u AS=0.1626p AD=0.2516p
+ PS=1.415u PD=2.16u rfmode=0
M$2390 VSS \$2325 \$2326 VSS sg13_lv_nmos L=0.13u W=0.74u AS=0.1626p AD=0.2516p
+ PS=1.415u PD=2.16u rfmode=0
M$2391 \$2324 X4 \$2343 VSS sg13_lv_nmos L=0.13u W=0.42u AS=0.1428p AD=0.0609p
+ PS=1.52u PD=0.71u rfmode=0
M$2392 VSS VDD \$2343 VSS sg13_lv_nmos L=0.13u W=0.42u AS=0.1626p AD=0.0609p
+ PS=1.415u PD=0.71u rfmode=0
M$2393 VSS VDD \$2344 VSS sg13_lv_nmos L=0.13u W=0.42u AS=0.1701p AD=0.03885p
+ PS=1.65u PD=0.605u rfmode=0
M$2394 \$2344 \$2326 \$2328 VSS sg13_lv_nmos L=0.13u W=0.42u AS=0.03885p
+ AD=0.1596p PS=0.605u PD=1.6u rfmode=0
M$2395 VSS VDD \$2365 VSS sg13_lv_nmos L=0.13u W=0.42u AS=0.1701p AD=0.03885p
+ PS=1.65u PD=0.605u rfmode=0
M$2396 \$2365 \$2346 \$2349 VSS sg13_lv_nmos L=0.13u W=0.42u AS=0.03885p
+ AD=0.1596p PS=0.605u PD=1.6u rfmode=0
M$2397 \$2325 \$2329 \$2324 VSS sg13_lv_nmos L=0.13u W=0.42u AS=0.081p
+ AD=0.1296p PS=0.81u PD=1.52u rfmode=0
M$2398 \$2325 \$2327 \$2328 VSS sg13_lv_nmos L=0.13u W=0.42u AS=0.081p
+ AD=0.2163p PS=0.81u PD=1.87u rfmode=0
M$2399 \$2327 \$2329 VSS VSS sg13_lv_nmos L=0.13u W=0.74u AS=0.2516p
+ AD=0.43315p PS=2.16u PD=2.205u rfmode=0
M$2400 VSS CLK \$2329 VSS sg13_lv_nmos L=0.13u W=0.74u AS=0.43315p AD=0.2516p
+ PS=2.205u PD=2.16u rfmode=0
M$2401 VSS \$2347 \$2378 VSS sg13_lv_nmos L=0.13u W=0.74u AS=0.43315p
+ AD=0.2516p PS=2.205u PD=2.16u rfmode=0
M$2402 VSS CLK \$2347 VSS sg13_lv_nmos L=0.13u W=0.74u AS=0.43315p AD=0.2516p
+ PS=2.205u PD=2.16u rfmode=0
M$2403 \$2339 \$2329 \$2330 VSS sg13_lv_nmos L=0.13u W=0.42u AS=0.1428p
+ AD=0.12665p PS=1.52u PD=1.145u rfmode=0
M$2404 \$2330 \$2327 \$2326 VSS sg13_lv_nmos L=0.13u W=0.74u AS=0.12665p
+ AD=0.3473p PS=1.145u PD=2.71u rfmode=0
M$2405 \$2359 \$2347 \$2350 VSS sg13_lv_nmos L=0.13u W=0.42u AS=0.12665p
+ AD=0.1428p PS=1.145u PD=1.52u rfmode=0
M$2406 \$2346 \$2378 \$2359 VSS sg13_lv_nmos L=0.13u W=0.74u AS=0.3473p
+ AD=0.12665p PS=2.71u PD=1.145u rfmode=0
M$2407 \$2339 \$2331 VSS VSS sg13_lv_nmos L=0.13u W=0.42u AS=0.1428p AD=0.0798p
+ PS=1.52u PD=0.8u rfmode=0
M$2408 VSS VDD \$2345 VSS sg13_lv_nmos L=0.13u W=0.42u AS=0.0798p AD=0.0378p
+ PS=0.8u PD=0.6u rfmode=0
M$2409 \$2345 \$2330 \$2331 VSS sg13_lv_nmos L=0.13u W=0.42u AS=0.0378p
+ AD=0.1428p PS=0.6u PD=1.52u rfmode=0
M$2410 \$2350 \$2369 VSS VSS sg13_lv_nmos L=0.13u W=0.42u AS=0.1428p AD=0.0798p
+ PS=1.52u PD=0.8u rfmode=0
M$2411 VSS VDD \$2363 VSS sg13_lv_nmos L=0.13u W=0.42u AS=0.0798p AD=0.0378p
+ PS=0.8u PD=0.6u rfmode=0
M$2412 \$2363 \$2359 \$2369 VSS sg13_lv_nmos L=0.13u W=0.42u AS=0.0378p
+ AD=0.1428p PS=0.6u PD=1.52u rfmode=0
M$2413 VSS \$2330 \$2314 VSS sg13_lv_nmos L=0.13u W=1.48u AS=0.3922p AD=0.2737p
+ PS=3.28u PD=2.24u rfmode=0
M$2415 VSS \$2330 \$2332 VSS sg13_lv_nmos L=0.13u W=0.64u AS=0.1331p AD=0.2176p
+ PS=1.12u PD=1.96u rfmode=0
M$2416 VSS \$2359 \$2352 VSS sg13_lv_nmos L=0.13u W=0.64u AS=0.1331p AD=0.2176p
+ PS=1.12u PD=1.96u rfmode=0
M$2417 VSS \$2359 \$2351 VSS sg13_lv_nmos L=0.13u W=1.48u AS=0.3922p AD=0.2737p
+ PS=3.28u PD=2.24u rfmode=0
M$2419 VSS \$2332 \$2322 VSS sg13_lv_nmos L=0.13u W=1.48u AS=0.3922p AD=0.3922p
+ PS=3.28u PD=3.28u rfmode=0
M$2421 VSS \$2352 \$2353 VSS sg13_lv_nmos L=0.13u W=1.48u AS=0.3922p AD=0.3922p
+ PS=3.28u PD=3.28u rfmode=0
M$2423 VSS VSS \$2315 VSS sg13_lv_nmos L=0.13u W=1u AS=0.265p AD=0.265p
+ PS=2.56u PD=2.56u rfmode=0
M$2424 \$2315 \$2314 OUTN VSS sg13_lv_nmos L=0.13u W=2u AS=0.38p AD=0.38p
+ PS=3.52u PD=3.52u rfmode=0
M$2426 \$2315 \$2322 OUTP VSS sg13_lv_nmos L=0.13u W=2u AS=0.38p AD=0.38p
+ PS=3.52u PD=3.52u rfmode=0
M$2433 VSS \$2384 \$2355 VSS sg13_lv_nmos L=0.13u W=1.48u AS=0.4218p AD=0.2737p
+ PS=3.36u PD=2.24u rfmode=0
M$2435 VSS X6 \$2394 VSS sg13_lv_nmos L=0.13u W=0.64u AS=0.1331p AD=0.1216p
+ PS=1.12u PD=1.02u rfmode=0
M$2436 \$2394 X5 \$2384 VSS sg13_lv_nmos L=0.13u W=0.64u AS=0.1216p AD=0.2176p
+ PS=1.02u PD=1.96u rfmode=0
M$2437 VSS \$2389 \$2382 VSS sg13_lv_nmos L=0.13u W=1.48u AS=0.4477p
+ AD=0.312925p PS=3.43u PD=2.345u rfmode=0
M$2439 VSS X5 \$2389 VSS sg13_lv_nmos L=0.13u W=0.55u AS=0.146425p AD=0.1045p
+ PS=1.155u PD=0.93u rfmode=0
M$2440 \$2389 X6 VSS VSS sg13_lv_nmos L=0.13u W=0.55u AS=0.1045p AD=0.187p
+ PS=0.93u PD=1.78u rfmode=0
M$2441 VSS \$2390 \$190 VSS sg13_lv_nmos L=0.13u W=1.48u AS=0.4477p
+ AD=0.312925p PS=3.43u PD=2.345u rfmode=0
M$2443 VSS X7 \$2390 VSS sg13_lv_nmos L=0.13u W=0.55u AS=0.146425p AD=0.1045p
+ PS=1.155u PD=0.93u rfmode=0
M$2444 \$2390 X6 VSS VSS sg13_lv_nmos L=0.13u W=0.55u AS=0.1045p AD=0.187p
+ PS=0.93u PD=1.78u rfmode=0
M$2445 VSS \$2391 \$202 VSS sg13_lv_nmos L=0.13u W=1.48u AS=0.4218p AD=0.2737p
+ PS=3.36u PD=2.24u rfmode=0
M$2447 VSS X7 \$2401 VSS sg13_lv_nmos L=0.13u W=0.64u AS=0.1331p AD=0.1216p
+ PS=1.12u PD=1.02u rfmode=0
M$2448 \$2401 X6 \$2391 VSS sg13_lv_nmos L=0.13u W=0.64u AS=0.1216p AD=0.2176p
+ PS=1.02u PD=1.96u rfmode=0
M$2449 VSS \$2385 \$2383 VSS sg13_lv_nmos L=0.13u W=1.48u AS=0.4218p AD=0.2737p
+ PS=3.36u PD=2.24u rfmode=0
M$2451 VSS X6 \$2402 VSS sg13_lv_nmos L=0.13u W=0.64u AS=0.1331p AD=0.1216p
+ PS=1.12u PD=1.02u rfmode=0
M$2452 \$2402 X5 \$2385 VSS sg13_lv_nmos L=0.13u W=0.64u AS=0.1216p AD=0.2176p
+ PS=1.02u PD=1.96u rfmode=0
M$2453 \$2348 \$2347 \$2368 VSS sg13_lv_nmos L=0.13u W=0.42u AS=0.1296p
+ AD=0.081p PS=1.52u PD=0.81u rfmode=0
M$2454 \$2368 \$2378 \$2349 VSS sg13_lv_nmos L=0.13u W=0.42u AS=0.081p
+ AD=0.2163p PS=0.81u PD=1.87u rfmode=0
M$2455 VSS \$2381 \$196 VSS sg13_lv_nmos L=0.13u W=1.48u AS=0.3922p AD=0.2777p
+ PS=3.28u PD=2.24u rfmode=0
M$2457 VSS X7 \$2381 VSS sg13_lv_nmos L=0.13u W=0.64u AS=0.1371p AD=0.2176p
+ PS=1.12u PD=1.96u rfmode=0
M$2458 VSS VSS \$2370 VSS sg13_lv_nmos L=0.13u W=1u AS=0.265p AD=0.265p
+ PS=2.56u PD=2.56u rfmode=0
M$2459 \$2370 \$2351 OUTN VSS sg13_lv_nmos L=0.13u W=2u AS=0.38p AD=0.38p
+ PS=3.52u PD=3.52u rfmode=0
M$2461 \$2370 \$2353 OUTP VSS sg13_lv_nmos L=0.13u W=2u AS=0.38p AD=0.38p
+ PS=3.52u PD=3.52u rfmode=0
M$2468 VSS VSS \$2404 VSS sg13_lv_nmos L=0.13u W=1u AS=0.265p AD=0.265p
+ PS=2.56u PD=2.56u rfmode=0
M$2469 \$2404 \$2403 OUTN VSS sg13_lv_nmos L=0.13u W=2u AS=0.38p AD=0.38p
+ PS=3.52u PD=3.52u rfmode=0
M$2471 \$2404 \$2418 OUTP VSS sg13_lv_nmos L=0.13u W=2u AS=0.38p AD=0.38p
+ PS=3.52u PD=3.52u rfmode=0
M$2478 \$2413 \$2422 \$2411 VSS sg13_lv_nmos L=0.13u W=0.42u AS=0.081p
+ AD=0.1296p PS=0.81u PD=1.52u rfmode=0
M$2479 \$2413 \$2414 \$2421 VSS sg13_lv_nmos L=0.13u W=0.42u AS=0.081p
+ AD=0.2163p PS=0.81u PD=1.87u rfmode=0
M$2480 \$2414 \$2422 VSS VSS sg13_lv_nmos L=0.13u W=0.74u AS=0.2516p
+ AD=0.43315p PS=2.16u PD=2.205u rfmode=0
M$2481 VSS CLK \$2422 VSS sg13_lv_nmos L=0.13u W=0.74u AS=0.43315p AD=0.2516p
+ PS=2.205u PD=2.16u rfmode=0
M$2482 \$2428 \$2422 \$2415 VSS sg13_lv_nmos L=0.13u W=0.42u AS=0.1428p
+ AD=0.12665p PS=1.52u PD=1.145u rfmode=0
M$2483 \$2415 \$2414 \$2412 VSS sg13_lv_nmos L=0.13u W=0.74u AS=0.12665p
+ AD=0.3473p PS=1.145u PD=2.71u rfmode=0
M$2484 VSS VDD \$2432 VSS sg13_lv_nmos L=0.13u W=0.42u AS=0.1701p AD=0.03885p
+ PS=1.65u PD=0.605u rfmode=0
M$2485 \$2432 \$2412 \$2421 VSS sg13_lv_nmos L=0.13u W=0.42u AS=0.03885p
+ AD=0.1596p PS=0.605u PD=1.6u rfmode=0
M$2486 VSS \$2415 \$2403 VSS sg13_lv_nmos L=0.13u W=1.48u AS=0.3922p AD=0.2737p
+ PS=3.28u PD=2.24u rfmode=0
M$2488 VSS \$2415 \$2417 VSS sg13_lv_nmos L=0.13u W=0.64u AS=0.1331p AD=0.2176p
+ PS=1.12u PD=1.96u rfmode=0
M$2489 VSS \$2417 \$2418 VSS sg13_lv_nmos L=0.13u W=1.48u AS=0.3922p AD=0.3922p
+ PS=3.28u PD=3.28u rfmode=0
M$2491 \$2440 X1 \$2449 VSS sg13_lv_nmos L=0.13u W=0.42u AS=0.1428p AD=0.0609p
+ PS=1.52u PD=0.71u rfmode=0
M$2492 \$2449 VDD VSS VSS sg13_lv_nmos L=0.13u W=0.42u AS=0.0609p AD=0.1626p
+ PS=0.71u PD=1.415u rfmode=0
M$2493 VSS \$2452 \$2435 VSS sg13_lv_nmos L=0.13u W=0.74u AS=0.1626p AD=0.2516p
+ PS=1.415u PD=2.16u rfmode=0
M$2494 VSS \$2413 \$2412 VSS sg13_lv_nmos L=0.13u W=0.74u AS=0.1626p AD=0.2516p
+ PS=1.415u PD=2.16u rfmode=0
M$2495 \$2411 X2 \$2431 VSS sg13_lv_nmos L=0.13u W=0.42u AS=0.1428p AD=0.0609p
+ PS=1.52u PD=0.71u rfmode=0
M$2496 VSS VDD \$2431 VSS sg13_lv_nmos L=0.13u W=0.42u AS=0.1626p AD=0.0609p
+ PS=1.415u PD=0.71u rfmode=0
M$2497 \$2428 \$2416 VSS VSS sg13_lv_nmos L=0.13u W=0.42u AS=0.1428p AD=0.0798p
+ PS=1.52u PD=0.8u rfmode=0
M$2498 VSS VDD \$2434 VSS sg13_lv_nmos L=0.13u W=0.42u AS=0.0798p AD=0.0378p
+ PS=0.8u PD=0.6u rfmode=0
M$2499 \$2434 \$2415 \$2416 VSS sg13_lv_nmos L=0.13u W=0.42u AS=0.0378p
+ AD=0.1428p PS=0.6u PD=1.52u rfmode=0
M$2500 \$2443 \$2454 VSS VSS sg13_lv_nmos L=0.13u W=0.42u AS=0.1428p AD=0.0798p
+ PS=1.52u PD=0.8u rfmode=0
M$2501 VSS VDD \$2451 VSS sg13_lv_nmos L=0.13u W=0.42u AS=0.0798p AD=0.0378p
+ PS=0.8u PD=0.6u rfmode=0
M$2502 \$2451 \$2444 \$2454 VSS sg13_lv_nmos L=0.13u W=0.42u AS=0.0378p
+ AD=0.1428p PS=0.6u PD=1.52u rfmode=0
M$2503 VSS \$2444 \$2438 VSS sg13_lv_nmos L=0.13u W=0.64u AS=0.1331p AD=0.2176p
+ PS=1.12u PD=1.96u rfmode=0
M$2504 VSS \$2444 \$2437 VSS sg13_lv_nmos L=0.13u W=1.48u AS=0.3922p AD=0.2737p
+ PS=3.28u PD=2.24u rfmode=0
M$2506 VSS \$2438 \$2439 VSS sg13_lv_nmos L=0.13u W=1.48u AS=0.3922p AD=0.3922p
+ PS=3.28u PD=3.28u rfmode=0
M$2508 VSS VDD \$2450 VSS sg13_lv_nmos L=0.13u W=0.42u AS=0.1701p AD=0.03885p
+ PS=1.65u PD=0.605u rfmode=0
M$2509 \$2450 \$2435 \$2442 VSS sg13_lv_nmos L=0.13u W=0.42u AS=0.03885p
+ AD=0.1596p PS=0.605u PD=1.6u rfmode=0
M$2510 \$2440 \$2436 \$2452 VSS sg13_lv_nmos L=0.13u W=0.42u AS=0.1296p
+ AD=0.081p PS=1.52u PD=0.81u rfmode=0
M$2511 \$2452 \$2453 \$2442 VSS sg13_lv_nmos L=0.13u W=0.42u AS=0.081p
+ AD=0.2163p PS=0.81u PD=1.87u rfmode=0
M$2512 VSS \$2436 \$2453 VSS sg13_lv_nmos L=0.13u W=0.74u AS=0.43315p
+ AD=0.2516p PS=2.205u PD=2.16u rfmode=0
M$2513 VSS CLK \$2436 VSS sg13_lv_nmos L=0.13u W=0.74u AS=0.43315p AD=0.2516p
+ PS=2.205u PD=2.16u rfmode=0
M$2514 \$2444 \$2436 \$2443 VSS sg13_lv_nmos L=0.13u W=0.42u AS=0.12665p
+ AD=0.1428p PS=1.145u PD=1.52u rfmode=0
M$2515 \$2435 \$2453 \$2444 VSS sg13_lv_nmos L=0.13u W=0.74u AS=0.3473p
+ AD=0.12665p PS=2.71u PD=1.145u rfmode=0
M$2516 VSS VSS \$2455 VSS sg13_lv_nmos L=0.13u W=1u AS=0.265p AD=0.265p
+ PS=2.56u PD=2.56u rfmode=0
M$2517 \$2455 \$2437 OUTN VSS sg13_lv_nmos L=0.13u W=2u AS=0.38p AD=0.38p
+ PS=3.52u PD=3.52u rfmode=0
M$2519 \$2455 \$2439 OUTP VSS sg13_lv_nmos L=0.13u W=2u AS=0.38p AD=0.38p
+ PS=3.52u PD=3.52u rfmode=0
M$2526 VSS VSS VSS VSS sg13_hv_nmos L=0.45u W=82.2u AS=21.7605p AD=21.8055p
+ PS=190.31u PD=190.91u rfmode=0
M$2527 VSS VBIAS \$48 VSS sg13_hv_nmos L=0.45u W=5.2u AS=0.988p AD=0.988p
+ PS=8.24u PD=8.24u rfmode=0
M$2537 VSS VBIAS \$58 VSS sg13_hv_nmos L=0.45u W=5.2u AS=0.988p AD=0.988p
+ PS=8.24u PD=8.24u rfmode=0
M$2547 VSS VBIAS \$68 VSS sg13_hv_nmos L=0.45u W=5.2u AS=0.988p AD=0.988p
+ PS=8.24u PD=8.24u rfmode=0
M$2557 VSS VBIAS \$78 VSS sg13_hv_nmos L=0.45u W=5.2u AS=0.988p AD=0.988p
+ PS=8.24u PD=8.24u rfmode=0
M$2567 VSS VBIAS \$88 VSS sg13_hv_nmos L=0.45u W=5.2u AS=0.988p AD=0.988p
+ PS=8.24u PD=8.24u rfmode=0
M$2577 VSS VBIAS \$98 VSS sg13_hv_nmos L=0.45u W=5.2u AS=0.988p AD=0.988p
+ PS=8.24u PD=8.24u rfmode=0
M$2587 VSS VBIAS \$108 VSS sg13_hv_nmos L=0.45u W=5.2u AS=0.988p AD=0.988p
+ PS=8.24u PD=8.24u rfmode=0
M$2597 VSS VBIAS \$118 VSS sg13_hv_nmos L=0.45u W=5.2u AS=0.988p AD=0.988p
+ PS=8.24u PD=8.24u rfmode=0
M$2606 VSS VSS \$189 VSS sg13_hv_nmos L=0.45u W=1.3u AS=0.3445p AD=0.3445p
+ PS=3.01u PD=3.01u rfmode=0
M$2607 \$189 VBIAS \$48 VSS sg13_hv_nmos L=0.45u W=5.2u AS=0.988p AD=0.988p
+ PS=8.24u PD=8.24u rfmode=0
M$2616 VSS VSS \$192 VSS sg13_hv_nmos L=0.45u W=1.3u AS=0.3445p AD=0.3445p
+ PS=3.01u PD=3.01u rfmode=0
M$2617 \$192 VBIAS \$58 VSS sg13_hv_nmos L=0.45u W=5.2u AS=0.988p AD=0.988p
+ PS=8.24u PD=8.24u rfmode=0
M$2626 VSS VSS \$195 VSS sg13_hv_nmos L=0.45u W=1.3u AS=0.3445p AD=0.3445p
+ PS=3.01u PD=3.01u rfmode=0
M$2627 \$195 VBIAS \$68 VSS sg13_hv_nmos L=0.45u W=5.2u AS=0.988p AD=0.988p
+ PS=8.24u PD=8.24u rfmode=0
M$2636 VSS VSS \$198 VSS sg13_hv_nmos L=0.45u W=1.3u AS=0.3445p AD=0.3445p
+ PS=3.01u PD=3.01u rfmode=0
M$2637 \$198 VBIAS \$78 VSS sg13_hv_nmos L=0.45u W=5.2u AS=0.988p AD=0.988p
+ PS=8.24u PD=8.24u rfmode=0
M$2646 VSS VSS \$201 VSS sg13_hv_nmos L=0.45u W=1.3u AS=0.3445p AD=0.3445p
+ PS=3.01u PD=3.01u rfmode=0
M$2647 \$201 VBIAS \$88 VSS sg13_hv_nmos L=0.45u W=5.2u AS=0.988p AD=0.988p
+ PS=8.24u PD=8.24u rfmode=0
M$2656 VSS VSS \$204 VSS sg13_hv_nmos L=0.45u W=1.3u AS=0.3445p AD=0.3445p
+ PS=3.01u PD=3.01u rfmode=0
M$2657 \$204 VBIAS \$98 VSS sg13_hv_nmos L=0.45u W=5.2u AS=0.988p AD=0.988p
+ PS=8.24u PD=8.24u rfmode=0
M$2666 VSS VSS \$207 VSS sg13_hv_nmos L=0.45u W=1.3u AS=0.3445p AD=0.3445p
+ PS=3.01u PD=3.01u rfmode=0
M$2667 \$207 VBIAS \$108 VSS sg13_hv_nmos L=0.45u W=5.2u AS=0.988p AD=0.988p
+ PS=8.24u PD=8.24u rfmode=0
M$2676 VSS VSS \$209 VSS sg13_hv_nmos L=0.45u W=1.3u AS=0.3445p AD=0.3445p
+ PS=3.01u PD=3.01u rfmode=0
M$2677 \$209 VBIAS \$118 VSS sg13_hv_nmos L=0.45u W=5.2u AS=0.988p AD=0.988p
+ PS=8.24u PD=8.24u rfmode=0
M$2687 VSS VBIAS \$383 VSS sg13_hv_nmos L=0.45u W=5.2u AS=0.988p AD=0.988p
+ PS=8.24u PD=8.24u rfmode=0
M$2697 VSS VBIAS \$392 VSS sg13_hv_nmos L=0.45u W=5.2u AS=0.988p AD=0.988p
+ PS=8.24u PD=8.24u rfmode=0
M$2707 VSS VBIAS \$401 VSS sg13_hv_nmos L=0.45u W=5.2u AS=0.988p AD=0.988p
+ PS=8.24u PD=8.24u rfmode=0
M$2717 VSS VBIAS \$410 VSS sg13_hv_nmos L=0.45u W=5.2u AS=0.988p AD=0.988p
+ PS=8.24u PD=8.24u rfmode=0
M$2727 VSS VBIAS \$419 VSS sg13_hv_nmos L=0.45u W=5.2u AS=0.988p AD=0.988p
+ PS=8.24u PD=8.24u rfmode=0
M$2737 VSS VBIAS \$428 VSS sg13_hv_nmos L=0.45u W=5.2u AS=0.988p AD=0.988p
+ PS=8.24u PD=8.24u rfmode=0
M$2747 VSS VBIAS \$436 VSS sg13_hv_nmos L=0.45u W=5.2u AS=0.988p AD=0.988p
+ PS=8.24u PD=8.24u rfmode=0
M$2757 VSS VBIAS \$445 VSS sg13_hv_nmos L=0.45u W=5.2u AS=0.988p AD=0.988p
+ PS=8.24u PD=8.24u rfmode=0
M$2766 VSS VSS \$511 VSS sg13_hv_nmos L=0.45u W=1.3u AS=0.3445p AD=0.3445p
+ PS=3.01u PD=3.01u rfmode=0
M$2767 \$511 VBIAS \$383 VSS sg13_hv_nmos L=0.45u W=5.2u AS=0.988p AD=0.988p
+ PS=8.24u PD=8.24u rfmode=0
M$2776 VSS VSS \$512 VSS sg13_hv_nmos L=0.45u W=1.3u AS=0.3445p AD=0.3445p
+ PS=3.01u PD=3.01u rfmode=0
M$2777 \$512 VBIAS \$392 VSS sg13_hv_nmos L=0.45u W=5.2u AS=0.988p AD=0.988p
+ PS=8.24u PD=8.24u rfmode=0
M$2786 VSS VSS \$513 VSS sg13_hv_nmos L=0.45u W=1.3u AS=0.3445p AD=0.3445p
+ PS=3.01u PD=3.01u rfmode=0
M$2787 \$513 VBIAS \$401 VSS sg13_hv_nmos L=0.45u W=5.2u AS=0.988p AD=0.988p
+ PS=8.24u PD=8.24u rfmode=0
M$2796 VSS VSS \$514 VSS sg13_hv_nmos L=0.45u W=1.3u AS=0.3445p AD=0.3445p
+ PS=3.01u PD=3.01u rfmode=0
M$2797 \$514 VBIAS \$410 VSS sg13_hv_nmos L=0.45u W=5.2u AS=0.988p AD=0.988p
+ PS=8.24u PD=8.24u rfmode=0
M$2806 VSS VSS \$515 VSS sg13_hv_nmos L=0.45u W=1.3u AS=0.3445p AD=0.3445p
+ PS=3.01u PD=3.01u rfmode=0
M$2807 \$515 VBIAS \$419 VSS sg13_hv_nmos L=0.45u W=5.2u AS=0.988p AD=0.988p
+ PS=8.24u PD=8.24u rfmode=0
M$2816 VSS VSS \$516 VSS sg13_hv_nmos L=0.45u W=1.3u AS=0.3445p AD=0.3445p
+ PS=3.01u PD=3.01u rfmode=0
M$2817 \$516 VBIAS \$428 VSS sg13_hv_nmos L=0.45u W=5.2u AS=0.988p AD=0.988p
+ PS=8.24u PD=8.24u rfmode=0
M$2826 VSS VSS \$518 VSS sg13_hv_nmos L=0.45u W=1.3u AS=0.3445p AD=0.3445p
+ PS=3.01u PD=3.01u rfmode=0
M$2827 \$518 VBIAS \$436 VSS sg13_hv_nmos L=0.45u W=5.2u AS=0.988p AD=0.988p
+ PS=8.24u PD=8.24u rfmode=0
M$2836 VSS VSS \$519 VSS sg13_hv_nmos L=0.45u W=1.3u AS=0.3445p AD=0.3445p
+ PS=3.01u PD=3.01u rfmode=0
M$2837 \$519 VBIAS \$445 VSS sg13_hv_nmos L=0.45u W=5.2u AS=0.988p AD=0.988p
+ PS=8.24u PD=8.24u rfmode=0
M$2847 VSS VBIAS \$663 VSS sg13_hv_nmos L=0.45u W=5.2u AS=0.988p AD=0.988p
+ PS=8.24u PD=8.24u rfmode=0
M$2857 VSS VBIAS \$673 VSS sg13_hv_nmos L=0.45u W=5.2u AS=0.988p AD=0.988p
+ PS=8.24u PD=8.24u rfmode=0
M$2867 VSS VBIAS \$683 VSS sg13_hv_nmos L=0.45u W=5.2u AS=0.988p AD=0.988p
+ PS=8.24u PD=8.24u rfmode=0
M$2877 VSS VBIAS \$693 VSS sg13_hv_nmos L=0.45u W=5.2u AS=0.988p AD=0.988p
+ PS=8.24u PD=8.24u rfmode=0
M$2887 VSS VBIAS \$703 VSS sg13_hv_nmos L=0.45u W=5.2u AS=0.988p AD=0.988p
+ PS=8.24u PD=8.24u rfmode=0
M$2897 VSS VBIAS \$713 VSS sg13_hv_nmos L=0.45u W=5.2u AS=0.988p AD=0.988p
+ PS=8.24u PD=8.24u rfmode=0
M$2907 VSS VBIAS \$723 VSS sg13_hv_nmos L=0.45u W=5.2u AS=0.988p AD=0.988p
+ PS=8.24u PD=8.24u rfmode=0
M$2917 VSS VBIAS \$733 VSS sg13_hv_nmos L=0.45u W=5.2u AS=0.988p AD=0.988p
+ PS=8.24u PD=8.24u rfmode=0
M$2926 VSS VSS \$799 VSS sg13_hv_nmos L=0.45u W=1.3u AS=0.3445p AD=0.3445p
+ PS=3.01u PD=3.01u rfmode=0
M$2927 \$799 VBIAS \$663 VSS sg13_hv_nmos L=0.45u W=5.2u AS=0.988p AD=0.988p
+ PS=8.24u PD=8.24u rfmode=0
M$2936 VSS VSS \$801 VSS sg13_hv_nmos L=0.45u W=1.3u AS=0.3445p AD=0.3445p
+ PS=3.01u PD=3.01u rfmode=0
M$2937 \$801 VBIAS \$673 VSS sg13_hv_nmos L=0.45u W=5.2u AS=0.988p AD=0.988p
+ PS=8.24u PD=8.24u rfmode=0
M$2946 VSS VSS \$803 VSS sg13_hv_nmos L=0.45u W=1.3u AS=0.3445p AD=0.3445p
+ PS=3.01u PD=3.01u rfmode=0
M$2947 \$803 VBIAS \$683 VSS sg13_hv_nmos L=0.45u W=5.2u AS=0.988p AD=0.988p
+ PS=8.24u PD=8.24u rfmode=0
M$2956 VSS VSS \$805 VSS sg13_hv_nmos L=0.45u W=1.3u AS=0.3445p AD=0.3445p
+ PS=3.01u PD=3.01u rfmode=0
M$2957 \$805 VBIAS \$693 VSS sg13_hv_nmos L=0.45u W=5.2u AS=0.988p AD=0.988p
+ PS=8.24u PD=8.24u rfmode=0
M$2966 VSS VSS \$807 VSS sg13_hv_nmos L=0.45u W=1.3u AS=0.3445p AD=0.3445p
+ PS=3.01u PD=3.01u rfmode=0
M$2967 \$807 VBIAS \$703 VSS sg13_hv_nmos L=0.45u W=5.2u AS=0.988p AD=0.988p
+ PS=8.24u PD=8.24u rfmode=0
M$2976 VSS VSS \$809 VSS sg13_hv_nmos L=0.45u W=1.3u AS=0.3445p AD=0.3445p
+ PS=3.01u PD=3.01u rfmode=0
M$2977 \$809 VBIAS \$713 VSS sg13_hv_nmos L=0.45u W=5.2u AS=0.988p AD=0.988p
+ PS=8.24u PD=8.24u rfmode=0
M$2986 VSS VSS \$811 VSS sg13_hv_nmos L=0.45u W=1.3u AS=0.3445p AD=0.3445p
+ PS=3.01u PD=3.01u rfmode=0
M$2987 \$811 VBIAS \$723 VSS sg13_hv_nmos L=0.45u W=5.2u AS=0.988p AD=0.988p
+ PS=8.24u PD=8.24u rfmode=0
M$2996 VSS VSS \$813 VSS sg13_hv_nmos L=0.45u W=1.3u AS=0.3445p AD=0.3445p
+ PS=3.01u PD=3.01u rfmode=0
M$2997 \$813 VBIAS \$733 VSS sg13_hv_nmos L=0.45u W=5.2u AS=0.988p AD=0.988p
+ PS=8.24u PD=8.24u rfmode=0
M$3007 VSS VBIAS \$951 VSS sg13_hv_nmos L=0.45u W=5.2u AS=0.988p AD=0.988p
+ PS=8.24u PD=8.24u rfmode=0
M$3017 VSS VBIAS \$961 VSS sg13_hv_nmos L=0.45u W=5.2u AS=0.988p AD=0.988p
+ PS=8.24u PD=8.24u rfmode=0
M$3027 VSS VBIAS \$971 VSS sg13_hv_nmos L=0.45u W=5.2u AS=0.988p AD=0.988p
+ PS=8.24u PD=8.24u rfmode=0
M$3037 VSS VBIAS \$981 VSS sg13_hv_nmos L=0.45u W=5.2u AS=0.988p AD=0.988p
+ PS=8.24u PD=8.24u rfmode=0
M$3047 VSS VBIAS \$991 VSS sg13_hv_nmos L=0.45u W=5.2u AS=0.988p AD=0.988p
+ PS=8.24u PD=8.24u rfmode=0
M$3057 VSS VBIAS \$1001 VSS sg13_hv_nmos L=0.45u W=5.2u AS=0.988p AD=0.988p
+ PS=8.24u PD=8.24u rfmode=0
M$3067 VSS VBIAS \$1011 VSS sg13_hv_nmos L=0.45u W=5.2u AS=0.988p AD=0.988p
+ PS=8.24u PD=8.24u rfmode=0
M$3077 VSS VBIAS \$1021 VSS sg13_hv_nmos L=0.45u W=5.2u AS=0.988p AD=0.988p
+ PS=8.24u PD=8.24u rfmode=0
M$3086 VSS VSS \$1087 VSS sg13_hv_nmos L=0.45u W=1.3u AS=0.3445p AD=0.3445p
+ PS=3.01u PD=3.01u rfmode=0
M$3087 \$1087 VBIAS \$951 VSS sg13_hv_nmos L=0.45u W=5.2u AS=0.988p AD=0.988p
+ PS=8.24u PD=8.24u rfmode=0
M$3096 VSS VSS \$1089 VSS sg13_hv_nmos L=0.45u W=1.3u AS=0.3445p AD=0.3445p
+ PS=3.01u PD=3.01u rfmode=0
M$3097 \$1089 VBIAS \$961 VSS sg13_hv_nmos L=0.45u W=5.2u AS=0.988p AD=0.988p
+ PS=8.24u PD=8.24u rfmode=0
M$3106 VSS VSS \$1091 VSS sg13_hv_nmos L=0.45u W=1.3u AS=0.3445p AD=0.3445p
+ PS=3.01u PD=3.01u rfmode=0
M$3107 \$1091 VBIAS \$971 VSS sg13_hv_nmos L=0.45u W=5.2u AS=0.988p AD=0.988p
+ PS=8.24u PD=8.24u rfmode=0
M$3116 VSS VSS \$1093 VSS sg13_hv_nmos L=0.45u W=1.3u AS=0.3445p AD=0.3445p
+ PS=3.01u PD=3.01u rfmode=0
M$3117 \$1093 VBIAS \$981 VSS sg13_hv_nmos L=0.45u W=5.2u AS=0.988p AD=0.988p
+ PS=8.24u PD=8.24u rfmode=0
M$3126 VSS VSS \$1095 VSS sg13_hv_nmos L=0.45u W=1.3u AS=0.3445p AD=0.3445p
+ PS=3.01u PD=3.01u rfmode=0
M$3127 \$1095 VBIAS \$991 VSS sg13_hv_nmos L=0.45u W=5.2u AS=0.988p AD=0.988p
+ PS=8.24u PD=8.24u rfmode=0
M$3136 VSS VSS \$1097 VSS sg13_hv_nmos L=0.45u W=1.3u AS=0.3445p AD=0.3445p
+ PS=3.01u PD=3.01u rfmode=0
M$3137 \$1097 VBIAS \$1001 VSS sg13_hv_nmos L=0.45u W=5.2u AS=0.988p AD=0.988p
+ PS=8.24u PD=8.24u rfmode=0
M$3146 VSS VSS \$1099 VSS sg13_hv_nmos L=0.45u W=1.3u AS=0.3445p AD=0.3445p
+ PS=3.01u PD=3.01u rfmode=0
M$3147 \$1099 VBIAS \$1011 VSS sg13_hv_nmos L=0.45u W=5.2u AS=0.988p AD=0.988p
+ PS=8.24u PD=8.24u rfmode=0
M$3156 VSS VSS \$1101 VSS sg13_hv_nmos L=0.45u W=1.3u AS=0.3445p AD=0.3445p
+ PS=3.01u PD=3.01u rfmode=0
M$3157 \$1101 VBIAS \$1021 VSS sg13_hv_nmos L=0.45u W=5.2u AS=0.988p AD=0.988p
+ PS=8.24u PD=8.24u rfmode=0
M$3167 VSS VBIAS \$1239 VSS sg13_hv_nmos L=0.45u W=5.2u AS=0.988p AD=0.988p
+ PS=8.24u PD=8.24u rfmode=0
M$3177 VSS VBIAS \$1249 VSS sg13_hv_nmos L=0.45u W=5.2u AS=0.988p AD=0.988p
+ PS=8.24u PD=8.24u rfmode=0
M$3187 VSS VBIAS \$1259 VSS sg13_hv_nmos L=0.45u W=5.2u AS=0.988p AD=0.988p
+ PS=8.24u PD=8.24u rfmode=0
M$3197 VSS VBIAS \$1269 VSS sg13_hv_nmos L=0.45u W=5.2u AS=0.988p AD=0.988p
+ PS=8.24u PD=8.24u rfmode=0
M$3207 VSS VBIAS \$1279 VSS sg13_hv_nmos L=0.45u W=5.2u AS=0.988p AD=0.988p
+ PS=8.24u PD=8.24u rfmode=0
M$3217 VSS VBIAS \$1289 VSS sg13_hv_nmos L=0.45u W=5.2u AS=0.988p AD=0.988p
+ PS=8.24u PD=8.24u rfmode=0
M$3227 VSS VBIAS \$1299 VSS sg13_hv_nmos L=0.45u W=5.2u AS=0.988p AD=0.988p
+ PS=8.24u PD=8.24u rfmode=0
M$3237 VSS VBIAS \$1309 VSS sg13_hv_nmos L=0.45u W=5.2u AS=0.988p AD=0.988p
+ PS=8.24u PD=8.24u rfmode=0
M$3246 VSS VSS \$1375 VSS sg13_hv_nmos L=0.45u W=1.3u AS=0.3445p AD=0.3445p
+ PS=3.01u PD=3.01u rfmode=0
M$3247 \$1375 VBIAS \$1239 VSS sg13_hv_nmos L=0.45u W=5.2u AS=0.988p AD=0.988p
+ PS=8.24u PD=8.24u rfmode=0
M$3256 VSS VSS \$1377 VSS sg13_hv_nmos L=0.45u W=1.3u AS=0.3445p AD=0.3445p
+ PS=3.01u PD=3.01u rfmode=0
M$3257 \$1377 VBIAS \$1249 VSS sg13_hv_nmos L=0.45u W=5.2u AS=0.988p AD=0.988p
+ PS=8.24u PD=8.24u rfmode=0
M$3266 VSS VSS \$1379 VSS sg13_hv_nmos L=0.45u W=1.3u AS=0.3445p AD=0.3445p
+ PS=3.01u PD=3.01u rfmode=0
M$3267 \$1379 VBIAS \$1259 VSS sg13_hv_nmos L=0.45u W=5.2u AS=0.988p AD=0.988p
+ PS=8.24u PD=8.24u rfmode=0
M$3276 VSS VSS \$1381 VSS sg13_hv_nmos L=0.45u W=1.3u AS=0.3445p AD=0.3445p
+ PS=3.01u PD=3.01u rfmode=0
M$3277 \$1381 VBIAS \$1269 VSS sg13_hv_nmos L=0.45u W=5.2u AS=0.988p AD=0.988p
+ PS=8.24u PD=8.24u rfmode=0
M$3286 VSS VSS \$1383 VSS sg13_hv_nmos L=0.45u W=1.3u AS=0.3445p AD=0.3445p
+ PS=3.01u PD=3.01u rfmode=0
M$3287 \$1383 VBIAS \$1279 VSS sg13_hv_nmos L=0.45u W=5.2u AS=0.988p AD=0.988p
+ PS=8.24u PD=8.24u rfmode=0
M$3296 VSS VSS \$1385 VSS sg13_hv_nmos L=0.45u W=1.3u AS=0.3445p AD=0.3445p
+ PS=3.01u PD=3.01u rfmode=0
M$3297 \$1385 VBIAS \$1289 VSS sg13_hv_nmos L=0.45u W=5.2u AS=0.988p AD=0.988p
+ PS=8.24u PD=8.24u rfmode=0
M$3306 VSS VSS \$1387 VSS sg13_hv_nmos L=0.45u W=1.3u AS=0.3445p AD=0.3445p
+ PS=3.01u PD=3.01u rfmode=0
M$3307 \$1387 VBIAS \$1299 VSS sg13_hv_nmos L=0.45u W=5.2u AS=0.988p AD=0.988p
+ PS=8.24u PD=8.24u rfmode=0
M$3316 VSS VSS \$1389 VSS sg13_hv_nmos L=0.45u W=1.3u AS=0.3445p AD=0.3445p
+ PS=3.01u PD=3.01u rfmode=0
M$3317 \$1389 VBIAS \$1309 VSS sg13_hv_nmos L=0.45u W=5.2u AS=0.988p AD=0.988p
+ PS=8.24u PD=8.24u rfmode=0
M$3327 VSS VBIAS \$1527 VSS sg13_hv_nmos L=0.45u W=5.2u AS=0.988p AD=0.988p
+ PS=8.24u PD=8.24u rfmode=0
M$3337 VSS VBIAS \$1537 VSS sg13_hv_nmos L=0.45u W=5.2u AS=0.988p AD=0.988p
+ PS=8.24u PD=8.24u rfmode=0
M$3347 VSS VBIAS \$1547 VSS sg13_hv_nmos L=0.45u W=5.2u AS=0.988p AD=0.988p
+ PS=8.24u PD=8.24u rfmode=0
M$3357 VSS VBIAS \$1557 VSS sg13_hv_nmos L=0.45u W=5.2u AS=0.988p AD=0.988p
+ PS=8.24u PD=8.24u rfmode=0
M$3367 VSS VBIAS \$1567 VSS sg13_hv_nmos L=0.45u W=5.2u AS=0.988p AD=0.988p
+ PS=8.24u PD=8.24u rfmode=0
M$3377 VSS VBIAS \$1577 VSS sg13_hv_nmos L=0.45u W=5.2u AS=0.988p AD=0.988p
+ PS=8.24u PD=8.24u rfmode=0
M$3387 VSS VBIAS \$1587 VSS sg13_hv_nmos L=0.45u W=5.2u AS=0.988p AD=0.988p
+ PS=8.24u PD=8.24u rfmode=0
M$3397 VSS VBIAS \$1597 VSS sg13_hv_nmos L=0.45u W=5.2u AS=0.988p AD=0.988p
+ PS=8.24u PD=8.24u rfmode=0
M$3406 VSS VSS \$1663 VSS sg13_hv_nmos L=0.45u W=1.3u AS=0.3445p AD=0.3445p
+ PS=3.01u PD=3.01u rfmode=0
M$3407 \$1663 VBIAS \$1527 VSS sg13_hv_nmos L=0.45u W=5.2u AS=0.988p AD=0.988p
+ PS=8.24u PD=8.24u rfmode=0
M$3416 VSS VSS \$1665 VSS sg13_hv_nmos L=0.45u W=1.3u AS=0.3445p AD=0.3445p
+ PS=3.01u PD=3.01u rfmode=0
M$3417 \$1665 VBIAS \$1537 VSS sg13_hv_nmos L=0.45u W=5.2u AS=0.988p AD=0.988p
+ PS=8.24u PD=8.24u rfmode=0
M$3426 VSS VSS \$1667 VSS sg13_hv_nmos L=0.45u W=1.3u AS=0.3445p AD=0.3445p
+ PS=3.01u PD=3.01u rfmode=0
M$3427 \$1667 VBIAS \$1547 VSS sg13_hv_nmos L=0.45u W=5.2u AS=0.988p AD=0.988p
+ PS=8.24u PD=8.24u rfmode=0
M$3436 VSS VSS \$1669 VSS sg13_hv_nmos L=0.45u W=1.3u AS=0.3445p AD=0.3445p
+ PS=3.01u PD=3.01u rfmode=0
M$3437 \$1669 VBIAS \$1557 VSS sg13_hv_nmos L=0.45u W=5.2u AS=0.988p AD=0.988p
+ PS=8.24u PD=8.24u rfmode=0
M$3446 VSS VSS \$1671 VSS sg13_hv_nmos L=0.45u W=1.3u AS=0.3445p AD=0.3445p
+ PS=3.01u PD=3.01u rfmode=0
M$3447 \$1671 VBIAS \$1567 VSS sg13_hv_nmos L=0.45u W=5.2u AS=0.988p AD=0.988p
+ PS=8.24u PD=8.24u rfmode=0
M$3456 VSS VSS \$1673 VSS sg13_hv_nmos L=0.45u W=1.3u AS=0.3445p AD=0.3445p
+ PS=3.01u PD=3.01u rfmode=0
M$3457 \$1673 VBIAS \$1577 VSS sg13_hv_nmos L=0.45u W=5.2u AS=0.988p AD=0.988p
+ PS=8.24u PD=8.24u rfmode=0
M$3466 VSS VSS \$1675 VSS sg13_hv_nmos L=0.45u W=1.3u AS=0.3445p AD=0.3445p
+ PS=3.01u PD=3.01u rfmode=0
M$3467 \$1675 VBIAS \$1587 VSS sg13_hv_nmos L=0.45u W=5.2u AS=0.988p AD=0.988p
+ PS=8.24u PD=8.24u rfmode=0
M$3476 VSS VSS \$1677 VSS sg13_hv_nmos L=0.45u W=1.3u AS=0.3445p AD=0.3445p
+ PS=3.01u PD=3.01u rfmode=0
M$3477 \$1677 VBIAS \$1597 VSS sg13_hv_nmos L=0.45u W=5.2u AS=0.988p AD=0.988p
+ PS=8.24u PD=8.24u rfmode=0
M$3487 VSS VBIAS \$1815 VSS sg13_hv_nmos L=0.45u W=5.2u AS=0.988p AD=0.988p
+ PS=8.24u PD=8.24u rfmode=0
M$3497 VSS VBIAS \$1825 VSS sg13_hv_nmos L=0.45u W=5.2u AS=0.988p AD=0.988p
+ PS=8.24u PD=8.24u rfmode=0
M$3507 VSS VBIAS \$1835 VSS sg13_hv_nmos L=0.45u W=5.2u AS=0.988p AD=0.988p
+ PS=8.24u PD=8.24u rfmode=0
M$3517 VSS VBIAS \$1845 VSS sg13_hv_nmos L=0.45u W=5.2u AS=0.988p AD=0.988p
+ PS=8.24u PD=8.24u rfmode=0
M$3527 VSS VBIAS \$1855 VSS sg13_hv_nmos L=0.45u W=5.2u AS=0.988p AD=0.988p
+ PS=8.24u PD=8.24u rfmode=0
M$3537 VSS VBIAS \$1865 VSS sg13_hv_nmos L=0.45u W=5.2u AS=0.988p AD=0.988p
+ PS=8.24u PD=8.24u rfmode=0
M$3547 VSS VBIAS \$1875 VSS sg13_hv_nmos L=0.45u W=5.2u AS=0.988p AD=0.988p
+ PS=8.24u PD=8.24u rfmode=0
M$3557 VSS VBIAS \$1885 VSS sg13_hv_nmos L=0.45u W=5.2u AS=0.988p AD=0.988p
+ PS=8.24u PD=8.24u rfmode=0
M$3566 VSS VSS \$1951 VSS sg13_hv_nmos L=0.45u W=1.3u AS=0.3445p AD=0.3445p
+ PS=3.01u PD=3.01u rfmode=0
M$3567 \$1951 VBIAS \$1815 VSS sg13_hv_nmos L=0.45u W=5.2u AS=0.988p AD=0.988p
+ PS=8.24u PD=8.24u rfmode=0
M$3576 VSS VSS \$1953 VSS sg13_hv_nmos L=0.45u W=1.3u AS=0.3445p AD=0.3445p
+ PS=3.01u PD=3.01u rfmode=0
M$3577 \$1953 VBIAS \$1825 VSS sg13_hv_nmos L=0.45u W=5.2u AS=0.988p AD=0.988p
+ PS=8.24u PD=8.24u rfmode=0
M$3586 VSS VSS \$1955 VSS sg13_hv_nmos L=0.45u W=1.3u AS=0.3445p AD=0.3445p
+ PS=3.01u PD=3.01u rfmode=0
M$3587 \$1955 VBIAS \$1835 VSS sg13_hv_nmos L=0.45u W=5.2u AS=0.988p AD=0.988p
+ PS=8.24u PD=8.24u rfmode=0
M$3596 VSS VSS \$1957 VSS sg13_hv_nmos L=0.45u W=1.3u AS=0.3445p AD=0.3445p
+ PS=3.01u PD=3.01u rfmode=0
M$3597 \$1957 VBIAS \$1845 VSS sg13_hv_nmos L=0.45u W=5.2u AS=0.988p AD=0.988p
+ PS=8.24u PD=8.24u rfmode=0
M$3606 VSS VSS \$1959 VSS sg13_hv_nmos L=0.45u W=1.3u AS=0.3445p AD=0.3445p
+ PS=3.01u PD=3.01u rfmode=0
M$3607 \$1959 VBIAS \$1855 VSS sg13_hv_nmos L=0.45u W=5.2u AS=0.988p AD=0.988p
+ PS=8.24u PD=8.24u rfmode=0
M$3616 VSS VSS \$1961 VSS sg13_hv_nmos L=0.45u W=1.3u AS=0.3445p AD=0.3445p
+ PS=3.01u PD=3.01u rfmode=0
M$3617 \$1961 VBIAS \$1865 VSS sg13_hv_nmos L=0.45u W=5.2u AS=0.988p AD=0.988p
+ PS=8.24u PD=8.24u rfmode=0
M$3626 VSS VSS \$1963 VSS sg13_hv_nmos L=0.45u W=1.3u AS=0.3445p AD=0.3445p
+ PS=3.01u PD=3.01u rfmode=0
M$3627 \$1963 VBIAS \$1875 VSS sg13_hv_nmos L=0.45u W=5.2u AS=0.988p AD=0.988p
+ PS=8.24u PD=8.24u rfmode=0
M$3636 VSS VSS \$1965 VSS sg13_hv_nmos L=0.45u W=1.3u AS=0.3445p AD=0.3445p
+ PS=3.01u PD=3.01u rfmode=0
M$3637 \$1965 VBIAS \$1885 VSS sg13_hv_nmos L=0.45u W=5.2u AS=0.988p AD=0.988p
+ PS=8.24u PD=8.24u rfmode=0
M$3647 VSS VBIAS \$2099 VSS sg13_hv_nmos L=0.45u W=5.2u AS=0.988p AD=0.988p
+ PS=8.24u PD=8.24u rfmode=0
M$3657 VSS VBIAS \$2109 VSS sg13_hv_nmos L=0.45u W=5.2u AS=0.988p AD=0.988p
+ PS=8.24u PD=8.24u rfmode=0
M$3667 VSS VBIAS \$2119 VSS sg13_hv_nmos L=0.45u W=5.2u AS=0.988p AD=0.988p
+ PS=8.24u PD=8.24u rfmode=0
M$3677 VSS VBIAS \$2129 VSS sg13_hv_nmos L=0.45u W=5.2u AS=0.988p AD=0.988p
+ PS=8.24u PD=8.24u rfmode=0
M$3687 VSS VBIAS \$2139 VSS sg13_hv_nmos L=0.45u W=5.2u AS=0.988p AD=0.988p
+ PS=8.24u PD=8.24u rfmode=0
M$3697 VSS VBIAS \$2149 VSS sg13_hv_nmos L=0.45u W=5.2u AS=0.988p AD=0.988p
+ PS=8.24u PD=8.24u rfmode=0
M$3707 VSS VBIAS \$2159 VSS sg13_hv_nmos L=0.45u W=5.2u AS=0.988p AD=0.988p
+ PS=8.24u PD=8.24u rfmode=0
M$3716 VSS VSS \$2217 VSS sg13_hv_nmos L=0.45u W=1.3u AS=0.3445p AD=0.3445p
+ PS=3.01u PD=3.01u rfmode=0
M$3717 \$2217 VBIAS \$2099 VSS sg13_hv_nmos L=0.45u W=5.2u AS=0.988p AD=0.988p
+ PS=8.24u PD=8.24u rfmode=0
M$3726 VSS VSS \$2219 VSS sg13_hv_nmos L=0.45u W=1.3u AS=0.3445p AD=0.3445p
+ PS=3.01u PD=3.01u rfmode=0
M$3727 \$2219 VBIAS \$2109 VSS sg13_hv_nmos L=0.45u W=5.2u AS=0.988p AD=0.988p
+ PS=8.24u PD=8.24u rfmode=0
M$3736 VSS VSS \$2221 VSS sg13_hv_nmos L=0.45u W=1.3u AS=0.3445p AD=0.3445p
+ PS=3.01u PD=3.01u rfmode=0
M$3737 \$2221 VBIAS \$2119 VSS sg13_hv_nmos L=0.45u W=5.2u AS=0.988p AD=0.988p
+ PS=8.24u PD=8.24u rfmode=0
M$3746 VSS VSS \$2223 VSS sg13_hv_nmos L=0.45u W=1.3u AS=0.3445p AD=0.3445p
+ PS=3.01u PD=3.01u rfmode=0
M$3747 \$2223 VBIAS \$2129 VSS sg13_hv_nmos L=0.45u W=5.2u AS=0.988p AD=0.988p
+ PS=8.24u PD=8.24u rfmode=0
M$3756 VSS VSS \$2225 VSS sg13_hv_nmos L=0.45u W=1.3u AS=0.3445p AD=0.3445p
+ PS=3.01u PD=3.01u rfmode=0
M$3757 \$2225 VBIAS \$2139 VSS sg13_hv_nmos L=0.45u W=5.2u AS=0.988p AD=0.988p
+ PS=8.24u PD=8.24u rfmode=0
M$3766 VSS VSS \$2227 VSS sg13_hv_nmos L=0.45u W=1.3u AS=0.3445p AD=0.3445p
+ PS=3.01u PD=3.01u rfmode=0
M$3767 \$2227 VBIAS \$2149 VSS sg13_hv_nmos L=0.45u W=5.2u AS=0.988p AD=0.988p
+ PS=8.24u PD=8.24u rfmode=0
M$3776 VSS VSS \$2229 VSS sg13_hv_nmos L=0.45u W=1.3u AS=0.3445p AD=0.3445p
+ PS=3.01u PD=3.01u rfmode=0
M$3777 \$2229 VBIAS \$2159 VSS sg13_hv_nmos L=0.45u W=5.2u AS=0.988p AD=0.988p
+ PS=8.24u PD=8.24u rfmode=0
M$3786 VSS VSS \$2333 VSS sg13_hv_nmos L=0.45u W=2.4u AS=0.636p AD=0.636p
+ PS=5.72u PD=5.72u rfmode=0
M$3787 \$2333 VBIAS \$2315 VSS sg13_hv_nmos L=0.48u W=2.4u AS=0.456p AD=0.456p
+ PS=3.92u PD=3.92u rfmode=0
M$3792 VSS VSS \$2354 VSS sg13_hv_nmos L=0.45u W=1.2u AS=0.318p AD=0.318p
+ PS=3.92u PD=3.92u rfmode=0
M$3793 \$2354 VBIAS \$2370 VSS sg13_hv_nmos L=0.45u W=1.2u AS=0.228p AD=0.228p
+ PS=2.72u PD=2.72u rfmode=0
M$3799 \$2354 VBIAS VSS VSS sg13_hv_nmos L=0.45u W=1.2u AS=0.228p AD=0.228p
+ PS=2.72u PD=2.72u rfmode=0
M$3805 \$2333 VBIAS VSS VSS sg13_hv_nmos L=0.48u W=2.4u AS=0.456p AD=0.456p
+ PS=3.92u PD=3.92u rfmode=0
M$3810 VSS VSS \$2423 VSS sg13_hv_nmos L=0.45u W=1.2u AS=0.318p AD=0.318p
+ PS=3.92u PD=3.92u rfmode=0
M$3811 \$2423 VBIAS \$2404 VSS sg13_hv_nmos L=0.45u W=0.6u AS=0.114p AD=0.114p
+ PS=1.36u PD=1.36u rfmode=0
M$3815 \$2423 VBIAS VSS VSS sg13_hv_nmos L=0.45u W=0.6u AS=0.114p AD=0.114p
+ PS=1.36u PD=1.36u rfmode=0
M$3818 VSS VSS \$2445 VSS sg13_hv_nmos L=0.45u W=0.6u AS=0.204p AD=0.114p
+ PS=2.56u PD=1.36u rfmode=0
M$3819 \$2445 VBIAS VSS VSS sg13_hv_nmos L=0.45u W=0.3u AS=0.057p AD=0.057p
+ PS=0.68u PD=0.68u rfmode=0
M$3822 \$2445 VBIAS \$2455 VSS sg13_hv_nmos L=0.45u W=0.3u AS=0.057p AD=0.057p
+ PS=0.68u PD=0.68u rfmode=0
M$3823 \$2455 VSS VSS VSS sg13_hv_nmos L=0.45u W=0.3u AS=0.057p AD=0.102p
+ PS=0.68u PD=1.28u rfmode=0
M$3824 VDD X10 \$4 VDD sg13_lv_pmos L=0.13u W=1u AS=0.2086p AD=0.34p PS=1.5u
+ PD=2.68u rfmode=0
M$3825 VDD \$4 \$5 VDD sg13_lv_pmos L=0.13u W=2.24u AS=0.4214p AD=0.9464p PS=3u
+ PD=5.05u rfmode=0
M$3827 VDD \$8 \$40 VDD sg13_lv_pmos L=0.13u W=2.24u AS=0.616p AD=0.4312p
+ PS=4.46u PD=3.01u rfmode=0
M$3829 VDD VDD \$40 VDD sg13_lv_pmos L=0.13u W=2.24u AS=0.4312p AD=0.6048p
+ PS=3.01u PD=4.44u rfmode=0
M$3831 \$188 \$10 VDD VDD sg13_lv_pmos L=0.13u W=1.12u AS=0.3864p AD=0.431025p
+ PS=2.93u PD=2.145u rfmode=0
M$3832 VDD CLK \$10 VDD sg13_lv_pmos L=0.13u W=1.12u AS=0.431025p AD=0.3808p
+ PS=2.145u PD=2.92u rfmode=0
M$3833 VDD \$46 \$47 VDD sg13_lv_pmos L=0.13u W=2.24u AS=0.5964p AD=0.5964p
+ PS=4.425u PD=4.425u rfmode=0
M$3835 VDD \$12 \$50 VDD sg13_lv_pmos L=0.13u W=2.24u AS=0.616p AD=0.4312p
+ PS=4.46u PD=3.01u rfmode=0
M$3837 VDD VDD \$50 VDD sg13_lv_pmos L=0.13u W=2.24u AS=0.4312p AD=0.6048p
+ PS=3.01u PD=4.44u rfmode=0
M$3839 \$191 \$14 VDD VDD sg13_lv_pmos L=0.13u W=1.12u AS=0.3864p AD=0.431025p
+ PS=2.93u PD=2.145u rfmode=0
M$3840 VDD CLK \$14 VDD sg13_lv_pmos L=0.13u W=1.12u AS=0.431025p AD=0.3808p
+ PS=2.145u PD=2.92u rfmode=0
M$3841 VDD \$56 \$57 VDD sg13_lv_pmos L=0.13u W=2.24u AS=0.5964p AD=0.5964p
+ PS=4.425u PD=4.425u rfmode=0
M$3843 VDD \$16 \$60 VDD sg13_lv_pmos L=0.13u W=2.24u AS=0.616p AD=0.4312p
+ PS=4.46u PD=3.01u rfmode=0
M$3845 VDD VDD \$60 VDD sg13_lv_pmos L=0.13u W=2.24u AS=0.4312p AD=0.6048p
+ PS=3.01u PD=4.44u rfmode=0
M$3847 \$194 \$18 VDD VDD sg13_lv_pmos L=0.13u W=1.12u AS=0.3864p AD=0.431025p
+ PS=2.93u PD=2.145u rfmode=0
M$3848 VDD CLK \$18 VDD sg13_lv_pmos L=0.13u W=1.12u AS=0.431025p AD=0.3808p
+ PS=2.145u PD=2.92u rfmode=0
M$3849 VDD \$66 \$67 VDD sg13_lv_pmos L=0.13u W=2.24u AS=0.5964p AD=0.5964p
+ PS=4.425u PD=4.425u rfmode=0
M$3851 VDD \$20 \$70 VDD sg13_lv_pmos L=0.13u W=2.24u AS=0.616p AD=0.4312p
+ PS=4.46u PD=3.01u rfmode=0
M$3853 VDD VDD \$70 VDD sg13_lv_pmos L=0.13u W=2.24u AS=0.4312p AD=0.6048p
+ PS=3.01u PD=4.44u rfmode=0
M$3855 \$197 \$22 VDD VDD sg13_lv_pmos L=0.13u W=1.12u AS=0.3864p AD=0.431025p
+ PS=2.93u PD=2.145u rfmode=0
M$3856 VDD CLK \$22 VDD sg13_lv_pmos L=0.13u W=1.12u AS=0.431025p AD=0.3808p
+ PS=2.145u PD=2.92u rfmode=0
M$3857 VDD \$76 \$77 VDD sg13_lv_pmos L=0.13u W=2.24u AS=0.5964p AD=0.5964p
+ PS=4.425u PD=4.425u rfmode=0
M$3859 VDD \$24 \$80 VDD sg13_lv_pmos L=0.13u W=2.24u AS=0.616p AD=0.4312p
+ PS=4.46u PD=3.01u rfmode=0
M$3861 VDD VDD \$80 VDD sg13_lv_pmos L=0.13u W=2.24u AS=0.4312p AD=0.6048p
+ PS=3.01u PD=4.44u rfmode=0
M$3863 \$200 \$26 VDD VDD sg13_lv_pmos L=0.13u W=1.12u AS=0.3864p AD=0.431025p
+ PS=2.93u PD=2.145u rfmode=0
M$3864 VDD CLK \$26 VDD sg13_lv_pmos L=0.13u W=1.12u AS=0.431025p AD=0.3808p
+ PS=2.145u PD=2.92u rfmode=0
M$3865 VDD \$86 \$87 VDD sg13_lv_pmos L=0.13u W=2.24u AS=0.5964p AD=0.5964p
+ PS=4.425u PD=4.425u rfmode=0
M$3867 VDD \$28 \$90 VDD sg13_lv_pmos L=0.13u W=2.24u AS=0.616p AD=0.4312p
+ PS=4.46u PD=3.01u rfmode=0
M$3869 VDD VDD \$90 VDD sg13_lv_pmos L=0.13u W=2.24u AS=0.4312p AD=0.6048p
+ PS=3.01u PD=4.44u rfmode=0
M$3871 \$203 \$30 VDD VDD sg13_lv_pmos L=0.13u W=1.12u AS=0.3864p AD=0.431025p
+ PS=2.93u PD=2.145u rfmode=0
M$3872 VDD CLK \$30 VDD sg13_lv_pmos L=0.13u W=1.12u AS=0.431025p AD=0.3808p
+ PS=2.145u PD=2.92u rfmode=0
M$3873 VDD \$96 \$97 VDD sg13_lv_pmos L=0.13u W=2.24u AS=0.5964p AD=0.5964p
+ PS=4.425u PD=4.425u rfmode=0
M$3875 VDD \$32 \$100 VDD sg13_lv_pmos L=0.13u W=2.24u AS=0.616p AD=0.4312p
+ PS=4.46u PD=3.01u rfmode=0
M$3877 VDD VDD \$100 VDD sg13_lv_pmos L=0.13u W=2.24u AS=0.4312p AD=0.6048p
+ PS=3.01u PD=4.44u rfmode=0
M$3879 \$206 \$34 VDD VDD sg13_lv_pmos L=0.13u W=1.12u AS=0.3864p AD=0.431025p
+ PS=2.93u PD=2.145u rfmode=0
M$3880 VDD CLK \$34 VDD sg13_lv_pmos L=0.13u W=1.12u AS=0.431025p AD=0.3808p
+ PS=2.145u PD=2.92u rfmode=0
M$3881 VDD \$106 \$107 VDD sg13_lv_pmos L=0.13u W=2.24u AS=0.5964p AD=0.5964p
+ PS=4.425u PD=4.425u rfmode=0
M$3883 VDD \$36 \$110 VDD sg13_lv_pmos L=0.13u W=2.24u AS=0.616p AD=0.4312p
+ PS=4.46u PD=3.01u rfmode=0
M$3885 VDD VDD \$110 VDD sg13_lv_pmos L=0.13u W=2.24u AS=0.4312p AD=0.6048p
+ PS=3.01u PD=4.44u rfmode=0
M$3887 \$208 \$38 VDD VDD sg13_lv_pmos L=0.13u W=1.12u AS=0.3864p AD=0.431025p
+ PS=2.93u PD=2.145u rfmode=0
M$3888 VDD CLK \$38 VDD sg13_lv_pmos L=0.13u W=1.12u AS=0.431025p AD=0.3808p
+ PS=2.145u PD=2.92u rfmode=0
M$3889 VDD \$116 \$117 VDD sg13_lv_pmos L=0.13u W=2.24u AS=0.5964p AD=0.5964p
+ PS=4.425u PD=4.425u rfmode=0
M$3891 \$7 \$187 \$254 VDD sg13_lv_pmos L=0.13u W=0.84u AS=0.2856p AD=0.1596p
+ PS=2.36u PD=1.22u rfmode=0
M$3892 VDD \$320 \$254 VDD sg13_lv_pmos L=0.13u W=0.84u AS=0.2226p AD=0.1596p
+ PS=1.535u PD=1.22u rfmode=0
M$3893 VDD \$7 \$8 VDD sg13_lv_pmos L=0.13u W=2.24u AS=0.4746p AD=0.6776p
+ PS=3.105u PD=4.57u rfmode=0
M$3895 VDD \$40 \$41 VDD sg13_lv_pmos L=0.13u W=0.42u AS=0.1428p AD=0.0798p
+ PS=1.52u PD=0.8u rfmode=0
M$3896 VDD VDD \$41 VDD sg13_lv_pmos L=0.13u W=0.42u AS=0.3623875p AD=0.0798p
+ PS=2.605u PD=0.8u rfmode=0
M$3897 VDD \$167 \$9 VDD sg13_lv_pmos L=0.13u W=1u AS=0.3623875p AD=0.34p
+ PS=2.605u PD=2.68u rfmode=0
M$3898 \$44 \$188 \$216 VDD sg13_lv_pmos L=0.13u W=0.42u AS=0.19115p AD=0.0525p
+ PS=1.565u PD=0.67u rfmode=0
M$3899 \$216 \$168 VDD VDD sg13_lv_pmos L=0.13u W=0.42u AS=0.0525p AD=0.25605p
+ PS=0.67u PD=1.935u rfmode=0
M$3900 VDD VDD \$168 VDD sg13_lv_pmos L=0.13u W=0.42u AS=0.25605p AD=0.0798p
+ PS=1.935u PD=0.8u rfmode=0
M$3901 VDD \$44 \$168 VDD sg13_lv_pmos L=0.13u W=0.42u AS=0.2014p AD=0.0798p
+ PS=1.53u PD=0.8u rfmode=0
M$3902 VDD \$44 \$46 VDD sg13_lv_pmos L=0.13u W=1u AS=0.2083p AD=0.34p PS=1.5u
+ PD=2.68u rfmode=0
M$3903 VDD \$44 \$45 VDD sg13_lv_pmos L=0.13u W=2.24u AS=0.4142p AD=0.4211p
+ PS=3.03u PD=3u rfmode=0
M$3905 \$9 \$10 \$44 VDD sg13_lv_pmos L=0.13u W=1u AS=0.34p AD=0.19115p
+ PS=2.68u PD=1.565u rfmode=0
M$3906 \$11 \$190 \$255 VDD sg13_lv_pmos L=0.13u W=0.84u AS=0.2856p AD=0.1596p
+ PS=2.36u PD=1.22u rfmode=0
M$3907 VDD \$320 \$255 VDD sg13_lv_pmos L=0.13u W=0.84u AS=0.2226p AD=0.1596p
+ PS=1.535u PD=1.22u rfmode=0
M$3908 VDD \$11 \$12 VDD sg13_lv_pmos L=0.13u W=2.24u AS=0.4746p AD=0.6776p
+ PS=3.105u PD=4.57u rfmode=0
M$3910 VDD \$50 \$51 VDD sg13_lv_pmos L=0.13u W=0.42u AS=0.1428p AD=0.0798p
+ PS=1.52u PD=0.8u rfmode=0
M$3911 VDD VDD \$51 VDD sg13_lv_pmos L=0.13u W=0.42u AS=0.3623875p AD=0.0798p
+ PS=2.605u PD=0.8u rfmode=0
M$3912 VDD \$169 \$13 VDD sg13_lv_pmos L=0.13u W=1u AS=0.3623875p AD=0.34p
+ PS=2.605u PD=2.68u rfmode=0
M$3913 \$54 \$191 \$224 VDD sg13_lv_pmos L=0.13u W=0.42u AS=0.19115p AD=0.0525p
+ PS=1.565u PD=0.67u rfmode=0
M$3914 \$224 \$170 VDD VDD sg13_lv_pmos L=0.13u W=0.42u AS=0.0525p AD=0.25605p
+ PS=0.67u PD=1.935u rfmode=0
M$3915 VDD VDD \$170 VDD sg13_lv_pmos L=0.13u W=0.42u AS=0.25605p AD=0.0798p
+ PS=1.935u PD=0.8u rfmode=0
M$3916 VDD \$54 \$170 VDD sg13_lv_pmos L=0.13u W=0.42u AS=0.2014p AD=0.0798p
+ PS=1.53u PD=0.8u rfmode=0
M$3917 VDD \$54 \$56 VDD sg13_lv_pmos L=0.13u W=1u AS=0.2083p AD=0.34p PS=1.5u
+ PD=2.68u rfmode=0
M$3918 VDD \$54 \$55 VDD sg13_lv_pmos L=0.13u W=2.24u AS=0.4142p AD=0.4211p
+ PS=3.03u PD=3u rfmode=0
M$3920 \$13 \$14 \$54 VDD sg13_lv_pmos L=0.13u W=1u AS=0.34p AD=0.19115p
+ PS=2.68u PD=1.565u rfmode=0
M$3921 \$15 \$193 \$256 VDD sg13_lv_pmos L=0.13u W=0.84u AS=0.2856p AD=0.1596p
+ PS=2.36u PD=1.22u rfmode=0
M$3922 VDD \$320 \$256 VDD sg13_lv_pmos L=0.13u W=0.84u AS=0.2226p AD=0.1596p
+ PS=1.535u PD=1.22u rfmode=0
M$3923 VDD \$15 \$16 VDD sg13_lv_pmos L=0.13u W=2.24u AS=0.4746p AD=0.6776p
+ PS=3.105u PD=4.57u rfmode=0
M$3925 VDD \$60 \$61 VDD sg13_lv_pmos L=0.13u W=0.42u AS=0.1428p AD=0.0798p
+ PS=1.52u PD=0.8u rfmode=0
M$3926 VDD VDD \$61 VDD sg13_lv_pmos L=0.13u W=0.42u AS=0.3623875p AD=0.0798p
+ PS=2.605u PD=0.8u rfmode=0
M$3927 VDD \$171 \$17 VDD sg13_lv_pmos L=0.13u W=1u AS=0.3623875p AD=0.34p
+ PS=2.605u PD=2.68u rfmode=0
M$3928 \$64 \$194 \$232 VDD sg13_lv_pmos L=0.13u W=0.42u AS=0.19115p AD=0.0525p
+ PS=1.565u PD=0.67u rfmode=0
M$3929 \$232 \$172 VDD VDD sg13_lv_pmos L=0.13u W=0.42u AS=0.0525p AD=0.25605p
+ PS=0.67u PD=1.935u rfmode=0
M$3930 VDD VDD \$172 VDD sg13_lv_pmos L=0.13u W=0.42u AS=0.25605p AD=0.0798p
+ PS=1.935u PD=0.8u rfmode=0
M$3931 VDD \$64 \$172 VDD sg13_lv_pmos L=0.13u W=0.42u AS=0.2014p AD=0.0798p
+ PS=1.53u PD=0.8u rfmode=0
M$3932 VDD \$64 \$66 VDD sg13_lv_pmos L=0.13u W=1u AS=0.2083p AD=0.34p PS=1.5u
+ PD=2.68u rfmode=0
M$3933 VDD \$64 \$65 VDD sg13_lv_pmos L=0.13u W=2.24u AS=0.4142p AD=0.4211p
+ PS=3.03u PD=3u rfmode=0
M$3935 \$17 \$18 \$64 VDD sg13_lv_pmos L=0.13u W=1u AS=0.34p AD=0.19115p
+ PS=2.68u PD=1.565u rfmode=0
M$3936 \$19 \$196 \$257 VDD sg13_lv_pmos L=0.13u W=0.84u AS=0.2856p AD=0.1596p
+ PS=2.36u PD=1.22u rfmode=0
M$3937 VDD \$320 \$257 VDD sg13_lv_pmos L=0.13u W=0.84u AS=0.2226p AD=0.1596p
+ PS=1.535u PD=1.22u rfmode=0
M$3938 VDD \$19 \$20 VDD sg13_lv_pmos L=0.13u W=2.24u AS=0.4746p AD=0.6776p
+ PS=3.105u PD=4.57u rfmode=0
M$3940 VDD \$70 \$71 VDD sg13_lv_pmos L=0.13u W=0.42u AS=0.1428p AD=0.0798p
+ PS=1.52u PD=0.8u rfmode=0
M$3941 VDD VDD \$71 VDD sg13_lv_pmos L=0.13u W=0.42u AS=0.3623875p AD=0.0798p
+ PS=2.605u PD=0.8u rfmode=0
M$3942 VDD \$173 \$21 VDD sg13_lv_pmos L=0.13u W=1u AS=0.3623875p AD=0.34p
+ PS=2.605u PD=2.68u rfmode=0
M$3943 \$74 \$197 \$241 VDD sg13_lv_pmos L=0.13u W=0.42u AS=0.19115p AD=0.0525p
+ PS=1.565u PD=0.67u rfmode=0
M$3944 \$241 \$174 VDD VDD sg13_lv_pmos L=0.13u W=0.42u AS=0.0525p AD=0.25605p
+ PS=0.67u PD=1.935u rfmode=0
M$3945 VDD VDD \$174 VDD sg13_lv_pmos L=0.13u W=0.42u AS=0.25605p AD=0.0798p
+ PS=1.935u PD=0.8u rfmode=0
M$3946 VDD \$74 \$174 VDD sg13_lv_pmos L=0.13u W=0.42u AS=0.2014p AD=0.0798p
+ PS=1.53u PD=0.8u rfmode=0
M$3947 VDD \$74 \$76 VDD sg13_lv_pmos L=0.13u W=1u AS=0.2083p AD=0.34p PS=1.5u
+ PD=2.68u rfmode=0
M$3948 VDD \$74 \$75 VDD sg13_lv_pmos L=0.13u W=2.24u AS=0.4142p AD=0.4211p
+ PS=3.03u PD=3u rfmode=0
M$3950 \$21 \$22 \$74 VDD sg13_lv_pmos L=0.13u W=1u AS=0.34p AD=0.19115p
+ PS=2.68u PD=1.565u rfmode=0
M$3951 \$23 \$199 \$258 VDD sg13_lv_pmos L=0.13u W=0.84u AS=0.2856p AD=0.1596p
+ PS=2.36u PD=1.22u rfmode=0
M$3952 VDD \$320 \$258 VDD sg13_lv_pmos L=0.13u W=0.84u AS=0.2226p AD=0.1596p
+ PS=1.535u PD=1.22u rfmode=0
M$3953 VDD \$23 \$24 VDD sg13_lv_pmos L=0.13u W=2.24u AS=0.4746p AD=0.6776p
+ PS=3.105u PD=4.57u rfmode=0
M$3955 VDD \$80 \$81 VDD sg13_lv_pmos L=0.13u W=0.42u AS=0.1428p AD=0.0798p
+ PS=1.52u PD=0.8u rfmode=0
M$3956 VDD VDD \$81 VDD sg13_lv_pmos L=0.13u W=0.42u AS=0.3623875p AD=0.0798p
+ PS=2.605u PD=0.8u rfmode=0
M$3957 VDD \$175 \$25 VDD sg13_lv_pmos L=0.13u W=1u AS=0.3623875p AD=0.34p
+ PS=2.605u PD=2.68u rfmode=0
M$3958 \$84 \$200 \$249 VDD sg13_lv_pmos L=0.13u W=0.42u AS=0.19115p AD=0.0525p
+ PS=1.565u PD=0.67u rfmode=0
M$3959 \$249 \$176 VDD VDD sg13_lv_pmos L=0.13u W=0.42u AS=0.0525p AD=0.25605p
+ PS=0.67u PD=1.935u rfmode=0
M$3960 VDD VDD \$176 VDD sg13_lv_pmos L=0.13u W=0.42u AS=0.25605p AD=0.0798p
+ PS=1.935u PD=0.8u rfmode=0
M$3961 VDD \$84 \$176 VDD sg13_lv_pmos L=0.13u W=0.42u AS=0.2014p AD=0.0798p
+ PS=1.53u PD=0.8u rfmode=0
M$3962 VDD \$84 \$86 VDD sg13_lv_pmos L=0.13u W=1u AS=0.2083p AD=0.34p PS=1.5u
+ PD=2.68u rfmode=0
M$3963 VDD \$84 \$85 VDD sg13_lv_pmos L=0.13u W=2.24u AS=0.4142p AD=0.4211p
+ PS=3.03u PD=3u rfmode=0
M$3965 \$25 \$26 \$84 VDD sg13_lv_pmos L=0.13u W=1u AS=0.34p AD=0.19115p
+ PS=2.68u PD=1.565u rfmode=0
M$3966 \$27 \$202 \$260 VDD sg13_lv_pmos L=0.13u W=0.84u AS=0.2856p AD=0.1596p
+ PS=2.36u PD=1.22u rfmode=0
M$3967 VDD \$320 \$260 VDD sg13_lv_pmos L=0.13u W=0.84u AS=0.2226p AD=0.1596p
+ PS=1.535u PD=1.22u rfmode=0
M$3968 VDD \$27 \$28 VDD sg13_lv_pmos L=0.13u W=2.24u AS=0.4746p AD=0.6776p
+ PS=3.105u PD=4.57u rfmode=0
M$3970 VDD \$90 \$91 VDD sg13_lv_pmos L=0.13u W=0.42u AS=0.1428p AD=0.0798p
+ PS=1.52u PD=0.8u rfmode=0
M$3971 VDD VDD \$91 VDD sg13_lv_pmos L=0.13u W=0.42u AS=0.3623875p AD=0.0798p
+ PS=2.605u PD=0.8u rfmode=0
M$3972 VDD \$177 \$29 VDD sg13_lv_pmos L=0.13u W=1u AS=0.3623875p AD=0.34p
+ PS=2.605u PD=2.68u rfmode=0
M$3973 \$94 \$203 \$238 VDD sg13_lv_pmos L=0.13u W=0.42u AS=0.19115p AD=0.0525p
+ PS=1.565u PD=0.67u rfmode=0
M$3974 \$238 \$178 VDD VDD sg13_lv_pmos L=0.13u W=0.42u AS=0.0525p AD=0.25605p
+ PS=0.67u PD=1.935u rfmode=0
M$3975 VDD VDD \$178 VDD sg13_lv_pmos L=0.13u W=0.42u AS=0.25605p AD=0.0798p
+ PS=1.935u PD=0.8u rfmode=0
M$3976 VDD \$94 \$178 VDD sg13_lv_pmos L=0.13u W=0.42u AS=0.2014p AD=0.0798p
+ PS=1.53u PD=0.8u rfmode=0
M$3977 VDD \$94 \$96 VDD sg13_lv_pmos L=0.13u W=1u AS=0.2083p AD=0.34p PS=1.5u
+ PD=2.68u rfmode=0
M$3978 VDD \$94 \$95 VDD sg13_lv_pmos L=0.13u W=2.24u AS=0.4142p AD=0.4211p
+ PS=3.03u PD=3u rfmode=0
M$3980 \$29 \$30 \$94 VDD sg13_lv_pmos L=0.13u W=1u AS=0.34p AD=0.19115p
+ PS=2.68u PD=1.565u rfmode=0
M$3981 \$31 \$205 \$261 VDD sg13_lv_pmos L=0.13u W=0.84u AS=0.2856p AD=0.1596p
+ PS=2.36u PD=1.22u rfmode=0
M$3982 VDD \$320 \$261 VDD sg13_lv_pmos L=0.13u W=0.84u AS=0.2226p AD=0.1596p
+ PS=1.535u PD=1.22u rfmode=0
M$3983 VDD \$31 \$32 VDD sg13_lv_pmos L=0.13u W=2.24u AS=0.4746p AD=0.6776p
+ PS=3.105u PD=4.57u rfmode=0
M$3985 VDD \$100 \$101 VDD sg13_lv_pmos L=0.13u W=0.42u AS=0.1428p AD=0.0798p
+ PS=1.52u PD=0.8u rfmode=0
M$3986 VDD VDD \$101 VDD sg13_lv_pmos L=0.13u W=0.42u AS=0.3623875p AD=0.0798p
+ PS=2.605u PD=0.8u rfmode=0
M$3987 VDD \$179 \$33 VDD sg13_lv_pmos L=0.13u W=1u AS=0.3623875p AD=0.34p
+ PS=2.605u PD=2.68u rfmode=0
M$3988 \$104 \$206 \$225 VDD sg13_lv_pmos L=0.13u W=0.42u AS=0.19115p
+ AD=0.0525p PS=1.565u PD=0.67u rfmode=0
M$3989 \$225 \$180 VDD VDD sg13_lv_pmos L=0.13u W=0.42u AS=0.0525p AD=0.25605p
+ PS=0.67u PD=1.935u rfmode=0
M$3990 VDD VDD \$180 VDD sg13_lv_pmos L=0.13u W=0.42u AS=0.25605p AD=0.0798p
+ PS=1.935u PD=0.8u rfmode=0
M$3991 VDD \$104 \$180 VDD sg13_lv_pmos L=0.13u W=0.42u AS=0.2014p AD=0.0798p
+ PS=1.53u PD=0.8u rfmode=0
M$3992 VDD \$104 \$106 VDD sg13_lv_pmos L=0.13u W=1u AS=0.2083p AD=0.34p
+ PS=1.5u PD=2.68u rfmode=0
M$3993 VDD \$104 \$105 VDD sg13_lv_pmos L=0.13u W=2.24u AS=0.4142p AD=0.4211p
+ PS=3.03u PD=3u rfmode=0
M$3995 \$33 \$34 \$104 VDD sg13_lv_pmos L=0.13u W=1u AS=0.34p AD=0.19115p
+ PS=2.68u PD=1.565u rfmode=0
M$3996 \$35 VSS \$259 VDD sg13_lv_pmos L=0.13u W=0.84u AS=0.2856p AD=0.1596p
+ PS=2.36u PD=1.22u rfmode=0
M$3997 VDD \$320 \$259 VDD sg13_lv_pmos L=0.13u W=0.84u AS=0.2226p AD=0.1596p
+ PS=1.535u PD=1.22u rfmode=0
M$3998 VDD \$35 \$36 VDD sg13_lv_pmos L=0.13u W=2.24u AS=0.4746p AD=0.6776p
+ PS=3.105u PD=4.57u rfmode=0
M$4000 VDD \$110 \$111 VDD sg13_lv_pmos L=0.13u W=0.42u AS=0.1428p AD=0.0798p
+ PS=1.52u PD=0.8u rfmode=0
M$4001 VDD VDD \$111 VDD sg13_lv_pmos L=0.13u W=0.42u AS=0.3623875p AD=0.0798p
+ PS=2.605u PD=0.8u rfmode=0
M$4002 VDD \$181 \$37 VDD sg13_lv_pmos L=0.13u W=1u AS=0.3623875p AD=0.34p
+ PS=2.605u PD=2.68u rfmode=0
M$4003 \$114 \$208 \$213 VDD sg13_lv_pmos L=0.13u W=0.42u AS=0.19115p
+ AD=0.0525p PS=1.565u PD=0.67u rfmode=0
M$4004 \$213 \$182 VDD VDD sg13_lv_pmos L=0.13u W=0.42u AS=0.0525p AD=0.25605p
+ PS=0.67u PD=1.935u rfmode=0
M$4005 VDD VDD \$182 VDD sg13_lv_pmos L=0.13u W=0.42u AS=0.25605p AD=0.0798p
+ PS=1.935u PD=0.8u rfmode=0
M$4006 VDD \$114 \$182 VDD sg13_lv_pmos L=0.13u W=0.42u AS=0.2014p AD=0.0798p
+ PS=1.53u PD=0.8u rfmode=0
M$4007 VDD \$114 \$116 VDD sg13_lv_pmos L=0.13u W=1u AS=0.2083p AD=0.34p
+ PS=1.5u PD=2.68u rfmode=0
M$4008 VDD \$114 \$115 VDD sg13_lv_pmos L=0.13u W=2.24u AS=0.4142p AD=0.4211p
+ PS=3.03u PD=3u rfmode=0
M$4010 \$37 \$38 \$114 VDD sg13_lv_pmos L=0.13u W=1u AS=0.34p AD=0.19115p
+ PS=2.68u PD=1.565u rfmode=0
M$4011 \$263 X9 \$267 VDD sg13_lv_pmos L=0.13u W=0.84u AS=0.2856p AD=0.1596p
+ PS=2.36u PD=1.22u rfmode=0
M$4012 \$267 X8 VDD VDD sg13_lv_pmos L=0.13u W=0.84u AS=0.1596p AD=0.2226p
+ PS=1.22u PD=1.535u rfmode=0
M$4013 VDD \$263 \$264 VDD sg13_lv_pmos L=0.13u W=2.24u AS=0.4746p AD=0.6776p
+ PS=3.105u PD=4.57u rfmode=0
M$4015 \$317 X9 \$323 VDD sg13_lv_pmos L=0.13u W=0.84u AS=0.2856p AD=0.1596p
+ PS=2.36u PD=1.22u rfmode=0
M$4016 VDD X10 \$323 VDD sg13_lv_pmos L=0.13u W=0.84u AS=0.2226p AD=0.1596p
+ PS=1.535u PD=1.22u rfmode=0
M$4017 VDD \$317 \$318 VDD sg13_lv_pmos L=0.13u W=2.24u AS=0.4746p AD=0.6776p
+ PS=3.105u PD=4.57u rfmode=0
M$4019 VDD X8 \$251 VDD sg13_lv_pmos L=0.13u W=0.84u AS=0.2856p AD=0.1596p
+ PS=2.36u PD=1.22u rfmode=0
M$4020 VDD X9 \$251 VDD sg13_lv_pmos L=0.13u W=0.84u AS=0.1918p AD=0.1596p
+ PS=1.5u PD=1.22u rfmode=0
M$4021 VDD \$251 \$184 VDD sg13_lv_pmos L=0.13u W=2.24u AS=0.4046p AD=0.6384p
+ PS=3u PD=4.5u rfmode=0
M$4023 VDD X9 \$325 VDD sg13_lv_pmos L=0.13u W=0.84u AS=0.2856p AD=0.1596p
+ PS=2.36u PD=1.22u rfmode=0
M$4024 \$325 X10 VDD VDD sg13_lv_pmos L=0.13u W=0.84u AS=0.1596p AD=0.1918p
+ PS=1.22u PD=1.5u rfmode=0
M$4025 VDD \$325 \$326 VDD sg13_lv_pmos L=0.13u W=2.24u AS=0.4046p AD=0.6384p
+ PS=3u PD=4.5u rfmode=0
M$4027 \$319 X8 \$324 VDD sg13_lv_pmos L=0.13u W=0.84u AS=0.2856p AD=0.1596p
+ PS=2.36u PD=1.22u rfmode=0
M$4028 VDD \$318 \$324 VDD sg13_lv_pmos L=0.13u W=0.84u AS=0.2226p AD=0.1596p
+ PS=1.535u PD=1.22u rfmode=0
M$4029 VDD \$319 \$320 VDD sg13_lv_pmos L=0.13u W=2.24u AS=0.4746p AD=0.6776p
+ PS=3.105u PD=4.57u rfmode=0
M$4031 \$185 X10 \$268 VDD sg13_lv_pmos L=0.13u W=0.84u AS=0.2856p AD=0.1596p
+ PS=2.36u PD=1.22u rfmode=0
M$4032 VDD \$184 \$268 VDD sg13_lv_pmos L=0.13u W=0.84u AS=0.2226p AD=0.1596p
+ PS=1.535u PD=1.22u rfmode=0
M$4033 VDD \$185 \$186 VDD sg13_lv_pmos L=0.13u W=2.24u AS=0.4746p AD=0.6776p
+ PS=3.105u PD=4.57u rfmode=0
M$4035 VDD X10 \$265 VDD sg13_lv_pmos L=0.13u W=0.84u AS=0.2856p AD=0.1596p
+ PS=2.36u PD=1.22u rfmode=0
M$4036 \$265 \$264 VDD VDD sg13_lv_pmos L=0.13u W=0.84u AS=0.1596p AD=0.1918p
+ PS=1.22u PD=1.5u rfmode=0
M$4037 VDD \$265 \$266 VDD sg13_lv_pmos L=0.13u W=2.24u AS=0.4046p AD=0.6384p
+ PS=3u PD=4.5u rfmode=0
M$4039 VDD \$328 \$376 VDD sg13_lv_pmos L=0.13u W=2.24u AS=0.616p AD=0.4312p
+ PS=4.46u PD=3.01u rfmode=0
M$4041 VDD \$320 \$376 VDD sg13_lv_pmos L=0.13u W=2.24u AS=0.4312p AD=0.6048p
+ PS=3.01u PD=4.44u rfmode=0
M$4043 \$167 VDD VDD VDD sg13_lv_pmos L=0.13u W=0.42u AS=0.147p AD=0.1563p
+ PS=1.54u PD=1.22u rfmode=0
M$4044 VDD \$9 \$214 VDD sg13_lv_pmos L=0.13u W=0.42u AS=0.1563p AD=0.0546p
+ PS=1.22u PD=0.68u rfmode=0
M$4045 \$214 \$10 \$167 VDD sg13_lv_pmos L=0.13u W=0.42u AS=0.0546p AD=0.0798p
+ PS=0.68u PD=0.8u rfmode=0
M$4046 \$167 \$188 \$41 VDD sg13_lv_pmos L=0.13u W=0.42u AS=0.0798p AD=0.1428p
+ PS=0.8u PD=1.52u rfmode=0
M$4047 \$379 \$330 VDD VDD sg13_lv_pmos L=0.13u W=1.12u AS=0.3864p AD=0.431025p
+ PS=2.93u PD=2.145u rfmode=0
M$4048 VDD CLK \$330 VDD sg13_lv_pmos L=0.13u W=1.12u AS=0.431025p AD=0.3808p
+ PS=2.145u PD=2.92u rfmode=0
M$4049 \$381 \$379 \$523 VDD sg13_lv_pmos L=0.13u W=0.42u AS=0.19115p
+ AD=0.0525p PS=1.565u PD=0.67u rfmode=0
M$4050 \$523 \$495 VDD VDD sg13_lv_pmos L=0.13u W=0.42u AS=0.0525p AD=0.25605p
+ PS=0.67u PD=1.935u rfmode=0
M$4051 VDD VDD \$495 VDD sg13_lv_pmos L=0.13u W=0.42u AS=0.25605p AD=0.0798p
+ PS=1.935u PD=0.8u rfmode=0
M$4052 VDD \$381 \$495 VDD sg13_lv_pmos L=0.13u W=0.42u AS=0.2014p AD=0.0798p
+ PS=1.53u PD=0.8u rfmode=0
M$4053 VDD \$381 \$332 VDD sg13_lv_pmos L=0.13u W=1u AS=0.2083p AD=0.34p
+ PS=1.5u PD=2.68u rfmode=0
M$4054 VDD \$381 \$331 VDD sg13_lv_pmos L=0.13u W=2.24u AS=0.4142p AD=0.4211p
+ PS=3.03u PD=3u rfmode=0
M$4056 \$329 \$330 \$381 VDD sg13_lv_pmos L=0.13u W=1u AS=0.34p AD=0.19115p
+ PS=2.68u PD=1.565u rfmode=0
M$4057 VDD \$332 \$382 VDD sg13_lv_pmos L=0.13u W=2.24u AS=0.5964p AD=0.5964p
+ PS=4.425u PD=4.425u rfmode=0
M$4059 VDD \$334 \$385 VDD sg13_lv_pmos L=0.13u W=2.24u AS=0.616p AD=0.4312p
+ PS=4.46u PD=3.01u rfmode=0
M$4061 VDD \$320 \$385 VDD sg13_lv_pmos L=0.13u W=2.24u AS=0.4312p AD=0.6048p
+ PS=3.01u PD=4.44u rfmode=0
M$4063 \$169 VDD VDD VDD sg13_lv_pmos L=0.13u W=0.42u AS=0.147p AD=0.1563p
+ PS=1.54u PD=1.22u rfmode=0
M$4064 VDD \$13 \$223 VDD sg13_lv_pmos L=0.13u W=0.42u AS=0.1563p AD=0.0546p
+ PS=1.22u PD=0.68u rfmode=0
M$4065 \$223 \$14 \$169 VDD sg13_lv_pmos L=0.13u W=0.42u AS=0.0546p AD=0.0798p
+ PS=0.68u PD=0.8u rfmode=0
M$4066 \$169 \$191 \$51 VDD sg13_lv_pmos L=0.13u W=0.42u AS=0.0798p AD=0.1428p
+ PS=0.8u PD=1.52u rfmode=0
M$4067 \$388 \$336 VDD VDD sg13_lv_pmos L=0.13u W=1.12u AS=0.3864p AD=0.431025p
+ PS=2.93u PD=2.145u rfmode=0
M$4068 VDD CLK \$336 VDD sg13_lv_pmos L=0.13u W=1.12u AS=0.431025p AD=0.3808p
+ PS=2.145u PD=2.92u rfmode=0
M$4069 \$390 \$388 \$531 VDD sg13_lv_pmos L=0.13u W=0.42u AS=0.19115p
+ AD=0.0525p PS=1.565u PD=0.67u rfmode=0
M$4070 \$531 \$497 VDD VDD sg13_lv_pmos L=0.13u W=0.42u AS=0.0525p AD=0.25605p
+ PS=0.67u PD=1.935u rfmode=0
M$4071 VDD VDD \$497 VDD sg13_lv_pmos L=0.13u W=0.42u AS=0.25605p AD=0.0798p
+ PS=1.935u PD=0.8u rfmode=0
M$4072 VDD \$390 \$497 VDD sg13_lv_pmos L=0.13u W=0.42u AS=0.2014p AD=0.0798p
+ PS=1.53u PD=0.8u rfmode=0
M$4073 VDD \$390 \$338 VDD sg13_lv_pmos L=0.13u W=1u AS=0.2083p AD=0.34p
+ PS=1.5u PD=2.68u rfmode=0
M$4074 VDD \$390 \$337 VDD sg13_lv_pmos L=0.13u W=2.24u AS=0.4142p AD=0.4211p
+ PS=3.03u PD=3u rfmode=0
M$4076 \$335 \$336 \$390 VDD sg13_lv_pmos L=0.13u W=1u AS=0.34p AD=0.19115p
+ PS=2.68u PD=1.565u rfmode=0
M$4077 VDD \$338 \$391 VDD sg13_lv_pmos L=0.13u W=2.24u AS=0.5964p AD=0.5964p
+ PS=4.425u PD=4.425u rfmode=0
M$4079 VDD \$340 \$394 VDD sg13_lv_pmos L=0.13u W=2.24u AS=0.616p AD=0.4312p
+ PS=4.46u PD=3.01u rfmode=0
M$4081 VDD \$320 \$394 VDD sg13_lv_pmos L=0.13u W=2.24u AS=0.4312p AD=0.6048p
+ PS=3.01u PD=4.44u rfmode=0
M$4083 \$171 VDD VDD VDD sg13_lv_pmos L=0.13u W=0.42u AS=0.147p AD=0.1563p
+ PS=1.54u PD=1.22u rfmode=0
M$4084 VDD \$17 \$230 VDD sg13_lv_pmos L=0.13u W=0.42u AS=0.1563p AD=0.0546p
+ PS=1.22u PD=0.68u rfmode=0
M$4085 \$230 \$18 \$171 VDD sg13_lv_pmos L=0.13u W=0.42u AS=0.0546p AD=0.0798p
+ PS=0.68u PD=0.8u rfmode=0
M$4086 \$171 \$194 \$61 VDD sg13_lv_pmos L=0.13u W=0.42u AS=0.0798p AD=0.1428p
+ PS=0.8u PD=1.52u rfmode=0
M$4087 \$397 \$342 VDD VDD sg13_lv_pmos L=0.13u W=1.12u AS=0.3864p AD=0.431025p
+ PS=2.93u PD=2.145u rfmode=0
M$4088 VDD CLK \$342 VDD sg13_lv_pmos L=0.13u W=1.12u AS=0.431025p AD=0.3808p
+ PS=2.145u PD=2.92u rfmode=0
M$4089 \$399 \$397 \$538 VDD sg13_lv_pmos L=0.13u W=0.42u AS=0.19115p
+ AD=0.0525p PS=1.565u PD=0.67u rfmode=0
M$4090 \$538 \$499 VDD VDD sg13_lv_pmos L=0.13u W=0.42u AS=0.0525p AD=0.25605p
+ PS=0.67u PD=1.935u rfmode=0
M$4091 VDD VDD \$499 VDD sg13_lv_pmos L=0.13u W=0.42u AS=0.25605p AD=0.0798p
+ PS=1.935u PD=0.8u rfmode=0
M$4092 VDD \$399 \$499 VDD sg13_lv_pmos L=0.13u W=0.42u AS=0.2014p AD=0.0798p
+ PS=1.53u PD=0.8u rfmode=0
M$4093 VDD \$399 \$344 VDD sg13_lv_pmos L=0.13u W=1u AS=0.2083p AD=0.34p
+ PS=1.5u PD=2.68u rfmode=0
M$4094 VDD \$399 \$343 VDD sg13_lv_pmos L=0.13u W=2.24u AS=0.4142p AD=0.4211p
+ PS=3.03u PD=3u rfmode=0
M$4096 \$341 \$342 \$399 VDD sg13_lv_pmos L=0.13u W=1u AS=0.34p AD=0.19115p
+ PS=2.68u PD=1.565u rfmode=0
M$4097 VDD \$344 \$400 VDD sg13_lv_pmos L=0.13u W=2.24u AS=0.5964p AD=0.5964p
+ PS=4.425u PD=4.425u rfmode=0
M$4099 VDD \$346 \$403 VDD sg13_lv_pmos L=0.13u W=2.24u AS=0.616p AD=0.4312p
+ PS=4.46u PD=3.01u rfmode=0
M$4101 VDD \$320 \$403 VDD sg13_lv_pmos L=0.13u W=2.24u AS=0.4312p AD=0.6048p
+ PS=3.01u PD=4.44u rfmode=0
M$4103 \$173 VDD VDD VDD sg13_lv_pmos L=0.13u W=0.42u AS=0.147p AD=0.1563p
+ PS=1.54u PD=1.22u rfmode=0
M$4104 VDD \$21 \$240 VDD sg13_lv_pmos L=0.13u W=0.42u AS=0.1563p AD=0.0546p
+ PS=1.22u PD=0.68u rfmode=0
M$4105 \$240 \$22 \$173 VDD sg13_lv_pmos L=0.13u W=0.42u AS=0.0546p AD=0.0798p
+ PS=0.68u PD=0.8u rfmode=0
M$4106 \$173 \$197 \$71 VDD sg13_lv_pmos L=0.13u W=0.42u AS=0.0798p AD=0.1428p
+ PS=0.8u PD=1.52u rfmode=0
M$4107 \$406 \$348 VDD VDD sg13_lv_pmos L=0.13u W=1.12u AS=0.3864p AD=0.431025p
+ PS=2.93u PD=2.145u rfmode=0
M$4108 VDD CLK \$348 VDD sg13_lv_pmos L=0.13u W=1.12u AS=0.431025p AD=0.3808p
+ PS=2.145u PD=2.92u rfmode=0
M$4109 \$408 \$406 \$544 VDD sg13_lv_pmos L=0.13u W=0.42u AS=0.19115p
+ AD=0.0525p PS=1.565u PD=0.67u rfmode=0
M$4110 \$544 \$501 VDD VDD sg13_lv_pmos L=0.13u W=0.42u AS=0.0525p AD=0.25605p
+ PS=0.67u PD=1.935u rfmode=0
M$4111 VDD VDD \$501 VDD sg13_lv_pmos L=0.13u W=0.42u AS=0.25605p AD=0.0798p
+ PS=1.935u PD=0.8u rfmode=0
M$4112 VDD \$408 \$501 VDD sg13_lv_pmos L=0.13u W=0.42u AS=0.2014p AD=0.0798p
+ PS=1.53u PD=0.8u rfmode=0
M$4113 VDD \$408 \$350 VDD sg13_lv_pmos L=0.13u W=1u AS=0.2083p AD=0.34p
+ PS=1.5u PD=2.68u rfmode=0
M$4114 VDD \$408 \$349 VDD sg13_lv_pmos L=0.13u W=2.24u AS=0.4142p AD=0.4211p
+ PS=3.03u PD=3u rfmode=0
M$4116 \$347 \$348 \$408 VDD sg13_lv_pmos L=0.13u W=1u AS=0.34p AD=0.19115p
+ PS=2.68u PD=1.565u rfmode=0
M$4117 VDD \$350 \$409 VDD sg13_lv_pmos L=0.13u W=2.24u AS=0.5964p AD=0.5964p
+ PS=4.425u PD=4.425u rfmode=0
M$4119 VDD \$352 \$412 VDD sg13_lv_pmos L=0.13u W=2.24u AS=0.616p AD=0.4312p
+ PS=4.46u PD=3.01u rfmode=0
M$4121 VDD \$320 \$412 VDD sg13_lv_pmos L=0.13u W=2.24u AS=0.4312p AD=0.6048p
+ PS=3.01u PD=4.44u rfmode=0
M$4123 \$175 VDD VDD VDD sg13_lv_pmos L=0.13u W=0.42u AS=0.147p AD=0.1563p
+ PS=1.54u PD=1.22u rfmode=0
M$4124 VDD \$25 \$248 VDD sg13_lv_pmos L=0.13u W=0.42u AS=0.1563p AD=0.0546p
+ PS=1.22u PD=0.68u rfmode=0
M$4125 \$248 \$26 \$175 VDD sg13_lv_pmos L=0.13u W=0.42u AS=0.0546p AD=0.0798p
+ PS=0.68u PD=0.8u rfmode=0
M$4126 \$175 \$200 \$81 VDD sg13_lv_pmos L=0.13u W=0.42u AS=0.0798p AD=0.1428p
+ PS=0.8u PD=1.52u rfmode=0
M$4127 \$415 \$354 VDD VDD sg13_lv_pmos L=0.13u W=1.12u AS=0.3864p AD=0.431025p
+ PS=2.93u PD=2.145u rfmode=0
M$4128 VDD CLK \$354 VDD sg13_lv_pmos L=0.13u W=1.12u AS=0.431025p AD=0.3808p
+ PS=2.145u PD=2.92u rfmode=0
M$4129 \$417 \$415 \$551 VDD sg13_lv_pmos L=0.13u W=0.42u AS=0.19115p
+ AD=0.0525p PS=1.565u PD=0.67u rfmode=0
M$4130 \$551 \$503 VDD VDD sg13_lv_pmos L=0.13u W=0.42u AS=0.0525p AD=0.25605p
+ PS=0.67u PD=1.935u rfmode=0
M$4131 VDD VDD \$503 VDD sg13_lv_pmos L=0.13u W=0.42u AS=0.25605p AD=0.0798p
+ PS=1.935u PD=0.8u rfmode=0
M$4132 VDD \$417 \$503 VDD sg13_lv_pmos L=0.13u W=0.42u AS=0.2014p AD=0.0798p
+ PS=1.53u PD=0.8u rfmode=0
M$4133 VDD \$417 \$356 VDD sg13_lv_pmos L=0.13u W=1u AS=0.2083p AD=0.34p
+ PS=1.5u PD=2.68u rfmode=0
M$4134 VDD \$417 \$355 VDD sg13_lv_pmos L=0.13u W=2.24u AS=0.4142p AD=0.4211p
+ PS=3.03u PD=3u rfmode=0
M$4136 \$353 \$354 \$417 VDD sg13_lv_pmos L=0.13u W=1u AS=0.34p AD=0.19115p
+ PS=2.68u PD=1.565u rfmode=0
M$4137 VDD \$356 \$418 VDD sg13_lv_pmos L=0.13u W=2.24u AS=0.5964p AD=0.5964p
+ PS=4.425u PD=4.425u rfmode=0
M$4139 VDD \$358 \$421 VDD sg13_lv_pmos L=0.13u W=2.24u AS=0.616p AD=0.4312p
+ PS=4.46u PD=3.01u rfmode=0
M$4141 VDD \$320 \$421 VDD sg13_lv_pmos L=0.13u W=2.24u AS=0.4312p AD=0.6048p
+ PS=3.01u PD=4.44u rfmode=0
M$4143 \$177 VDD VDD VDD sg13_lv_pmos L=0.13u W=0.42u AS=0.147p AD=0.1563p
+ PS=1.54u PD=1.22u rfmode=0
M$4144 VDD \$29 \$239 VDD sg13_lv_pmos L=0.13u W=0.42u AS=0.1563p AD=0.0546p
+ PS=1.22u PD=0.68u rfmode=0
M$4145 \$239 \$30 \$177 VDD sg13_lv_pmos L=0.13u W=0.42u AS=0.0546p AD=0.0798p
+ PS=0.68u PD=0.8u rfmode=0
M$4146 \$177 \$203 \$91 VDD sg13_lv_pmos L=0.13u W=0.42u AS=0.0798p AD=0.1428p
+ PS=0.8u PD=1.52u rfmode=0
M$4147 \$424 \$360 VDD VDD sg13_lv_pmos L=0.13u W=1.12u AS=0.3864p AD=0.431025p
+ PS=2.93u PD=2.145u rfmode=0
M$4148 VDD CLK \$360 VDD sg13_lv_pmos L=0.13u W=1.12u AS=0.431025p AD=0.3808p
+ PS=2.145u PD=2.92u rfmode=0
M$4149 \$426 \$424 \$557 VDD sg13_lv_pmos L=0.13u W=0.42u AS=0.19115p
+ AD=0.0525p PS=1.565u PD=0.67u rfmode=0
M$4150 \$557 \$505 VDD VDD sg13_lv_pmos L=0.13u W=0.42u AS=0.0525p AD=0.25605p
+ PS=0.67u PD=1.935u rfmode=0
M$4151 VDD VDD \$505 VDD sg13_lv_pmos L=0.13u W=0.42u AS=0.25605p AD=0.0798p
+ PS=1.935u PD=0.8u rfmode=0
M$4152 VDD \$426 \$505 VDD sg13_lv_pmos L=0.13u W=0.42u AS=0.2014p AD=0.0798p
+ PS=1.53u PD=0.8u rfmode=0
M$4153 VDD \$426 \$362 VDD sg13_lv_pmos L=0.13u W=1u AS=0.2083p AD=0.34p
+ PS=1.5u PD=2.68u rfmode=0
M$4154 VDD \$426 \$361 VDD sg13_lv_pmos L=0.13u W=2.24u AS=0.4142p AD=0.4211p
+ PS=3.03u PD=3u rfmode=0
M$4156 \$359 \$360 \$426 VDD sg13_lv_pmos L=0.13u W=1u AS=0.34p AD=0.19115p
+ PS=2.68u PD=1.565u rfmode=0
M$4157 VDD \$362 \$427 VDD sg13_lv_pmos L=0.13u W=2.24u AS=0.5964p AD=0.5964p
+ PS=4.425u PD=4.425u rfmode=0
M$4159 VDD \$364 \$430 VDD sg13_lv_pmos L=0.13u W=2.24u AS=0.616p AD=0.4312p
+ PS=4.46u PD=3.01u rfmode=0
M$4161 VDD \$320 \$430 VDD sg13_lv_pmos L=0.13u W=2.24u AS=0.4312p AD=0.6048p
+ PS=3.01u PD=4.44u rfmode=0
M$4163 \$179 VDD VDD VDD sg13_lv_pmos L=0.13u W=0.42u AS=0.147p AD=0.1563p
+ PS=1.54u PD=1.22u rfmode=0
M$4164 VDD \$33 \$229 VDD sg13_lv_pmos L=0.13u W=0.42u AS=0.1563p AD=0.0546p
+ PS=1.22u PD=0.68u rfmode=0
M$4165 \$229 \$34 \$179 VDD sg13_lv_pmos L=0.13u W=0.42u AS=0.0546p AD=0.0798p
+ PS=0.68u PD=0.8u rfmode=0
M$4166 \$179 \$206 \$101 VDD sg13_lv_pmos L=0.13u W=0.42u AS=0.0798p AD=0.1428p
+ PS=0.8u PD=1.52u rfmode=0
M$4167 \$432 \$366 VDD VDD sg13_lv_pmos L=0.13u W=1.12u AS=0.3864p AD=0.431025p
+ PS=2.93u PD=2.145u rfmode=0
M$4168 VDD CLK \$366 VDD sg13_lv_pmos L=0.13u W=1.12u AS=0.431025p AD=0.3808p
+ PS=2.145u PD=2.92u rfmode=0
M$4169 \$434 \$432 \$565 VDD sg13_lv_pmos L=0.13u W=0.42u AS=0.19115p
+ AD=0.0525p PS=1.565u PD=0.67u rfmode=0
M$4170 \$565 \$507 VDD VDD sg13_lv_pmos L=0.13u W=0.42u AS=0.0525p AD=0.25605p
+ PS=0.67u PD=1.935u rfmode=0
M$4171 VDD VDD \$507 VDD sg13_lv_pmos L=0.13u W=0.42u AS=0.25605p AD=0.0798p
+ PS=1.935u PD=0.8u rfmode=0
M$4172 VDD \$434 \$507 VDD sg13_lv_pmos L=0.13u W=0.42u AS=0.2014p AD=0.0798p
+ PS=1.53u PD=0.8u rfmode=0
M$4173 VDD \$434 \$368 VDD sg13_lv_pmos L=0.13u W=1u AS=0.2083p AD=0.34p
+ PS=1.5u PD=2.68u rfmode=0
M$4174 VDD \$434 \$367 VDD sg13_lv_pmos L=0.13u W=2.24u AS=0.4142p AD=0.4211p
+ PS=3.03u PD=3u rfmode=0
M$4176 \$365 \$366 \$434 VDD sg13_lv_pmos L=0.13u W=1u AS=0.34p AD=0.19115p
+ PS=2.68u PD=1.565u rfmode=0
M$4177 VDD \$368 \$435 VDD sg13_lv_pmos L=0.13u W=2.24u AS=0.5964p AD=0.5964p
+ PS=4.425u PD=4.425u rfmode=0
M$4179 VDD \$370 \$438 VDD sg13_lv_pmos L=0.13u W=2.24u AS=0.616p AD=0.4312p
+ PS=4.46u PD=3.01u rfmode=0
M$4181 VDD \$320 \$438 VDD sg13_lv_pmos L=0.13u W=2.24u AS=0.4312p AD=0.6048p
+ PS=3.01u PD=4.44u rfmode=0
M$4183 \$181 VDD VDD VDD sg13_lv_pmos L=0.13u W=0.42u AS=0.147p AD=0.1563p
+ PS=1.54u PD=1.22u rfmode=0
M$4184 VDD \$37 \$215 VDD sg13_lv_pmos L=0.13u W=0.42u AS=0.1563p AD=0.0546p
+ PS=1.22u PD=0.68u rfmode=0
M$4185 \$215 \$38 \$181 VDD sg13_lv_pmos L=0.13u W=0.42u AS=0.0546p AD=0.0798p
+ PS=0.68u PD=0.8u rfmode=0
M$4186 \$181 \$208 \$111 VDD sg13_lv_pmos L=0.13u W=0.42u AS=0.0798p AD=0.1428p
+ PS=0.8u PD=1.52u rfmode=0
M$4187 \$441 \$372 VDD VDD sg13_lv_pmos L=0.13u W=1.12u AS=0.3864p AD=0.431025p
+ PS=2.93u PD=2.145u rfmode=0
M$4188 VDD CLK \$372 VDD sg13_lv_pmos L=0.13u W=1.12u AS=0.431025p AD=0.3808p
+ PS=2.145u PD=2.92u rfmode=0
M$4189 \$443 \$441 \$537 VDD sg13_lv_pmos L=0.13u W=0.42u AS=0.19115p
+ AD=0.0525p PS=1.565u PD=0.67u rfmode=0
M$4190 \$537 \$509 VDD VDD sg13_lv_pmos L=0.13u W=0.42u AS=0.0525p AD=0.25605p
+ PS=0.67u PD=1.935u rfmode=0
M$4191 VDD VDD \$509 VDD sg13_lv_pmos L=0.13u W=0.42u AS=0.25605p AD=0.0798p
+ PS=1.935u PD=0.8u rfmode=0
M$4192 VDD \$443 \$509 VDD sg13_lv_pmos L=0.13u W=0.42u AS=0.2014p AD=0.0798p
+ PS=1.53u PD=0.8u rfmode=0
M$4193 VDD \$443 \$374 VDD sg13_lv_pmos L=0.13u W=1u AS=0.2083p AD=0.34p
+ PS=1.5u PD=2.68u rfmode=0
M$4194 VDD \$443 \$373 VDD sg13_lv_pmos L=0.13u W=2.24u AS=0.4142p AD=0.4211p
+ PS=3.03u PD=3u rfmode=0
M$4196 \$371 \$372 \$443 VDD sg13_lv_pmos L=0.13u W=1u AS=0.34p AD=0.19115p
+ PS=2.68u PD=1.565u rfmode=0
M$4197 VDD \$374 \$444 VDD sg13_lv_pmos L=0.13u W=2.24u AS=0.5964p AD=0.5964p
+ PS=4.425u PD=4.425u rfmode=0
M$4199 VDD X8 \$568 VDD sg13_lv_pmos L=0.13u W=0.84u AS=0.2856p AD=0.1596p
+ PS=2.36u PD=1.22u rfmode=0
M$4200 VDD X9 \$568 VDD sg13_lv_pmos L=0.13u W=0.84u AS=0.1918p AD=0.1596p
+ PS=1.5u PD=1.22u rfmode=0
M$4201 VDD \$568 \$569 VDD sg13_lv_pmos L=0.13u W=2.24u AS=0.4046p AD=0.6384p
+ PS=3u PD=4.5u rfmode=0
M$4203 VDD X10 \$570 VDD sg13_lv_pmos L=0.13u W=0.84u AS=0.2856p AD=0.1596p
+ PS=2.36u PD=1.22u rfmode=0
M$4204 VDD \$569 \$570 VDD sg13_lv_pmos L=0.13u W=0.84u AS=0.1918p AD=0.1596p
+ PS=1.5u PD=1.22u rfmode=0
M$4205 VDD \$570 \$571 VDD sg13_lv_pmos L=0.13u W=2.24u AS=0.4046p AD=0.6384p
+ PS=3u PD=4.5u rfmode=0
M$4207 \$327 \$187 \$521 VDD sg13_lv_pmos L=0.13u W=0.84u AS=0.2856p AD=0.1596p
+ PS=2.36u PD=1.22u rfmode=0
M$4208 VDD \$318 \$521 VDD sg13_lv_pmos L=0.13u W=0.84u AS=0.2226p AD=0.1596p
+ PS=1.535u PD=1.22u rfmode=0
M$4209 VDD \$327 \$328 VDD sg13_lv_pmos L=0.13u W=2.24u AS=0.4746p AD=0.6776p
+ PS=3.105u PD=4.57u rfmode=0
M$4211 VDD \$376 \$377 VDD sg13_lv_pmos L=0.13u W=0.42u AS=0.1428p AD=0.0798p
+ PS=1.52u PD=0.8u rfmode=0
M$4212 VDD VDD \$377 VDD sg13_lv_pmos L=0.13u W=0.42u AS=0.3623875p AD=0.0798p
+ PS=2.605u PD=0.8u rfmode=0
M$4213 VDD \$494 \$329 VDD sg13_lv_pmos L=0.13u W=1u AS=0.3623875p AD=0.34p
+ PS=2.605u PD=2.68u rfmode=0
M$4214 \$494 VDD VDD VDD sg13_lv_pmos L=0.13u W=0.42u AS=0.147p AD=0.1563p
+ PS=1.54u PD=1.22u rfmode=0
M$4215 VDD \$329 \$522 VDD sg13_lv_pmos L=0.13u W=0.42u AS=0.1563p AD=0.0546p
+ PS=1.22u PD=0.68u rfmode=0
M$4216 \$522 \$330 \$494 VDD sg13_lv_pmos L=0.13u W=0.42u AS=0.0546p AD=0.0798p
+ PS=0.68u PD=0.8u rfmode=0
M$4217 \$494 \$379 \$377 VDD sg13_lv_pmos L=0.13u W=0.42u AS=0.0798p AD=0.1428p
+ PS=0.8u PD=1.52u rfmode=0
M$4218 \$798 \$625 VDD VDD sg13_lv_pmos L=0.13u W=1.12u AS=0.3864p AD=0.431025p
+ PS=2.93u PD=2.145u rfmode=0
M$4219 VDD CLK \$625 VDD sg13_lv_pmos L=0.13u W=1.12u AS=0.431025p AD=0.3808p
+ PS=2.145u PD=2.92u rfmode=0
M$4220 \$333 \$190 \$528 VDD sg13_lv_pmos L=0.13u W=0.84u AS=0.2856p AD=0.1596p
+ PS=2.36u PD=1.22u rfmode=0
M$4221 VDD \$318 \$528 VDD sg13_lv_pmos L=0.13u W=0.84u AS=0.2226p AD=0.1596p
+ PS=1.535u PD=1.22u rfmode=0
M$4222 VDD \$333 \$334 VDD sg13_lv_pmos L=0.13u W=2.24u AS=0.4746p AD=0.6776p
+ PS=3.105u PD=4.57u rfmode=0
M$4224 VDD \$385 \$386 VDD sg13_lv_pmos L=0.13u W=0.42u AS=0.1428p AD=0.0798p
+ PS=1.52u PD=0.8u rfmode=0
M$4225 VDD VDD \$386 VDD sg13_lv_pmos L=0.13u W=0.42u AS=0.3623875p AD=0.0798p
+ PS=2.605u PD=0.8u rfmode=0
M$4226 VDD \$496 \$335 VDD sg13_lv_pmos L=0.13u W=1u AS=0.3623875p AD=0.34p
+ PS=2.605u PD=2.68u rfmode=0
M$4227 \$496 VDD VDD VDD sg13_lv_pmos L=0.13u W=0.42u AS=0.147p AD=0.1563p
+ PS=1.54u PD=1.22u rfmode=0
M$4228 VDD \$335 \$530 VDD sg13_lv_pmos L=0.13u W=0.42u AS=0.1563p AD=0.0546p
+ PS=1.22u PD=0.68u rfmode=0
M$4229 \$530 \$336 \$496 VDD sg13_lv_pmos L=0.13u W=0.42u AS=0.0546p AD=0.0798p
+ PS=0.68u PD=0.8u rfmode=0
M$4230 \$496 \$388 \$386 VDD sg13_lv_pmos L=0.13u W=0.42u AS=0.0798p AD=0.1428p
+ PS=0.8u PD=1.52u rfmode=0
M$4231 \$800 \$629 VDD VDD sg13_lv_pmos L=0.13u W=1.12u AS=0.3864p AD=0.431025p
+ PS=2.93u PD=2.145u rfmode=0
M$4232 VDD CLK \$629 VDD sg13_lv_pmos L=0.13u W=1.12u AS=0.431025p AD=0.3808p
+ PS=2.145u PD=2.92u rfmode=0
M$4233 \$339 \$193 \$535 VDD sg13_lv_pmos L=0.13u W=0.84u AS=0.2856p AD=0.1596p
+ PS=2.36u PD=1.22u rfmode=0
M$4234 VDD \$318 \$535 VDD sg13_lv_pmos L=0.13u W=0.84u AS=0.2226p AD=0.1596p
+ PS=1.535u PD=1.22u rfmode=0
M$4235 VDD \$339 \$340 VDD sg13_lv_pmos L=0.13u W=2.24u AS=0.4746p AD=0.6776p
+ PS=3.105u PD=4.57u rfmode=0
M$4237 VDD \$394 \$395 VDD sg13_lv_pmos L=0.13u W=0.42u AS=0.1428p AD=0.0798p
+ PS=1.52u PD=0.8u rfmode=0
M$4238 VDD VDD \$395 VDD sg13_lv_pmos L=0.13u W=0.42u AS=0.3623875p AD=0.0798p
+ PS=2.605u PD=0.8u rfmode=0
M$4239 VDD \$498 \$341 VDD sg13_lv_pmos L=0.13u W=1u AS=0.3623875p AD=0.34p
+ PS=2.605u PD=2.68u rfmode=0
M$4240 \$498 VDD VDD VDD sg13_lv_pmos L=0.13u W=0.42u AS=0.147p AD=0.1563p
+ PS=1.54u PD=1.22u rfmode=0
M$4241 VDD \$341 \$536 VDD sg13_lv_pmos L=0.13u W=0.42u AS=0.1563p AD=0.0546p
+ PS=1.22u PD=0.68u rfmode=0
M$4242 \$536 \$342 \$498 VDD sg13_lv_pmos L=0.13u W=0.42u AS=0.0546p AD=0.0798p
+ PS=0.68u PD=0.8u rfmode=0
M$4243 \$498 \$397 \$395 VDD sg13_lv_pmos L=0.13u W=0.42u AS=0.0798p AD=0.1428p
+ PS=0.8u PD=1.52u rfmode=0
M$4244 \$802 \$633 VDD VDD sg13_lv_pmos L=0.13u W=1.12u AS=0.3864p AD=0.431025p
+ PS=2.93u PD=2.145u rfmode=0
M$4245 VDD CLK \$633 VDD sg13_lv_pmos L=0.13u W=1.12u AS=0.431025p AD=0.3808p
+ PS=2.145u PD=2.92u rfmode=0
M$4246 \$345 \$196 \$542 VDD sg13_lv_pmos L=0.13u W=0.84u AS=0.2856p AD=0.1596p
+ PS=2.36u PD=1.22u rfmode=0
M$4247 VDD \$318 \$542 VDD sg13_lv_pmos L=0.13u W=0.84u AS=0.2226p AD=0.1596p
+ PS=1.535u PD=1.22u rfmode=0
M$4248 VDD \$345 \$346 VDD sg13_lv_pmos L=0.13u W=2.24u AS=0.4746p AD=0.6776p
+ PS=3.105u PD=4.57u rfmode=0
M$4250 VDD \$403 \$404 VDD sg13_lv_pmos L=0.13u W=0.42u AS=0.1428p AD=0.0798p
+ PS=1.52u PD=0.8u rfmode=0
M$4251 VDD VDD \$404 VDD sg13_lv_pmos L=0.13u W=0.42u AS=0.3623875p AD=0.0798p
+ PS=2.605u PD=0.8u rfmode=0
M$4252 VDD \$500 \$347 VDD sg13_lv_pmos L=0.13u W=1u AS=0.3623875p AD=0.34p
+ PS=2.605u PD=2.68u rfmode=0
M$4253 \$500 VDD VDD VDD sg13_lv_pmos L=0.13u W=0.42u AS=0.147p AD=0.1563p
+ PS=1.54u PD=1.22u rfmode=0
M$4254 VDD \$347 \$543 VDD sg13_lv_pmos L=0.13u W=0.42u AS=0.1563p AD=0.0546p
+ PS=1.22u PD=0.68u rfmode=0
M$4255 \$543 \$348 \$500 VDD sg13_lv_pmos L=0.13u W=0.42u AS=0.0546p AD=0.0798p
+ PS=0.68u PD=0.8u rfmode=0
M$4256 \$500 \$406 \$404 VDD sg13_lv_pmos L=0.13u W=0.42u AS=0.0798p AD=0.1428p
+ PS=0.8u PD=1.52u rfmode=0
M$4257 \$804 \$637 VDD VDD sg13_lv_pmos L=0.13u W=1.12u AS=0.3864p AD=0.431025p
+ PS=2.93u PD=2.145u rfmode=0
M$4258 VDD CLK \$637 VDD sg13_lv_pmos L=0.13u W=1.12u AS=0.431025p AD=0.3808p
+ PS=2.145u PD=2.92u rfmode=0
M$4259 \$351 \$199 \$549 VDD sg13_lv_pmos L=0.13u W=0.84u AS=0.2856p AD=0.1596p
+ PS=2.36u PD=1.22u rfmode=0
M$4260 VDD \$318 \$549 VDD sg13_lv_pmos L=0.13u W=0.84u AS=0.2226p AD=0.1596p
+ PS=1.535u PD=1.22u rfmode=0
M$4261 VDD \$351 \$352 VDD sg13_lv_pmos L=0.13u W=2.24u AS=0.4746p AD=0.6776p
+ PS=3.105u PD=4.57u rfmode=0
M$4263 VDD \$412 \$413 VDD sg13_lv_pmos L=0.13u W=0.42u AS=0.1428p AD=0.0798p
+ PS=1.52u PD=0.8u rfmode=0
M$4264 VDD VDD \$413 VDD sg13_lv_pmos L=0.13u W=0.42u AS=0.3623875p AD=0.0798p
+ PS=2.605u PD=0.8u rfmode=0
M$4265 VDD \$502 \$353 VDD sg13_lv_pmos L=0.13u W=1u AS=0.3623875p AD=0.34p
+ PS=2.605u PD=2.68u rfmode=0
M$4266 \$502 VDD VDD VDD sg13_lv_pmos L=0.13u W=0.42u AS=0.147p AD=0.1563p
+ PS=1.54u PD=1.22u rfmode=0
M$4267 VDD \$353 \$550 VDD sg13_lv_pmos L=0.13u W=0.42u AS=0.1563p AD=0.0546p
+ PS=1.22u PD=0.68u rfmode=0
M$4268 \$550 \$354 \$502 VDD sg13_lv_pmos L=0.13u W=0.42u AS=0.0546p AD=0.0798p
+ PS=0.68u PD=0.8u rfmode=0
M$4269 \$502 \$415 \$413 VDD sg13_lv_pmos L=0.13u W=0.42u AS=0.0798p AD=0.1428p
+ PS=0.8u PD=1.52u rfmode=0
M$4270 \$806 \$641 VDD VDD sg13_lv_pmos L=0.13u W=1.12u AS=0.3864p AD=0.431025p
+ PS=2.93u PD=2.145u rfmode=0
M$4271 VDD CLK \$641 VDD sg13_lv_pmos L=0.13u W=1.12u AS=0.431025p AD=0.3808p
+ PS=2.145u PD=2.92u rfmode=0
M$4272 \$357 \$202 \$555 VDD sg13_lv_pmos L=0.13u W=0.84u AS=0.2856p AD=0.1596p
+ PS=2.36u PD=1.22u rfmode=0
M$4273 VDD \$318 \$555 VDD sg13_lv_pmos L=0.13u W=0.84u AS=0.2226p AD=0.1596p
+ PS=1.535u PD=1.22u rfmode=0
M$4274 VDD \$357 \$358 VDD sg13_lv_pmos L=0.13u W=2.24u AS=0.4746p AD=0.6776p
+ PS=3.105u PD=4.57u rfmode=0
M$4276 VDD \$421 \$422 VDD sg13_lv_pmos L=0.13u W=0.42u AS=0.1428p AD=0.0798p
+ PS=1.52u PD=0.8u rfmode=0
M$4277 VDD VDD \$422 VDD sg13_lv_pmos L=0.13u W=0.42u AS=0.3623875p AD=0.0798p
+ PS=2.605u PD=0.8u rfmode=0
M$4278 VDD \$504 \$359 VDD sg13_lv_pmos L=0.13u W=1u AS=0.3623875p AD=0.34p
+ PS=2.605u PD=2.68u rfmode=0
M$4279 \$504 VDD VDD VDD sg13_lv_pmos L=0.13u W=0.42u AS=0.147p AD=0.1563p
+ PS=1.54u PD=1.22u rfmode=0
M$4280 VDD \$359 \$556 VDD sg13_lv_pmos L=0.13u W=0.42u AS=0.1563p AD=0.0546p
+ PS=1.22u PD=0.68u rfmode=0
M$4281 \$556 \$360 \$504 VDD sg13_lv_pmos L=0.13u W=0.42u AS=0.0546p AD=0.0798p
+ PS=0.68u PD=0.8u rfmode=0
M$4282 \$504 \$424 \$422 VDD sg13_lv_pmos L=0.13u W=0.42u AS=0.0798p AD=0.1428p
+ PS=0.8u PD=1.52u rfmode=0
M$4283 \$808 \$645 VDD VDD sg13_lv_pmos L=0.13u W=1.12u AS=0.3864p AD=0.431025p
+ PS=2.93u PD=2.145u rfmode=0
M$4284 VDD CLK \$645 VDD sg13_lv_pmos L=0.13u W=1.12u AS=0.431025p AD=0.3808p
+ PS=2.145u PD=2.92u rfmode=0
M$4285 \$363 \$205 \$562 VDD sg13_lv_pmos L=0.13u W=0.84u AS=0.2856p AD=0.1596p
+ PS=2.36u PD=1.22u rfmode=0
M$4286 VDD \$318 \$562 VDD sg13_lv_pmos L=0.13u W=0.84u AS=0.2226p AD=0.1596p
+ PS=1.535u PD=1.22u rfmode=0
M$4287 VDD \$363 \$364 VDD sg13_lv_pmos L=0.13u W=2.24u AS=0.4746p AD=0.6776p
+ PS=3.105u PD=4.57u rfmode=0
M$4289 VDD \$430 \$517 VDD sg13_lv_pmos L=0.13u W=0.42u AS=0.1428p AD=0.0798p
+ PS=1.52u PD=0.8u rfmode=0
M$4290 VDD VDD \$517 VDD sg13_lv_pmos L=0.13u W=0.42u AS=0.3623875p AD=0.0798p
+ PS=2.605u PD=0.8u rfmode=0
M$4291 VDD \$506 \$365 VDD sg13_lv_pmos L=0.13u W=1u AS=0.3623875p AD=0.34p
+ PS=2.605u PD=2.68u rfmode=0
M$4292 \$506 VDD VDD VDD sg13_lv_pmos L=0.13u W=0.42u AS=0.147p AD=0.1563p
+ PS=1.54u PD=1.22u rfmode=0
M$4293 VDD \$365 \$564 VDD sg13_lv_pmos L=0.13u W=0.42u AS=0.1563p AD=0.0546p
+ PS=1.22u PD=0.68u rfmode=0
M$4294 \$564 \$366 \$506 VDD sg13_lv_pmos L=0.13u W=0.42u AS=0.0546p AD=0.0798p
+ PS=0.68u PD=0.8u rfmode=0
M$4295 \$506 \$432 \$517 VDD sg13_lv_pmos L=0.13u W=0.42u AS=0.0798p AD=0.1428p
+ PS=0.8u PD=1.52u rfmode=0
M$4296 \$810 \$649 VDD VDD sg13_lv_pmos L=0.13u W=1.12u AS=0.3864p AD=0.431025p
+ PS=2.93u PD=2.145u rfmode=0
M$4297 VDD CLK \$649 VDD sg13_lv_pmos L=0.13u W=1.12u AS=0.431025p AD=0.3808p
+ PS=2.145u PD=2.92u rfmode=0
M$4298 \$369 VSS \$558 VDD sg13_lv_pmos L=0.13u W=0.84u AS=0.2856p AD=0.1596p
+ PS=2.36u PD=1.22u rfmode=0
M$4299 VDD \$318 \$558 VDD sg13_lv_pmos L=0.13u W=0.84u AS=0.2226p AD=0.1596p
+ PS=1.535u PD=1.22u rfmode=0
M$4300 VDD \$369 \$370 VDD sg13_lv_pmos L=0.13u W=2.24u AS=0.4746p AD=0.6776p
+ PS=3.105u PD=4.57u rfmode=0
M$4302 VDD \$438 \$439 VDD sg13_lv_pmos L=0.13u W=0.42u AS=0.1428p AD=0.0798p
+ PS=1.52u PD=0.8u rfmode=0
M$4303 VDD VDD \$439 VDD sg13_lv_pmos L=0.13u W=0.42u AS=0.3623875p AD=0.0798p
+ PS=2.605u PD=0.8u rfmode=0
M$4304 VDD \$508 \$371 VDD sg13_lv_pmos L=0.13u W=1u AS=0.3623875p AD=0.34p
+ PS=2.605u PD=2.68u rfmode=0
M$4305 \$508 VDD VDD VDD sg13_lv_pmos L=0.13u W=0.42u AS=0.147p AD=0.1563p
+ PS=1.54u PD=1.22u rfmode=0
M$4306 VDD \$371 \$547 VDD sg13_lv_pmos L=0.13u W=0.42u AS=0.1563p AD=0.0546p
+ PS=1.22u PD=0.68u rfmode=0
M$4307 \$547 \$372 \$508 VDD sg13_lv_pmos L=0.13u W=0.42u AS=0.0546p AD=0.0798p
+ PS=0.68u PD=0.8u rfmode=0
M$4308 \$508 \$441 \$439 VDD sg13_lv_pmos L=0.13u W=0.42u AS=0.0798p AD=0.1428p
+ PS=0.8u PD=1.52u rfmode=0
M$4309 \$812 \$653 VDD VDD sg13_lv_pmos L=0.13u W=1.12u AS=0.3864p AD=0.431025p
+ PS=2.93u PD=2.145u rfmode=0
M$4310 VDD CLK \$653 VDD sg13_lv_pmos L=0.13u W=1.12u AS=0.431025p AD=0.3808p
+ PS=2.145u PD=2.92u rfmode=0
M$4311 VDD \$623 \$655 VDD sg13_lv_pmos L=0.13u W=2.24u AS=0.616p AD=0.4312p
+ PS=4.46u PD=3.01u rfmode=0
M$4313 VDD \$318 \$655 VDD sg13_lv_pmos L=0.13u W=2.24u AS=0.4312p AD=0.6048p
+ PS=3.01u PD=4.44u rfmode=0
M$4315 VDD \$661 \$662 VDD sg13_lv_pmos L=0.13u W=2.24u AS=0.5964p AD=0.5964p
+ PS=4.425u PD=4.425u rfmode=0
M$4317 VDD \$627 \$665 VDD sg13_lv_pmos L=0.13u W=2.24u AS=0.616p AD=0.4312p
+ PS=4.46u PD=3.01u rfmode=0
M$4319 VDD \$318 \$665 VDD sg13_lv_pmos L=0.13u W=2.24u AS=0.4312p AD=0.6048p
+ PS=3.01u PD=4.44u rfmode=0
M$4321 VDD \$671 \$672 VDD sg13_lv_pmos L=0.13u W=2.24u AS=0.5964p AD=0.5964p
+ PS=4.425u PD=4.425u rfmode=0
M$4323 VDD \$631 \$675 VDD sg13_lv_pmos L=0.13u W=2.24u AS=0.616p AD=0.4312p
+ PS=4.46u PD=3.01u rfmode=0
M$4325 VDD \$318 \$675 VDD sg13_lv_pmos L=0.13u W=2.24u AS=0.4312p AD=0.6048p
+ PS=3.01u PD=4.44u rfmode=0
M$4327 VDD \$681 \$682 VDD sg13_lv_pmos L=0.13u W=2.24u AS=0.5964p AD=0.5964p
+ PS=4.425u PD=4.425u rfmode=0
M$4329 VDD \$635 \$685 VDD sg13_lv_pmos L=0.13u W=2.24u AS=0.616p AD=0.4312p
+ PS=4.46u PD=3.01u rfmode=0
M$4331 VDD \$318 \$685 VDD sg13_lv_pmos L=0.13u W=2.24u AS=0.4312p AD=0.6048p
+ PS=3.01u PD=4.44u rfmode=0
M$4333 VDD \$691 \$692 VDD sg13_lv_pmos L=0.13u W=2.24u AS=0.5964p AD=0.5964p
+ PS=4.425u PD=4.425u rfmode=0
M$4335 VDD \$639 \$695 VDD sg13_lv_pmos L=0.13u W=2.24u AS=0.616p AD=0.4312p
+ PS=4.46u PD=3.01u rfmode=0
M$4337 VDD \$318 \$695 VDD sg13_lv_pmos L=0.13u W=2.24u AS=0.4312p AD=0.6048p
+ PS=3.01u PD=4.44u rfmode=0
M$4339 VDD \$701 \$702 VDD sg13_lv_pmos L=0.13u W=2.24u AS=0.5964p AD=0.5964p
+ PS=4.425u PD=4.425u rfmode=0
M$4341 VDD \$643 \$705 VDD sg13_lv_pmos L=0.13u W=2.24u AS=0.616p AD=0.4312p
+ PS=4.46u PD=3.01u rfmode=0
M$4343 VDD \$318 \$705 VDD sg13_lv_pmos L=0.13u W=2.24u AS=0.4312p AD=0.6048p
+ PS=3.01u PD=4.44u rfmode=0
M$4345 VDD \$711 \$712 VDD sg13_lv_pmos L=0.13u W=2.24u AS=0.5964p AD=0.5964p
+ PS=4.425u PD=4.425u rfmode=0
M$4347 VDD \$647 \$715 VDD sg13_lv_pmos L=0.13u W=2.24u AS=0.616p AD=0.4312p
+ PS=4.46u PD=3.01u rfmode=0
M$4349 VDD \$318 \$715 VDD sg13_lv_pmos L=0.13u W=2.24u AS=0.4312p AD=0.6048p
+ PS=3.01u PD=4.44u rfmode=0
M$4351 VDD \$721 \$722 VDD sg13_lv_pmos L=0.13u W=2.24u AS=0.5964p AD=0.5964p
+ PS=4.425u PD=4.425u rfmode=0
M$4353 VDD \$651 \$725 VDD sg13_lv_pmos L=0.13u W=2.24u AS=0.616p AD=0.4312p
+ PS=4.46u PD=3.01u rfmode=0
M$4355 VDD \$318 \$725 VDD sg13_lv_pmos L=0.13u W=2.24u AS=0.4312p AD=0.6048p
+ PS=3.01u PD=4.44u rfmode=0
M$4357 VDD \$731 \$732 VDD sg13_lv_pmos L=0.13u W=2.24u AS=0.5964p AD=0.5964p
+ PS=4.425u PD=4.425u rfmode=0
M$4359 \$622 \$187 \$854 VDD sg13_lv_pmos L=0.13u W=0.84u AS=0.2856p AD=0.1596p
+ PS=2.36u PD=1.22u rfmode=0
M$4360 VDD \$186 \$854 VDD sg13_lv_pmos L=0.13u W=0.84u AS=0.2226p AD=0.1596p
+ PS=1.535u PD=1.22u rfmode=0
M$4361 VDD \$622 \$623 VDD sg13_lv_pmos L=0.13u W=2.24u AS=0.4746p AD=0.6776p
+ PS=3.105u PD=4.57u rfmode=0
M$4363 VDD \$655 \$656 VDD sg13_lv_pmos L=0.13u W=0.42u AS=0.1428p AD=0.0798p
+ PS=1.52u PD=0.8u rfmode=0
M$4364 VDD VDD \$656 VDD sg13_lv_pmos L=0.13u W=0.42u AS=0.3623875p AD=0.0798p
+ PS=2.605u PD=0.8u rfmode=0
M$4365 VDD \$782 \$624 VDD sg13_lv_pmos L=0.13u W=1u AS=0.3623875p AD=0.34p
+ PS=2.605u PD=2.68u rfmode=0
M$4366 \$659 \$798 \$818 VDD sg13_lv_pmos L=0.13u W=0.42u AS=0.19115p
+ AD=0.0525p PS=1.565u PD=0.67u rfmode=0
M$4367 \$818 \$783 VDD VDD sg13_lv_pmos L=0.13u W=0.42u AS=0.0525p AD=0.25605p
+ PS=0.67u PD=1.935u rfmode=0
M$4368 VDD VDD \$783 VDD sg13_lv_pmos L=0.13u W=0.42u AS=0.25605p AD=0.0798p
+ PS=1.935u PD=0.8u rfmode=0
M$4369 VDD \$659 \$783 VDD sg13_lv_pmos L=0.13u W=0.42u AS=0.2014p AD=0.0798p
+ PS=1.53u PD=0.8u rfmode=0
M$4370 VDD \$659 \$661 VDD sg13_lv_pmos L=0.13u W=1u AS=0.2083p AD=0.34p
+ PS=1.5u PD=2.68u rfmode=0
M$4371 VDD \$659 \$660 VDD sg13_lv_pmos L=0.13u W=2.24u AS=0.4142p AD=0.4211p
+ PS=3.03u PD=3u rfmode=0
M$4373 \$624 \$625 \$659 VDD sg13_lv_pmos L=0.13u W=1u AS=0.34p AD=0.19115p
+ PS=2.68u PD=1.565u rfmode=0
M$4374 \$626 \$190 \$855 VDD sg13_lv_pmos L=0.13u W=0.84u AS=0.2856p AD=0.1596p
+ PS=2.36u PD=1.22u rfmode=0
M$4375 VDD \$186 \$855 VDD sg13_lv_pmos L=0.13u W=0.84u AS=0.2226p AD=0.1596p
+ PS=1.535u PD=1.22u rfmode=0
M$4376 VDD \$626 \$627 VDD sg13_lv_pmos L=0.13u W=2.24u AS=0.4746p AD=0.6776p
+ PS=3.105u PD=4.57u rfmode=0
M$4378 VDD \$665 \$666 VDD sg13_lv_pmos L=0.13u W=0.42u AS=0.1428p AD=0.0798p
+ PS=1.52u PD=0.8u rfmode=0
M$4379 VDD VDD \$666 VDD sg13_lv_pmos L=0.13u W=0.42u AS=0.3623875p AD=0.0798p
+ PS=2.605u PD=0.8u rfmode=0
M$4380 VDD \$784 \$628 VDD sg13_lv_pmos L=0.13u W=1u AS=0.3623875p AD=0.34p
+ PS=2.605u PD=2.68u rfmode=0
M$4381 \$669 \$800 \$826 VDD sg13_lv_pmos L=0.13u W=0.42u AS=0.19115p
+ AD=0.0525p PS=1.565u PD=0.67u rfmode=0
M$4382 \$826 \$785 VDD VDD sg13_lv_pmos L=0.13u W=0.42u AS=0.0525p AD=0.25605p
+ PS=0.67u PD=1.935u rfmode=0
M$4383 VDD VDD \$785 VDD sg13_lv_pmos L=0.13u W=0.42u AS=0.25605p AD=0.0798p
+ PS=1.935u PD=0.8u rfmode=0
M$4384 VDD \$669 \$785 VDD sg13_lv_pmos L=0.13u W=0.42u AS=0.2014p AD=0.0798p
+ PS=1.53u PD=0.8u rfmode=0
M$4385 VDD \$669 \$671 VDD sg13_lv_pmos L=0.13u W=1u AS=0.2083p AD=0.34p
+ PS=1.5u PD=2.68u rfmode=0
M$4386 VDD \$669 \$670 VDD sg13_lv_pmos L=0.13u W=2.24u AS=0.4142p AD=0.4211p
+ PS=3.03u PD=3u rfmode=0
M$4388 \$628 \$629 \$669 VDD sg13_lv_pmos L=0.13u W=1u AS=0.34p AD=0.19115p
+ PS=2.68u PD=1.565u rfmode=0
M$4389 \$630 \$193 \$856 VDD sg13_lv_pmos L=0.13u W=0.84u AS=0.2856p AD=0.1596p
+ PS=2.36u PD=1.22u rfmode=0
M$4390 VDD \$186 \$856 VDD sg13_lv_pmos L=0.13u W=0.84u AS=0.2226p AD=0.1596p
+ PS=1.535u PD=1.22u rfmode=0
M$4391 VDD \$630 \$631 VDD sg13_lv_pmos L=0.13u W=2.24u AS=0.4746p AD=0.6776p
+ PS=3.105u PD=4.57u rfmode=0
M$4393 VDD \$675 \$676 VDD sg13_lv_pmos L=0.13u W=0.42u AS=0.1428p AD=0.0798p
+ PS=1.52u PD=0.8u rfmode=0
M$4394 VDD VDD \$676 VDD sg13_lv_pmos L=0.13u W=0.42u AS=0.3623875p AD=0.0798p
+ PS=2.605u PD=0.8u rfmode=0
M$4395 VDD \$786 \$632 VDD sg13_lv_pmos L=0.13u W=1u AS=0.3623875p AD=0.34p
+ PS=2.605u PD=2.68u rfmode=0
M$4396 \$679 \$802 \$835 VDD sg13_lv_pmos L=0.13u W=0.42u AS=0.19115p
+ AD=0.0525p PS=1.565u PD=0.67u rfmode=0
M$4397 \$835 \$787 VDD VDD sg13_lv_pmos L=0.13u W=0.42u AS=0.0525p AD=0.25605p
+ PS=0.67u PD=1.935u rfmode=0
M$4398 VDD VDD \$787 VDD sg13_lv_pmos L=0.13u W=0.42u AS=0.25605p AD=0.0798p
+ PS=1.935u PD=0.8u rfmode=0
M$4399 VDD \$679 \$787 VDD sg13_lv_pmos L=0.13u W=0.42u AS=0.2014p AD=0.0798p
+ PS=1.53u PD=0.8u rfmode=0
M$4400 VDD \$679 \$681 VDD sg13_lv_pmos L=0.13u W=1u AS=0.2083p AD=0.34p
+ PS=1.5u PD=2.68u rfmode=0
M$4401 VDD \$679 \$680 VDD sg13_lv_pmos L=0.13u W=2.24u AS=0.4142p AD=0.4211p
+ PS=3.03u PD=3u rfmode=0
M$4403 \$632 \$633 \$679 VDD sg13_lv_pmos L=0.13u W=1u AS=0.34p AD=0.19115p
+ PS=2.68u PD=1.565u rfmode=0
M$4404 \$634 \$196 \$857 VDD sg13_lv_pmos L=0.13u W=0.84u AS=0.2856p AD=0.1596p
+ PS=2.36u PD=1.22u rfmode=0
M$4405 VDD \$186 \$857 VDD sg13_lv_pmos L=0.13u W=0.84u AS=0.2226p AD=0.1596p
+ PS=1.535u PD=1.22u rfmode=0
M$4406 VDD \$634 \$635 VDD sg13_lv_pmos L=0.13u W=2.24u AS=0.4746p AD=0.6776p
+ PS=3.105u PD=4.57u rfmode=0
M$4408 VDD \$685 \$686 VDD sg13_lv_pmos L=0.13u W=0.42u AS=0.1428p AD=0.0798p
+ PS=1.52u PD=0.8u rfmode=0
M$4409 VDD VDD \$686 VDD sg13_lv_pmos L=0.13u W=0.42u AS=0.3623875p AD=0.0798p
+ PS=2.605u PD=0.8u rfmode=0
M$4410 VDD \$788 \$636 VDD sg13_lv_pmos L=0.13u W=1u AS=0.3623875p AD=0.34p
+ PS=2.605u PD=2.68u rfmode=0
M$4411 \$689 \$804 \$844 VDD sg13_lv_pmos L=0.13u W=0.42u AS=0.19115p
+ AD=0.0525p PS=1.565u PD=0.67u rfmode=0
M$4412 \$844 \$789 VDD VDD sg13_lv_pmos L=0.13u W=0.42u AS=0.0525p AD=0.25605p
+ PS=0.67u PD=1.935u rfmode=0
M$4413 VDD VDD \$789 VDD sg13_lv_pmos L=0.13u W=0.42u AS=0.25605p AD=0.0798p
+ PS=1.935u PD=0.8u rfmode=0
M$4414 VDD \$689 \$789 VDD sg13_lv_pmos L=0.13u W=0.42u AS=0.2014p AD=0.0798p
+ PS=1.53u PD=0.8u rfmode=0
M$4415 VDD \$689 \$691 VDD sg13_lv_pmos L=0.13u W=1u AS=0.2083p AD=0.34p
+ PS=1.5u PD=2.68u rfmode=0
M$4416 VDD \$689 \$690 VDD sg13_lv_pmos L=0.13u W=2.24u AS=0.4142p AD=0.4211p
+ PS=3.03u PD=3u rfmode=0
M$4418 \$636 \$637 \$689 VDD sg13_lv_pmos L=0.13u W=1u AS=0.34p AD=0.19115p
+ PS=2.68u PD=1.565u rfmode=0
M$4419 \$638 \$199 \$859 VDD sg13_lv_pmos L=0.13u W=0.84u AS=0.2856p AD=0.1596p
+ PS=2.36u PD=1.22u rfmode=0
M$4420 VDD \$186 \$859 VDD sg13_lv_pmos L=0.13u W=0.84u AS=0.2226p AD=0.1596p
+ PS=1.535u PD=1.22u rfmode=0
M$4421 VDD \$638 \$639 VDD sg13_lv_pmos L=0.13u W=2.24u AS=0.4746p AD=0.6776p
+ PS=3.105u PD=4.57u rfmode=0
M$4423 VDD \$695 \$696 VDD sg13_lv_pmos L=0.13u W=0.42u AS=0.1428p AD=0.0798p
+ PS=1.52u PD=0.8u rfmode=0
M$4424 VDD VDD \$696 VDD sg13_lv_pmos L=0.13u W=0.42u AS=0.3623875p AD=0.0798p
+ PS=2.605u PD=0.8u rfmode=0
M$4425 VDD \$790 \$640 VDD sg13_lv_pmos L=0.13u W=1u AS=0.3623875p AD=0.34p
+ PS=2.605u PD=2.68u rfmode=0
M$4426 \$699 \$806 \$853 VDD sg13_lv_pmos L=0.13u W=0.42u AS=0.19115p
+ AD=0.0525p PS=1.565u PD=0.67u rfmode=0
M$4427 \$853 \$791 VDD VDD sg13_lv_pmos L=0.13u W=0.42u AS=0.0525p AD=0.25605p
+ PS=0.67u PD=1.935u rfmode=0
M$4428 VDD VDD \$791 VDD sg13_lv_pmos L=0.13u W=0.42u AS=0.25605p AD=0.0798p
+ PS=1.935u PD=0.8u rfmode=0
M$4429 VDD \$699 \$791 VDD sg13_lv_pmos L=0.13u W=0.42u AS=0.2014p AD=0.0798p
+ PS=1.53u PD=0.8u rfmode=0
M$4430 VDD \$699 \$701 VDD sg13_lv_pmos L=0.13u W=1u AS=0.2083p AD=0.34p
+ PS=1.5u PD=2.68u rfmode=0
M$4431 VDD \$699 \$700 VDD sg13_lv_pmos L=0.13u W=2.24u AS=0.4142p AD=0.4211p
+ PS=3.03u PD=3u rfmode=0
M$4433 \$640 \$641 \$699 VDD sg13_lv_pmos L=0.13u W=1u AS=0.34p AD=0.19115p
+ PS=2.68u PD=1.565u rfmode=0
M$4434 \$642 \$202 \$860 VDD sg13_lv_pmos L=0.13u W=0.84u AS=0.2856p AD=0.1596p
+ PS=2.36u PD=1.22u rfmode=0
M$4435 VDD \$186 \$860 VDD sg13_lv_pmos L=0.13u W=0.84u AS=0.2226p AD=0.1596p
+ PS=1.535u PD=1.22u rfmode=0
M$4436 VDD \$642 \$643 VDD sg13_lv_pmos L=0.13u W=2.24u AS=0.4746p AD=0.6776p
+ PS=3.105u PD=4.57u rfmode=0
M$4438 VDD \$705 \$706 VDD sg13_lv_pmos L=0.13u W=0.42u AS=0.1428p AD=0.0798p
+ PS=1.52u PD=0.8u rfmode=0
M$4439 VDD VDD \$706 VDD sg13_lv_pmos L=0.13u W=0.42u AS=0.3623875p AD=0.0798p
+ PS=2.605u PD=0.8u rfmode=0
M$4440 VDD \$792 \$644 VDD sg13_lv_pmos L=0.13u W=1u AS=0.3623875p AD=0.34p
+ PS=2.605u PD=2.68u rfmode=0
M$4441 \$709 \$808 \$842 VDD sg13_lv_pmos L=0.13u W=0.42u AS=0.19115p
+ AD=0.0525p PS=1.565u PD=0.67u rfmode=0
M$4442 \$842 \$793 VDD VDD sg13_lv_pmos L=0.13u W=0.42u AS=0.0525p AD=0.25605p
+ PS=0.67u PD=1.935u rfmode=0
M$4443 VDD VDD \$793 VDD sg13_lv_pmos L=0.13u W=0.42u AS=0.25605p AD=0.0798p
+ PS=1.935u PD=0.8u rfmode=0
M$4444 VDD \$709 \$793 VDD sg13_lv_pmos L=0.13u W=0.42u AS=0.2014p AD=0.0798p
+ PS=1.53u PD=0.8u rfmode=0
M$4445 VDD \$709 \$711 VDD sg13_lv_pmos L=0.13u W=1u AS=0.2083p AD=0.34p
+ PS=1.5u PD=2.68u rfmode=0
M$4446 VDD \$709 \$710 VDD sg13_lv_pmos L=0.13u W=2.24u AS=0.4142p AD=0.4211p
+ PS=3.03u PD=3u rfmode=0
M$4448 \$644 \$645 \$709 VDD sg13_lv_pmos L=0.13u W=1u AS=0.34p AD=0.19115p
+ PS=2.68u PD=1.565u rfmode=0
M$4449 \$646 \$205 \$861 VDD sg13_lv_pmos L=0.13u W=0.84u AS=0.2856p AD=0.1596p
+ PS=2.36u PD=1.22u rfmode=0
M$4450 VDD \$186 \$861 VDD sg13_lv_pmos L=0.13u W=0.84u AS=0.2226p AD=0.1596p
+ PS=1.535u PD=1.22u rfmode=0
M$4451 VDD \$646 \$647 VDD sg13_lv_pmos L=0.13u W=2.24u AS=0.4746p AD=0.6776p
+ PS=3.105u PD=4.57u rfmode=0
M$4453 VDD \$715 \$716 VDD sg13_lv_pmos L=0.13u W=0.42u AS=0.1428p AD=0.0798p
+ PS=1.52u PD=0.8u rfmode=0
M$4454 VDD VDD \$716 VDD sg13_lv_pmos L=0.13u W=0.42u AS=0.3623875p AD=0.0798p
+ PS=2.605u PD=0.8u rfmode=0
M$4455 VDD \$794 \$648 VDD sg13_lv_pmos L=0.13u W=1u AS=0.3623875p AD=0.34p
+ PS=2.605u PD=2.68u rfmode=0
M$4456 \$719 \$810 \$832 VDD sg13_lv_pmos L=0.13u W=0.42u AS=0.19115p
+ AD=0.0525p PS=1.565u PD=0.67u rfmode=0
M$4457 \$832 \$795 VDD VDD sg13_lv_pmos L=0.13u W=0.42u AS=0.0525p AD=0.25605p
+ PS=0.67u PD=1.935u rfmode=0
M$4458 VDD VDD \$795 VDD sg13_lv_pmos L=0.13u W=0.42u AS=0.25605p AD=0.0798p
+ PS=1.935u PD=0.8u rfmode=0
M$4459 VDD \$719 \$795 VDD sg13_lv_pmos L=0.13u W=0.42u AS=0.2014p AD=0.0798p
+ PS=1.53u PD=0.8u rfmode=0
M$4460 VDD \$719 \$721 VDD sg13_lv_pmos L=0.13u W=1u AS=0.2083p AD=0.34p
+ PS=1.5u PD=2.68u rfmode=0
M$4461 VDD \$719 \$720 VDD sg13_lv_pmos L=0.13u W=2.24u AS=0.4142p AD=0.4211p
+ PS=3.03u PD=3u rfmode=0
M$4463 \$648 \$649 \$719 VDD sg13_lv_pmos L=0.13u W=1u AS=0.34p AD=0.19115p
+ PS=2.68u PD=1.565u rfmode=0
M$4464 \$650 VSS \$858 VDD sg13_lv_pmos L=0.13u W=0.84u AS=0.2856p AD=0.1596p
+ PS=2.36u PD=1.22u rfmode=0
M$4465 VDD \$186 \$858 VDD sg13_lv_pmos L=0.13u W=0.84u AS=0.2226p AD=0.1596p
+ PS=1.535u PD=1.22u rfmode=0
M$4466 VDD \$650 \$651 VDD sg13_lv_pmos L=0.13u W=2.24u AS=0.4746p AD=0.6776p
+ PS=3.105u PD=4.57u rfmode=0
M$4468 VDD \$725 \$726 VDD sg13_lv_pmos L=0.13u W=0.42u AS=0.1428p AD=0.0798p
+ PS=1.52u PD=0.8u rfmode=0
M$4469 VDD VDD \$726 VDD sg13_lv_pmos L=0.13u W=0.42u AS=0.3623875p AD=0.0798p
+ PS=2.605u PD=0.8u rfmode=0
M$4470 VDD \$796 \$652 VDD sg13_lv_pmos L=0.13u W=1u AS=0.3623875p AD=0.34p
+ PS=2.605u PD=2.68u rfmode=0
M$4471 \$729 \$812 \$819 VDD sg13_lv_pmos L=0.13u W=0.42u AS=0.19115p
+ AD=0.0525p PS=1.565u PD=0.67u rfmode=0
M$4472 \$819 \$797 VDD VDD sg13_lv_pmos L=0.13u W=0.42u AS=0.0525p AD=0.25605p
+ PS=0.67u PD=1.935u rfmode=0
M$4473 VDD VDD \$797 VDD sg13_lv_pmos L=0.13u W=0.42u AS=0.25605p AD=0.0798p
+ PS=1.935u PD=0.8u rfmode=0
M$4474 VDD \$729 \$797 VDD sg13_lv_pmos L=0.13u W=0.42u AS=0.2014p AD=0.0798p
+ PS=1.53u PD=0.8u rfmode=0
M$4475 VDD \$729 \$731 VDD sg13_lv_pmos L=0.13u W=1u AS=0.2083p AD=0.34p
+ PS=1.5u PD=2.68u rfmode=0
M$4476 VDD \$729 \$730 VDD sg13_lv_pmos L=0.13u W=2.24u AS=0.4142p AD=0.4211p
+ PS=3.03u PD=3u rfmode=0
M$4478 \$652 \$653 \$729 VDD sg13_lv_pmos L=0.13u W=1u AS=0.34p AD=0.19115p
+ PS=2.68u PD=1.565u rfmode=0
M$4479 VDD \$911 \$943 VDD sg13_lv_pmos L=0.13u W=2.24u AS=0.616p AD=0.4312p
+ PS=4.46u PD=3.01u rfmode=0
M$4481 VDD \$186 \$943 VDD sg13_lv_pmos L=0.13u W=2.24u AS=0.4312p AD=0.6048p
+ PS=3.01u PD=4.44u rfmode=0
M$4483 VDD \$943 \$944 VDD sg13_lv_pmos L=0.13u W=0.42u AS=0.1428p AD=0.0798p
+ PS=1.52u PD=0.8u rfmode=0
M$4484 VDD VDD \$944 VDD sg13_lv_pmos L=0.13u W=0.42u AS=0.3623875p AD=0.0798p
+ PS=2.605u PD=0.8u rfmode=0
M$4485 VDD \$1070 \$912 VDD sg13_lv_pmos L=0.13u W=1u AS=0.3623875p AD=0.34p
+ PS=2.605u PD=2.68u rfmode=0
M$4486 \$782 VDD VDD VDD sg13_lv_pmos L=0.13u W=0.42u AS=0.147p AD=0.1563p
+ PS=1.54u PD=1.22u rfmode=0
M$4487 VDD \$624 \$817 VDD sg13_lv_pmos L=0.13u W=0.42u AS=0.1563p AD=0.0546p
+ PS=1.22u PD=0.68u rfmode=0
M$4488 \$817 \$625 \$782 VDD sg13_lv_pmos L=0.13u W=0.42u AS=0.0546p AD=0.0798p
+ PS=0.68u PD=0.8u rfmode=0
M$4489 \$782 \$798 \$656 VDD sg13_lv_pmos L=0.13u W=0.42u AS=0.0798p AD=0.1428p
+ PS=0.8u PD=1.52u rfmode=0
M$4490 \$1086 \$913 VDD VDD sg13_lv_pmos L=0.13u W=1.12u AS=0.3864p
+ AD=0.431025p PS=2.93u PD=2.145u rfmode=0
M$4491 VDD CLK \$913 VDD sg13_lv_pmos L=0.13u W=1.12u AS=0.431025p AD=0.3808p
+ PS=2.145u PD=2.92u rfmode=0
M$4492 \$947 \$1086 \$1106 VDD sg13_lv_pmos L=0.13u W=0.42u AS=0.19115p
+ AD=0.0525p PS=1.565u PD=0.67u rfmode=0
M$4493 \$1106 \$1071 VDD VDD sg13_lv_pmos L=0.13u W=0.42u AS=0.0525p
+ AD=0.25605p PS=0.67u PD=1.935u rfmode=0
M$4494 VDD VDD \$1071 VDD sg13_lv_pmos L=0.13u W=0.42u AS=0.25605p AD=0.0798p
+ PS=1.935u PD=0.8u rfmode=0
M$4495 VDD \$947 \$1071 VDD sg13_lv_pmos L=0.13u W=0.42u AS=0.2014p AD=0.0798p
+ PS=1.53u PD=0.8u rfmode=0
M$4496 VDD \$947 \$949 VDD sg13_lv_pmos L=0.13u W=1u AS=0.2083p AD=0.34p
+ PS=1.5u PD=2.68u rfmode=0
M$4497 VDD \$947 \$948 VDD sg13_lv_pmos L=0.13u W=2.24u AS=0.4142p AD=0.4211p
+ PS=3.03u PD=3u rfmode=0
M$4499 \$912 \$913 \$947 VDD sg13_lv_pmos L=0.13u W=1u AS=0.34p AD=0.19115p
+ PS=2.68u PD=1.565u rfmode=0
M$4500 VDD \$949 \$950 VDD sg13_lv_pmos L=0.13u W=2.24u AS=0.5964p AD=0.5964p
+ PS=4.425u PD=4.425u rfmode=0
M$4502 VDD \$915 \$953 VDD sg13_lv_pmos L=0.13u W=2.24u AS=0.616p AD=0.4312p
+ PS=4.46u PD=3.01u rfmode=0
M$4504 VDD \$186 \$953 VDD sg13_lv_pmos L=0.13u W=2.24u AS=0.4312p AD=0.6048p
+ PS=3.01u PD=4.44u rfmode=0
M$4506 VDD \$953 \$954 VDD sg13_lv_pmos L=0.13u W=0.42u AS=0.1428p AD=0.0798p
+ PS=1.52u PD=0.8u rfmode=0
M$4507 VDD VDD \$954 VDD sg13_lv_pmos L=0.13u W=0.42u AS=0.3623875p AD=0.0798p
+ PS=2.605u PD=0.8u rfmode=0
M$4508 VDD \$1072 \$916 VDD sg13_lv_pmos L=0.13u W=1u AS=0.3623875p AD=0.34p
+ PS=2.605u PD=2.68u rfmode=0
M$4509 \$784 VDD VDD VDD sg13_lv_pmos L=0.13u W=0.42u AS=0.147p AD=0.1563p
+ PS=1.54u PD=1.22u rfmode=0
M$4510 VDD \$628 \$825 VDD sg13_lv_pmos L=0.13u W=0.42u AS=0.1563p AD=0.0546p
+ PS=1.22u PD=0.68u rfmode=0
M$4511 \$825 \$629 \$784 VDD sg13_lv_pmos L=0.13u W=0.42u AS=0.0546p AD=0.0798p
+ PS=0.68u PD=0.8u rfmode=0
M$4512 \$784 \$800 \$666 VDD sg13_lv_pmos L=0.13u W=0.42u AS=0.0798p AD=0.1428p
+ PS=0.8u PD=1.52u rfmode=0
M$4513 \$1088 \$917 VDD VDD sg13_lv_pmos L=0.13u W=1.12u AS=0.3864p
+ AD=0.431025p PS=2.93u PD=2.145u rfmode=0
M$4514 VDD CLK \$917 VDD sg13_lv_pmos L=0.13u W=1.12u AS=0.431025p AD=0.3808p
+ PS=2.145u PD=2.92u rfmode=0
M$4515 \$957 \$1088 \$1114 VDD sg13_lv_pmos L=0.13u W=0.42u AS=0.19115p
+ AD=0.0525p PS=1.565u PD=0.67u rfmode=0
M$4516 \$1114 \$1073 VDD VDD sg13_lv_pmos L=0.13u W=0.42u AS=0.0525p
+ AD=0.25605p PS=0.67u PD=1.935u rfmode=0
M$4517 VDD VDD \$1073 VDD sg13_lv_pmos L=0.13u W=0.42u AS=0.25605p AD=0.0798p
+ PS=1.935u PD=0.8u rfmode=0
M$4518 VDD \$957 \$1073 VDD sg13_lv_pmos L=0.13u W=0.42u AS=0.2014p AD=0.0798p
+ PS=1.53u PD=0.8u rfmode=0
M$4519 VDD \$957 \$959 VDD sg13_lv_pmos L=0.13u W=1u AS=0.2083p AD=0.34p
+ PS=1.5u PD=2.68u rfmode=0
M$4520 VDD \$957 \$958 VDD sg13_lv_pmos L=0.13u W=2.24u AS=0.4142p AD=0.4211p
+ PS=3.03u PD=3u rfmode=0
M$4522 \$916 \$917 \$957 VDD sg13_lv_pmos L=0.13u W=1u AS=0.34p AD=0.19115p
+ PS=2.68u PD=1.565u rfmode=0
M$4523 VDD \$959 \$960 VDD sg13_lv_pmos L=0.13u W=2.24u AS=0.5964p AD=0.5964p
+ PS=4.425u PD=4.425u rfmode=0
M$4525 VDD \$919 \$963 VDD sg13_lv_pmos L=0.13u W=2.24u AS=0.616p AD=0.4312p
+ PS=4.46u PD=3.01u rfmode=0
M$4527 VDD \$186 \$963 VDD sg13_lv_pmos L=0.13u W=2.24u AS=0.4312p AD=0.6048p
+ PS=3.01u PD=4.44u rfmode=0
M$4529 VDD \$963 \$964 VDD sg13_lv_pmos L=0.13u W=0.42u AS=0.1428p AD=0.0798p
+ PS=1.52u PD=0.8u rfmode=0
M$4530 VDD VDD \$964 VDD sg13_lv_pmos L=0.13u W=0.42u AS=0.3623875p AD=0.0798p
+ PS=2.605u PD=0.8u rfmode=0
M$4531 VDD \$1074 \$920 VDD sg13_lv_pmos L=0.13u W=1u AS=0.3623875p AD=0.34p
+ PS=2.605u PD=2.68u rfmode=0
M$4532 \$786 VDD VDD VDD sg13_lv_pmos L=0.13u W=0.42u AS=0.147p AD=0.1563p
+ PS=1.54u PD=1.22u rfmode=0
M$4533 VDD \$632 \$834 VDD sg13_lv_pmos L=0.13u W=0.42u AS=0.1563p AD=0.0546p
+ PS=1.22u PD=0.68u rfmode=0
M$4534 \$834 \$633 \$786 VDD sg13_lv_pmos L=0.13u W=0.42u AS=0.0546p AD=0.0798p
+ PS=0.68u PD=0.8u rfmode=0
M$4535 \$786 \$802 \$676 VDD sg13_lv_pmos L=0.13u W=0.42u AS=0.0798p AD=0.1428p
+ PS=0.8u PD=1.52u rfmode=0
M$4536 \$1090 \$921 VDD VDD sg13_lv_pmos L=0.13u W=1.12u AS=0.3864p
+ AD=0.431025p PS=2.93u PD=2.145u rfmode=0
M$4537 VDD CLK \$921 VDD sg13_lv_pmos L=0.13u W=1.12u AS=0.431025p AD=0.3808p
+ PS=2.145u PD=2.92u rfmode=0
M$4538 \$967 \$1090 \$1123 VDD sg13_lv_pmos L=0.13u W=0.42u AS=0.19115p
+ AD=0.0525p PS=1.565u PD=0.67u rfmode=0
M$4539 \$1123 \$1075 VDD VDD sg13_lv_pmos L=0.13u W=0.42u AS=0.0525p
+ AD=0.25605p PS=0.67u PD=1.935u rfmode=0
M$4540 VDD VDD \$1075 VDD sg13_lv_pmos L=0.13u W=0.42u AS=0.25605p AD=0.0798p
+ PS=1.935u PD=0.8u rfmode=0
M$4541 VDD \$967 \$1075 VDD sg13_lv_pmos L=0.13u W=0.42u AS=0.2014p AD=0.0798p
+ PS=1.53u PD=0.8u rfmode=0
M$4542 VDD \$967 \$969 VDD sg13_lv_pmos L=0.13u W=1u AS=0.2083p AD=0.34p
+ PS=1.5u PD=2.68u rfmode=0
M$4543 VDD \$967 \$968 VDD sg13_lv_pmos L=0.13u W=2.24u AS=0.4142p AD=0.4211p
+ PS=3.03u PD=3u rfmode=0
M$4545 \$920 \$921 \$967 VDD sg13_lv_pmos L=0.13u W=1u AS=0.34p AD=0.19115p
+ PS=2.68u PD=1.565u rfmode=0
M$4546 VDD \$969 \$970 VDD sg13_lv_pmos L=0.13u W=2.24u AS=0.5964p AD=0.5964p
+ PS=4.425u PD=4.425u rfmode=0
M$4548 VDD \$923 \$973 VDD sg13_lv_pmos L=0.13u W=2.24u AS=0.616p AD=0.4312p
+ PS=4.46u PD=3.01u rfmode=0
M$4550 VDD \$186 \$973 VDD sg13_lv_pmos L=0.13u W=2.24u AS=0.4312p AD=0.6048p
+ PS=3.01u PD=4.44u rfmode=0
M$4552 VDD \$973 \$974 VDD sg13_lv_pmos L=0.13u W=0.42u AS=0.1428p AD=0.0798p
+ PS=1.52u PD=0.8u rfmode=0
M$4553 VDD VDD \$974 VDD sg13_lv_pmos L=0.13u W=0.42u AS=0.3623875p AD=0.0798p
+ PS=2.605u PD=0.8u rfmode=0
M$4554 VDD \$1076 \$924 VDD sg13_lv_pmos L=0.13u W=1u AS=0.3623875p AD=0.34p
+ PS=2.605u PD=2.68u rfmode=0
M$4555 \$788 VDD VDD VDD sg13_lv_pmos L=0.13u W=0.42u AS=0.147p AD=0.1563p
+ PS=1.54u PD=1.22u rfmode=0
M$4556 VDD \$636 \$843 VDD sg13_lv_pmos L=0.13u W=0.42u AS=0.1563p AD=0.0546p
+ PS=1.22u PD=0.68u rfmode=0
M$4557 \$843 \$637 \$788 VDD sg13_lv_pmos L=0.13u W=0.42u AS=0.0546p AD=0.0798p
+ PS=0.68u PD=0.8u rfmode=0
M$4558 \$788 \$804 \$686 VDD sg13_lv_pmos L=0.13u W=0.42u AS=0.0798p AD=0.1428p
+ PS=0.8u PD=1.52u rfmode=0
M$4559 \$1092 \$925 VDD VDD sg13_lv_pmos L=0.13u W=1.12u AS=0.3864p
+ AD=0.431025p PS=2.93u PD=2.145u rfmode=0
M$4560 VDD CLK \$925 VDD sg13_lv_pmos L=0.13u W=1.12u AS=0.431025p AD=0.3808p
+ PS=2.145u PD=2.92u rfmode=0
M$4561 \$977 \$1092 \$1132 VDD sg13_lv_pmos L=0.13u W=0.42u AS=0.19115p
+ AD=0.0525p PS=1.565u PD=0.67u rfmode=0
M$4562 \$1132 \$1077 VDD VDD sg13_lv_pmos L=0.13u W=0.42u AS=0.0525p
+ AD=0.25605p PS=0.67u PD=1.935u rfmode=0
M$4563 VDD VDD \$1077 VDD sg13_lv_pmos L=0.13u W=0.42u AS=0.25605p AD=0.0798p
+ PS=1.935u PD=0.8u rfmode=0
M$4564 VDD \$977 \$1077 VDD sg13_lv_pmos L=0.13u W=0.42u AS=0.2014p AD=0.0798p
+ PS=1.53u PD=0.8u rfmode=0
M$4565 VDD \$977 \$979 VDD sg13_lv_pmos L=0.13u W=1u AS=0.2083p AD=0.34p
+ PS=1.5u PD=2.68u rfmode=0
M$4566 VDD \$977 \$978 VDD sg13_lv_pmos L=0.13u W=2.24u AS=0.4142p AD=0.4211p
+ PS=3.03u PD=3u rfmode=0
M$4568 \$924 \$925 \$977 VDD sg13_lv_pmos L=0.13u W=1u AS=0.34p AD=0.19115p
+ PS=2.68u PD=1.565u rfmode=0
M$4569 VDD \$979 \$980 VDD sg13_lv_pmos L=0.13u W=2.24u AS=0.5964p AD=0.5964p
+ PS=4.425u PD=4.425u rfmode=0
M$4571 VDD \$927 \$983 VDD sg13_lv_pmos L=0.13u W=2.24u AS=0.616p AD=0.4312p
+ PS=4.46u PD=3.01u rfmode=0
M$4573 VDD \$186 \$983 VDD sg13_lv_pmos L=0.13u W=2.24u AS=0.4312p AD=0.6048p
+ PS=3.01u PD=4.44u rfmode=0
M$4575 VDD \$983 \$984 VDD sg13_lv_pmos L=0.13u W=0.42u AS=0.1428p AD=0.0798p
+ PS=1.52u PD=0.8u rfmode=0
M$4576 VDD VDD \$984 VDD sg13_lv_pmos L=0.13u W=0.42u AS=0.3623875p AD=0.0798p
+ PS=2.605u PD=0.8u rfmode=0
M$4577 VDD \$1078 \$928 VDD sg13_lv_pmos L=0.13u W=1u AS=0.3623875p AD=0.34p
+ PS=2.605u PD=2.68u rfmode=0
M$4578 \$790 VDD VDD VDD sg13_lv_pmos L=0.13u W=0.42u AS=0.147p AD=0.1563p
+ PS=1.54u PD=1.22u rfmode=0
M$4579 VDD \$640 \$850 VDD sg13_lv_pmos L=0.13u W=0.42u AS=0.1563p AD=0.0546p
+ PS=1.22u PD=0.68u rfmode=0
M$4580 \$850 \$641 \$790 VDD sg13_lv_pmos L=0.13u W=0.42u AS=0.0546p AD=0.0798p
+ PS=0.68u PD=0.8u rfmode=0
M$4581 \$790 \$806 \$696 VDD sg13_lv_pmos L=0.13u W=0.42u AS=0.0798p AD=0.1428p
+ PS=0.8u PD=1.52u rfmode=0
M$4582 \$1094 \$929 VDD VDD sg13_lv_pmos L=0.13u W=1.12u AS=0.3864p
+ AD=0.431025p PS=2.93u PD=2.145u rfmode=0
M$4583 VDD CLK \$929 VDD sg13_lv_pmos L=0.13u W=1.12u AS=0.431025p AD=0.3808p
+ PS=2.145u PD=2.92u rfmode=0
M$4584 \$987 \$1094 \$1141 VDD sg13_lv_pmos L=0.13u W=0.42u AS=0.19115p
+ AD=0.0525p PS=1.565u PD=0.67u rfmode=0
M$4585 \$1141 \$1079 VDD VDD sg13_lv_pmos L=0.13u W=0.42u AS=0.0525p
+ AD=0.25605p PS=0.67u PD=1.935u rfmode=0
M$4586 VDD VDD \$1079 VDD sg13_lv_pmos L=0.13u W=0.42u AS=0.25605p AD=0.0798p
+ PS=1.935u PD=0.8u rfmode=0
M$4587 VDD \$987 \$1079 VDD sg13_lv_pmos L=0.13u W=0.42u AS=0.2014p AD=0.0798p
+ PS=1.53u PD=0.8u rfmode=0
M$4588 VDD \$987 \$989 VDD sg13_lv_pmos L=0.13u W=1u AS=0.2083p AD=0.34p
+ PS=1.5u PD=2.68u rfmode=0
M$4589 VDD \$987 \$988 VDD sg13_lv_pmos L=0.13u W=2.24u AS=0.4142p AD=0.4211p
+ PS=3.03u PD=3u rfmode=0
M$4591 \$928 \$929 \$987 VDD sg13_lv_pmos L=0.13u W=1u AS=0.34p AD=0.19115p
+ PS=2.68u PD=1.565u rfmode=0
M$4592 VDD \$989 \$990 VDD sg13_lv_pmos L=0.13u W=2.24u AS=0.5964p AD=0.5964p
+ PS=4.425u PD=4.425u rfmode=0
M$4594 VDD \$931 \$993 VDD sg13_lv_pmos L=0.13u W=2.24u AS=0.616p AD=0.4312p
+ PS=4.46u PD=3.01u rfmode=0
M$4596 VDD \$186 \$993 VDD sg13_lv_pmos L=0.13u W=2.24u AS=0.4312p AD=0.6048p
+ PS=3.01u PD=4.44u rfmode=0
M$4598 VDD \$993 \$994 VDD sg13_lv_pmos L=0.13u W=0.42u AS=0.1428p AD=0.0798p
+ PS=1.52u PD=0.8u rfmode=0
M$4599 VDD VDD \$994 VDD sg13_lv_pmos L=0.13u W=0.42u AS=0.3623875p AD=0.0798p
+ PS=2.605u PD=0.8u rfmode=0
M$4600 VDD \$1080 \$932 VDD sg13_lv_pmos L=0.13u W=1u AS=0.3623875p AD=0.34p
+ PS=2.605u PD=2.68u rfmode=0
M$4601 \$792 VDD VDD VDD sg13_lv_pmos L=0.13u W=0.42u AS=0.147p AD=0.1563p
+ PS=1.54u PD=1.22u rfmode=0
M$4602 VDD \$644 \$845 VDD sg13_lv_pmos L=0.13u W=0.42u AS=0.1563p AD=0.0546p
+ PS=1.22u PD=0.68u rfmode=0
M$4603 \$845 \$645 \$792 VDD sg13_lv_pmos L=0.13u W=0.42u AS=0.0546p AD=0.0798p
+ PS=0.68u PD=0.8u rfmode=0
M$4604 \$792 \$808 \$706 VDD sg13_lv_pmos L=0.13u W=0.42u AS=0.0798p AD=0.1428p
+ PS=0.8u PD=1.52u rfmode=0
M$4605 \$1096 \$933 VDD VDD sg13_lv_pmos L=0.13u W=1.12u AS=0.3864p
+ AD=0.431025p PS=2.93u PD=2.145u rfmode=0
M$4606 VDD CLK \$933 VDD sg13_lv_pmos L=0.13u W=1.12u AS=0.431025p AD=0.3808p
+ PS=2.145u PD=2.92u rfmode=0
M$4607 \$997 \$1096 \$1130 VDD sg13_lv_pmos L=0.13u W=0.42u AS=0.19115p
+ AD=0.0525p PS=1.565u PD=0.67u rfmode=0
M$4608 \$1130 \$1081 VDD VDD sg13_lv_pmos L=0.13u W=0.42u AS=0.0525p
+ AD=0.25605p PS=0.67u PD=1.935u rfmode=0
M$4609 VDD VDD \$1081 VDD sg13_lv_pmos L=0.13u W=0.42u AS=0.25605p AD=0.0798p
+ PS=1.935u PD=0.8u rfmode=0
M$4610 VDD \$997 \$1081 VDD sg13_lv_pmos L=0.13u W=0.42u AS=0.2014p AD=0.0798p
+ PS=1.53u PD=0.8u rfmode=0
M$4611 VDD \$997 \$999 VDD sg13_lv_pmos L=0.13u W=1u AS=0.2083p AD=0.34p
+ PS=1.5u PD=2.68u rfmode=0
M$4612 VDD \$997 \$998 VDD sg13_lv_pmos L=0.13u W=2.24u AS=0.4142p AD=0.4211p
+ PS=3.03u PD=3u rfmode=0
M$4614 \$932 \$933 \$997 VDD sg13_lv_pmos L=0.13u W=1u AS=0.34p AD=0.19115p
+ PS=2.68u PD=1.565u rfmode=0
M$4615 VDD \$999 \$1000 VDD sg13_lv_pmos L=0.13u W=2.24u AS=0.5964p AD=0.5964p
+ PS=4.425u PD=4.425u rfmode=0
M$4617 VDD \$935 \$1003 VDD sg13_lv_pmos L=0.13u W=2.24u AS=0.616p AD=0.4312p
+ PS=4.46u PD=3.01u rfmode=0
M$4619 VDD \$186 \$1003 VDD sg13_lv_pmos L=0.13u W=2.24u AS=0.4312p AD=0.6048p
+ PS=3.01u PD=4.44u rfmode=0
M$4621 VDD \$1003 \$1004 VDD sg13_lv_pmos L=0.13u W=0.42u AS=0.1428p AD=0.0798p
+ PS=1.52u PD=0.8u rfmode=0
M$4622 VDD VDD \$1004 VDD sg13_lv_pmos L=0.13u W=0.42u AS=0.3623875p AD=0.0798p
+ PS=2.605u PD=0.8u rfmode=0
M$4623 VDD \$1082 \$936 VDD sg13_lv_pmos L=0.13u W=1u AS=0.3623875p AD=0.34p
+ PS=2.605u PD=2.68u rfmode=0
M$4624 \$794 VDD VDD VDD sg13_lv_pmos L=0.13u W=0.42u AS=0.147p AD=0.1563p
+ PS=1.54u PD=1.22u rfmode=0
M$4625 VDD \$648 \$833 VDD sg13_lv_pmos L=0.13u W=0.42u AS=0.1563p AD=0.0546p
+ PS=1.22u PD=0.68u rfmode=0
M$4626 \$833 \$649 \$794 VDD sg13_lv_pmos L=0.13u W=0.42u AS=0.0546p AD=0.0798p
+ PS=0.68u PD=0.8u rfmode=0
M$4627 \$794 \$810 \$716 VDD sg13_lv_pmos L=0.13u W=0.42u AS=0.0798p AD=0.1428p
+ PS=0.8u PD=1.52u rfmode=0
M$4628 \$1098 \$937 VDD VDD sg13_lv_pmos L=0.13u W=1.12u AS=0.3864p
+ AD=0.431025p PS=2.93u PD=2.145u rfmode=0
M$4629 VDD CLK \$937 VDD sg13_lv_pmos L=0.13u W=1.12u AS=0.431025p AD=0.3808p
+ PS=2.145u PD=2.92u rfmode=0
M$4630 \$1007 \$1098 \$1120 VDD sg13_lv_pmos L=0.13u W=0.42u AS=0.19115p
+ AD=0.0525p PS=1.565u PD=0.67u rfmode=0
M$4631 \$1120 \$1083 VDD VDD sg13_lv_pmos L=0.13u W=0.42u AS=0.0525p
+ AD=0.25605p PS=0.67u PD=1.935u rfmode=0
M$4632 VDD VDD \$1083 VDD sg13_lv_pmos L=0.13u W=0.42u AS=0.25605p AD=0.0798p
+ PS=1.935u PD=0.8u rfmode=0
M$4633 VDD \$1007 \$1083 VDD sg13_lv_pmos L=0.13u W=0.42u AS=0.2014p AD=0.0798p
+ PS=1.53u PD=0.8u rfmode=0
M$4634 VDD \$1007 \$1009 VDD sg13_lv_pmos L=0.13u W=1u AS=0.2083p AD=0.34p
+ PS=1.5u PD=2.68u rfmode=0
M$4635 VDD \$1007 \$1008 VDD sg13_lv_pmos L=0.13u W=2.24u AS=0.4142p AD=0.4211p
+ PS=3.03u PD=3u rfmode=0
M$4637 \$936 \$937 \$1007 VDD sg13_lv_pmos L=0.13u W=1u AS=0.34p AD=0.19115p
+ PS=2.68u PD=1.565u rfmode=0
M$4638 VDD \$1009 \$1010 VDD sg13_lv_pmos L=0.13u W=2.24u AS=0.5964p AD=0.5964p
+ PS=4.425u PD=4.425u rfmode=0
M$4640 VDD \$939 \$1013 VDD sg13_lv_pmos L=0.13u W=2.24u AS=0.616p AD=0.4312p
+ PS=4.46u PD=3.01u rfmode=0
M$4642 VDD \$186 \$1013 VDD sg13_lv_pmos L=0.13u W=2.24u AS=0.4312p AD=0.6048p
+ PS=3.01u PD=4.44u rfmode=0
M$4644 VDD \$1013 \$1014 VDD sg13_lv_pmos L=0.13u W=0.42u AS=0.1428p AD=0.0798p
+ PS=1.52u PD=0.8u rfmode=0
M$4645 VDD VDD \$1014 VDD sg13_lv_pmos L=0.13u W=0.42u AS=0.3623875p AD=0.0798p
+ PS=2.605u PD=0.8u rfmode=0
M$4646 VDD \$1084 \$940 VDD sg13_lv_pmos L=0.13u W=1u AS=0.3623875p AD=0.34p
+ PS=2.605u PD=2.68u rfmode=0
M$4647 \$796 VDD VDD VDD sg13_lv_pmos L=0.13u W=0.42u AS=0.147p AD=0.1563p
+ PS=1.54u PD=1.22u rfmode=0
M$4648 VDD \$652 \$822 VDD sg13_lv_pmos L=0.13u W=0.42u AS=0.1563p AD=0.0546p
+ PS=1.22u PD=0.68u rfmode=0
M$4649 \$822 \$653 \$796 VDD sg13_lv_pmos L=0.13u W=0.42u AS=0.0546p AD=0.0798p
+ PS=0.68u PD=0.8u rfmode=0
M$4650 \$796 \$812 \$726 VDD sg13_lv_pmos L=0.13u W=0.42u AS=0.0798p AD=0.1428p
+ PS=0.8u PD=1.52u rfmode=0
M$4651 \$1100 \$941 VDD VDD sg13_lv_pmos L=0.13u W=1.12u AS=0.3864p
+ AD=0.431025p PS=2.93u PD=2.145u rfmode=0
M$4652 VDD CLK \$941 VDD sg13_lv_pmos L=0.13u W=1.12u AS=0.431025p AD=0.3808p
+ PS=2.145u PD=2.92u rfmode=0
M$4653 \$1017 \$1100 \$1107 VDD sg13_lv_pmos L=0.13u W=0.42u AS=0.19115p
+ AD=0.0525p PS=1.565u PD=0.67u rfmode=0
M$4654 \$1107 \$1085 VDD VDD sg13_lv_pmos L=0.13u W=0.42u AS=0.0525p
+ AD=0.25605p PS=0.67u PD=1.935u rfmode=0
M$4655 VDD VDD \$1085 VDD sg13_lv_pmos L=0.13u W=0.42u AS=0.25605p AD=0.0798p
+ PS=1.935u PD=0.8u rfmode=0
M$4656 VDD \$1017 \$1085 VDD sg13_lv_pmos L=0.13u W=0.42u AS=0.2014p AD=0.0798p
+ PS=1.53u PD=0.8u rfmode=0
M$4657 VDD \$1017 \$1019 VDD sg13_lv_pmos L=0.13u W=1u AS=0.2083p AD=0.34p
+ PS=1.5u PD=2.68u rfmode=0
M$4658 VDD \$1017 \$1018 VDD sg13_lv_pmos L=0.13u W=2.24u AS=0.4142p AD=0.4211p
+ PS=3.03u PD=3u rfmode=0
M$4660 \$940 \$941 \$1017 VDD sg13_lv_pmos L=0.13u W=1u AS=0.34p AD=0.19115p
+ PS=2.68u PD=1.565u rfmode=0
M$4661 VDD \$1019 \$1020 VDD sg13_lv_pmos L=0.13u W=2.24u AS=0.5964p AD=0.5964p
+ PS=4.425u PD=4.425u rfmode=0
M$4663 \$910 \$187 \$1142 VDD sg13_lv_pmos L=0.13u W=0.84u AS=0.2856p
+ AD=0.1596p PS=2.36u PD=1.22u rfmode=0
M$4664 VDD \$5 \$1142 VDD sg13_lv_pmos L=0.13u W=0.84u AS=0.2226p AD=0.1596p
+ PS=1.535u PD=1.22u rfmode=0
M$4665 VDD \$910 \$911 VDD sg13_lv_pmos L=0.13u W=2.24u AS=0.4746p AD=0.6776p
+ PS=3.105u PD=4.57u rfmode=0
M$4667 VDD \$1199 \$1231 VDD sg13_lv_pmos L=0.13u W=2.24u AS=0.616p AD=0.4312p
+ PS=4.46u PD=3.01u rfmode=0
M$4669 VDD \$5 \$1231 VDD sg13_lv_pmos L=0.13u W=2.24u AS=0.4312p AD=0.6048p
+ PS=3.01u PD=4.44u rfmode=0
M$4671 \$1070 VDD VDD VDD sg13_lv_pmos L=0.13u W=0.42u AS=0.147p AD=0.1563p
+ PS=1.54u PD=1.22u rfmode=0
M$4672 VDD \$912 \$1105 VDD sg13_lv_pmos L=0.13u W=0.42u AS=0.1563p AD=0.0546p
+ PS=1.22u PD=0.68u rfmode=0
M$4673 \$1105 \$913 \$1070 VDD sg13_lv_pmos L=0.13u W=0.42u AS=0.0546p
+ AD=0.0798p PS=0.68u PD=0.8u rfmode=0
M$4674 \$1070 \$1086 \$944 VDD sg13_lv_pmos L=0.13u W=0.42u AS=0.0798p
+ AD=0.1428p PS=0.8u PD=1.52u rfmode=0
M$4675 \$1374 \$1201 VDD VDD sg13_lv_pmos L=0.13u W=1.12u AS=0.3864p
+ AD=0.431025p PS=2.93u PD=2.145u rfmode=0
M$4676 VDD CLK \$1201 VDD sg13_lv_pmos L=0.13u W=1.12u AS=0.431025p AD=0.3808p
+ PS=2.145u PD=2.92u rfmode=0
M$4677 VDD \$1237 \$1238 VDD sg13_lv_pmos L=0.13u W=2.24u AS=0.5964p AD=0.5964p
+ PS=4.425u PD=4.425u rfmode=0
M$4679 \$914 \$190 \$1143 VDD sg13_lv_pmos L=0.13u W=0.84u AS=0.2856p
+ AD=0.1596p PS=2.36u PD=1.22u rfmode=0
M$4680 VDD \$5 \$1143 VDD sg13_lv_pmos L=0.13u W=0.84u AS=0.2226p AD=0.1596p
+ PS=1.535u PD=1.22u rfmode=0
M$4681 VDD \$914 \$915 VDD sg13_lv_pmos L=0.13u W=2.24u AS=0.4746p AD=0.6776p
+ PS=3.105u PD=4.57u rfmode=0
M$4683 VDD \$1203 \$1241 VDD sg13_lv_pmos L=0.13u W=2.24u AS=0.616p AD=0.4312p
+ PS=4.46u PD=3.01u rfmode=0
M$4685 VDD \$5 \$1241 VDD sg13_lv_pmos L=0.13u W=2.24u AS=0.4312p AD=0.6048p
+ PS=3.01u PD=4.44u rfmode=0
M$4687 \$1072 VDD VDD VDD sg13_lv_pmos L=0.13u W=0.42u AS=0.147p AD=0.1563p
+ PS=1.54u PD=1.22u rfmode=0
M$4688 VDD \$916 \$1113 VDD sg13_lv_pmos L=0.13u W=0.42u AS=0.1563p AD=0.0546p
+ PS=1.22u PD=0.68u rfmode=0
M$4689 \$1113 \$917 \$1072 VDD sg13_lv_pmos L=0.13u W=0.42u AS=0.0546p
+ AD=0.0798p PS=0.68u PD=0.8u rfmode=0
M$4690 \$1072 \$1088 \$954 VDD sg13_lv_pmos L=0.13u W=0.42u AS=0.0798p
+ AD=0.1428p PS=0.8u PD=1.52u rfmode=0
M$4691 \$1376 \$1205 VDD VDD sg13_lv_pmos L=0.13u W=1.12u AS=0.3864p
+ AD=0.431025p PS=2.93u PD=2.145u rfmode=0
M$4692 VDD CLK \$1205 VDD sg13_lv_pmos L=0.13u W=1.12u AS=0.431025p AD=0.3808p
+ PS=2.145u PD=2.92u rfmode=0
M$4693 VDD \$1247 \$1248 VDD sg13_lv_pmos L=0.13u W=2.24u AS=0.5964p AD=0.5964p
+ PS=4.425u PD=4.425u rfmode=0
M$4695 \$918 \$193 \$1144 VDD sg13_lv_pmos L=0.13u W=0.84u AS=0.2856p
+ AD=0.1596p PS=2.36u PD=1.22u rfmode=0
M$4696 VDD \$5 \$1144 VDD sg13_lv_pmos L=0.13u W=0.84u AS=0.2226p AD=0.1596p
+ PS=1.535u PD=1.22u rfmode=0
M$4697 VDD \$918 \$919 VDD sg13_lv_pmos L=0.13u W=2.24u AS=0.4746p AD=0.6776p
+ PS=3.105u PD=4.57u rfmode=0
M$4699 VDD \$1207 \$1251 VDD sg13_lv_pmos L=0.13u W=2.24u AS=0.616p AD=0.4312p
+ PS=4.46u PD=3.01u rfmode=0
M$4701 VDD \$5 \$1251 VDD sg13_lv_pmos L=0.13u W=2.24u AS=0.4312p AD=0.6048p
+ PS=3.01u PD=4.44u rfmode=0
M$4703 \$1074 VDD VDD VDD sg13_lv_pmos L=0.13u W=0.42u AS=0.147p AD=0.1563p
+ PS=1.54u PD=1.22u rfmode=0
M$4704 VDD \$920 \$1122 VDD sg13_lv_pmos L=0.13u W=0.42u AS=0.1563p AD=0.0546p
+ PS=1.22u PD=0.68u rfmode=0
M$4705 \$1122 \$921 \$1074 VDD sg13_lv_pmos L=0.13u W=0.42u AS=0.0546p
+ AD=0.0798p PS=0.68u PD=0.8u rfmode=0
M$4706 \$1074 \$1090 \$964 VDD sg13_lv_pmos L=0.13u W=0.42u AS=0.0798p
+ AD=0.1428p PS=0.8u PD=1.52u rfmode=0
M$4707 \$1378 \$1209 VDD VDD sg13_lv_pmos L=0.13u W=1.12u AS=0.3864p
+ AD=0.431025p PS=2.93u PD=2.145u rfmode=0
M$4708 VDD CLK \$1209 VDD sg13_lv_pmos L=0.13u W=1.12u AS=0.431025p AD=0.3808p
+ PS=2.145u PD=2.92u rfmode=0
M$4709 VDD \$1257 \$1258 VDD sg13_lv_pmos L=0.13u W=2.24u AS=0.5964p AD=0.5964p
+ PS=4.425u PD=4.425u rfmode=0
M$4711 \$922 \$196 \$1145 VDD sg13_lv_pmos L=0.13u W=0.84u AS=0.2856p
+ AD=0.1596p PS=2.36u PD=1.22u rfmode=0
M$4712 VDD \$5 \$1145 VDD sg13_lv_pmos L=0.13u W=0.84u AS=0.2226p AD=0.1596p
+ PS=1.535u PD=1.22u rfmode=0
M$4713 VDD \$922 \$923 VDD sg13_lv_pmos L=0.13u W=2.24u AS=0.4746p AD=0.6776p
+ PS=3.105u PD=4.57u rfmode=0
M$4715 VDD \$1211 \$1261 VDD sg13_lv_pmos L=0.13u W=2.24u AS=0.616p AD=0.4312p
+ PS=4.46u PD=3.01u rfmode=0
M$4717 VDD \$5 \$1261 VDD sg13_lv_pmos L=0.13u W=2.24u AS=0.4312p AD=0.6048p
+ PS=3.01u PD=4.44u rfmode=0
M$4719 \$1076 VDD VDD VDD sg13_lv_pmos L=0.13u W=0.42u AS=0.147p AD=0.1563p
+ PS=1.54u PD=1.22u rfmode=0
M$4720 VDD \$924 \$1131 VDD sg13_lv_pmos L=0.13u W=0.42u AS=0.1563p AD=0.0546p
+ PS=1.22u PD=0.68u rfmode=0
M$4721 \$1131 \$925 \$1076 VDD sg13_lv_pmos L=0.13u W=0.42u AS=0.0546p
+ AD=0.0798p PS=0.68u PD=0.8u rfmode=0
M$4722 \$1076 \$1092 \$974 VDD sg13_lv_pmos L=0.13u W=0.42u AS=0.0798p
+ AD=0.1428p PS=0.8u PD=1.52u rfmode=0
M$4723 \$1380 \$1213 VDD VDD sg13_lv_pmos L=0.13u W=1.12u AS=0.3864p
+ AD=0.431025p PS=2.93u PD=2.145u rfmode=0
M$4724 VDD CLK \$1213 VDD sg13_lv_pmos L=0.13u W=1.12u AS=0.431025p AD=0.3808p
+ PS=2.145u PD=2.92u rfmode=0
M$4725 VDD \$1267 \$1268 VDD sg13_lv_pmos L=0.13u W=2.24u AS=0.5964p AD=0.5964p
+ PS=4.425u PD=4.425u rfmode=0
M$4727 \$926 \$199 \$1147 VDD sg13_lv_pmos L=0.13u W=0.84u AS=0.2856p
+ AD=0.1596p PS=2.36u PD=1.22u rfmode=0
M$4728 VDD \$5 \$1147 VDD sg13_lv_pmos L=0.13u W=0.84u AS=0.2226p AD=0.1596p
+ PS=1.535u PD=1.22u rfmode=0
M$4729 VDD \$926 \$927 VDD sg13_lv_pmos L=0.13u W=2.24u AS=0.4746p AD=0.6776p
+ PS=3.105u PD=4.57u rfmode=0
M$4731 VDD \$1215 \$1271 VDD sg13_lv_pmos L=0.13u W=2.24u AS=0.616p AD=0.4312p
+ PS=4.46u PD=3.01u rfmode=0
M$4733 VDD \$5 \$1271 VDD sg13_lv_pmos L=0.13u W=2.24u AS=0.4312p AD=0.6048p
+ PS=3.01u PD=4.44u rfmode=0
M$4735 \$1078 VDD VDD VDD sg13_lv_pmos L=0.13u W=0.42u AS=0.147p AD=0.1563p
+ PS=1.54u PD=1.22u rfmode=0
M$4736 VDD \$928 \$1139 VDD sg13_lv_pmos L=0.13u W=0.42u AS=0.1563p AD=0.0546p
+ PS=1.22u PD=0.68u rfmode=0
M$4737 \$1139 \$929 \$1078 VDD sg13_lv_pmos L=0.13u W=0.42u AS=0.0546p
+ AD=0.0798p PS=0.68u PD=0.8u rfmode=0
M$4738 \$1078 \$1094 \$984 VDD sg13_lv_pmos L=0.13u W=0.42u AS=0.0798p
+ AD=0.1428p PS=0.8u PD=1.52u rfmode=0
M$4739 \$1382 \$1217 VDD VDD sg13_lv_pmos L=0.13u W=1.12u AS=0.3864p
+ AD=0.431025p PS=2.93u PD=2.145u rfmode=0
M$4740 VDD CLK \$1217 VDD sg13_lv_pmos L=0.13u W=1.12u AS=0.431025p AD=0.3808p
+ PS=2.145u PD=2.92u rfmode=0
M$4741 VDD \$1277 \$1278 VDD sg13_lv_pmos L=0.13u W=2.24u AS=0.5964p AD=0.5964p
+ PS=4.425u PD=4.425u rfmode=0
M$4743 \$930 \$202 \$1148 VDD sg13_lv_pmos L=0.13u W=0.84u AS=0.2856p
+ AD=0.1596p PS=2.36u PD=1.22u rfmode=0
M$4744 VDD \$5 \$1148 VDD sg13_lv_pmos L=0.13u W=0.84u AS=0.2226p AD=0.1596p
+ PS=1.535u PD=1.22u rfmode=0
M$4745 VDD \$930 \$931 VDD sg13_lv_pmos L=0.13u W=2.24u AS=0.4746p AD=0.6776p
+ PS=3.105u PD=4.57u rfmode=0
M$4747 VDD \$1219 \$1281 VDD sg13_lv_pmos L=0.13u W=2.24u AS=0.616p AD=0.4312p
+ PS=4.46u PD=3.01u rfmode=0
M$4749 VDD \$5 \$1281 VDD sg13_lv_pmos L=0.13u W=2.24u AS=0.4312p AD=0.6048p
+ PS=3.01u PD=4.44u rfmode=0
M$4751 \$1080 VDD VDD VDD sg13_lv_pmos L=0.13u W=0.42u AS=0.147p AD=0.1563p
+ PS=1.54u PD=1.22u rfmode=0
M$4752 VDD \$932 \$1133 VDD sg13_lv_pmos L=0.13u W=0.42u AS=0.1563p AD=0.0546p
+ PS=1.22u PD=0.68u rfmode=0
M$4753 \$1133 \$933 \$1080 VDD sg13_lv_pmos L=0.13u W=0.42u AS=0.0546p
+ AD=0.0798p PS=0.68u PD=0.8u rfmode=0
M$4754 \$1080 \$1096 \$994 VDD sg13_lv_pmos L=0.13u W=0.42u AS=0.0798p
+ AD=0.1428p PS=0.8u PD=1.52u rfmode=0
M$4755 \$1384 \$1221 VDD VDD sg13_lv_pmos L=0.13u W=1.12u AS=0.3864p
+ AD=0.431025p PS=2.93u PD=2.145u rfmode=0
M$4756 VDD CLK \$1221 VDD sg13_lv_pmos L=0.13u W=1.12u AS=0.431025p AD=0.3808p
+ PS=2.145u PD=2.92u rfmode=0
M$4757 VDD \$1287 \$1288 VDD sg13_lv_pmos L=0.13u W=2.24u AS=0.5964p AD=0.5964p
+ PS=4.425u PD=4.425u rfmode=0
M$4759 \$934 \$205 \$1149 VDD sg13_lv_pmos L=0.13u W=0.84u AS=0.2856p
+ AD=0.1596p PS=2.36u PD=1.22u rfmode=0
M$4760 VDD \$5 \$1149 VDD sg13_lv_pmos L=0.13u W=0.84u AS=0.2226p AD=0.1596p
+ PS=1.535u PD=1.22u rfmode=0
M$4761 VDD \$934 \$935 VDD sg13_lv_pmos L=0.13u W=2.24u AS=0.4746p AD=0.6776p
+ PS=3.105u PD=4.57u rfmode=0
M$4763 VDD \$1223 \$1291 VDD sg13_lv_pmos L=0.13u W=2.24u AS=0.616p AD=0.4312p
+ PS=4.46u PD=3.01u rfmode=0
M$4765 VDD \$5 \$1291 VDD sg13_lv_pmos L=0.13u W=2.24u AS=0.4312p AD=0.6048p
+ PS=3.01u PD=4.44u rfmode=0
M$4767 \$1082 VDD VDD VDD sg13_lv_pmos L=0.13u W=0.42u AS=0.147p AD=0.1563p
+ PS=1.54u PD=1.22u rfmode=0
M$4768 VDD \$936 \$1121 VDD sg13_lv_pmos L=0.13u W=0.42u AS=0.1563p AD=0.0546p
+ PS=1.22u PD=0.68u rfmode=0
M$4769 \$1121 \$937 \$1082 VDD sg13_lv_pmos L=0.13u W=0.42u AS=0.0546p
+ AD=0.0798p PS=0.68u PD=0.8u rfmode=0
M$4770 \$1082 \$1098 \$1004 VDD sg13_lv_pmos L=0.13u W=0.42u AS=0.0798p
+ AD=0.1428p PS=0.8u PD=1.52u rfmode=0
M$4771 \$1386 \$1225 VDD VDD sg13_lv_pmos L=0.13u W=1.12u AS=0.3864p
+ AD=0.431025p PS=2.93u PD=2.145u rfmode=0
M$4772 VDD CLK \$1225 VDD sg13_lv_pmos L=0.13u W=1.12u AS=0.431025p AD=0.3808p
+ PS=2.145u PD=2.92u rfmode=0
M$4773 VDD \$1297 \$1298 VDD sg13_lv_pmos L=0.13u W=2.24u AS=0.5964p AD=0.5964p
+ PS=4.425u PD=4.425u rfmode=0
M$4775 \$938 VSS \$1146 VDD sg13_lv_pmos L=0.13u W=0.84u AS=0.2856p AD=0.1596p
+ PS=2.36u PD=1.22u rfmode=0
M$4776 VDD \$5 \$1146 VDD sg13_lv_pmos L=0.13u W=0.84u AS=0.2226p AD=0.1596p
+ PS=1.535u PD=1.22u rfmode=0
M$4777 VDD \$938 \$939 VDD sg13_lv_pmos L=0.13u W=2.24u AS=0.4746p AD=0.6776p
+ PS=3.105u PD=4.57u rfmode=0
M$4779 VDD \$1227 \$1301 VDD sg13_lv_pmos L=0.13u W=2.24u AS=0.616p AD=0.4312p
+ PS=4.46u PD=3.01u rfmode=0
M$4781 VDD \$5 \$1301 VDD sg13_lv_pmos L=0.13u W=2.24u AS=0.4312p AD=0.6048p
+ PS=3.01u PD=4.44u rfmode=0
M$4783 \$1084 VDD VDD VDD sg13_lv_pmos L=0.13u W=0.42u AS=0.147p AD=0.1563p
+ PS=1.54u PD=1.22u rfmode=0
M$4784 VDD \$940 \$1110 VDD sg13_lv_pmos L=0.13u W=0.42u AS=0.1563p AD=0.0546p
+ PS=1.22u PD=0.68u rfmode=0
M$4785 \$1110 \$941 \$1084 VDD sg13_lv_pmos L=0.13u W=0.42u AS=0.0546p
+ AD=0.0798p PS=0.68u PD=0.8u rfmode=0
M$4786 \$1084 \$1100 \$1014 VDD sg13_lv_pmos L=0.13u W=0.42u AS=0.0798p
+ AD=0.1428p PS=0.8u PD=1.52u rfmode=0
M$4787 \$1388 \$1229 VDD VDD sg13_lv_pmos L=0.13u W=1.12u AS=0.3864p
+ AD=0.431025p PS=2.93u PD=2.145u rfmode=0
M$4788 VDD CLK \$1229 VDD sg13_lv_pmos L=0.13u W=1.12u AS=0.431025p AD=0.3808p
+ PS=2.145u PD=2.92u rfmode=0
M$4789 VDD \$1307 \$1308 VDD sg13_lv_pmos L=0.13u W=2.24u AS=0.5964p AD=0.5964p
+ PS=4.425u PD=4.425u rfmode=0
M$4791 \$1198 \$187 \$1430 VDD sg13_lv_pmos L=0.13u W=0.84u AS=0.2856p
+ AD=0.1596p PS=2.36u PD=1.22u rfmode=0
M$4792 VDD \$266 \$1430 VDD sg13_lv_pmos L=0.13u W=0.84u AS=0.2226p AD=0.1596p
+ PS=1.535u PD=1.22u rfmode=0
M$4793 VDD \$1198 \$1199 VDD sg13_lv_pmos L=0.13u W=2.24u AS=0.4746p AD=0.6776p
+ PS=3.105u PD=4.57u rfmode=0
M$4795 VDD \$1231 \$1232 VDD sg13_lv_pmos L=0.13u W=0.42u AS=0.1428p AD=0.0798p
+ PS=1.52u PD=0.8u rfmode=0
M$4796 VDD VDD \$1232 VDD sg13_lv_pmos L=0.13u W=0.42u AS=0.3623875p AD=0.0798p
+ PS=2.605u PD=0.8u rfmode=0
M$4797 VDD \$1358 \$1200 VDD sg13_lv_pmos L=0.13u W=1u AS=0.3623875p AD=0.34p
+ PS=2.605u PD=2.68u rfmode=0
M$4798 \$1235 \$1374 \$1394 VDD sg13_lv_pmos L=0.13u W=0.42u AS=0.19115p
+ AD=0.0525p PS=1.565u PD=0.67u rfmode=0
M$4799 \$1394 \$1359 VDD VDD sg13_lv_pmos L=0.13u W=0.42u AS=0.0525p
+ AD=0.25605p PS=0.67u PD=1.935u rfmode=0
M$4800 VDD VDD \$1359 VDD sg13_lv_pmos L=0.13u W=0.42u AS=0.25605p AD=0.0798p
+ PS=1.935u PD=0.8u rfmode=0
M$4801 VDD \$1235 \$1359 VDD sg13_lv_pmos L=0.13u W=0.42u AS=0.2014p AD=0.0798p
+ PS=1.53u PD=0.8u rfmode=0
M$4802 VDD \$1235 \$1237 VDD sg13_lv_pmos L=0.13u W=1u AS=0.2083p AD=0.34p
+ PS=1.5u PD=2.68u rfmode=0
M$4803 VDD \$1235 \$1236 VDD sg13_lv_pmos L=0.13u W=2.24u AS=0.4142p AD=0.4211p
+ PS=3.03u PD=3u rfmode=0
M$4805 \$1200 \$1201 \$1235 VDD sg13_lv_pmos L=0.13u W=1u AS=0.34p AD=0.19115p
+ PS=2.68u PD=1.565u rfmode=0
M$4806 \$1202 \$190 \$1431 VDD sg13_lv_pmos L=0.13u W=0.84u AS=0.2856p
+ AD=0.1596p PS=2.36u PD=1.22u rfmode=0
M$4807 VDD \$266 \$1431 VDD sg13_lv_pmos L=0.13u W=0.84u AS=0.2226p AD=0.1596p
+ PS=1.535u PD=1.22u rfmode=0
M$4808 VDD \$1202 \$1203 VDD sg13_lv_pmos L=0.13u W=2.24u AS=0.4746p AD=0.6776p
+ PS=3.105u PD=4.57u rfmode=0
M$4810 VDD \$1241 \$1242 VDD sg13_lv_pmos L=0.13u W=0.42u AS=0.1428p AD=0.0798p
+ PS=1.52u PD=0.8u rfmode=0
M$4811 VDD VDD \$1242 VDD sg13_lv_pmos L=0.13u W=0.42u AS=0.3623875p AD=0.0798p
+ PS=2.605u PD=0.8u rfmode=0
M$4812 VDD \$1360 \$1204 VDD sg13_lv_pmos L=0.13u W=1u AS=0.3623875p AD=0.34p
+ PS=2.605u PD=2.68u rfmode=0
M$4813 \$1245 \$1376 \$1402 VDD sg13_lv_pmos L=0.13u W=0.42u AS=0.19115p
+ AD=0.0525p PS=1.565u PD=0.67u rfmode=0
M$4814 \$1402 \$1361 VDD VDD sg13_lv_pmos L=0.13u W=0.42u AS=0.0525p
+ AD=0.25605p PS=0.67u PD=1.935u rfmode=0
M$4815 VDD VDD \$1361 VDD sg13_lv_pmos L=0.13u W=0.42u AS=0.25605p AD=0.0798p
+ PS=1.935u PD=0.8u rfmode=0
M$4816 VDD \$1245 \$1361 VDD sg13_lv_pmos L=0.13u W=0.42u AS=0.2014p AD=0.0798p
+ PS=1.53u PD=0.8u rfmode=0
M$4817 VDD \$1245 \$1247 VDD sg13_lv_pmos L=0.13u W=1u AS=0.2083p AD=0.34p
+ PS=1.5u PD=2.68u rfmode=0
M$4818 VDD \$1245 \$1246 VDD sg13_lv_pmos L=0.13u W=2.24u AS=0.4142p AD=0.4211p
+ PS=3.03u PD=3u rfmode=0
M$4820 \$1204 \$1205 \$1245 VDD sg13_lv_pmos L=0.13u W=1u AS=0.34p AD=0.19115p
+ PS=2.68u PD=1.565u rfmode=0
M$4821 \$1206 \$193 \$1432 VDD sg13_lv_pmos L=0.13u W=0.84u AS=0.2856p
+ AD=0.1596p PS=2.36u PD=1.22u rfmode=0
M$4822 VDD \$266 \$1432 VDD sg13_lv_pmos L=0.13u W=0.84u AS=0.2226p AD=0.1596p
+ PS=1.535u PD=1.22u rfmode=0
M$4823 VDD \$1206 \$1207 VDD sg13_lv_pmos L=0.13u W=2.24u AS=0.4746p AD=0.6776p
+ PS=3.105u PD=4.57u rfmode=0
M$4825 VDD \$1251 \$1252 VDD sg13_lv_pmos L=0.13u W=0.42u AS=0.1428p AD=0.0798p
+ PS=1.52u PD=0.8u rfmode=0
M$4826 VDD VDD \$1252 VDD sg13_lv_pmos L=0.13u W=0.42u AS=0.3623875p AD=0.0798p
+ PS=2.605u PD=0.8u rfmode=0
M$4827 VDD \$1362 \$1208 VDD sg13_lv_pmos L=0.13u W=1u AS=0.3623875p AD=0.34p
+ PS=2.605u PD=2.68u rfmode=0
M$4828 \$1255 \$1378 \$1411 VDD sg13_lv_pmos L=0.13u W=0.42u AS=0.19115p
+ AD=0.0525p PS=1.565u PD=0.67u rfmode=0
M$4829 \$1411 \$1363 VDD VDD sg13_lv_pmos L=0.13u W=0.42u AS=0.0525p
+ AD=0.25605p PS=0.67u PD=1.935u rfmode=0
M$4830 VDD VDD \$1363 VDD sg13_lv_pmos L=0.13u W=0.42u AS=0.25605p AD=0.0798p
+ PS=1.935u PD=0.8u rfmode=0
M$4831 VDD \$1255 \$1363 VDD sg13_lv_pmos L=0.13u W=0.42u AS=0.2014p AD=0.0798p
+ PS=1.53u PD=0.8u rfmode=0
M$4832 VDD \$1255 \$1257 VDD sg13_lv_pmos L=0.13u W=1u AS=0.2083p AD=0.34p
+ PS=1.5u PD=2.68u rfmode=0
M$4833 VDD \$1255 \$1256 VDD sg13_lv_pmos L=0.13u W=2.24u AS=0.4142p AD=0.4211p
+ PS=3.03u PD=3u rfmode=0
M$4835 \$1208 \$1209 \$1255 VDD sg13_lv_pmos L=0.13u W=1u AS=0.34p AD=0.19115p
+ PS=2.68u PD=1.565u rfmode=0
M$4836 \$1210 \$196 \$1433 VDD sg13_lv_pmos L=0.13u W=0.84u AS=0.2856p
+ AD=0.1596p PS=2.36u PD=1.22u rfmode=0
M$4837 VDD \$266 \$1433 VDD sg13_lv_pmos L=0.13u W=0.84u AS=0.2226p AD=0.1596p
+ PS=1.535u PD=1.22u rfmode=0
M$4838 VDD \$1210 \$1211 VDD sg13_lv_pmos L=0.13u W=2.24u AS=0.4746p AD=0.6776p
+ PS=3.105u PD=4.57u rfmode=0
M$4840 VDD \$1261 \$1262 VDD sg13_lv_pmos L=0.13u W=0.42u AS=0.1428p AD=0.0798p
+ PS=1.52u PD=0.8u rfmode=0
M$4841 VDD VDD \$1262 VDD sg13_lv_pmos L=0.13u W=0.42u AS=0.3623875p AD=0.0798p
+ PS=2.605u PD=0.8u rfmode=0
M$4842 VDD \$1364 \$1212 VDD sg13_lv_pmos L=0.13u W=1u AS=0.3623875p AD=0.34p
+ PS=2.605u PD=2.68u rfmode=0
M$4843 \$1265 \$1380 \$1420 VDD sg13_lv_pmos L=0.13u W=0.42u AS=0.19115p
+ AD=0.0525p PS=1.565u PD=0.67u rfmode=0
M$4844 \$1420 \$1365 VDD VDD sg13_lv_pmos L=0.13u W=0.42u AS=0.0525p
+ AD=0.25605p PS=0.67u PD=1.935u rfmode=0
M$4845 VDD VDD \$1365 VDD sg13_lv_pmos L=0.13u W=0.42u AS=0.25605p AD=0.0798p
+ PS=1.935u PD=0.8u rfmode=0
M$4846 VDD \$1265 \$1365 VDD sg13_lv_pmos L=0.13u W=0.42u AS=0.2014p AD=0.0798p
+ PS=1.53u PD=0.8u rfmode=0
M$4847 VDD \$1265 \$1267 VDD sg13_lv_pmos L=0.13u W=1u AS=0.2083p AD=0.34p
+ PS=1.5u PD=2.68u rfmode=0
M$4848 VDD \$1265 \$1266 VDD sg13_lv_pmos L=0.13u W=2.24u AS=0.4142p AD=0.4211p
+ PS=3.03u PD=3u rfmode=0
M$4850 \$1212 \$1213 \$1265 VDD sg13_lv_pmos L=0.13u W=1u AS=0.34p AD=0.19115p
+ PS=2.68u PD=1.565u rfmode=0
M$4851 \$1214 \$199 \$1435 VDD sg13_lv_pmos L=0.13u W=0.84u AS=0.2856p
+ AD=0.1596p PS=2.36u PD=1.22u rfmode=0
M$4852 VDD \$266 \$1435 VDD sg13_lv_pmos L=0.13u W=0.84u AS=0.2226p AD=0.1596p
+ PS=1.535u PD=1.22u rfmode=0
M$4853 VDD \$1214 \$1215 VDD sg13_lv_pmos L=0.13u W=2.24u AS=0.4746p AD=0.6776p
+ PS=3.105u PD=4.57u rfmode=0
M$4855 VDD \$1271 \$1272 VDD sg13_lv_pmos L=0.13u W=0.42u AS=0.1428p AD=0.0798p
+ PS=1.52u PD=0.8u rfmode=0
M$4856 VDD VDD \$1272 VDD sg13_lv_pmos L=0.13u W=0.42u AS=0.3623875p AD=0.0798p
+ PS=2.605u PD=0.8u rfmode=0
M$4857 VDD \$1366 \$1216 VDD sg13_lv_pmos L=0.13u W=1u AS=0.3623875p AD=0.34p
+ PS=2.605u PD=2.68u rfmode=0
M$4858 \$1275 \$1382 \$1429 VDD sg13_lv_pmos L=0.13u W=0.42u AS=0.19115p
+ AD=0.0525p PS=1.565u PD=0.67u rfmode=0
M$4859 \$1429 \$1367 VDD VDD sg13_lv_pmos L=0.13u W=0.42u AS=0.0525p
+ AD=0.25605p PS=0.67u PD=1.935u rfmode=0
M$4860 VDD VDD \$1367 VDD sg13_lv_pmos L=0.13u W=0.42u AS=0.25605p AD=0.0798p
+ PS=1.935u PD=0.8u rfmode=0
M$4861 VDD \$1275 \$1367 VDD sg13_lv_pmos L=0.13u W=0.42u AS=0.2014p AD=0.0798p
+ PS=1.53u PD=0.8u rfmode=0
M$4862 VDD \$1275 \$1277 VDD sg13_lv_pmos L=0.13u W=1u AS=0.2083p AD=0.34p
+ PS=1.5u PD=2.68u rfmode=0
M$4863 VDD \$1275 \$1276 VDD sg13_lv_pmos L=0.13u W=2.24u AS=0.4142p AD=0.4211p
+ PS=3.03u PD=3u rfmode=0
M$4865 \$1216 \$1217 \$1275 VDD sg13_lv_pmos L=0.13u W=1u AS=0.34p AD=0.19115p
+ PS=2.68u PD=1.565u rfmode=0
M$4866 \$1218 \$202 \$1436 VDD sg13_lv_pmos L=0.13u W=0.84u AS=0.2856p
+ AD=0.1596p PS=2.36u PD=1.22u rfmode=0
M$4867 VDD \$266 \$1436 VDD sg13_lv_pmos L=0.13u W=0.84u AS=0.2226p AD=0.1596p
+ PS=1.535u PD=1.22u rfmode=0
M$4868 VDD \$1218 \$1219 VDD sg13_lv_pmos L=0.13u W=2.24u AS=0.4746p AD=0.6776p
+ PS=3.105u PD=4.57u rfmode=0
M$4870 VDD \$1281 \$1282 VDD sg13_lv_pmos L=0.13u W=0.42u AS=0.1428p AD=0.0798p
+ PS=1.52u PD=0.8u rfmode=0
M$4871 VDD VDD \$1282 VDD sg13_lv_pmos L=0.13u W=0.42u AS=0.3623875p AD=0.0798p
+ PS=2.605u PD=0.8u rfmode=0
M$4872 VDD \$1368 \$1220 VDD sg13_lv_pmos L=0.13u W=1u AS=0.3623875p AD=0.34p
+ PS=2.605u PD=2.68u rfmode=0
M$4873 \$1285 \$1384 \$1418 VDD sg13_lv_pmos L=0.13u W=0.42u AS=0.19115p
+ AD=0.0525p PS=1.565u PD=0.67u rfmode=0
M$4874 \$1418 \$1369 VDD VDD sg13_lv_pmos L=0.13u W=0.42u AS=0.0525p
+ AD=0.25605p PS=0.67u PD=1.935u rfmode=0
M$4875 VDD VDD \$1369 VDD sg13_lv_pmos L=0.13u W=0.42u AS=0.25605p AD=0.0798p
+ PS=1.935u PD=0.8u rfmode=0
M$4876 VDD \$1285 \$1369 VDD sg13_lv_pmos L=0.13u W=0.42u AS=0.2014p AD=0.0798p
+ PS=1.53u PD=0.8u rfmode=0
M$4877 VDD \$1285 \$1287 VDD sg13_lv_pmos L=0.13u W=1u AS=0.2083p AD=0.34p
+ PS=1.5u PD=2.68u rfmode=0
M$4878 VDD \$1285 \$1286 VDD sg13_lv_pmos L=0.13u W=2.24u AS=0.4142p AD=0.4211p
+ PS=3.03u PD=3u rfmode=0
M$4880 \$1220 \$1221 \$1285 VDD sg13_lv_pmos L=0.13u W=1u AS=0.34p AD=0.19115p
+ PS=2.68u PD=1.565u rfmode=0
M$4881 \$1222 \$205 \$1437 VDD sg13_lv_pmos L=0.13u W=0.84u AS=0.2856p
+ AD=0.1596p PS=2.36u PD=1.22u rfmode=0
M$4882 VDD \$266 \$1437 VDD sg13_lv_pmos L=0.13u W=0.84u AS=0.2226p AD=0.1596p
+ PS=1.535u PD=1.22u rfmode=0
M$4883 VDD \$1222 \$1223 VDD sg13_lv_pmos L=0.13u W=2.24u AS=0.4746p AD=0.6776p
+ PS=3.105u PD=4.57u rfmode=0
M$4885 VDD \$1291 \$1292 VDD sg13_lv_pmos L=0.13u W=0.42u AS=0.1428p AD=0.0798p
+ PS=1.52u PD=0.8u rfmode=0
M$4886 VDD VDD \$1292 VDD sg13_lv_pmos L=0.13u W=0.42u AS=0.3623875p AD=0.0798p
+ PS=2.605u PD=0.8u rfmode=0
M$4887 VDD \$1370 \$1224 VDD sg13_lv_pmos L=0.13u W=1u AS=0.3623875p AD=0.34p
+ PS=2.605u PD=2.68u rfmode=0
M$4888 \$1295 \$1386 \$1408 VDD sg13_lv_pmos L=0.13u W=0.42u AS=0.19115p
+ AD=0.0525p PS=1.565u PD=0.67u rfmode=0
M$4889 \$1408 \$1371 VDD VDD sg13_lv_pmos L=0.13u W=0.42u AS=0.0525p
+ AD=0.25605p PS=0.67u PD=1.935u rfmode=0
M$4890 VDD VDD \$1371 VDD sg13_lv_pmos L=0.13u W=0.42u AS=0.25605p AD=0.0798p
+ PS=1.935u PD=0.8u rfmode=0
M$4891 VDD \$1295 \$1371 VDD sg13_lv_pmos L=0.13u W=0.42u AS=0.2014p AD=0.0798p
+ PS=1.53u PD=0.8u rfmode=0
M$4892 VDD \$1295 \$1297 VDD sg13_lv_pmos L=0.13u W=1u AS=0.2083p AD=0.34p
+ PS=1.5u PD=2.68u rfmode=0
M$4893 VDD \$1295 \$1296 VDD sg13_lv_pmos L=0.13u W=2.24u AS=0.4142p AD=0.4211p
+ PS=3.03u PD=3u rfmode=0
M$4895 \$1224 \$1225 \$1295 VDD sg13_lv_pmos L=0.13u W=1u AS=0.34p AD=0.19115p
+ PS=2.68u PD=1.565u rfmode=0
M$4896 \$1226 VSS \$1434 VDD sg13_lv_pmos L=0.13u W=0.84u AS=0.2856p AD=0.1596p
+ PS=2.36u PD=1.22u rfmode=0
M$4897 VDD \$266 \$1434 VDD sg13_lv_pmos L=0.13u W=0.84u AS=0.2226p AD=0.1596p
+ PS=1.535u PD=1.22u rfmode=0
M$4898 VDD \$1226 \$1227 VDD sg13_lv_pmos L=0.13u W=2.24u AS=0.4746p AD=0.6776p
+ PS=3.105u PD=4.57u rfmode=0
M$4900 VDD \$1301 \$1302 VDD sg13_lv_pmos L=0.13u W=0.42u AS=0.1428p AD=0.0798p
+ PS=1.52u PD=0.8u rfmode=0
M$4901 VDD VDD \$1302 VDD sg13_lv_pmos L=0.13u W=0.42u AS=0.3623875p AD=0.0798p
+ PS=2.605u PD=0.8u rfmode=0
M$4902 VDD \$1372 \$1228 VDD sg13_lv_pmos L=0.13u W=1u AS=0.3623875p AD=0.34p
+ PS=2.605u PD=2.68u rfmode=0
M$4903 \$1305 \$1388 \$1395 VDD sg13_lv_pmos L=0.13u W=0.42u AS=0.19115p
+ AD=0.0525p PS=1.565u PD=0.67u rfmode=0
M$4904 \$1395 \$1373 VDD VDD sg13_lv_pmos L=0.13u W=0.42u AS=0.0525p
+ AD=0.25605p PS=0.67u PD=1.935u rfmode=0
M$4905 VDD VDD \$1373 VDD sg13_lv_pmos L=0.13u W=0.42u AS=0.25605p AD=0.0798p
+ PS=1.935u PD=0.8u rfmode=0
M$4906 VDD \$1305 \$1373 VDD sg13_lv_pmos L=0.13u W=0.42u AS=0.2014p AD=0.0798p
+ PS=1.53u PD=0.8u rfmode=0
M$4907 VDD \$1305 \$1307 VDD sg13_lv_pmos L=0.13u W=1u AS=0.2083p AD=0.34p
+ PS=1.5u PD=2.68u rfmode=0
M$4908 VDD \$1305 \$1306 VDD sg13_lv_pmos L=0.13u W=2.24u AS=0.4142p AD=0.4211p
+ PS=3.03u PD=3u rfmode=0
M$4910 \$1228 \$1229 \$1305 VDD sg13_lv_pmos L=0.13u W=1u AS=0.34p AD=0.19115p
+ PS=2.68u PD=1.565u rfmode=0
M$4911 VDD \$1487 \$1519 VDD sg13_lv_pmos L=0.13u W=2.24u AS=0.616p AD=0.4312p
+ PS=4.46u PD=3.01u rfmode=0
M$4913 VDD \$266 \$1519 VDD sg13_lv_pmos L=0.13u W=2.24u AS=0.4312p AD=0.6048p
+ PS=3.01u PD=4.44u rfmode=0
M$4915 VDD \$1519 \$1520 VDD sg13_lv_pmos L=0.13u W=0.42u AS=0.1428p AD=0.0798p
+ PS=1.52u PD=0.8u rfmode=0
M$4916 VDD VDD \$1520 VDD sg13_lv_pmos L=0.13u W=0.42u AS=0.3623875p AD=0.0798p
+ PS=2.605u PD=0.8u rfmode=0
M$4917 VDD \$1646 \$1488 VDD sg13_lv_pmos L=0.13u W=1u AS=0.3623875p AD=0.34p
+ PS=2.605u PD=2.68u rfmode=0
M$4918 \$1358 VDD VDD VDD sg13_lv_pmos L=0.13u W=0.42u AS=0.147p AD=0.1563p
+ PS=1.54u PD=1.22u rfmode=0
M$4919 VDD \$1200 \$1393 VDD sg13_lv_pmos L=0.13u W=0.42u AS=0.1563p AD=0.0546p
+ PS=1.22u PD=0.68u rfmode=0
M$4920 \$1393 \$1201 \$1358 VDD sg13_lv_pmos L=0.13u W=0.42u AS=0.0546p
+ AD=0.0798p PS=0.68u PD=0.8u rfmode=0
M$4921 \$1358 \$1374 \$1232 VDD sg13_lv_pmos L=0.13u W=0.42u AS=0.0798p
+ AD=0.1428p PS=0.8u PD=1.52u rfmode=0
M$4922 \$1662 \$1489 VDD VDD sg13_lv_pmos L=0.13u W=1.12u AS=0.3864p
+ AD=0.431025p PS=2.93u PD=2.145u rfmode=0
M$4923 VDD CLK \$1489 VDD sg13_lv_pmos L=0.13u W=1.12u AS=0.431025p AD=0.3808p
+ PS=2.145u PD=2.92u rfmode=0
M$4924 \$1523 \$1662 \$1682 VDD sg13_lv_pmos L=0.13u W=0.42u AS=0.19115p
+ AD=0.0525p PS=1.565u PD=0.67u rfmode=0
M$4925 \$1682 \$1647 VDD VDD sg13_lv_pmos L=0.13u W=0.42u AS=0.0525p
+ AD=0.25605p PS=0.67u PD=1.935u rfmode=0
M$4926 VDD VDD \$1647 VDD sg13_lv_pmos L=0.13u W=0.42u AS=0.25605p AD=0.0798p
+ PS=1.935u PD=0.8u rfmode=0
M$4927 VDD \$1523 \$1647 VDD sg13_lv_pmos L=0.13u W=0.42u AS=0.2014p AD=0.0798p
+ PS=1.53u PD=0.8u rfmode=0
M$4928 VDD \$1523 \$1525 VDD sg13_lv_pmos L=0.13u W=1u AS=0.2083p AD=0.34p
+ PS=1.5u PD=2.68u rfmode=0
M$4929 VDD \$1523 \$1524 VDD sg13_lv_pmos L=0.13u W=2.24u AS=0.4142p AD=0.4211p
+ PS=3.03u PD=3u rfmode=0
M$4931 \$1488 \$1489 \$1523 VDD sg13_lv_pmos L=0.13u W=1u AS=0.34p AD=0.19115p
+ PS=2.68u PD=1.565u rfmode=0
M$4932 VDD \$1525 \$1526 VDD sg13_lv_pmos L=0.13u W=2.24u AS=0.5964p AD=0.5964p
+ PS=4.425u PD=4.425u rfmode=0
M$4934 VDD \$1491 \$1529 VDD sg13_lv_pmos L=0.13u W=2.24u AS=0.616p AD=0.4312p
+ PS=4.46u PD=3.01u rfmode=0
M$4936 VDD \$266 \$1529 VDD sg13_lv_pmos L=0.13u W=2.24u AS=0.4312p AD=0.6048p
+ PS=3.01u PD=4.44u rfmode=0
M$4938 VDD \$1529 \$1530 VDD sg13_lv_pmos L=0.13u W=0.42u AS=0.1428p AD=0.0798p
+ PS=1.52u PD=0.8u rfmode=0
M$4939 VDD VDD \$1530 VDD sg13_lv_pmos L=0.13u W=0.42u AS=0.3623875p AD=0.0798p
+ PS=2.605u PD=0.8u rfmode=0
M$4940 VDD \$1648 \$1492 VDD sg13_lv_pmos L=0.13u W=1u AS=0.3623875p AD=0.34p
+ PS=2.605u PD=2.68u rfmode=0
M$4941 \$1360 VDD VDD VDD sg13_lv_pmos L=0.13u W=0.42u AS=0.147p AD=0.1563p
+ PS=1.54u PD=1.22u rfmode=0
M$4942 VDD \$1204 \$1401 VDD sg13_lv_pmos L=0.13u W=0.42u AS=0.1563p AD=0.0546p
+ PS=1.22u PD=0.68u rfmode=0
M$4943 \$1401 \$1205 \$1360 VDD sg13_lv_pmos L=0.13u W=0.42u AS=0.0546p
+ AD=0.0798p PS=0.68u PD=0.8u rfmode=0
M$4944 \$1360 \$1376 \$1242 VDD sg13_lv_pmos L=0.13u W=0.42u AS=0.0798p
+ AD=0.1428p PS=0.8u PD=1.52u rfmode=0
M$4945 \$1664 \$1493 VDD VDD sg13_lv_pmos L=0.13u W=1.12u AS=0.3864p
+ AD=0.431025p PS=2.93u PD=2.145u rfmode=0
M$4946 VDD CLK \$1493 VDD sg13_lv_pmos L=0.13u W=1.12u AS=0.431025p AD=0.3808p
+ PS=2.145u PD=2.92u rfmode=0
M$4947 \$1533 \$1664 \$1690 VDD sg13_lv_pmos L=0.13u W=0.42u AS=0.19115p
+ AD=0.0525p PS=1.565u PD=0.67u rfmode=0
M$4948 \$1690 \$1649 VDD VDD sg13_lv_pmos L=0.13u W=0.42u AS=0.0525p
+ AD=0.25605p PS=0.67u PD=1.935u rfmode=0
M$4949 VDD VDD \$1649 VDD sg13_lv_pmos L=0.13u W=0.42u AS=0.25605p AD=0.0798p
+ PS=1.935u PD=0.8u rfmode=0
M$4950 VDD \$1533 \$1649 VDD sg13_lv_pmos L=0.13u W=0.42u AS=0.2014p AD=0.0798p
+ PS=1.53u PD=0.8u rfmode=0
M$4951 VDD \$1533 \$1535 VDD sg13_lv_pmos L=0.13u W=1u AS=0.2083p AD=0.34p
+ PS=1.5u PD=2.68u rfmode=0
M$4952 VDD \$1533 \$1534 VDD sg13_lv_pmos L=0.13u W=2.24u AS=0.4142p AD=0.4211p
+ PS=3.03u PD=3u rfmode=0
M$4954 \$1492 \$1493 \$1533 VDD sg13_lv_pmos L=0.13u W=1u AS=0.34p AD=0.19115p
+ PS=2.68u PD=1.565u rfmode=0
M$4955 VDD \$1535 \$1536 VDD sg13_lv_pmos L=0.13u W=2.24u AS=0.5964p AD=0.5964p
+ PS=4.425u PD=4.425u rfmode=0
M$4957 VDD \$1495 \$1539 VDD sg13_lv_pmos L=0.13u W=2.24u AS=0.616p AD=0.4312p
+ PS=4.46u PD=3.01u rfmode=0
M$4959 VDD \$266 \$1539 VDD sg13_lv_pmos L=0.13u W=2.24u AS=0.4312p AD=0.6048p
+ PS=3.01u PD=4.44u rfmode=0
M$4961 VDD \$1539 \$1540 VDD sg13_lv_pmos L=0.13u W=0.42u AS=0.1428p AD=0.0798p
+ PS=1.52u PD=0.8u rfmode=0
M$4962 VDD VDD \$1540 VDD sg13_lv_pmos L=0.13u W=0.42u AS=0.3623875p AD=0.0798p
+ PS=2.605u PD=0.8u rfmode=0
M$4963 VDD \$1650 \$1496 VDD sg13_lv_pmos L=0.13u W=1u AS=0.3623875p AD=0.34p
+ PS=2.605u PD=2.68u rfmode=0
M$4964 \$1362 VDD VDD VDD sg13_lv_pmos L=0.13u W=0.42u AS=0.147p AD=0.1563p
+ PS=1.54u PD=1.22u rfmode=0
M$4965 VDD \$1208 \$1410 VDD sg13_lv_pmos L=0.13u W=0.42u AS=0.1563p AD=0.0546p
+ PS=1.22u PD=0.68u rfmode=0
M$4966 \$1410 \$1209 \$1362 VDD sg13_lv_pmos L=0.13u W=0.42u AS=0.0546p
+ AD=0.0798p PS=0.68u PD=0.8u rfmode=0
M$4967 \$1362 \$1378 \$1252 VDD sg13_lv_pmos L=0.13u W=0.42u AS=0.0798p
+ AD=0.1428p PS=0.8u PD=1.52u rfmode=0
M$4968 \$1666 \$1497 VDD VDD sg13_lv_pmos L=0.13u W=1.12u AS=0.3864p
+ AD=0.431025p PS=2.93u PD=2.145u rfmode=0
M$4969 VDD CLK \$1497 VDD sg13_lv_pmos L=0.13u W=1.12u AS=0.431025p AD=0.3808p
+ PS=2.145u PD=2.92u rfmode=0
M$4970 \$1543 \$1666 \$1698 VDD sg13_lv_pmos L=0.13u W=0.42u AS=0.19115p
+ AD=0.0525p PS=1.565u PD=0.67u rfmode=0
M$4971 \$1698 \$1651 VDD VDD sg13_lv_pmos L=0.13u W=0.42u AS=0.0525p
+ AD=0.25605p PS=0.67u PD=1.935u rfmode=0
M$4972 VDD VDD \$1651 VDD sg13_lv_pmos L=0.13u W=0.42u AS=0.25605p AD=0.0798p
+ PS=1.935u PD=0.8u rfmode=0
M$4973 VDD \$1543 \$1651 VDD sg13_lv_pmos L=0.13u W=0.42u AS=0.2014p AD=0.0798p
+ PS=1.53u PD=0.8u rfmode=0
M$4974 VDD \$1543 \$1545 VDD sg13_lv_pmos L=0.13u W=1u AS=0.2083p AD=0.34p
+ PS=1.5u PD=2.68u rfmode=0
M$4975 VDD \$1543 \$1544 VDD sg13_lv_pmos L=0.13u W=2.24u AS=0.4142p AD=0.4211p
+ PS=3.03u PD=3u rfmode=0
M$4977 \$1496 \$1497 \$1543 VDD sg13_lv_pmos L=0.13u W=1u AS=0.34p AD=0.19115p
+ PS=2.68u PD=1.565u rfmode=0
M$4978 VDD \$1545 \$1546 VDD sg13_lv_pmos L=0.13u W=2.24u AS=0.5964p AD=0.5964p
+ PS=4.425u PD=4.425u rfmode=0
M$4980 VDD \$1499 \$1549 VDD sg13_lv_pmos L=0.13u W=2.24u AS=0.616p AD=0.4312p
+ PS=4.46u PD=3.01u rfmode=0
M$4982 VDD \$266 \$1549 VDD sg13_lv_pmos L=0.13u W=2.24u AS=0.4312p AD=0.6048p
+ PS=3.01u PD=4.44u rfmode=0
M$4984 VDD \$1549 \$1550 VDD sg13_lv_pmos L=0.13u W=0.42u AS=0.1428p AD=0.0798p
+ PS=1.52u PD=0.8u rfmode=0
M$4985 VDD VDD \$1550 VDD sg13_lv_pmos L=0.13u W=0.42u AS=0.3623875p AD=0.0798p
+ PS=2.605u PD=0.8u rfmode=0
M$4986 VDD \$1652 \$1500 VDD sg13_lv_pmos L=0.13u W=1u AS=0.3623875p AD=0.34p
+ PS=2.605u PD=2.68u rfmode=0
M$4987 \$1364 VDD VDD VDD sg13_lv_pmos L=0.13u W=0.42u AS=0.147p AD=0.1563p
+ PS=1.54u PD=1.22u rfmode=0
M$4988 VDD \$1212 \$1419 VDD sg13_lv_pmos L=0.13u W=0.42u AS=0.1563p AD=0.0546p
+ PS=1.22u PD=0.68u rfmode=0
M$4989 \$1419 \$1213 \$1364 VDD sg13_lv_pmos L=0.13u W=0.42u AS=0.0546p
+ AD=0.0798p PS=0.68u PD=0.8u rfmode=0
M$4990 \$1364 \$1380 \$1262 VDD sg13_lv_pmos L=0.13u W=0.42u AS=0.0798p
+ AD=0.1428p PS=0.8u PD=1.52u rfmode=0
M$4991 \$1668 \$1501 VDD VDD sg13_lv_pmos L=0.13u W=1.12u AS=0.3864p
+ AD=0.431025p PS=2.93u PD=2.145u rfmode=0
M$4992 VDD CLK \$1501 VDD sg13_lv_pmos L=0.13u W=1.12u AS=0.431025p AD=0.3808p
+ PS=2.145u PD=2.92u rfmode=0
M$4993 \$1553 \$1668 \$1706 VDD sg13_lv_pmos L=0.13u W=0.42u AS=0.19115p
+ AD=0.0525p PS=1.565u PD=0.67u rfmode=0
M$4994 \$1706 \$1653 VDD VDD sg13_lv_pmos L=0.13u W=0.42u AS=0.0525p
+ AD=0.25605p PS=0.67u PD=1.935u rfmode=0
M$4995 VDD VDD \$1653 VDD sg13_lv_pmos L=0.13u W=0.42u AS=0.25605p AD=0.0798p
+ PS=1.935u PD=0.8u rfmode=0
M$4996 VDD \$1553 \$1653 VDD sg13_lv_pmos L=0.13u W=0.42u AS=0.2014p AD=0.0798p
+ PS=1.53u PD=0.8u rfmode=0
M$4997 VDD \$1553 \$1555 VDD sg13_lv_pmos L=0.13u W=1u AS=0.2083p AD=0.34p
+ PS=1.5u PD=2.68u rfmode=0
M$4998 VDD \$1553 \$1554 VDD sg13_lv_pmos L=0.13u W=2.24u AS=0.4142p AD=0.4211p
+ PS=3.03u PD=3u rfmode=0
M$5000 \$1500 \$1501 \$1553 VDD sg13_lv_pmos L=0.13u W=1u AS=0.34p AD=0.19115p
+ PS=2.68u PD=1.565u rfmode=0
M$5001 VDD \$1555 \$1556 VDD sg13_lv_pmos L=0.13u W=2.24u AS=0.5964p AD=0.5964p
+ PS=4.425u PD=4.425u rfmode=0
M$5003 VDD \$1503 \$1559 VDD sg13_lv_pmos L=0.13u W=2.24u AS=0.616p AD=0.4312p
+ PS=4.46u PD=3.01u rfmode=0
M$5005 VDD \$266 \$1559 VDD sg13_lv_pmos L=0.13u W=2.24u AS=0.4312p AD=0.6048p
+ PS=3.01u PD=4.44u rfmode=0
M$5007 VDD \$1559 \$1560 VDD sg13_lv_pmos L=0.13u W=0.42u AS=0.1428p AD=0.0798p
+ PS=1.52u PD=0.8u rfmode=0
M$5008 VDD VDD \$1560 VDD sg13_lv_pmos L=0.13u W=0.42u AS=0.3623875p AD=0.0798p
+ PS=2.605u PD=0.8u rfmode=0
M$5009 VDD \$1654 \$1504 VDD sg13_lv_pmos L=0.13u W=1u AS=0.3623875p AD=0.34p
+ PS=2.605u PD=2.68u rfmode=0
M$5010 \$1366 VDD VDD VDD sg13_lv_pmos L=0.13u W=0.42u AS=0.147p AD=0.1563p
+ PS=1.54u PD=1.22u rfmode=0
M$5011 VDD \$1216 \$1426 VDD sg13_lv_pmos L=0.13u W=0.42u AS=0.1563p AD=0.0546p
+ PS=1.22u PD=0.68u rfmode=0
M$5012 \$1426 \$1217 \$1366 VDD sg13_lv_pmos L=0.13u W=0.42u AS=0.0546p
+ AD=0.0798p PS=0.68u PD=0.8u rfmode=0
M$5013 \$1366 \$1382 \$1272 VDD sg13_lv_pmos L=0.13u W=0.42u AS=0.0798p
+ AD=0.1428p PS=0.8u PD=1.52u rfmode=0
M$5014 \$1670 \$1505 VDD VDD sg13_lv_pmos L=0.13u W=1.12u AS=0.3864p
+ AD=0.431025p PS=2.93u PD=2.145u rfmode=0
M$5015 VDD CLK \$1505 VDD sg13_lv_pmos L=0.13u W=1.12u AS=0.431025p AD=0.3808p
+ PS=2.145u PD=2.92u rfmode=0
M$5016 \$1563 \$1670 \$1714 VDD sg13_lv_pmos L=0.13u W=0.42u AS=0.19115p
+ AD=0.0525p PS=1.565u PD=0.67u rfmode=0
M$5017 \$1714 \$1655 VDD VDD sg13_lv_pmos L=0.13u W=0.42u AS=0.0525p
+ AD=0.25605p PS=0.67u PD=1.935u rfmode=0
M$5018 VDD VDD \$1655 VDD sg13_lv_pmos L=0.13u W=0.42u AS=0.25605p AD=0.0798p
+ PS=1.935u PD=0.8u rfmode=0
M$5019 VDD \$1563 \$1655 VDD sg13_lv_pmos L=0.13u W=0.42u AS=0.2014p AD=0.0798p
+ PS=1.53u PD=0.8u rfmode=0
M$5020 VDD \$1563 \$1565 VDD sg13_lv_pmos L=0.13u W=1u AS=0.2083p AD=0.34p
+ PS=1.5u PD=2.68u rfmode=0
M$5021 VDD \$1563 \$1564 VDD sg13_lv_pmos L=0.13u W=2.24u AS=0.4142p AD=0.4211p
+ PS=3.03u PD=3u rfmode=0
M$5023 \$1504 \$1505 \$1563 VDD sg13_lv_pmos L=0.13u W=1u AS=0.34p AD=0.19115p
+ PS=2.68u PD=1.565u rfmode=0
M$5024 VDD \$1565 \$1566 VDD sg13_lv_pmos L=0.13u W=2.24u AS=0.5964p AD=0.5964p
+ PS=4.425u PD=4.425u rfmode=0
M$5026 VDD \$1507 \$1569 VDD sg13_lv_pmos L=0.13u W=2.24u AS=0.616p AD=0.4312p
+ PS=4.46u PD=3.01u rfmode=0
M$5028 VDD \$266 \$1569 VDD sg13_lv_pmos L=0.13u W=2.24u AS=0.4312p AD=0.6048p
+ PS=3.01u PD=4.44u rfmode=0
M$5030 VDD \$1569 \$1570 VDD sg13_lv_pmos L=0.13u W=0.42u AS=0.1428p AD=0.0798p
+ PS=1.52u PD=0.8u rfmode=0
M$5031 VDD VDD \$1570 VDD sg13_lv_pmos L=0.13u W=0.42u AS=0.3623875p AD=0.0798p
+ PS=2.605u PD=0.8u rfmode=0
M$5032 VDD \$1656 \$1508 VDD sg13_lv_pmos L=0.13u W=1u AS=0.3623875p AD=0.34p
+ PS=2.605u PD=2.68u rfmode=0
M$5033 \$1368 VDD VDD VDD sg13_lv_pmos L=0.13u W=0.42u AS=0.147p AD=0.1563p
+ PS=1.54u PD=1.22u rfmode=0
M$5034 VDD \$1220 \$1421 VDD sg13_lv_pmos L=0.13u W=0.42u AS=0.1563p AD=0.0546p
+ PS=1.22u PD=0.68u rfmode=0
M$5035 \$1421 \$1221 \$1368 VDD sg13_lv_pmos L=0.13u W=0.42u AS=0.0546p
+ AD=0.0798p PS=0.68u PD=0.8u rfmode=0
M$5036 \$1368 \$1384 \$1282 VDD sg13_lv_pmos L=0.13u W=0.42u AS=0.0798p
+ AD=0.1428p PS=0.8u PD=1.52u rfmode=0
M$5037 \$1672 \$1509 VDD VDD sg13_lv_pmos L=0.13u W=1.12u AS=0.3864p
+ AD=0.431025p PS=2.93u PD=2.145u rfmode=0
M$5038 VDD CLK \$1509 VDD sg13_lv_pmos L=0.13u W=1.12u AS=0.431025p AD=0.3808p
+ PS=2.145u PD=2.92u rfmode=0
M$5039 \$1573 \$1672 \$1710 VDD sg13_lv_pmos L=0.13u W=0.42u AS=0.19115p
+ AD=0.0525p PS=1.565u PD=0.67u rfmode=0
M$5040 \$1710 \$1657 VDD VDD sg13_lv_pmos L=0.13u W=0.42u AS=0.0525p
+ AD=0.25605p PS=0.67u PD=1.935u rfmode=0
M$5041 VDD VDD \$1657 VDD sg13_lv_pmos L=0.13u W=0.42u AS=0.25605p AD=0.0798p
+ PS=1.935u PD=0.8u rfmode=0
M$5042 VDD \$1573 \$1657 VDD sg13_lv_pmos L=0.13u W=0.42u AS=0.2014p AD=0.0798p
+ PS=1.53u PD=0.8u rfmode=0
M$5043 VDD \$1573 \$1575 VDD sg13_lv_pmos L=0.13u W=1u AS=0.2083p AD=0.34p
+ PS=1.5u PD=2.68u rfmode=0
M$5044 VDD \$1573 \$1574 VDD sg13_lv_pmos L=0.13u W=2.24u AS=0.4142p AD=0.4211p
+ PS=3.03u PD=3u rfmode=0
M$5046 \$1508 \$1509 \$1573 VDD sg13_lv_pmos L=0.13u W=1u AS=0.34p AD=0.19115p
+ PS=2.68u PD=1.565u rfmode=0
M$5047 VDD \$1575 \$1576 VDD sg13_lv_pmos L=0.13u W=2.24u AS=0.5964p AD=0.5964p
+ PS=4.425u PD=4.425u rfmode=0
M$5049 VDD \$1511 \$1579 VDD sg13_lv_pmos L=0.13u W=2.24u AS=0.616p AD=0.4312p
+ PS=4.46u PD=3.01u rfmode=0
M$5051 VDD \$266 \$1579 VDD sg13_lv_pmos L=0.13u W=2.24u AS=0.4312p AD=0.6048p
+ PS=3.01u PD=4.44u rfmode=0
M$5053 VDD \$1579 \$1580 VDD sg13_lv_pmos L=0.13u W=0.42u AS=0.1428p AD=0.0798p
+ PS=1.52u PD=0.8u rfmode=0
M$5054 VDD VDD \$1580 VDD sg13_lv_pmos L=0.13u W=0.42u AS=0.3623875p AD=0.0798p
+ PS=2.605u PD=0.8u rfmode=0
M$5055 VDD \$1658 \$1512 VDD sg13_lv_pmos L=0.13u W=1u AS=0.3623875p AD=0.34p
+ PS=2.605u PD=2.68u rfmode=0
M$5056 \$1370 VDD VDD VDD sg13_lv_pmos L=0.13u W=0.42u AS=0.147p AD=0.1563p
+ PS=1.54u PD=1.22u rfmode=0
M$5057 VDD \$1224 \$1409 VDD sg13_lv_pmos L=0.13u W=0.42u AS=0.1563p AD=0.0546p
+ PS=1.22u PD=0.68u rfmode=0
M$5058 \$1409 \$1225 \$1370 VDD sg13_lv_pmos L=0.13u W=0.42u AS=0.0546p
+ AD=0.0798p PS=0.68u PD=0.8u rfmode=0
M$5059 \$1370 \$1386 \$1292 VDD sg13_lv_pmos L=0.13u W=0.42u AS=0.0798p
+ AD=0.1428p PS=0.8u PD=1.52u rfmode=0
M$5060 \$1674 \$1513 VDD VDD sg13_lv_pmos L=0.13u W=1.12u AS=0.3864p
+ AD=0.431025p PS=2.93u PD=2.145u rfmode=0
M$5061 VDD CLK \$1513 VDD sg13_lv_pmos L=0.13u W=1.12u AS=0.431025p AD=0.3808p
+ PS=2.145u PD=2.92u rfmode=0
M$5062 \$1583 \$1674 \$1696 VDD sg13_lv_pmos L=0.13u W=0.42u AS=0.19115p
+ AD=0.0525p PS=1.565u PD=0.67u rfmode=0
M$5063 \$1696 \$1659 VDD VDD sg13_lv_pmos L=0.13u W=0.42u AS=0.0525p
+ AD=0.25605p PS=0.67u PD=1.935u rfmode=0
M$5064 VDD VDD \$1659 VDD sg13_lv_pmos L=0.13u W=0.42u AS=0.25605p AD=0.0798p
+ PS=1.935u PD=0.8u rfmode=0
M$5065 VDD \$1583 \$1659 VDD sg13_lv_pmos L=0.13u W=0.42u AS=0.2014p AD=0.0798p
+ PS=1.53u PD=0.8u rfmode=0
M$5066 VDD \$1583 \$1585 VDD sg13_lv_pmos L=0.13u W=1u AS=0.2083p AD=0.34p
+ PS=1.5u PD=2.68u rfmode=0
M$5067 VDD \$1583 \$1584 VDD sg13_lv_pmos L=0.13u W=2.24u AS=0.4142p AD=0.4211p
+ PS=3.03u PD=3u rfmode=0
M$5069 \$1512 \$1513 \$1583 VDD sg13_lv_pmos L=0.13u W=1u AS=0.34p AD=0.19115p
+ PS=2.68u PD=1.565u rfmode=0
M$5070 VDD \$1585 \$1586 VDD sg13_lv_pmos L=0.13u W=2.24u AS=0.5964p AD=0.5964p
+ PS=4.425u PD=4.425u rfmode=0
M$5072 VDD \$1515 \$1589 VDD sg13_lv_pmos L=0.13u W=2.24u AS=0.616p AD=0.4312p
+ PS=4.46u PD=3.01u rfmode=0
M$5074 VDD \$266 \$1589 VDD sg13_lv_pmos L=0.13u W=2.24u AS=0.4312p AD=0.6048p
+ PS=3.01u PD=4.44u rfmode=0
M$5076 VDD \$1589 \$1590 VDD sg13_lv_pmos L=0.13u W=0.42u AS=0.1428p AD=0.0798p
+ PS=1.52u PD=0.8u rfmode=0
M$5077 VDD VDD \$1590 VDD sg13_lv_pmos L=0.13u W=0.42u AS=0.3623875p AD=0.0798p
+ PS=2.605u PD=0.8u rfmode=0
M$5078 VDD \$1660 \$1516 VDD sg13_lv_pmos L=0.13u W=1u AS=0.3623875p AD=0.34p
+ PS=2.605u PD=2.68u rfmode=0
M$5079 \$1372 VDD VDD VDD sg13_lv_pmos L=0.13u W=0.42u AS=0.147p AD=0.1563p
+ PS=1.54u PD=1.22u rfmode=0
M$5080 VDD \$1228 \$1398 VDD sg13_lv_pmos L=0.13u W=0.42u AS=0.1563p AD=0.0546p
+ PS=1.22u PD=0.68u rfmode=0
M$5081 \$1398 \$1229 \$1372 VDD sg13_lv_pmos L=0.13u W=0.42u AS=0.0546p
+ AD=0.0798p PS=0.68u PD=0.8u rfmode=0
M$5082 \$1372 \$1388 \$1302 VDD sg13_lv_pmos L=0.13u W=0.42u AS=0.0798p
+ AD=0.1428p PS=0.8u PD=1.52u rfmode=0
M$5083 \$1676 \$1517 VDD VDD sg13_lv_pmos L=0.13u W=1.12u AS=0.3864p
+ AD=0.431025p PS=2.93u PD=2.145u rfmode=0
M$5084 VDD CLK \$1517 VDD sg13_lv_pmos L=0.13u W=1.12u AS=0.431025p AD=0.3808p
+ PS=2.145u PD=2.92u rfmode=0
M$5085 \$1593 \$1676 \$1683 VDD sg13_lv_pmos L=0.13u W=0.42u AS=0.19115p
+ AD=0.0525p PS=1.565u PD=0.67u rfmode=0
M$5086 \$1683 \$1661 VDD VDD sg13_lv_pmos L=0.13u W=0.42u AS=0.0525p
+ AD=0.25605p PS=0.67u PD=1.935u rfmode=0
M$5087 VDD VDD \$1661 VDD sg13_lv_pmos L=0.13u W=0.42u AS=0.25605p AD=0.0798p
+ PS=1.935u PD=0.8u rfmode=0
M$5088 VDD \$1593 \$1661 VDD sg13_lv_pmos L=0.13u W=0.42u AS=0.2014p AD=0.0798p
+ PS=1.53u PD=0.8u rfmode=0
M$5089 VDD \$1593 \$1595 VDD sg13_lv_pmos L=0.13u W=1u AS=0.2083p AD=0.34p
+ PS=1.5u PD=2.68u rfmode=0
M$5090 VDD \$1593 \$1594 VDD sg13_lv_pmos L=0.13u W=2.24u AS=0.4142p AD=0.4211p
+ PS=3.03u PD=3u rfmode=0
M$5092 \$1516 \$1517 \$1593 VDD sg13_lv_pmos L=0.13u W=1u AS=0.34p AD=0.19115p
+ PS=2.68u PD=1.565u rfmode=0
M$5093 VDD \$1595 \$1596 VDD sg13_lv_pmos L=0.13u W=2.24u AS=0.5964p AD=0.5964p
+ PS=4.425u PD=4.425u rfmode=0
M$5095 \$1486 \$187 \$1718 VDD sg13_lv_pmos L=0.13u W=0.84u AS=0.2856p
+ AD=0.1596p PS=2.36u PD=1.22u rfmode=0
M$5096 VDD \$326 \$1718 VDD sg13_lv_pmos L=0.13u W=0.84u AS=0.2226p AD=0.1596p
+ PS=1.535u PD=1.22u rfmode=0
M$5097 VDD \$1486 \$1487 VDD sg13_lv_pmos L=0.13u W=2.24u AS=0.4746p AD=0.6776p
+ PS=3.105u PD=4.57u rfmode=0
M$5099 VDD \$1775 \$1807 VDD sg13_lv_pmos L=0.13u W=2.24u AS=0.616p AD=0.4312p
+ PS=4.46u PD=3.01u rfmode=0
M$5101 VDD \$326 \$1807 VDD sg13_lv_pmos L=0.13u W=2.24u AS=0.4312p AD=0.6048p
+ PS=3.01u PD=4.44u rfmode=0
M$5103 \$1646 VDD VDD VDD sg13_lv_pmos L=0.13u W=0.42u AS=0.147p AD=0.1563p
+ PS=1.54u PD=1.22u rfmode=0
M$5104 VDD \$1488 \$1680 VDD sg13_lv_pmos L=0.13u W=0.42u AS=0.1563p AD=0.0546p
+ PS=1.22u PD=0.68u rfmode=0
M$5105 \$1680 \$1489 \$1646 VDD sg13_lv_pmos L=0.13u W=0.42u AS=0.0546p
+ AD=0.0798p PS=0.68u PD=0.8u rfmode=0
M$5106 \$1646 \$1662 \$1520 VDD sg13_lv_pmos L=0.13u W=0.42u AS=0.0798p
+ AD=0.1428p PS=0.8u PD=1.52u rfmode=0
M$5107 \$1950 \$1777 VDD VDD sg13_lv_pmos L=0.13u W=1.12u AS=0.3864p
+ AD=0.431025p PS=2.93u PD=2.145u rfmode=0
M$5108 VDD CLK \$1777 VDD sg13_lv_pmos L=0.13u W=1.12u AS=0.431025p AD=0.3808p
+ PS=2.145u PD=2.92u rfmode=0
M$5109 VDD \$1813 \$1814 VDD sg13_lv_pmos L=0.13u W=2.24u AS=0.5964p AD=0.5964p
+ PS=4.425u PD=4.425u rfmode=0
M$5111 \$1490 \$190 \$1719 VDD sg13_lv_pmos L=0.13u W=0.84u AS=0.2856p
+ AD=0.1596p PS=2.36u PD=1.22u rfmode=0
M$5112 VDD \$326 \$1719 VDD sg13_lv_pmos L=0.13u W=0.84u AS=0.2226p AD=0.1596p
+ PS=1.535u PD=1.22u rfmode=0
M$5113 VDD \$1490 \$1491 VDD sg13_lv_pmos L=0.13u W=2.24u AS=0.4746p AD=0.6776p
+ PS=3.105u PD=4.57u rfmode=0
M$5115 VDD \$1779 \$1817 VDD sg13_lv_pmos L=0.13u W=2.24u AS=0.616p AD=0.4312p
+ PS=4.46u PD=3.01u rfmode=0
M$5117 VDD \$326 \$1817 VDD sg13_lv_pmos L=0.13u W=2.24u AS=0.4312p AD=0.6048p
+ PS=3.01u PD=4.44u rfmode=0
M$5119 \$1648 VDD VDD VDD sg13_lv_pmos L=0.13u W=0.42u AS=0.147p AD=0.1563p
+ PS=1.54u PD=1.22u rfmode=0
M$5120 VDD \$1492 \$1688 VDD sg13_lv_pmos L=0.13u W=0.42u AS=0.1563p AD=0.0546p
+ PS=1.22u PD=0.68u rfmode=0
M$5121 \$1688 \$1493 \$1648 VDD sg13_lv_pmos L=0.13u W=0.42u AS=0.0546p
+ AD=0.0798p PS=0.68u PD=0.8u rfmode=0
M$5122 \$1648 \$1664 \$1530 VDD sg13_lv_pmos L=0.13u W=0.42u AS=0.0798p
+ AD=0.1428p PS=0.8u PD=1.52u rfmode=0
M$5123 \$1952 \$1781 VDD VDD sg13_lv_pmos L=0.13u W=1.12u AS=0.3864p
+ AD=0.431025p PS=2.93u PD=2.145u rfmode=0
M$5124 VDD CLK \$1781 VDD sg13_lv_pmos L=0.13u W=1.12u AS=0.431025p AD=0.3808p
+ PS=2.145u PD=2.92u rfmode=0
M$5125 VDD \$1823 \$1824 VDD sg13_lv_pmos L=0.13u W=2.24u AS=0.5964p AD=0.5964p
+ PS=4.425u PD=4.425u rfmode=0
M$5127 \$1494 \$193 \$1720 VDD sg13_lv_pmos L=0.13u W=0.84u AS=0.2856p
+ AD=0.1596p PS=2.36u PD=1.22u rfmode=0
M$5128 VDD \$326 \$1720 VDD sg13_lv_pmos L=0.13u W=0.84u AS=0.2226p AD=0.1596p
+ PS=1.535u PD=1.22u rfmode=0
M$5129 VDD \$1494 \$1495 VDD sg13_lv_pmos L=0.13u W=2.24u AS=0.4746p AD=0.6776p
+ PS=3.105u PD=4.57u rfmode=0
M$5131 VDD \$1783 \$1827 VDD sg13_lv_pmos L=0.13u W=2.24u AS=0.616p AD=0.4312p
+ PS=4.46u PD=3.01u rfmode=0
M$5133 VDD \$326 \$1827 VDD sg13_lv_pmos L=0.13u W=2.24u AS=0.4312p AD=0.6048p
+ PS=3.01u PD=4.44u rfmode=0
M$5135 \$1650 VDD VDD VDD sg13_lv_pmos L=0.13u W=0.42u AS=0.147p AD=0.1563p
+ PS=1.54u PD=1.22u rfmode=0
M$5136 VDD \$1496 \$1697 VDD sg13_lv_pmos L=0.13u W=0.42u AS=0.1563p AD=0.0546p
+ PS=1.22u PD=0.68u rfmode=0
M$5137 \$1697 \$1497 \$1650 VDD sg13_lv_pmos L=0.13u W=0.42u AS=0.0546p
+ AD=0.0798p PS=0.68u PD=0.8u rfmode=0
M$5138 \$1650 \$1666 \$1540 VDD sg13_lv_pmos L=0.13u W=0.42u AS=0.0798p
+ AD=0.1428p PS=0.8u PD=1.52u rfmode=0
M$5139 \$1954 \$1785 VDD VDD sg13_lv_pmos L=0.13u W=1.12u AS=0.3864p
+ AD=0.431025p PS=2.93u PD=2.145u rfmode=0
M$5140 VDD CLK \$1785 VDD sg13_lv_pmos L=0.13u W=1.12u AS=0.431025p AD=0.3808p
+ PS=2.145u PD=2.92u rfmode=0
M$5141 VDD \$1833 \$1834 VDD sg13_lv_pmos L=0.13u W=2.24u AS=0.5964p AD=0.5964p
+ PS=4.425u PD=4.425u rfmode=0
M$5143 \$1498 \$196 \$1721 VDD sg13_lv_pmos L=0.13u W=0.84u AS=0.2856p
+ AD=0.1596p PS=2.36u PD=1.22u rfmode=0
M$5144 VDD \$326 \$1721 VDD sg13_lv_pmos L=0.13u W=0.84u AS=0.2226p AD=0.1596p
+ PS=1.535u PD=1.22u rfmode=0
M$5145 VDD \$1498 \$1499 VDD sg13_lv_pmos L=0.13u W=2.24u AS=0.4746p AD=0.6776p
+ PS=3.105u PD=4.57u rfmode=0
M$5147 VDD \$1787 \$1837 VDD sg13_lv_pmos L=0.13u W=2.24u AS=0.616p AD=0.4312p
+ PS=4.46u PD=3.01u rfmode=0
M$5149 VDD \$326 \$1837 VDD sg13_lv_pmos L=0.13u W=2.24u AS=0.4312p AD=0.6048p
+ PS=3.01u PD=4.44u rfmode=0
M$5151 \$1652 VDD VDD VDD sg13_lv_pmos L=0.13u W=0.42u AS=0.147p AD=0.1563p
+ PS=1.54u PD=1.22u rfmode=0
M$5152 VDD \$1500 \$1704 VDD sg13_lv_pmos L=0.13u W=0.42u AS=0.1563p AD=0.0546p
+ PS=1.22u PD=0.68u rfmode=0
M$5153 \$1704 \$1501 \$1652 VDD sg13_lv_pmos L=0.13u W=0.42u AS=0.0546p
+ AD=0.0798p PS=0.68u PD=0.8u rfmode=0
M$5154 \$1652 \$1668 \$1550 VDD sg13_lv_pmos L=0.13u W=0.42u AS=0.0798p
+ AD=0.1428p PS=0.8u PD=1.52u rfmode=0
M$5155 \$1956 \$1789 VDD VDD sg13_lv_pmos L=0.13u W=1.12u AS=0.3864p
+ AD=0.431025p PS=2.93u PD=2.145u rfmode=0
M$5156 VDD CLK \$1789 VDD sg13_lv_pmos L=0.13u W=1.12u AS=0.431025p AD=0.3808p
+ PS=2.145u PD=2.92u rfmode=0
M$5157 VDD \$1843 \$1844 VDD sg13_lv_pmos L=0.13u W=2.24u AS=0.5964p AD=0.5964p
+ PS=4.425u PD=4.425u rfmode=0
M$5159 \$1502 \$199 \$1723 VDD sg13_lv_pmos L=0.13u W=0.84u AS=0.2856p
+ AD=0.1596p PS=2.36u PD=1.22u rfmode=0
M$5160 VDD \$326 \$1723 VDD sg13_lv_pmos L=0.13u W=0.84u AS=0.2226p AD=0.1596p
+ PS=1.535u PD=1.22u rfmode=0
M$5161 VDD \$1502 \$1503 VDD sg13_lv_pmos L=0.13u W=2.24u AS=0.4746p AD=0.6776p
+ PS=3.105u PD=4.57u rfmode=0
M$5163 VDD \$1791 \$1847 VDD sg13_lv_pmos L=0.13u W=2.24u AS=0.616p AD=0.4312p
+ PS=4.46u PD=3.01u rfmode=0
M$5165 VDD \$326 \$1847 VDD sg13_lv_pmos L=0.13u W=2.24u AS=0.4312p AD=0.6048p
+ PS=3.01u PD=4.44u rfmode=0
M$5167 \$1654 VDD VDD VDD sg13_lv_pmos L=0.13u W=0.42u AS=0.147p AD=0.1563p
+ PS=1.54u PD=1.22u rfmode=0
M$5168 VDD \$1504 \$1713 VDD sg13_lv_pmos L=0.13u W=0.42u AS=0.1563p AD=0.0546p
+ PS=1.22u PD=0.68u rfmode=0
M$5169 \$1713 \$1505 \$1654 VDD sg13_lv_pmos L=0.13u W=0.42u AS=0.0546p
+ AD=0.0798p PS=0.68u PD=0.8u rfmode=0
M$5170 \$1654 \$1670 \$1560 VDD sg13_lv_pmos L=0.13u W=0.42u AS=0.0798p
+ AD=0.1428p PS=0.8u PD=1.52u rfmode=0
M$5171 \$1958 \$1793 VDD VDD sg13_lv_pmos L=0.13u W=1.12u AS=0.3864p
+ AD=0.431025p PS=2.93u PD=2.145u rfmode=0
M$5172 VDD CLK \$1793 VDD sg13_lv_pmos L=0.13u W=1.12u AS=0.431025p AD=0.3808p
+ PS=2.145u PD=2.92u rfmode=0
M$5173 VDD \$1853 \$1854 VDD sg13_lv_pmos L=0.13u W=2.24u AS=0.5964p AD=0.5964p
+ PS=4.425u PD=4.425u rfmode=0
M$5175 \$1506 \$202 \$1724 VDD sg13_lv_pmos L=0.13u W=0.84u AS=0.2856p
+ AD=0.1596p PS=2.36u PD=1.22u rfmode=0
M$5176 VDD \$326 \$1724 VDD sg13_lv_pmos L=0.13u W=0.84u AS=0.2226p AD=0.1596p
+ PS=1.535u PD=1.22u rfmode=0
M$5177 VDD \$1506 \$1507 VDD sg13_lv_pmos L=0.13u W=2.24u AS=0.4746p AD=0.6776p
+ PS=3.105u PD=4.57u rfmode=0
M$5179 VDD \$1795 \$1857 VDD sg13_lv_pmos L=0.13u W=2.24u AS=0.616p AD=0.4312p
+ PS=4.46u PD=3.01u rfmode=0
M$5181 VDD \$326 \$1857 VDD sg13_lv_pmos L=0.13u W=2.24u AS=0.4312p AD=0.6048p
+ PS=3.01u PD=4.44u rfmode=0
M$5183 \$1656 VDD VDD VDD sg13_lv_pmos L=0.13u W=0.42u AS=0.147p AD=0.1563p
+ PS=1.54u PD=1.22u rfmode=0
M$5184 VDD \$1508 \$1712 VDD sg13_lv_pmos L=0.13u W=0.42u AS=0.1563p AD=0.0546p
+ PS=1.22u PD=0.68u rfmode=0
M$5185 \$1712 \$1509 \$1656 VDD sg13_lv_pmos L=0.13u W=0.42u AS=0.0546p
+ AD=0.0798p PS=0.68u PD=0.8u rfmode=0
M$5186 \$1656 \$1672 \$1570 VDD sg13_lv_pmos L=0.13u W=0.42u AS=0.0798p
+ AD=0.1428p PS=0.8u PD=1.52u rfmode=0
M$5187 \$1960 \$1797 VDD VDD sg13_lv_pmos L=0.13u W=1.12u AS=0.3864p
+ AD=0.431025p PS=2.93u PD=2.145u rfmode=0
M$5188 VDD CLK \$1797 VDD sg13_lv_pmos L=0.13u W=1.12u AS=0.431025p AD=0.3808p
+ PS=2.145u PD=2.92u rfmode=0
M$5189 VDD \$1863 \$1864 VDD sg13_lv_pmos L=0.13u W=2.24u AS=0.5964p AD=0.5964p
+ PS=4.425u PD=4.425u rfmode=0
M$5191 \$1510 \$205 \$1725 VDD sg13_lv_pmos L=0.13u W=0.84u AS=0.2856p
+ AD=0.1596p PS=2.36u PD=1.22u rfmode=0
M$5192 VDD \$326 \$1725 VDD sg13_lv_pmos L=0.13u W=0.84u AS=0.2226p AD=0.1596p
+ PS=1.535u PD=1.22u rfmode=0
M$5193 VDD \$1510 \$1511 VDD sg13_lv_pmos L=0.13u W=2.24u AS=0.4746p AD=0.6776p
+ PS=3.105u PD=4.57u rfmode=0
M$5195 VDD \$1799 \$1867 VDD sg13_lv_pmos L=0.13u W=2.24u AS=0.616p AD=0.4312p
+ PS=4.46u PD=3.01u rfmode=0
M$5197 VDD \$326 \$1867 VDD sg13_lv_pmos L=0.13u W=2.24u AS=0.4312p AD=0.6048p
+ PS=3.01u PD=4.44u rfmode=0
M$5199 \$1658 VDD VDD VDD sg13_lv_pmos L=0.13u W=0.42u AS=0.147p AD=0.1563p
+ PS=1.54u PD=1.22u rfmode=0
M$5200 VDD \$1512 \$1699 VDD sg13_lv_pmos L=0.13u W=0.42u AS=0.1563p AD=0.0546p
+ PS=1.22u PD=0.68u rfmode=0
M$5201 \$1699 \$1513 \$1658 VDD sg13_lv_pmos L=0.13u W=0.42u AS=0.0546p
+ AD=0.0798p PS=0.68u PD=0.8u rfmode=0
M$5202 \$1658 \$1674 \$1580 VDD sg13_lv_pmos L=0.13u W=0.42u AS=0.0798p
+ AD=0.1428p PS=0.8u PD=1.52u rfmode=0
M$5203 \$1962 \$1801 VDD VDD sg13_lv_pmos L=0.13u W=1.12u AS=0.3864p
+ AD=0.431025p PS=2.93u PD=2.145u rfmode=0
M$5204 VDD CLK \$1801 VDD sg13_lv_pmos L=0.13u W=1.12u AS=0.431025p AD=0.3808p
+ PS=2.145u PD=2.92u rfmode=0
M$5205 VDD \$1873 \$1874 VDD sg13_lv_pmos L=0.13u W=2.24u AS=0.5964p AD=0.5964p
+ PS=4.425u PD=4.425u rfmode=0
M$5207 \$1514 VSS \$1722 VDD sg13_lv_pmos L=0.13u W=0.84u AS=0.2856p AD=0.1596p
+ PS=2.36u PD=1.22u rfmode=0
M$5208 VDD \$326 \$1722 VDD sg13_lv_pmos L=0.13u W=0.84u AS=0.2226p AD=0.1596p
+ PS=1.535u PD=1.22u rfmode=0
M$5209 VDD \$1514 \$1515 VDD sg13_lv_pmos L=0.13u W=2.24u AS=0.4746p AD=0.6776p
+ PS=3.105u PD=4.57u rfmode=0
M$5211 VDD \$1803 \$1877 VDD sg13_lv_pmos L=0.13u W=2.24u AS=0.616p AD=0.4312p
+ PS=4.46u PD=3.01u rfmode=0
M$5213 VDD \$326 \$1877 VDD sg13_lv_pmos L=0.13u W=2.24u AS=0.4312p AD=0.6048p
+ PS=3.01u PD=4.44u rfmode=0
M$5215 \$1660 VDD VDD VDD sg13_lv_pmos L=0.13u W=0.42u AS=0.147p AD=0.1563p
+ PS=1.54u PD=1.22u rfmode=0
M$5216 VDD \$1516 \$1687 VDD sg13_lv_pmos L=0.13u W=0.42u AS=0.1563p AD=0.0546p
+ PS=1.22u PD=0.68u rfmode=0
M$5217 \$1687 \$1517 \$1660 VDD sg13_lv_pmos L=0.13u W=0.42u AS=0.0546p
+ AD=0.0798p PS=0.68u PD=0.8u rfmode=0
M$5218 \$1660 \$1676 \$1590 VDD sg13_lv_pmos L=0.13u W=0.42u AS=0.0798p
+ AD=0.1428p PS=0.8u PD=1.52u rfmode=0
M$5219 \$1964 \$1805 VDD VDD sg13_lv_pmos L=0.13u W=1.12u AS=0.3864p
+ AD=0.431025p PS=2.93u PD=2.145u rfmode=0
M$5220 VDD CLK \$1805 VDD sg13_lv_pmos L=0.13u W=1.12u AS=0.431025p AD=0.3808p
+ PS=2.145u PD=2.92u rfmode=0
M$5221 VDD \$1883 \$1884 VDD sg13_lv_pmos L=0.13u W=2.24u AS=0.5964p AD=0.5964p
+ PS=4.425u PD=4.425u rfmode=0
M$5223 \$1774 \$187 \$2006 VDD sg13_lv_pmos L=0.13u W=0.84u AS=0.2856p
+ AD=0.1596p PS=2.36u PD=1.22u rfmode=0
M$5224 VDD \$571 \$2006 VDD sg13_lv_pmos L=0.13u W=0.84u AS=0.2226p AD=0.1596p
+ PS=1.535u PD=1.22u rfmode=0
M$5225 VDD \$1774 \$1775 VDD sg13_lv_pmos L=0.13u W=2.24u AS=0.4746p AD=0.6776p
+ PS=3.105u PD=4.57u rfmode=0
M$5227 VDD \$1807 \$1808 VDD sg13_lv_pmos L=0.13u W=0.42u AS=0.1428p AD=0.0798p
+ PS=1.52u PD=0.8u rfmode=0
M$5228 VDD VDD \$1808 VDD sg13_lv_pmos L=0.13u W=0.42u AS=0.3623875p AD=0.0798p
+ PS=2.605u PD=0.8u rfmode=0
M$5229 VDD \$1934 \$1776 VDD sg13_lv_pmos L=0.13u W=1u AS=0.3623875p AD=0.34p
+ PS=2.605u PD=2.68u rfmode=0
M$5230 \$1811 \$1950 \$1970 VDD sg13_lv_pmos L=0.13u W=0.42u AS=0.19115p
+ AD=0.0525p PS=1.565u PD=0.67u rfmode=0
M$5231 \$1970 \$1935 VDD VDD sg13_lv_pmos L=0.13u W=0.42u AS=0.0525p
+ AD=0.25605p PS=0.67u PD=1.935u rfmode=0
M$5232 VDD VDD \$1935 VDD sg13_lv_pmos L=0.13u W=0.42u AS=0.25605p AD=0.0798p
+ PS=1.935u PD=0.8u rfmode=0
M$5233 VDD \$1811 \$1935 VDD sg13_lv_pmos L=0.13u W=0.42u AS=0.2014p AD=0.0798p
+ PS=1.53u PD=0.8u rfmode=0
M$5234 VDD \$1811 \$1813 VDD sg13_lv_pmos L=0.13u W=1u AS=0.2083p AD=0.34p
+ PS=1.5u PD=2.68u rfmode=0
M$5235 VDD \$1811 \$1812 VDD sg13_lv_pmos L=0.13u W=2.24u AS=0.4142p AD=0.4211p
+ PS=3.03u PD=3u rfmode=0
M$5237 \$1776 \$1777 \$1811 VDD sg13_lv_pmos L=0.13u W=1u AS=0.34p AD=0.19115p
+ PS=2.68u PD=1.565u rfmode=0
M$5238 \$1778 \$190 \$2007 VDD sg13_lv_pmos L=0.13u W=0.84u AS=0.2856p
+ AD=0.1596p PS=2.36u PD=1.22u rfmode=0
M$5239 VDD \$571 \$2007 VDD sg13_lv_pmos L=0.13u W=0.84u AS=0.2226p AD=0.1596p
+ PS=1.535u PD=1.22u rfmode=0
M$5240 VDD \$1778 \$1779 VDD sg13_lv_pmos L=0.13u W=2.24u AS=0.4746p AD=0.6776p
+ PS=3.105u PD=4.57u rfmode=0
M$5242 VDD \$1817 \$1818 VDD sg13_lv_pmos L=0.13u W=0.42u AS=0.1428p AD=0.0798p
+ PS=1.52u PD=0.8u rfmode=0
M$5243 VDD VDD \$1818 VDD sg13_lv_pmos L=0.13u W=0.42u AS=0.3623875p AD=0.0798p
+ PS=2.605u PD=0.8u rfmode=0
M$5244 VDD \$1936 \$1780 VDD sg13_lv_pmos L=0.13u W=1u AS=0.3623875p AD=0.34p
+ PS=2.605u PD=2.68u rfmode=0
M$5245 \$1821 \$1952 \$1978 VDD sg13_lv_pmos L=0.13u W=0.42u AS=0.19115p
+ AD=0.0525p PS=1.565u PD=0.67u rfmode=0
M$5246 \$1978 \$1937 VDD VDD sg13_lv_pmos L=0.13u W=0.42u AS=0.0525p
+ AD=0.25605p PS=0.67u PD=1.935u rfmode=0
M$5247 VDD VDD \$1937 VDD sg13_lv_pmos L=0.13u W=0.42u AS=0.25605p AD=0.0798p
+ PS=1.935u PD=0.8u rfmode=0
M$5248 VDD \$1821 \$1937 VDD sg13_lv_pmos L=0.13u W=0.42u AS=0.2014p AD=0.0798p
+ PS=1.53u PD=0.8u rfmode=0
M$5249 VDD \$1821 \$1823 VDD sg13_lv_pmos L=0.13u W=1u AS=0.2083p AD=0.34p
+ PS=1.5u PD=2.68u rfmode=0
M$5250 VDD \$1821 \$1822 VDD sg13_lv_pmos L=0.13u W=2.24u AS=0.4142p AD=0.4211p
+ PS=3.03u PD=3u rfmode=0
M$5252 \$1780 \$1781 \$1821 VDD sg13_lv_pmos L=0.13u W=1u AS=0.34p AD=0.19115p
+ PS=2.68u PD=1.565u rfmode=0
M$5253 \$1782 \$193 \$2008 VDD sg13_lv_pmos L=0.13u W=0.84u AS=0.2856p
+ AD=0.1596p PS=2.36u PD=1.22u rfmode=0
M$5254 VDD \$571 \$2008 VDD sg13_lv_pmos L=0.13u W=0.84u AS=0.2226p AD=0.1596p
+ PS=1.535u PD=1.22u rfmode=0
M$5255 VDD \$1782 \$1783 VDD sg13_lv_pmos L=0.13u W=2.24u AS=0.4746p AD=0.6776p
+ PS=3.105u PD=4.57u rfmode=0
M$5257 VDD \$1827 \$1828 VDD sg13_lv_pmos L=0.13u W=0.42u AS=0.1428p AD=0.0798p
+ PS=1.52u PD=0.8u rfmode=0
M$5258 VDD VDD \$1828 VDD sg13_lv_pmos L=0.13u W=0.42u AS=0.3623875p AD=0.0798p
+ PS=2.605u PD=0.8u rfmode=0
M$5259 VDD \$1938 \$1784 VDD sg13_lv_pmos L=0.13u W=1u AS=0.3623875p AD=0.34p
+ PS=2.605u PD=2.68u rfmode=0
M$5260 \$1831 \$1954 \$1987 VDD sg13_lv_pmos L=0.13u W=0.42u AS=0.19115p
+ AD=0.0525p PS=1.565u PD=0.67u rfmode=0
M$5261 \$1987 \$1939 VDD VDD sg13_lv_pmos L=0.13u W=0.42u AS=0.0525p
+ AD=0.25605p PS=0.67u PD=1.935u rfmode=0
M$5262 VDD VDD \$1939 VDD sg13_lv_pmos L=0.13u W=0.42u AS=0.25605p AD=0.0798p
+ PS=1.935u PD=0.8u rfmode=0
M$5263 VDD \$1831 \$1939 VDD sg13_lv_pmos L=0.13u W=0.42u AS=0.2014p AD=0.0798p
+ PS=1.53u PD=0.8u rfmode=0
M$5264 VDD \$1831 \$1833 VDD sg13_lv_pmos L=0.13u W=1u AS=0.2083p AD=0.34p
+ PS=1.5u PD=2.68u rfmode=0
M$5265 VDD \$1831 \$1832 VDD sg13_lv_pmos L=0.13u W=2.24u AS=0.4142p AD=0.4211p
+ PS=3.03u PD=3u rfmode=0
M$5267 \$1784 \$1785 \$1831 VDD sg13_lv_pmos L=0.13u W=1u AS=0.34p AD=0.19115p
+ PS=2.68u PD=1.565u rfmode=0
M$5268 \$1786 \$196 \$2009 VDD sg13_lv_pmos L=0.13u W=0.84u AS=0.2856p
+ AD=0.1596p PS=2.36u PD=1.22u rfmode=0
M$5269 VDD \$571 \$2009 VDD sg13_lv_pmos L=0.13u W=0.84u AS=0.2226p AD=0.1596p
+ PS=1.535u PD=1.22u rfmode=0
M$5270 VDD \$1786 \$1787 VDD sg13_lv_pmos L=0.13u W=2.24u AS=0.4746p AD=0.6776p
+ PS=3.105u PD=4.57u rfmode=0
M$5272 VDD \$1837 \$1838 VDD sg13_lv_pmos L=0.13u W=0.42u AS=0.1428p AD=0.0798p
+ PS=1.52u PD=0.8u rfmode=0
M$5273 VDD VDD \$1838 VDD sg13_lv_pmos L=0.13u W=0.42u AS=0.3623875p AD=0.0798p
+ PS=2.605u PD=0.8u rfmode=0
M$5274 VDD \$1940 \$1788 VDD sg13_lv_pmos L=0.13u W=1u AS=0.3623875p AD=0.34p
+ PS=2.605u PD=2.68u rfmode=0
M$5275 \$1841 \$1956 \$1996 VDD sg13_lv_pmos L=0.13u W=0.42u AS=0.19115p
+ AD=0.0525p PS=1.565u PD=0.67u rfmode=0
M$5276 \$1996 \$1941 VDD VDD sg13_lv_pmos L=0.13u W=0.42u AS=0.0525p
+ AD=0.25605p PS=0.67u PD=1.935u rfmode=0
M$5277 VDD VDD \$1941 VDD sg13_lv_pmos L=0.13u W=0.42u AS=0.25605p AD=0.0798p
+ PS=1.935u PD=0.8u rfmode=0
M$5278 VDD \$1841 \$1941 VDD sg13_lv_pmos L=0.13u W=0.42u AS=0.2014p AD=0.0798p
+ PS=1.53u PD=0.8u rfmode=0
M$5279 VDD \$1841 \$1843 VDD sg13_lv_pmos L=0.13u W=1u AS=0.2083p AD=0.34p
+ PS=1.5u PD=2.68u rfmode=0
M$5280 VDD \$1841 \$1842 VDD sg13_lv_pmos L=0.13u W=2.24u AS=0.4142p AD=0.4211p
+ PS=3.03u PD=3u rfmode=0
M$5282 \$1788 \$1789 \$1841 VDD sg13_lv_pmos L=0.13u W=1u AS=0.34p AD=0.19115p
+ PS=2.68u PD=1.565u rfmode=0
M$5283 \$1790 \$199 \$2011 VDD sg13_lv_pmos L=0.13u W=0.84u AS=0.2856p
+ AD=0.1596p PS=2.36u PD=1.22u rfmode=0
M$5284 VDD \$571 \$2011 VDD sg13_lv_pmos L=0.13u W=0.84u AS=0.2226p AD=0.1596p
+ PS=1.535u PD=1.22u rfmode=0
M$5285 VDD \$1790 \$1791 VDD sg13_lv_pmos L=0.13u W=2.24u AS=0.4746p AD=0.6776p
+ PS=3.105u PD=4.57u rfmode=0
M$5287 VDD \$1847 \$1848 VDD sg13_lv_pmos L=0.13u W=0.42u AS=0.1428p AD=0.0798p
+ PS=1.52u PD=0.8u rfmode=0
M$5288 VDD VDD \$1848 VDD sg13_lv_pmos L=0.13u W=0.42u AS=0.3623875p AD=0.0798p
+ PS=2.605u PD=0.8u rfmode=0
M$5289 VDD \$1942 \$1792 VDD sg13_lv_pmos L=0.13u W=1u AS=0.3623875p AD=0.34p
+ PS=2.605u PD=2.68u rfmode=0
M$5290 \$1851 \$1958 \$2005 VDD sg13_lv_pmos L=0.13u W=0.42u AS=0.19115p
+ AD=0.0525p PS=1.565u PD=0.67u rfmode=0
M$5291 \$2005 \$1943 VDD VDD sg13_lv_pmos L=0.13u W=0.42u AS=0.0525p
+ AD=0.25605p PS=0.67u PD=1.935u rfmode=0
M$5292 VDD VDD \$1943 VDD sg13_lv_pmos L=0.13u W=0.42u AS=0.25605p AD=0.0798p
+ PS=1.935u PD=0.8u rfmode=0
M$5293 VDD \$1851 \$1943 VDD sg13_lv_pmos L=0.13u W=0.42u AS=0.2014p AD=0.0798p
+ PS=1.53u PD=0.8u rfmode=0
M$5294 VDD \$1851 \$1853 VDD sg13_lv_pmos L=0.13u W=1u AS=0.2083p AD=0.34p
+ PS=1.5u PD=2.68u rfmode=0
M$5295 VDD \$1851 \$1852 VDD sg13_lv_pmos L=0.13u W=2.24u AS=0.4142p AD=0.4211p
+ PS=3.03u PD=3u rfmode=0
M$5297 \$1792 \$1793 \$1851 VDD sg13_lv_pmos L=0.13u W=1u AS=0.34p AD=0.19115p
+ PS=2.68u PD=1.565u rfmode=0
M$5298 \$1794 \$202 \$2012 VDD sg13_lv_pmos L=0.13u W=0.84u AS=0.2856p
+ AD=0.1596p PS=2.36u PD=1.22u rfmode=0
M$5299 VDD \$571 \$2012 VDD sg13_lv_pmos L=0.13u W=0.84u AS=0.2226p AD=0.1596p
+ PS=1.535u PD=1.22u rfmode=0
M$5300 VDD \$1794 \$1795 VDD sg13_lv_pmos L=0.13u W=2.24u AS=0.4746p AD=0.6776p
+ PS=3.105u PD=4.57u rfmode=0
M$5302 VDD \$1857 \$1858 VDD sg13_lv_pmos L=0.13u W=0.42u AS=0.1428p AD=0.0798p
+ PS=1.52u PD=0.8u rfmode=0
M$5303 VDD VDD \$1858 VDD sg13_lv_pmos L=0.13u W=0.42u AS=0.3623875p AD=0.0798p
+ PS=2.605u PD=0.8u rfmode=0
M$5304 VDD \$1944 \$1796 VDD sg13_lv_pmos L=0.13u W=1u AS=0.3623875p AD=0.34p
+ PS=2.605u PD=2.68u rfmode=0
M$5305 \$1861 \$1960 \$1995 VDD sg13_lv_pmos L=0.13u W=0.42u AS=0.19115p
+ AD=0.0525p PS=1.565u PD=0.67u rfmode=0
M$5306 \$1995 \$1945 VDD VDD sg13_lv_pmos L=0.13u W=0.42u AS=0.0525p
+ AD=0.25605p PS=0.67u PD=1.935u rfmode=0
M$5307 VDD VDD \$1945 VDD sg13_lv_pmos L=0.13u W=0.42u AS=0.25605p AD=0.0798p
+ PS=1.935u PD=0.8u rfmode=0
M$5308 VDD \$1861 \$1945 VDD sg13_lv_pmos L=0.13u W=0.42u AS=0.2014p AD=0.0798p
+ PS=1.53u PD=0.8u rfmode=0
M$5309 VDD \$1861 \$1863 VDD sg13_lv_pmos L=0.13u W=1u AS=0.2083p AD=0.34p
+ PS=1.5u PD=2.68u rfmode=0
M$5310 VDD \$1861 \$1862 VDD sg13_lv_pmos L=0.13u W=2.24u AS=0.4142p AD=0.4211p
+ PS=3.03u PD=3u rfmode=0
M$5312 \$1796 \$1797 \$1861 VDD sg13_lv_pmos L=0.13u W=1u AS=0.34p AD=0.19115p
+ PS=2.68u PD=1.565u rfmode=0
M$5313 \$1798 \$205 \$2013 VDD sg13_lv_pmos L=0.13u W=0.84u AS=0.2856p
+ AD=0.1596p PS=2.36u PD=1.22u rfmode=0
M$5314 VDD \$571 \$2013 VDD sg13_lv_pmos L=0.13u W=0.84u AS=0.2226p AD=0.1596p
+ PS=1.535u PD=1.22u rfmode=0
M$5315 VDD \$1798 \$1799 VDD sg13_lv_pmos L=0.13u W=2.24u AS=0.4746p AD=0.6776p
+ PS=3.105u PD=4.57u rfmode=0
M$5317 VDD \$1867 \$1868 VDD sg13_lv_pmos L=0.13u W=0.42u AS=0.1428p AD=0.0798p
+ PS=1.52u PD=0.8u rfmode=0
M$5318 VDD VDD \$1868 VDD sg13_lv_pmos L=0.13u W=0.42u AS=0.3623875p AD=0.0798p
+ PS=2.605u PD=0.8u rfmode=0
M$5319 VDD \$1946 \$1800 VDD sg13_lv_pmos L=0.13u W=1u AS=0.3623875p AD=0.34p
+ PS=2.605u PD=2.68u rfmode=0
M$5320 \$1871 \$1962 \$1984 VDD sg13_lv_pmos L=0.13u W=0.42u AS=0.19115p
+ AD=0.0525p PS=1.565u PD=0.67u rfmode=0
M$5321 \$1984 \$1947 VDD VDD sg13_lv_pmos L=0.13u W=0.42u AS=0.0525p
+ AD=0.25605p PS=0.67u PD=1.935u rfmode=0
M$5322 VDD VDD \$1947 VDD sg13_lv_pmos L=0.13u W=0.42u AS=0.25605p AD=0.0798p
+ PS=1.935u PD=0.8u rfmode=0
M$5323 VDD \$1871 \$1947 VDD sg13_lv_pmos L=0.13u W=0.42u AS=0.2014p AD=0.0798p
+ PS=1.53u PD=0.8u rfmode=0
M$5324 VDD \$1871 \$1873 VDD sg13_lv_pmos L=0.13u W=1u AS=0.2083p AD=0.34p
+ PS=1.5u PD=2.68u rfmode=0
M$5325 VDD \$1871 \$1872 VDD sg13_lv_pmos L=0.13u W=2.24u AS=0.4142p AD=0.4211p
+ PS=3.03u PD=3u rfmode=0
M$5327 \$1800 \$1801 \$1871 VDD sg13_lv_pmos L=0.13u W=1u AS=0.34p AD=0.19115p
+ PS=2.68u PD=1.565u rfmode=0
M$5328 \$1802 VSS \$2010 VDD sg13_lv_pmos L=0.13u W=0.84u AS=0.2856p AD=0.1596p
+ PS=2.36u PD=1.22u rfmode=0
M$5329 VDD \$571 \$2010 VDD sg13_lv_pmos L=0.13u W=0.84u AS=0.2226p AD=0.1596p
+ PS=1.535u PD=1.22u rfmode=0
M$5330 VDD \$1802 \$1803 VDD sg13_lv_pmos L=0.13u W=2.24u AS=0.4746p AD=0.6776p
+ PS=3.105u PD=4.57u rfmode=0
M$5332 VDD \$1877 \$1878 VDD sg13_lv_pmos L=0.13u W=0.42u AS=0.1428p AD=0.0798p
+ PS=1.52u PD=0.8u rfmode=0
M$5333 VDD VDD \$1878 VDD sg13_lv_pmos L=0.13u W=0.42u AS=0.3623875p AD=0.0798p
+ PS=2.605u PD=0.8u rfmode=0
M$5334 VDD \$1948 \$1804 VDD sg13_lv_pmos L=0.13u W=1u AS=0.3623875p AD=0.34p
+ PS=2.605u PD=2.68u rfmode=0
M$5335 \$1881 \$1964 \$1971 VDD sg13_lv_pmos L=0.13u W=0.42u AS=0.19115p
+ AD=0.0525p PS=1.565u PD=0.67u rfmode=0
M$5336 \$1971 \$1949 VDD VDD sg13_lv_pmos L=0.13u W=0.42u AS=0.0525p
+ AD=0.25605p PS=0.67u PD=1.935u rfmode=0
M$5337 VDD VDD \$1949 VDD sg13_lv_pmos L=0.13u W=0.42u AS=0.25605p AD=0.0798p
+ PS=1.935u PD=0.8u rfmode=0
M$5338 VDD \$1881 \$1949 VDD sg13_lv_pmos L=0.13u W=0.42u AS=0.2014p AD=0.0798p
+ PS=1.53u PD=0.8u rfmode=0
M$5339 VDD \$1881 \$1883 VDD sg13_lv_pmos L=0.13u W=1u AS=0.2083p AD=0.34p
+ PS=1.5u PD=2.68u rfmode=0
M$5340 VDD \$1881 \$1882 VDD sg13_lv_pmos L=0.13u W=2.24u AS=0.4142p AD=0.4211p
+ PS=3.03u PD=3u rfmode=0
M$5342 \$1804 \$1805 \$1881 VDD sg13_lv_pmos L=0.13u W=1u AS=0.34p AD=0.19115p
+ PS=2.68u PD=1.565u rfmode=0
M$5343 \$2062 \$187 \$2265 VDD sg13_lv_pmos L=0.13u W=0.84u AS=0.2856p
+ AD=0.1596p PS=2.36u PD=1.22u rfmode=0
M$5344 VDD VSS \$2265 VDD sg13_lv_pmos L=0.13u W=0.84u AS=0.2226p AD=0.1596p
+ PS=1.535u PD=1.22u rfmode=0
M$5345 VDD \$2062 \$2063 VDD sg13_lv_pmos L=0.13u W=2.24u AS=0.4746p AD=0.6776p
+ PS=3.105u PD=4.57u rfmode=0
M$5347 VDD \$2063 \$2091 VDD sg13_lv_pmos L=0.13u W=2.24u AS=0.616p AD=0.4312p
+ PS=4.46u PD=3.01u rfmode=0
M$5349 VDD \$571 \$2091 VDD sg13_lv_pmos L=0.13u W=2.24u AS=0.4312p AD=0.6048p
+ PS=3.01u PD=4.44u rfmode=0
M$5351 VDD \$2091 \$2092 VDD sg13_lv_pmos L=0.13u W=0.42u AS=0.1428p AD=0.0798p
+ PS=1.52u PD=0.8u rfmode=0
M$5352 VDD VDD \$2092 VDD sg13_lv_pmos L=0.13u W=0.42u AS=0.3623875p AD=0.0798p
+ PS=2.605u PD=0.8u rfmode=0
M$5353 VDD \$2202 \$2064 VDD sg13_lv_pmos L=0.13u W=1u AS=0.3623875p AD=0.34p
+ PS=2.605u PD=2.68u rfmode=0
M$5354 \$1934 VDD VDD VDD sg13_lv_pmos L=0.13u W=0.42u AS=0.147p AD=0.1563p
+ PS=1.54u PD=1.22u rfmode=0
M$5355 VDD \$1776 \$1969 VDD sg13_lv_pmos L=0.13u W=0.42u AS=0.1563p AD=0.0546p
+ PS=1.22u PD=0.68u rfmode=0
M$5356 \$1969 \$1777 \$1934 VDD sg13_lv_pmos L=0.13u W=0.42u AS=0.0546p
+ AD=0.0798p PS=0.68u PD=0.8u rfmode=0
M$5357 \$1934 \$1950 \$1808 VDD sg13_lv_pmos L=0.13u W=0.42u AS=0.0798p
+ AD=0.1428p PS=0.8u PD=1.52u rfmode=0
M$5358 \$2216 \$2065 VDD VDD sg13_lv_pmos L=0.13u W=1.12u AS=0.3864p
+ AD=0.431025p PS=2.93u PD=2.145u rfmode=0
M$5359 VDD CLK \$2065 VDD sg13_lv_pmos L=0.13u W=1.12u AS=0.431025p AD=0.3808p
+ PS=2.145u PD=2.92u rfmode=0
M$5360 \$2095 \$2216 \$2234 VDD sg13_lv_pmos L=0.13u W=0.42u AS=0.19115p
+ AD=0.0525p PS=1.565u PD=0.67u rfmode=0
M$5361 \$2234 \$2203 VDD VDD sg13_lv_pmos L=0.13u W=0.42u AS=0.0525p
+ AD=0.25605p PS=0.67u PD=1.935u rfmode=0
M$5362 VDD VDD \$2203 VDD sg13_lv_pmos L=0.13u W=0.42u AS=0.25605p AD=0.0798p
+ PS=1.935u PD=0.8u rfmode=0
M$5363 VDD \$2095 \$2203 VDD sg13_lv_pmos L=0.13u W=0.42u AS=0.2014p AD=0.0798p
+ PS=1.53u PD=0.8u rfmode=0
M$5364 VDD \$2095 \$2097 VDD sg13_lv_pmos L=0.13u W=1u AS=0.2083p AD=0.34p
+ PS=1.5u PD=2.68u rfmode=0
M$5365 VDD \$2095 \$2096 VDD sg13_lv_pmos L=0.13u W=2.24u AS=0.4142p AD=0.4211p
+ PS=3.03u PD=3u rfmode=0
M$5367 \$2064 \$2065 \$2095 VDD sg13_lv_pmos L=0.13u W=1u AS=0.34p AD=0.19115p
+ PS=2.68u PD=1.565u rfmode=0
M$5368 VDD \$2097 \$2098 VDD sg13_lv_pmos L=0.13u W=2.24u AS=0.5964p AD=0.5964p
+ PS=4.425u PD=4.425u rfmode=0
M$5370 \$2066 \$190 \$2266 VDD sg13_lv_pmos L=0.13u W=0.84u AS=0.2856p
+ AD=0.1596p PS=2.36u PD=1.22u rfmode=0
M$5371 VDD VSS \$2266 VDD sg13_lv_pmos L=0.13u W=0.84u AS=0.2226p AD=0.1596p
+ PS=1.535u PD=1.22u rfmode=0
M$5372 VDD \$2066 \$2067 VDD sg13_lv_pmos L=0.13u W=2.24u AS=0.4746p AD=0.6776p
+ PS=3.105u PD=4.57u rfmode=0
M$5374 VDD \$2067 \$2101 VDD sg13_lv_pmos L=0.13u W=2.24u AS=0.616p AD=0.4312p
+ PS=4.46u PD=3.01u rfmode=0
M$5376 VDD \$571 \$2101 VDD sg13_lv_pmos L=0.13u W=2.24u AS=0.4312p AD=0.6048p
+ PS=3.01u PD=4.44u rfmode=0
M$5378 VDD \$2101 \$2102 VDD sg13_lv_pmos L=0.13u W=0.42u AS=0.1428p AD=0.0798p
+ PS=1.52u PD=0.8u rfmode=0
M$5379 VDD VDD \$2102 VDD sg13_lv_pmos L=0.13u W=0.42u AS=0.3623875p AD=0.0798p
+ PS=2.605u PD=0.8u rfmode=0
M$5380 VDD \$2204 \$2068 VDD sg13_lv_pmos L=0.13u W=1u AS=0.3623875p AD=0.34p
+ PS=2.605u PD=2.68u rfmode=0
M$5381 \$1936 VDD VDD VDD sg13_lv_pmos L=0.13u W=0.42u AS=0.147p AD=0.1563p
+ PS=1.54u PD=1.22u rfmode=0
M$5382 VDD \$1780 \$1977 VDD sg13_lv_pmos L=0.13u W=0.42u AS=0.1563p AD=0.0546p
+ PS=1.22u PD=0.68u rfmode=0
M$5383 \$1977 \$1781 \$1936 VDD sg13_lv_pmos L=0.13u W=0.42u AS=0.0546p
+ AD=0.0798p PS=0.68u PD=0.8u rfmode=0
M$5384 \$1936 \$1952 \$1818 VDD sg13_lv_pmos L=0.13u W=0.42u AS=0.0798p
+ AD=0.1428p PS=0.8u PD=1.52u rfmode=0
M$5385 \$2218 \$2069 VDD VDD sg13_lv_pmos L=0.13u W=1.12u AS=0.3864p
+ AD=0.431025p PS=2.93u PD=2.145u rfmode=0
M$5386 VDD CLK \$2069 VDD sg13_lv_pmos L=0.13u W=1.12u AS=0.431025p AD=0.3808p
+ PS=2.145u PD=2.92u rfmode=0
M$5387 \$2105 \$2218 \$2242 VDD sg13_lv_pmos L=0.13u W=0.42u AS=0.19115p
+ AD=0.0525p PS=1.565u PD=0.67u rfmode=0
M$5388 \$2242 \$2205 VDD VDD sg13_lv_pmos L=0.13u W=0.42u AS=0.0525p
+ AD=0.25605p PS=0.67u PD=1.935u rfmode=0
M$5389 VDD VDD \$2205 VDD sg13_lv_pmos L=0.13u W=0.42u AS=0.25605p AD=0.0798p
+ PS=1.935u PD=0.8u rfmode=0
M$5390 VDD \$2105 \$2205 VDD sg13_lv_pmos L=0.13u W=0.42u AS=0.2014p AD=0.0798p
+ PS=1.53u PD=0.8u rfmode=0
M$5391 VDD \$2105 \$2107 VDD sg13_lv_pmos L=0.13u W=1u AS=0.2083p AD=0.34p
+ PS=1.5u PD=2.68u rfmode=0
M$5392 VDD \$2105 \$2106 VDD sg13_lv_pmos L=0.13u W=2.24u AS=0.4142p AD=0.4211p
+ PS=3.03u PD=3u rfmode=0
M$5394 \$2068 \$2069 \$2105 VDD sg13_lv_pmos L=0.13u W=1u AS=0.34p AD=0.19115p
+ PS=2.68u PD=1.565u rfmode=0
M$5395 VDD \$2107 \$2108 VDD sg13_lv_pmos L=0.13u W=2.24u AS=0.5964p AD=0.5964p
+ PS=4.425u PD=4.425u rfmode=0
M$5397 \$2070 \$193 \$2267 VDD sg13_lv_pmos L=0.13u W=0.84u AS=0.2856p
+ AD=0.1596p PS=2.36u PD=1.22u rfmode=0
M$5398 VDD VSS \$2267 VDD sg13_lv_pmos L=0.13u W=0.84u AS=0.2226p AD=0.1596p
+ PS=1.535u PD=1.22u rfmode=0
M$5399 VDD \$2070 \$2071 VDD sg13_lv_pmos L=0.13u W=2.24u AS=0.4746p AD=0.6776p
+ PS=3.105u PD=4.57u rfmode=0
M$5401 VDD \$2071 \$2111 VDD sg13_lv_pmos L=0.13u W=2.24u AS=0.616p AD=0.4312p
+ PS=4.46u PD=3.01u rfmode=0
M$5403 VDD \$571 \$2111 VDD sg13_lv_pmos L=0.13u W=2.24u AS=0.4312p AD=0.6048p
+ PS=3.01u PD=4.44u rfmode=0
M$5405 VDD \$2111 \$2112 VDD sg13_lv_pmos L=0.13u W=0.42u AS=0.1428p AD=0.0798p
+ PS=1.52u PD=0.8u rfmode=0
M$5406 VDD VDD \$2112 VDD sg13_lv_pmos L=0.13u W=0.42u AS=0.3623875p AD=0.0798p
+ PS=2.605u PD=0.8u rfmode=0
M$5407 VDD \$2206 \$2072 VDD sg13_lv_pmos L=0.13u W=1u AS=0.3623875p AD=0.34p
+ PS=2.605u PD=2.68u rfmode=0
M$5408 \$1938 VDD VDD VDD sg13_lv_pmos L=0.13u W=0.42u AS=0.147p AD=0.1563p
+ PS=1.54u PD=1.22u rfmode=0
M$5409 VDD \$1784 \$1986 VDD sg13_lv_pmos L=0.13u W=0.42u AS=0.1563p AD=0.0546p
+ PS=1.22u PD=0.68u rfmode=0
M$5410 \$1986 \$1785 \$1938 VDD sg13_lv_pmos L=0.13u W=0.42u AS=0.0546p
+ AD=0.0798p PS=0.68u PD=0.8u rfmode=0
M$5411 \$1938 \$1954 \$1828 VDD sg13_lv_pmos L=0.13u W=0.42u AS=0.0798p
+ AD=0.1428p PS=0.8u PD=1.52u rfmode=0
M$5412 \$2220 \$2073 VDD VDD sg13_lv_pmos L=0.13u W=1.12u AS=0.3864p
+ AD=0.431025p PS=2.93u PD=2.145u rfmode=0
M$5413 VDD CLK \$2073 VDD sg13_lv_pmos L=0.13u W=1.12u AS=0.431025p AD=0.3808p
+ PS=2.145u PD=2.92u rfmode=0
M$5414 \$2115 \$2220 \$2250 VDD sg13_lv_pmos L=0.13u W=0.42u AS=0.19115p
+ AD=0.0525p PS=1.565u PD=0.67u rfmode=0
M$5415 \$2250 \$2207 VDD VDD sg13_lv_pmos L=0.13u W=0.42u AS=0.0525p
+ AD=0.25605p PS=0.67u PD=1.935u rfmode=0
M$5416 VDD VDD \$2207 VDD sg13_lv_pmos L=0.13u W=0.42u AS=0.25605p AD=0.0798p
+ PS=1.935u PD=0.8u rfmode=0
M$5417 VDD \$2115 \$2207 VDD sg13_lv_pmos L=0.13u W=0.42u AS=0.2014p AD=0.0798p
+ PS=1.53u PD=0.8u rfmode=0
M$5418 VDD \$2115 \$2117 VDD sg13_lv_pmos L=0.13u W=1u AS=0.2083p AD=0.34p
+ PS=1.5u PD=2.68u rfmode=0
M$5419 VDD \$2115 \$2116 VDD sg13_lv_pmos L=0.13u W=2.24u AS=0.4142p AD=0.4211p
+ PS=3.03u PD=3u rfmode=0
M$5421 \$2072 \$2073 \$2115 VDD sg13_lv_pmos L=0.13u W=1u AS=0.34p AD=0.19115p
+ PS=2.68u PD=1.565u rfmode=0
M$5422 VDD \$2117 \$2118 VDD sg13_lv_pmos L=0.13u W=2.24u AS=0.5964p AD=0.5964p
+ PS=4.425u PD=4.425u rfmode=0
M$5424 \$2074 \$196 \$2268 VDD sg13_lv_pmos L=0.13u W=0.84u AS=0.2856p
+ AD=0.1596p PS=2.36u PD=1.22u rfmode=0
M$5425 VDD VSS \$2268 VDD sg13_lv_pmos L=0.13u W=0.84u AS=0.2226p AD=0.1596p
+ PS=1.535u PD=1.22u rfmode=0
M$5426 VDD \$2074 \$2075 VDD sg13_lv_pmos L=0.13u W=2.24u AS=0.4746p AD=0.6776p
+ PS=3.105u PD=4.57u rfmode=0
M$5428 VDD \$2075 \$2121 VDD sg13_lv_pmos L=0.13u W=2.24u AS=0.616p AD=0.4312p
+ PS=4.46u PD=3.01u rfmode=0
M$5430 VDD \$571 \$2121 VDD sg13_lv_pmos L=0.13u W=2.24u AS=0.4312p AD=0.6048p
+ PS=3.01u PD=4.44u rfmode=0
M$5432 VDD \$2121 \$2122 VDD sg13_lv_pmos L=0.13u W=0.42u AS=0.1428p AD=0.0798p
+ PS=1.52u PD=0.8u rfmode=0
M$5433 VDD VDD \$2122 VDD sg13_lv_pmos L=0.13u W=0.42u AS=0.3623875p AD=0.0798p
+ PS=2.605u PD=0.8u rfmode=0
M$5434 VDD \$2208 \$2076 VDD sg13_lv_pmos L=0.13u W=1u AS=0.3623875p AD=0.34p
+ PS=2.605u PD=2.68u rfmode=0
M$5435 \$1940 VDD VDD VDD sg13_lv_pmos L=0.13u W=0.42u AS=0.147p AD=0.1563p
+ PS=1.54u PD=1.22u rfmode=0
M$5436 VDD \$1788 \$1994 VDD sg13_lv_pmos L=0.13u W=0.42u AS=0.1563p AD=0.0546p
+ PS=1.22u PD=0.68u rfmode=0
M$5437 \$1994 \$1789 \$1940 VDD sg13_lv_pmos L=0.13u W=0.42u AS=0.0546p
+ AD=0.0798p PS=0.68u PD=0.8u rfmode=0
M$5438 \$1940 \$1956 \$1838 VDD sg13_lv_pmos L=0.13u W=0.42u AS=0.0798p
+ AD=0.1428p PS=0.8u PD=1.52u rfmode=0
M$5439 \$2222 \$2077 VDD VDD sg13_lv_pmos L=0.13u W=1.12u AS=0.3864p
+ AD=0.431025p PS=2.93u PD=2.145u rfmode=0
M$5440 VDD CLK \$2077 VDD sg13_lv_pmos L=0.13u W=1.12u AS=0.431025p AD=0.3808p
+ PS=2.145u PD=2.92u rfmode=0
M$5441 \$2125 \$2222 \$2258 VDD sg13_lv_pmos L=0.13u W=0.42u AS=0.19115p
+ AD=0.0525p PS=1.565u PD=0.67u rfmode=0
M$5442 \$2258 \$2209 VDD VDD sg13_lv_pmos L=0.13u W=0.42u AS=0.0525p
+ AD=0.25605p PS=0.67u PD=1.935u rfmode=0
M$5443 VDD VDD \$2209 VDD sg13_lv_pmos L=0.13u W=0.42u AS=0.25605p AD=0.0798p
+ PS=1.935u PD=0.8u rfmode=0
M$5444 VDD \$2125 \$2209 VDD sg13_lv_pmos L=0.13u W=0.42u AS=0.2014p AD=0.0798p
+ PS=1.53u PD=0.8u rfmode=0
M$5445 VDD \$2125 \$2127 VDD sg13_lv_pmos L=0.13u W=1u AS=0.2083p AD=0.34p
+ PS=1.5u PD=2.68u rfmode=0
M$5446 VDD \$2125 \$2126 VDD sg13_lv_pmos L=0.13u W=2.24u AS=0.4142p AD=0.4211p
+ PS=3.03u PD=3u rfmode=0
M$5448 \$2076 \$2077 \$2125 VDD sg13_lv_pmos L=0.13u W=1u AS=0.34p AD=0.19115p
+ PS=2.68u PD=1.565u rfmode=0
M$5449 VDD \$2127 \$2128 VDD sg13_lv_pmos L=0.13u W=2.24u AS=0.5964p AD=0.5964p
+ PS=4.425u PD=4.425u rfmode=0
M$5451 \$2078 \$199 \$2269 VDD sg13_lv_pmos L=0.13u W=0.84u AS=0.2856p
+ AD=0.1596p PS=2.36u PD=1.22u rfmode=0
M$5452 VDD VSS \$2269 VDD sg13_lv_pmos L=0.13u W=0.84u AS=0.2226p AD=0.1596p
+ PS=1.535u PD=1.22u rfmode=0
M$5453 VDD \$2078 \$2079 VDD sg13_lv_pmos L=0.13u W=2.24u AS=0.4746p AD=0.6776p
+ PS=3.105u PD=4.57u rfmode=0
M$5455 VDD \$2079 \$2131 VDD sg13_lv_pmos L=0.13u W=2.24u AS=0.616p AD=0.4312p
+ PS=4.46u PD=3.01u rfmode=0
M$5457 VDD \$571 \$2131 VDD sg13_lv_pmos L=0.13u W=2.24u AS=0.4312p AD=0.6048p
+ PS=3.01u PD=4.44u rfmode=0
M$5459 VDD \$2131 \$2132 VDD sg13_lv_pmos L=0.13u W=0.42u AS=0.1428p AD=0.0798p
+ PS=1.52u PD=0.8u rfmode=0
M$5460 VDD VDD \$2132 VDD sg13_lv_pmos L=0.13u W=0.42u AS=0.3623875p AD=0.0798p
+ PS=2.605u PD=0.8u rfmode=0
M$5461 VDD \$2210 \$2080 VDD sg13_lv_pmos L=0.13u W=1u AS=0.3623875p AD=0.34p
+ PS=2.605u PD=2.68u rfmode=0
M$5462 \$1942 VDD VDD VDD sg13_lv_pmos L=0.13u W=0.42u AS=0.147p AD=0.1563p
+ PS=1.54u PD=1.22u rfmode=0
M$5463 VDD \$1792 \$2002 VDD sg13_lv_pmos L=0.13u W=0.42u AS=0.1563p AD=0.0546p
+ PS=1.22u PD=0.68u rfmode=0
M$5464 \$2002 \$1793 \$1942 VDD sg13_lv_pmos L=0.13u W=0.42u AS=0.0546p
+ AD=0.0798p PS=0.68u PD=0.8u rfmode=0
M$5465 \$1942 \$1958 \$1848 VDD sg13_lv_pmos L=0.13u W=0.42u AS=0.0798p
+ AD=0.1428p PS=0.8u PD=1.52u rfmode=0
M$5466 \$2224 \$2081 VDD VDD sg13_lv_pmos L=0.13u W=1.12u AS=0.3864p
+ AD=0.431025p PS=2.93u PD=2.145u rfmode=0
M$5467 VDD CLK \$2081 VDD sg13_lv_pmos L=0.13u W=1.12u AS=0.431025p AD=0.3808p
+ PS=2.145u PD=2.92u rfmode=0
M$5468 \$2135 \$2224 \$2263 VDD sg13_lv_pmos L=0.13u W=0.42u AS=0.19115p
+ AD=0.0525p PS=1.565u PD=0.67u rfmode=0
M$5469 \$2263 \$2211 VDD VDD sg13_lv_pmos L=0.13u W=0.42u AS=0.0525p
+ AD=0.25605p PS=0.67u PD=1.935u rfmode=0
M$5470 VDD VDD \$2211 VDD sg13_lv_pmos L=0.13u W=0.42u AS=0.25605p AD=0.0798p
+ PS=1.935u PD=0.8u rfmode=0
M$5471 VDD \$2135 \$2211 VDD sg13_lv_pmos L=0.13u W=0.42u AS=0.2014p AD=0.0798p
+ PS=1.53u PD=0.8u rfmode=0
M$5472 VDD \$2135 \$2137 VDD sg13_lv_pmos L=0.13u W=1u AS=0.2083p AD=0.34p
+ PS=1.5u PD=2.68u rfmode=0
M$5473 VDD \$2135 \$2136 VDD sg13_lv_pmos L=0.13u W=2.24u AS=0.4142p AD=0.4211p
+ PS=3.03u PD=3u rfmode=0
M$5475 \$2080 \$2081 \$2135 VDD sg13_lv_pmos L=0.13u W=1u AS=0.34p AD=0.19115p
+ PS=2.68u PD=1.565u rfmode=0
M$5476 VDD \$2137 \$2138 VDD sg13_lv_pmos L=0.13u W=2.24u AS=0.5964p AD=0.5964p
+ PS=4.425u PD=4.425u rfmode=0
M$5478 \$2082 \$202 \$2271 VDD sg13_lv_pmos L=0.13u W=0.84u AS=0.2856p
+ AD=0.1596p PS=2.36u PD=1.22u rfmode=0
M$5479 VDD VSS \$2271 VDD sg13_lv_pmos L=0.13u W=0.84u AS=0.2226p AD=0.1596p
+ PS=1.535u PD=1.22u rfmode=0
M$5480 VDD \$2082 \$2083 VDD sg13_lv_pmos L=0.13u W=2.24u AS=0.4746p AD=0.6776p
+ PS=3.105u PD=4.57u rfmode=0
M$5482 VDD \$2083 \$2141 VDD sg13_lv_pmos L=0.13u W=2.24u AS=0.616p AD=0.4312p
+ PS=4.46u PD=3.01u rfmode=0
M$5484 VDD \$571 \$2141 VDD sg13_lv_pmos L=0.13u W=2.24u AS=0.4312p AD=0.6048p
+ PS=3.01u PD=4.44u rfmode=0
M$5486 VDD \$2141 \$2142 VDD sg13_lv_pmos L=0.13u W=0.42u AS=0.1428p AD=0.0798p
+ PS=1.52u PD=0.8u rfmode=0
M$5487 VDD VDD \$2142 VDD sg13_lv_pmos L=0.13u W=0.42u AS=0.3623875p AD=0.0798p
+ PS=2.605u PD=0.8u rfmode=0
M$5488 VDD \$2212 \$2084 VDD sg13_lv_pmos L=0.13u W=1u AS=0.3623875p AD=0.34p
+ PS=2.605u PD=2.68u rfmode=0
M$5489 \$1944 VDD VDD VDD sg13_lv_pmos L=0.13u W=0.42u AS=0.147p AD=0.1563p
+ PS=1.54u PD=1.22u rfmode=0
M$5490 VDD \$1796 \$1997 VDD sg13_lv_pmos L=0.13u W=0.42u AS=0.1563p AD=0.0546p
+ PS=1.22u PD=0.68u rfmode=0
M$5491 \$1997 \$1797 \$1944 VDD sg13_lv_pmos L=0.13u W=0.42u AS=0.0546p
+ AD=0.0798p PS=0.68u PD=0.8u rfmode=0
M$5492 \$1944 \$1960 \$1858 VDD sg13_lv_pmos L=0.13u W=0.42u AS=0.0798p
+ AD=0.1428p PS=0.8u PD=1.52u rfmode=0
M$5493 \$2226 \$2085 VDD VDD sg13_lv_pmos L=0.13u W=1.12u AS=0.3864p
+ AD=0.431025p PS=2.93u PD=2.145u rfmode=0
M$5494 VDD CLK \$2085 VDD sg13_lv_pmos L=0.13u W=1.12u AS=0.431025p AD=0.3808p
+ PS=2.145u PD=2.92u rfmode=0
M$5495 \$2145 \$2226 \$2249 VDD sg13_lv_pmos L=0.13u W=0.42u AS=0.19115p
+ AD=0.0525p PS=1.565u PD=0.67u rfmode=0
M$5496 \$2249 \$2213 VDD VDD sg13_lv_pmos L=0.13u W=0.42u AS=0.0525p
+ AD=0.25605p PS=0.67u PD=1.935u rfmode=0
M$5497 VDD VDD \$2213 VDD sg13_lv_pmos L=0.13u W=0.42u AS=0.25605p AD=0.0798p
+ PS=1.935u PD=0.8u rfmode=0
M$5498 VDD \$2145 \$2213 VDD sg13_lv_pmos L=0.13u W=0.42u AS=0.2014p AD=0.0798p
+ PS=1.53u PD=0.8u rfmode=0
M$5499 VDD \$2145 \$2147 VDD sg13_lv_pmos L=0.13u W=1u AS=0.2083p AD=0.34p
+ PS=1.5u PD=2.68u rfmode=0
M$5500 VDD \$2145 \$2146 VDD sg13_lv_pmos L=0.13u W=2.24u AS=0.4142p AD=0.4211p
+ PS=3.03u PD=3u rfmode=0
M$5502 \$2084 \$2085 \$2145 VDD sg13_lv_pmos L=0.13u W=1u AS=0.34p AD=0.19115p
+ PS=2.68u PD=1.565u rfmode=0
M$5503 VDD \$2147 \$2148 VDD sg13_lv_pmos L=0.13u W=2.24u AS=0.5964p AD=0.5964p
+ PS=4.425u PD=4.425u rfmode=0
M$5505 \$2086 \$205 \$2270 VDD sg13_lv_pmos L=0.13u W=0.84u AS=0.2856p
+ AD=0.1596p PS=2.36u PD=1.22u rfmode=0
M$5506 VDD VSS \$2270 VDD sg13_lv_pmos L=0.13u W=0.84u AS=0.2226p AD=0.1596p
+ PS=1.535u PD=1.22u rfmode=0
M$5507 VDD \$2086 \$2087 VDD sg13_lv_pmos L=0.13u W=2.24u AS=0.4746p AD=0.6776p
+ PS=3.105u PD=4.57u rfmode=0
M$5509 VDD \$2087 \$2151 VDD sg13_lv_pmos L=0.13u W=2.24u AS=0.616p AD=0.4312p
+ PS=4.46u PD=3.01u rfmode=0
M$5511 VDD \$571 \$2151 VDD sg13_lv_pmos L=0.13u W=2.24u AS=0.4312p AD=0.6048p
+ PS=3.01u PD=4.44u rfmode=0
M$5513 VDD \$2151 \$2152 VDD sg13_lv_pmos L=0.13u W=0.42u AS=0.1428p AD=0.0798p
+ PS=1.52u PD=0.8u rfmode=0
M$5514 VDD VDD \$2152 VDD sg13_lv_pmos L=0.13u W=0.42u AS=0.3623875p AD=0.0798p
+ PS=2.605u PD=0.8u rfmode=0
M$5515 VDD \$2214 \$2088 VDD sg13_lv_pmos L=0.13u W=1u AS=0.3623875p AD=0.34p
+ PS=2.605u PD=2.68u rfmode=0
M$5516 \$1946 VDD VDD VDD sg13_lv_pmos L=0.13u W=0.42u AS=0.147p AD=0.1563p
+ PS=1.54u PD=1.22u rfmode=0
M$5517 VDD \$1800 \$1985 VDD sg13_lv_pmos L=0.13u W=0.42u AS=0.1563p AD=0.0546p
+ PS=1.22u PD=0.68u rfmode=0
M$5518 \$1985 \$1801 \$1946 VDD sg13_lv_pmos L=0.13u W=0.42u AS=0.0546p
+ AD=0.0798p PS=0.68u PD=0.8u rfmode=0
M$5519 \$1946 \$1962 \$1868 VDD sg13_lv_pmos L=0.13u W=0.42u AS=0.0798p
+ AD=0.1428p PS=0.8u PD=1.52u rfmode=0
M$5520 \$2228 \$2089 VDD VDD sg13_lv_pmos L=0.13u W=1.12u AS=0.3864p
+ AD=0.431025p PS=2.93u PD=2.145u rfmode=0
M$5521 VDD CLK \$2089 VDD sg13_lv_pmos L=0.13u W=1.12u AS=0.431025p AD=0.3808p
+ PS=2.145u PD=2.92u rfmode=0
M$5522 \$2155 \$2228 \$2235 VDD sg13_lv_pmos L=0.13u W=0.42u AS=0.19115p
+ AD=0.0525p PS=1.565u PD=0.67u rfmode=0
M$5523 \$2235 \$2215 VDD VDD sg13_lv_pmos L=0.13u W=0.42u AS=0.0525p
+ AD=0.25605p PS=0.67u PD=1.935u rfmode=0
M$5524 VDD VDD \$2215 VDD sg13_lv_pmos L=0.13u W=0.42u AS=0.25605p AD=0.0798p
+ PS=1.935u PD=0.8u rfmode=0
M$5525 VDD \$2155 \$2215 VDD sg13_lv_pmos L=0.13u W=0.42u AS=0.2014p AD=0.0798p
+ PS=1.53u PD=0.8u rfmode=0
M$5526 VDD \$2155 \$2157 VDD sg13_lv_pmos L=0.13u W=1u AS=0.2083p AD=0.34p
+ PS=1.5u PD=2.68u rfmode=0
M$5527 VDD \$2155 \$2156 VDD sg13_lv_pmos L=0.13u W=2.24u AS=0.4142p AD=0.4211p
+ PS=3.03u PD=3u rfmode=0
M$5529 \$2088 \$2089 \$2155 VDD sg13_lv_pmos L=0.13u W=1u AS=0.34p AD=0.19115p
+ PS=2.68u PD=1.565u rfmode=0
M$5530 VDD \$2157 \$2158 VDD sg13_lv_pmos L=0.13u W=2.24u AS=0.5964p AD=0.5964p
+ PS=4.425u PD=4.425u rfmode=0
M$5532 \$1948 VDD VDD VDD sg13_lv_pmos L=0.13u W=0.42u AS=0.147p AD=0.1563p
+ PS=1.54u PD=1.22u rfmode=0
M$5533 VDD \$1804 \$1974 VDD sg13_lv_pmos L=0.13u W=0.42u AS=0.1563p AD=0.0546p
+ PS=1.22u PD=0.68u rfmode=0
M$5534 \$1974 \$1805 \$1948 VDD sg13_lv_pmos L=0.13u W=0.42u AS=0.0546p
+ AD=0.0798p PS=0.68u PD=0.8u rfmode=0
M$5535 \$1948 \$1964 \$1878 VDD sg13_lv_pmos L=0.13u W=0.42u AS=0.0798p
+ AD=0.1428p PS=0.8u PD=1.52u rfmode=0
M$5536 VDD \$2381 \$196 VDD sg13_lv_pmos L=0.13u W=2.24u AS=0.9464p AD=0.4214p
+ PS=5.05u PD=3u rfmode=0
M$5538 VDD X7 \$2381 VDD sg13_lv_pmos L=0.13u W=1u AS=0.2086p AD=0.34p PS=1.5u
+ PD=2.68u rfmode=0
M$5539 VDD \$2384 \$2355 VDD sg13_lv_pmos L=0.13u W=2.24u AS=0.6384p AD=0.4046p
+ PS=4.5u PD=3u rfmode=0
M$5541 VDD X6 \$2384 VDD sg13_lv_pmos L=0.13u W=0.84u AS=0.1918p AD=0.1596p
+ PS=1.5u PD=1.22u rfmode=0
M$5542 \$2384 X5 VDD VDD sg13_lv_pmos L=0.13u W=0.84u AS=0.1596p AD=0.2856p
+ PS=1.22u PD=2.36u rfmode=0
M$5543 VDD \$2366 \$193 VDD sg13_lv_pmos L=0.13u W=2.24u AS=0.6776p AD=0.4746p
+ PS=4.57u PD=3.105u rfmode=0
M$5545 VDD \$2355 \$2371 VDD sg13_lv_pmos L=0.13u W=0.84u AS=0.2226p AD=0.1596p
+ PS=1.535u PD=1.22u rfmode=0
M$5546 \$2371 X7 \$2366 VDD sg13_lv_pmos L=0.13u W=0.84u AS=0.1596p AD=0.2856p
+ PS=1.22u PD=2.36u rfmode=0
M$5547 VDD \$2389 \$2382 VDD sg13_lv_pmos L=0.13u W=2.24u AS=0.6776p AD=0.4746p
+ PS=4.57u PD=3.105u rfmode=0
M$5549 VDD X5 \$2397 VDD sg13_lv_pmos L=0.13u W=0.84u AS=0.2226p AD=0.1596p
+ PS=1.535u PD=1.22u rfmode=0
M$5550 \$2397 X6 \$2389 VDD sg13_lv_pmos L=0.13u W=0.84u AS=0.1596p AD=0.2856p
+ PS=1.22u PD=2.36u rfmode=0
M$5551 VDD \$2367 \$199 VDD sg13_lv_pmos L=0.13u W=2.24u AS=0.6384p AD=0.4046p
+ PS=4.5u PD=3u rfmode=0
M$5553 VDD \$2382 \$2367 VDD sg13_lv_pmos L=0.13u W=0.84u AS=0.1918p AD=0.1596p
+ PS=1.5u PD=1.22u rfmode=0
M$5554 \$2367 X7 VDD VDD sg13_lv_pmos L=0.13u W=0.84u AS=0.1596p AD=0.2856p
+ PS=1.22u PD=2.36u rfmode=0
M$5555 \$2202 VDD VDD VDD sg13_lv_pmos L=0.13u W=0.42u AS=0.147p AD=0.1563p
+ PS=1.54u PD=1.22u rfmode=0
M$5556 VDD \$2064 \$2233 VDD sg13_lv_pmos L=0.13u W=0.42u AS=0.1563p AD=0.0546p
+ PS=1.22u PD=0.68u rfmode=0
M$5557 \$2233 \$2065 \$2202 VDD sg13_lv_pmos L=0.13u W=0.42u AS=0.0546p
+ AD=0.0798p PS=0.68u PD=0.8u rfmode=0
M$5558 \$2202 \$2216 \$2092 VDD sg13_lv_pmos L=0.13u W=0.42u AS=0.0798p
+ AD=0.1428p PS=0.8u PD=1.52u rfmode=0
M$5559 VDD \$2390 \$190 VDD sg13_lv_pmos L=0.13u W=2.24u AS=0.6776p AD=0.4746p
+ PS=4.57u PD=3.105u rfmode=0
M$5561 VDD X7 \$2400 VDD sg13_lv_pmos L=0.13u W=0.84u AS=0.2226p AD=0.1596p
+ PS=1.535u PD=1.22u rfmode=0
M$5562 \$2400 X6 \$2390 VDD sg13_lv_pmos L=0.13u W=0.84u AS=0.1596p AD=0.2856p
+ PS=1.22u PD=2.36u rfmode=0
M$5563 VDD \$2356 \$187 VDD sg13_lv_pmos L=0.13u W=2.24u AS=0.6776p AD=0.4746p
+ PS=4.57u PD=3.105u rfmode=0
M$5565 VDD \$190 \$2376 VDD sg13_lv_pmos L=0.13u W=0.84u AS=0.2226p AD=0.1596p
+ PS=1.535u PD=1.22u rfmode=0
M$5566 \$2376 X5 \$2356 VDD sg13_lv_pmos L=0.13u W=0.84u AS=0.1596p AD=0.2856p
+ PS=1.22u PD=2.36u rfmode=0
M$5567 VDD \$2391 \$202 VDD sg13_lv_pmos L=0.13u W=2.24u AS=0.6384p AD=0.4046p
+ PS=4.5u PD=3u rfmode=0
M$5569 VDD X7 \$2391 VDD sg13_lv_pmos L=0.13u W=0.84u AS=0.1918p AD=0.1596p
+ PS=1.5u PD=1.22u rfmode=0
M$5570 \$2391 X6 VDD VDD sg13_lv_pmos L=0.13u W=0.84u AS=0.1596p AD=0.2856p
+ PS=1.22u PD=2.36u rfmode=0
M$5571 VDD \$2357 \$205 VDD sg13_lv_pmos L=0.13u W=2.24u AS=0.6384p AD=0.4046p
+ PS=4.5u PD=3u rfmode=0
M$5573 VDD \$2383 \$2357 VDD sg13_lv_pmos L=0.13u W=0.84u AS=0.1918p AD=0.1596p
+ PS=1.5u PD=1.22u rfmode=0
M$5574 \$2357 X7 VDD VDD sg13_lv_pmos L=0.13u W=0.84u AS=0.1596p AD=0.2856p
+ PS=1.22u PD=2.36u rfmode=0
M$5575 VDD \$2385 \$2383 VDD sg13_lv_pmos L=0.13u W=2.24u AS=0.6384p AD=0.4046p
+ PS=4.5u PD=3u rfmode=0
M$5577 VDD X6 \$2385 VDD sg13_lv_pmos L=0.13u W=0.84u AS=0.1918p AD=0.1596p
+ PS=1.5u PD=1.22u rfmode=0
M$5578 \$2385 X5 VDD VDD sg13_lv_pmos L=0.13u W=0.84u AS=0.1596p AD=0.2856p
+ PS=1.22u PD=2.36u rfmode=0
M$5579 \$2204 VDD VDD VDD sg13_lv_pmos L=0.13u W=0.42u AS=0.147p AD=0.1563p
+ PS=1.54u PD=1.22u rfmode=0
M$5580 VDD \$2068 \$2240 VDD sg13_lv_pmos L=0.13u W=0.42u AS=0.1563p AD=0.0546p
+ PS=1.22u PD=0.68u rfmode=0
M$5581 \$2240 \$2069 \$2204 VDD sg13_lv_pmos L=0.13u W=0.42u AS=0.0546p
+ AD=0.0798p PS=0.68u PD=0.8u rfmode=0
M$5582 \$2204 \$2218 \$2102 VDD sg13_lv_pmos L=0.13u W=0.42u AS=0.0798p
+ AD=0.1428p PS=0.8u PD=1.52u rfmode=0
M$5583 \$2206 VDD VDD VDD sg13_lv_pmos L=0.13u W=0.42u AS=0.147p AD=0.1563p
+ PS=1.54u PD=1.22u rfmode=0
M$5584 VDD \$2072 \$2248 VDD sg13_lv_pmos L=0.13u W=0.42u AS=0.1563p AD=0.0546p
+ PS=1.22u PD=0.68u rfmode=0
M$5585 \$2248 \$2073 \$2206 VDD sg13_lv_pmos L=0.13u W=0.42u AS=0.0546p
+ AD=0.0798p PS=0.68u PD=0.8u rfmode=0
M$5586 \$2206 \$2220 \$2112 VDD sg13_lv_pmos L=0.13u W=0.42u AS=0.0798p
+ AD=0.1428p PS=0.8u PD=1.52u rfmode=0
M$5587 \$2208 VDD VDD VDD sg13_lv_pmos L=0.13u W=0.42u AS=0.147p AD=0.1563p
+ PS=1.54u PD=1.22u rfmode=0
M$5588 VDD \$2076 \$2256 VDD sg13_lv_pmos L=0.13u W=0.42u AS=0.1563p AD=0.0546p
+ PS=1.22u PD=0.68u rfmode=0
M$5589 \$2256 \$2077 \$2208 VDD sg13_lv_pmos L=0.13u W=0.42u AS=0.0546p
+ AD=0.0798p PS=0.68u PD=0.8u rfmode=0
M$5590 \$2208 \$2222 \$2122 VDD sg13_lv_pmos L=0.13u W=0.42u AS=0.0798p
+ AD=0.1428p PS=0.8u PD=1.52u rfmode=0
M$5591 \$2210 VDD VDD VDD sg13_lv_pmos L=0.13u W=0.42u AS=0.147p AD=0.1563p
+ PS=1.54u PD=1.22u rfmode=0
M$5592 VDD \$2080 \$2264 VDD sg13_lv_pmos L=0.13u W=0.42u AS=0.1563p AD=0.0546p
+ PS=1.22u PD=0.68u rfmode=0
M$5593 \$2264 \$2081 \$2210 VDD sg13_lv_pmos L=0.13u W=0.42u AS=0.0546p
+ AD=0.0798p PS=0.68u PD=0.8u rfmode=0
M$5594 \$2210 \$2224 \$2132 VDD sg13_lv_pmos L=0.13u W=0.42u AS=0.0798p
+ AD=0.1428p PS=0.8u PD=1.52u rfmode=0
M$5595 \$2212 VDD VDD VDD sg13_lv_pmos L=0.13u W=0.42u AS=0.147p AD=0.1563p
+ PS=1.54u PD=1.22u rfmode=0
M$5596 VDD \$2084 \$2251 VDD sg13_lv_pmos L=0.13u W=0.42u AS=0.1563p AD=0.0546p
+ PS=1.22u PD=0.68u rfmode=0
M$5597 \$2251 \$2085 \$2212 VDD sg13_lv_pmos L=0.13u W=0.42u AS=0.0546p
+ AD=0.0798p PS=0.68u PD=0.8u rfmode=0
M$5598 \$2212 \$2226 \$2142 VDD sg13_lv_pmos L=0.13u W=0.42u AS=0.0798p
+ AD=0.1428p PS=0.8u PD=1.52u rfmode=0
M$5599 \$2214 VDD VDD VDD sg13_lv_pmos L=0.13u W=0.42u AS=0.147p AD=0.1563p
+ PS=1.54u PD=1.22u rfmode=0
M$5600 VDD \$2088 \$2239 VDD sg13_lv_pmos L=0.13u W=0.42u AS=0.1563p AD=0.0546p
+ PS=1.22u PD=0.68u rfmode=0
M$5601 \$2239 \$2089 \$2214 VDD sg13_lv_pmos L=0.13u W=0.42u AS=0.0546p
+ AD=0.0798p PS=0.68u PD=0.8u rfmode=0
M$5602 \$2214 \$2228 \$2152 VDD sg13_lv_pmos L=0.13u W=0.42u AS=0.0798p
+ AD=0.1428p PS=0.8u PD=1.52u rfmode=0
M$5603 VDD X4 \$2324 VDD sg13_lv_pmos L=0.13u W=0.42u AS=0.1428p AD=0.0798p
+ PS=1.52u PD=0.8u rfmode=0
M$5604 VDD VDD \$2324 VDD sg13_lv_pmos L=0.13u W=0.42u AS=0.3623875p AD=0.0798p
+ PS=2.605u PD=0.8u rfmode=0
M$5605 VDD \$2325 \$2326 VDD sg13_lv_pmos L=0.13u W=1u AS=0.3623875p AD=0.34p
+ PS=2.605u PD=2.68u rfmode=0
M$5606 VDD X3 \$2348 VDD sg13_lv_pmos L=0.13u W=0.42u AS=0.1428p AD=0.0798p
+ PS=1.52u PD=0.8u rfmode=0
M$5607 VDD VDD \$2348 VDD sg13_lv_pmos L=0.13u W=0.42u AS=0.3623875p AD=0.0798p
+ PS=2.605u PD=0.8u rfmode=0
M$5608 VDD \$2368 \$2346 VDD sg13_lv_pmos L=0.13u W=1u AS=0.3623875p AD=0.34p
+ PS=2.605u PD=2.68u rfmode=0
M$5609 VDD X1 \$2440 VDD sg13_lv_pmos L=0.13u W=0.42u AS=0.1428p AD=0.0798p
+ PS=1.52u PD=0.8u rfmode=0
M$5610 VDD VDD \$2440 VDD sg13_lv_pmos L=0.13u W=0.42u AS=0.3623875p AD=0.0798p
+ PS=2.605u PD=0.8u rfmode=0
M$5611 VDD \$2452 \$2435 VDD sg13_lv_pmos L=0.13u W=1u AS=0.3623875p AD=0.34p
+ PS=2.605u PD=2.68u rfmode=0
M$5612 VDD X2 \$2411 VDD sg13_lv_pmos L=0.13u W=0.42u AS=0.1428p AD=0.0798p
+ PS=1.52u PD=0.8u rfmode=0
M$5613 VDD VDD \$2411 VDD sg13_lv_pmos L=0.13u W=0.42u AS=0.3623875p AD=0.0798p
+ PS=2.605u PD=0.8u rfmode=0
M$5614 VDD \$2413 \$2412 VDD sg13_lv_pmos L=0.13u W=1u AS=0.3623875p AD=0.34p
+ PS=2.605u PD=2.68u rfmode=0
M$5615 VDD VDD \$2325 VDD sg13_lv_pmos L=0.13u W=0.42u AS=0.1563p AD=0.147p
+ PS=1.22u PD=1.54u rfmode=0
M$5616 VDD \$2326 \$2337 VDD sg13_lv_pmos L=0.13u W=0.42u AS=0.1563p AD=0.0546p
+ PS=1.22u PD=0.68u rfmode=0
M$5617 \$2337 \$2329 \$2325 VDD sg13_lv_pmos L=0.13u W=0.42u AS=0.0546p
+ AD=0.0798p PS=0.68u PD=0.8u rfmode=0
M$5618 \$2325 \$2327 \$2324 VDD sg13_lv_pmos L=0.13u W=0.42u AS=0.0798p
+ AD=0.1428p PS=0.8u PD=1.52u rfmode=0
M$5619 \$2368 VDD VDD VDD sg13_lv_pmos L=0.13u W=0.42u AS=0.147p AD=0.1563p
+ PS=1.54u PD=1.22u rfmode=0
M$5620 VDD \$2346 \$2380 VDD sg13_lv_pmos L=0.13u W=0.42u AS=0.1563p AD=0.0546p
+ PS=1.22u PD=0.68u rfmode=0
M$5621 \$2380 \$2347 \$2368 VDD sg13_lv_pmos L=0.13u W=0.42u AS=0.0546p
+ AD=0.0798p PS=0.68u PD=0.8u rfmode=0
M$5622 \$2368 \$2378 \$2348 VDD sg13_lv_pmos L=0.13u W=0.42u AS=0.0798p
+ AD=0.1428p PS=0.8u PD=1.52u rfmode=0
M$5623 VDD VDD \$2413 VDD sg13_lv_pmos L=0.13u W=0.42u AS=0.1563p AD=0.147p
+ PS=1.22u PD=1.54u rfmode=0
M$5624 VDD \$2412 \$2419 VDD sg13_lv_pmos L=0.13u W=0.42u AS=0.1563p AD=0.0546p
+ PS=1.22u PD=0.68u rfmode=0
M$5625 \$2419 \$2422 \$2413 VDD sg13_lv_pmos L=0.13u W=0.42u AS=0.0546p
+ AD=0.0798p PS=0.68u PD=0.8u rfmode=0
M$5626 \$2413 \$2414 \$2411 VDD sg13_lv_pmos L=0.13u W=0.42u AS=0.0798p
+ AD=0.1428p PS=0.8u PD=1.52u rfmode=0
M$5627 \$2452 VDD VDD VDD sg13_lv_pmos L=0.13u W=0.42u AS=0.147p AD=0.1563p
+ PS=1.54u PD=1.22u rfmode=0
M$5628 VDD \$2435 \$2459 VDD sg13_lv_pmos L=0.13u W=0.42u AS=0.1563p AD=0.0546p
+ PS=1.22u PD=0.68u rfmode=0
M$5629 \$2459 \$2436 \$2452 VDD sg13_lv_pmos L=0.13u W=0.42u AS=0.0546p
+ AD=0.0798p PS=0.68u PD=0.8u rfmode=0
M$5630 \$2452 \$2453 \$2440 VDD sg13_lv_pmos L=0.13u W=0.42u AS=0.0798p
+ AD=0.1428p PS=0.8u PD=1.52u rfmode=0
M$5631 \$2378 \$2347 VDD VDD sg13_lv_pmos L=0.13u W=1.12u AS=0.3864p
+ AD=0.431025p PS=2.93u PD=2.145u rfmode=0
M$5632 VDD CLK \$2347 VDD sg13_lv_pmos L=0.13u W=1.12u AS=0.431025p AD=0.3808p
+ PS=2.145u PD=2.92u rfmode=0
M$5633 VDD \$2329 \$2327 VDD sg13_lv_pmos L=0.13u W=1.12u AS=0.431025p
+ AD=0.3864p PS=2.145u PD=2.93u rfmode=0
M$5634 VDD CLK \$2329 VDD sg13_lv_pmos L=0.13u W=1.12u AS=0.431025p AD=0.3808p
+ PS=2.145u PD=2.92u rfmode=0
M$5635 \$2453 \$2436 VDD VDD sg13_lv_pmos L=0.13u W=1.12u AS=0.3864p
+ AD=0.431025p PS=2.93u PD=2.145u rfmode=0
M$5636 VDD CLK \$2436 VDD sg13_lv_pmos L=0.13u W=1.12u AS=0.431025p AD=0.3808p
+ PS=2.145u PD=2.92u rfmode=0
M$5637 VDD \$2422 \$2414 VDD sg13_lv_pmos L=0.13u W=1.12u AS=0.431025p
+ AD=0.3864p PS=2.145u PD=2.93u rfmode=0
M$5638 VDD CLK \$2422 VDD sg13_lv_pmos L=0.13u W=1.12u AS=0.431025p AD=0.3808p
+ PS=2.145u PD=2.92u rfmode=0
M$5639 \$2359 \$2378 \$2379 VDD sg13_lv_pmos L=0.13u W=0.42u AS=0.19115p
+ AD=0.0525p PS=1.565u PD=0.67u rfmode=0
M$5640 \$2379 \$2369 VDD VDD sg13_lv_pmos L=0.13u W=0.42u AS=0.0525p
+ AD=0.25605p PS=0.67u PD=1.935u rfmode=0
M$5641 VDD VDD \$2369 VDD sg13_lv_pmos L=0.13u W=0.42u AS=0.25605p AD=0.0798p
+ PS=1.935u PD=0.8u rfmode=0
M$5642 VDD \$2359 \$2369 VDD sg13_lv_pmos L=0.13u W=0.42u AS=0.2014p AD=0.0798p
+ PS=1.53u PD=0.8u rfmode=0
M$5643 VDD \$2359 \$2352 VDD sg13_lv_pmos L=0.13u W=1u AS=0.2083p AD=0.34p
+ PS=1.5u PD=2.68u rfmode=0
M$5644 VDD \$2359 \$2351 VDD sg13_lv_pmos L=0.13u W=2.24u AS=0.4142p AD=0.4211p
+ PS=3.03u PD=3u rfmode=0
M$5646 \$2346 \$2347 \$2359 VDD sg13_lv_pmos L=0.13u W=1u AS=0.34p AD=0.19115p
+ PS=2.68u PD=1.565u rfmode=0
M$5647 \$2326 \$2329 \$2330 VDD sg13_lv_pmos L=0.13u W=1u AS=0.34p AD=0.19115p
+ PS=2.68u PD=1.565u rfmode=0
M$5648 \$2330 \$2327 \$2338 VDD sg13_lv_pmos L=0.13u W=0.42u AS=0.19115p
+ AD=0.0525p PS=1.565u PD=0.67u rfmode=0
M$5649 VDD \$2331 \$2338 VDD sg13_lv_pmos L=0.13u W=0.42u AS=0.25605p
+ AD=0.0525p PS=1.935u PD=0.67u rfmode=0
M$5650 VDD VDD \$2331 VDD sg13_lv_pmos L=0.13u W=0.42u AS=0.25605p AD=0.0798p
+ PS=1.935u PD=0.8u rfmode=0
M$5651 VDD \$2330 \$2331 VDD sg13_lv_pmos L=0.13u W=0.42u AS=0.2014p AD=0.0798p
+ PS=1.53u PD=0.8u rfmode=0
M$5652 VDD \$2330 \$2314 VDD sg13_lv_pmos L=0.13u W=2.24u AS=0.4142p AD=0.4211p
+ PS=3.03u PD=3u rfmode=0
M$5654 VDD \$2330 \$2332 VDD sg13_lv_pmos L=0.13u W=1u AS=0.2083p AD=0.34p
+ PS=1.5u PD=2.68u rfmode=0
M$5655 \$2444 \$2453 \$2460 VDD sg13_lv_pmos L=0.13u W=0.42u AS=0.19115p
+ AD=0.0525p PS=1.565u PD=0.67u rfmode=0
M$5656 \$2460 \$2454 VDD VDD sg13_lv_pmos L=0.13u W=0.42u AS=0.0525p
+ AD=0.25605p PS=0.67u PD=1.935u rfmode=0
M$5657 VDD VDD \$2454 VDD sg13_lv_pmos L=0.13u W=0.42u AS=0.25605p AD=0.0798p
+ PS=1.935u PD=0.8u rfmode=0
M$5658 VDD \$2444 \$2454 VDD sg13_lv_pmos L=0.13u W=0.42u AS=0.2014p AD=0.0798p
+ PS=1.53u PD=0.8u rfmode=0
M$5659 VDD \$2444 \$2438 VDD sg13_lv_pmos L=0.13u W=1u AS=0.2083p AD=0.34p
+ PS=1.5u PD=2.68u rfmode=0
M$5660 VDD \$2444 \$2437 VDD sg13_lv_pmos L=0.13u W=2.24u AS=0.4142p AD=0.4211p
+ PS=3.03u PD=3u rfmode=0
M$5662 \$2435 \$2436 \$2444 VDD sg13_lv_pmos L=0.13u W=1u AS=0.34p AD=0.19115p
+ PS=2.68u PD=1.565u rfmode=0
M$5663 \$2412 \$2422 \$2415 VDD sg13_lv_pmos L=0.13u W=1u AS=0.34p AD=0.19115p
+ PS=2.68u PD=1.565u rfmode=0
M$5664 \$2415 \$2414 \$2427 VDD sg13_lv_pmos L=0.13u W=0.42u AS=0.19115p
+ AD=0.0525p PS=1.565u PD=0.67u rfmode=0
M$5665 VDD \$2416 \$2427 VDD sg13_lv_pmos L=0.13u W=0.42u AS=0.25605p
+ AD=0.0525p PS=1.935u PD=0.67u rfmode=0
M$5666 VDD VDD \$2416 VDD sg13_lv_pmos L=0.13u W=0.42u AS=0.25605p AD=0.0798p
+ PS=1.935u PD=0.8u rfmode=0
M$5667 VDD \$2415 \$2416 VDD sg13_lv_pmos L=0.13u W=0.42u AS=0.2014p AD=0.0798p
+ PS=1.53u PD=0.8u rfmode=0
M$5668 VDD \$2415 \$2403 VDD sg13_lv_pmos L=0.13u W=2.24u AS=0.4142p AD=0.4211p
+ PS=3.03u PD=3u rfmode=0
M$5670 VDD \$2415 \$2417 VDD sg13_lv_pmos L=0.13u W=1u AS=0.2083p AD=0.34p
+ PS=1.5u PD=2.68u rfmode=0
M$5671 VDD \$2352 \$2353 VDD sg13_lv_pmos L=0.13u W=2.24u AS=0.5964p AD=0.5964p
+ PS=4.425u PD=4.425u rfmode=0
M$5673 VDD \$2332 \$2322 VDD sg13_lv_pmos L=0.13u W=2.24u AS=0.5964p AD=0.5964p
+ PS=4.425u PD=4.425u rfmode=0
M$5675 VDD \$2438 \$2439 VDD sg13_lv_pmos L=0.13u W=2.24u AS=0.5964p AD=0.5964p
+ PS=4.425u PD=4.425u rfmode=0
M$5677 VDD \$2417 \$2418 VDD sg13_lv_pmos L=0.13u W=2.24u AS=0.5964p AD=0.5964p
+ PS=4.425u PD=4.425u rfmode=0
.ENDS CS_DAC_10b
