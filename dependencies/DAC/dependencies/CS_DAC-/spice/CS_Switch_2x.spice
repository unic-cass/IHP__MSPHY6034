** sch_path: /home/designer/shared/CS_DAC/CS_DAC-/xschem/CS_Switch_2x.sch
.subckt CS_Switch_2x INN INP OUTN OUTP VBIAS VSS
*.PININFO VSS:B VBIAS:I OUTP:B OUTN:B INP:I INN:I
MM7 net1 VBIAS net2 VSS sg13_hv_nmos w=0.6u l=0.45u ng=1 m=1
MM5 net2 VBIAS VSS VSS sg13_hv_nmos w=0.6u l=0.45u ng=1 m=1
MM1 OUTP INP net1 VSS sg13_lv_nmos w=2u l=0.13u ng=1 m=1
MM2 OUTN INN net1 VSS sg13_lv_nmos w=2u l=0.13u ng=1 m=1
MM3 VSS VSS net1 VSS sg13_lv_nmos w=0.5u l=0.13u ng=1 m=1
MM6 VSS VSS net2 VSS sg13_hv_nmos w=0.3u l=0.45u ng=1 m=1
MM8 VSS VSS net2 VSS sg13_hv_nmos w=0.3u l=0.45u ng=1 m=1
MM9 net2 VSS VSS VSS sg13_hv_nmos w=0.3u l=0.45u ng=1 m=1
MM10 net2 VSS VSS VSS sg13_hv_nmos w=0.3u l=0.45u ng=1 m=1
MM4 VSS VSS net1 VSS sg13_lv_nmos w=0.5u l=0.13u ng=1 m=1
.ends
