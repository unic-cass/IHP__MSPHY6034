* Extracted by KLayout with SG13G2 LVS runset on : 21/09/2026 21:44

.SUBCKT SAR_ADC VSS clk_comp fclk_samp bias Op Om vin_neg vin_pos En rst
+ fclk_in VDD fdac_clk D0 D1 D2 D3 D4 D5 D6 D7
M$1 VDD \$71 \$16 VSS sg13_lv_nmos L=0.13u W=1u AS=0.34p AD=0.34p PS=2.68u
+ PD=2.68u rfmode=0
M$2 \$17 \$82 VDD VSS sg13_lv_nmos L=0.13u W=1u AS=0.34p AD=0.34p PS=2.68u
+ PD=2.68u rfmode=0
M$3 VSS \$29 \$16 VSS sg13_lv_nmos L=0.13u W=1u AS=0.34p AD=0.34p PS=2.68u
+ PD=2.68u rfmode=0
M$4 \$17 \$40 VSS VSS sg13_lv_nmos L=0.13u W=1u AS=0.34p AD=0.34p PS=2.68u
+ PD=2.68u rfmode=0
M$5 VDD \$70 \$6 VSS sg13_lv_nmos L=0.13u W=1u AS=0.34p AD=0.34p PS=2.68u
+ PD=2.68u rfmode=0
M$6 VSS \$28 \$6 VSS sg13_lv_nmos L=0.13u W=1u AS=0.34p AD=0.34p PS=2.68u
+ PD=2.68u rfmode=0
M$7 VDD \$76 \$21 VSS sg13_lv_nmos L=0.13u W=1u AS=0.34p AD=0.34p PS=2.68u
+ PD=2.68u rfmode=0
M$8 \$22 \$77 VDD VSS sg13_lv_nmos L=0.13u W=1u AS=0.34p AD=0.34p PS=2.68u
+ PD=2.68u rfmode=0
M$9 \$8 \$41 VSS VSS sg13_lv_nmos L=0.13u W=1u AS=0.34p AD=0.34p PS=2.68u
+ PD=2.68u rfmode=0
M$10 \$8 \$83 VDD VSS sg13_lv_nmos L=0.13u W=1u AS=0.34p AD=0.34p PS=2.68u
+ PD=2.68u rfmode=0
M$11 VDD \$72 \$18 VSS sg13_lv_nmos L=0.13u W=1u AS=0.34p AD=0.34p PS=2.68u
+ PD=2.68u rfmode=0
M$12 VSS \$30 \$18 VSS sg13_lv_nmos L=0.13u W=1u AS=0.34p AD=0.34p PS=2.68u
+ PD=2.68u rfmode=0
M$13 VDD \$73 \$19 VSS sg13_lv_nmos L=0.13u W=1u AS=0.34p AD=0.34p PS=2.68u
+ PD=2.68u rfmode=0
M$14 VSS \$31 \$19 VSS sg13_lv_nmos L=0.13u W=1u AS=0.34p AD=0.34p PS=2.68u
+ PD=2.68u rfmode=0
M$15 VDD \$74 \$25 VSS sg13_lv_nmos L=0.13u W=1u AS=0.34p AD=0.34p PS=2.68u
+ PD=2.68u rfmode=0
M$16 VSS \$32 \$25 VSS sg13_lv_nmos L=0.13u W=1u AS=0.34p AD=0.34p PS=2.68u
+ PD=2.68u rfmode=0
M$17 VSS \$34 \$21 VSS sg13_lv_nmos L=0.13u W=1u AS=0.34p AD=0.34p PS=2.68u
+ PD=2.68u rfmode=0
M$18 \$22 \$35 VSS VSS sg13_lv_nmos L=0.13u W=1u AS=0.34p AD=0.34p PS=2.68u
+ PD=2.68u rfmode=0
M$19 \$26 \$37 VSS VSS sg13_lv_nmos L=0.13u W=1u AS=0.34p AD=0.34p PS=2.68u
+ PD=2.68u rfmode=0
M$20 \$26 \$79 VDD VSS sg13_lv_nmos L=0.13u W=1u AS=0.34p AD=0.34p PS=2.68u
+ PD=2.68u rfmode=0
M$21 \$20 \$38 VSS VSS sg13_lv_nmos L=0.13u W=1u AS=0.34p AD=0.34p PS=2.68u
+ PD=2.68u rfmode=0
M$22 \$20 \$80 VDD VSS sg13_lv_nmos L=0.13u W=1u AS=0.34p AD=0.34p PS=2.68u
+ PD=2.68u rfmode=0
M$23 \$27 \$39 VSS VSS sg13_lv_nmos L=0.13u W=1u AS=0.34p AD=0.34p PS=2.68u
+ PD=2.68u rfmode=0
M$24 \$27 \$81 VDD VSS sg13_lv_nmos L=0.13u W=1u AS=0.34p AD=0.34p PS=2.68u
+ PD=2.68u rfmode=0
M$25 VSS \$28 \$70 VSS sg13_lv_nmos L=0.13u W=0.4u AS=0.136p AD=0.136p PS=1.48u
+ PD=1.48u rfmode=0
M$26 VSS \$29 \$71 VSS sg13_lv_nmos L=0.13u W=0.4u AS=0.136p AD=0.136p PS=1.48u
+ PD=1.48u rfmode=0
M$27 VSS \$30 \$72 VSS sg13_lv_nmos L=0.13u W=0.4u AS=0.136p AD=0.136p PS=1.48u
+ PD=1.48u rfmode=0
M$28 VSS \$31 \$73 VSS sg13_lv_nmos L=0.13u W=0.4u AS=0.136p AD=0.136p PS=1.48u
+ PD=1.48u rfmode=0
M$29 VSS \$32 \$74 VSS sg13_lv_nmos L=0.13u W=0.4u AS=0.136p AD=0.136p PS=1.48u
+ PD=1.48u rfmode=0
M$30 VDD \$75 \$23 VSS sg13_lv_nmos L=0.13u W=1u AS=0.34p AD=0.34p PS=2.68u
+ PD=2.68u rfmode=0
M$31 VSS \$33 \$75 VSS sg13_lv_nmos L=0.13u W=0.4u AS=0.136p AD=0.136p PS=1.48u
+ PD=1.48u rfmode=0
M$32 VSS \$33 \$23 VSS sg13_lv_nmos L=0.13u W=1u AS=0.34p AD=0.34p PS=2.68u
+ PD=2.68u rfmode=0
M$33 VSS \$34 \$76 VSS sg13_lv_nmos L=0.13u W=0.4u AS=0.136p AD=0.136p PS=1.48u
+ PD=1.48u rfmode=0
M$35 VSS clk_comp \$201 VSS sg13_lv_nmos L=0.2u W=4u AS=0.76p AD=1.44p PS=4.38u
+ PD=4.72u rfmode=0
M$36 \$201 \$202 VSS VSS sg13_lv_nmos L=0.2u W=4u AS=1.44p AD=0.76p PS=4.72u
+ PD=4.38u rfmode=0
M$39 VSS \$201 \$202 VSS sg13_lv_nmos L=0.2u W=4u AS=0.76p AD=1.44p PS=4.38u
+ PD=4.72u rfmode=0
M$40 \$202 clk_comp VSS VSS sg13_lv_nmos L=0.2u W=4u AS=1.44p AD=0.76p PS=4.72u
+ PD=4.38u rfmode=0
M$42 \$77 \$35 VSS VSS sg13_lv_nmos L=0.13u W=0.4u AS=0.136p AD=0.136p PS=1.48u
+ PD=1.48u rfmode=0
M$43 \$24 \$36 VSS VSS sg13_lv_nmos L=0.13u W=1u AS=0.34p AD=0.34p PS=2.68u
+ PD=2.68u rfmode=0
M$44 \$78 \$36 VSS VSS sg13_lv_nmos L=0.13u W=0.4u AS=0.136p AD=0.136p PS=1.48u
+ PD=1.48u rfmode=0
M$45 \$24 \$78 VDD VSS sg13_lv_nmos L=0.13u W=1u AS=0.34p AD=0.34p PS=2.68u
+ PD=2.68u rfmode=0
M$46 \$79 \$37 VSS VSS sg13_lv_nmos L=0.13u W=0.4u AS=0.136p AD=0.136p PS=1.48u
+ PD=1.48u rfmode=0
M$47 \$80 \$38 VSS VSS sg13_lv_nmos L=0.13u W=0.4u AS=0.136p AD=0.136p PS=1.48u
+ PD=1.48u rfmode=0
M$48 \$81 \$39 VSS VSS sg13_lv_nmos L=0.13u W=0.4u AS=0.136p AD=0.136p PS=1.48u
+ PD=1.48u rfmode=0
M$49 \$82 \$40 VSS VSS sg13_lv_nmos L=0.13u W=0.4u AS=0.136p AD=0.136p PS=1.48u
+ PD=1.48u rfmode=0
M$50 \$83 \$41 VSS VSS sg13_lv_nmos L=0.13u W=0.4u AS=0.136p AD=0.136p PS=1.48u
+ PD=1.48u rfmode=0
M$51 \$10 \$258 vin_neg VSS sg13_lv_nmos L=0.13u W=2.5u AS=0.85p AD=0.85p
+ PS=5.68u PD=5.68u rfmode=0
M$52 vin_neg \$234 \$224 VSS sg13_lv_nmos L=0.13u W=3u AS=1.02p AD=1.02p
+ PS=6.68u PD=6.68u rfmode=0
M$53 Op \$201 VSS VSS sg13_lv_nmos L=0.2u W=4u AS=1.06p AD=1.06p PS=7.06u
+ PD=7.06u rfmode=0
M$55 Om \$202 VSS VSS sg13_lv_nmos L=0.2u W=4u AS=1.06p AD=1.06p PS=7.06u
+ PD=7.06u rfmode=0
M$57 \$228 \$238 vin_pos VSS sg13_lv_nmos L=0.13u W=3u AS=1.02p AD=1.02p
+ PS=6.68u PD=6.68u rfmode=0
M$58 vin_pos \$260 \$11 VSS sg13_lv_nmos L=0.13u W=2.5u AS=0.85p AD=0.85p
+ PS=5.68u PD=5.68u rfmode=0
M$59 \$234 VDD \$235 VSS sg13_lv_nmos L=0.13u W=3u AS=1.02p AD=1.02p PS=6.68u
+ PD=6.68u rfmode=0
M$60 \$235 \$223 VSS VSS sg13_lv_nmos L=0.13u W=3u AS=1.02p AD=1.02p PS=6.68u
+ PD=6.68u rfmode=0
M$61 VSS \$223 \$224 VSS sg13_lv_nmos L=0.4u W=1.3u AS=0.442p AD=0.442p
+ PS=3.28u PD=3.28u rfmode=0
M$62 \$228 \$226 VSS VSS sg13_lv_nmos L=0.4u W=1.3u AS=0.442p AD=0.442p
+ PS=3.28u PD=3.28u rfmode=0
M$63 VSS \$226 \$237 VSS sg13_lv_nmos L=0.13u W=3u AS=1.02p AD=1.02p PS=6.68u
+ PD=6.68u rfmode=0
M$64 \$237 VDD \$238 VSS sg13_lv_nmos L=0.13u W=3u AS=1.02p AD=1.02p PS=6.68u
+ PD=6.68u rfmode=0
M$65 \$274 \$278 VSS VSS sg13_lv_nmos L=0.13u W=0.4u AS=0.136p AD=0.136p
+ PS=1.48u PD=1.48u rfmode=0
M$66 VSS \$223 \$259 VSS sg13_lv_nmos L=0.13u W=0.5u AS=0.17p AD=0.17p PS=1.68u
+ PD=1.68u rfmode=0
M$67 \$259 VDD \$258 VSS sg13_lv_nmos L=0.13u W=0.5u AS=0.17p AD=0.17p PS=1.68u
+ PD=1.68u rfmode=0
M$68 \$225 \$223 VSS VSS sg13_lv_nmos L=0.13u W=0.4u AS=0.136p AD=0.136p
+ PS=1.48u PD=1.48u rfmode=0
M$69 \$223 fclk_samp VSS VSS sg13_lv_nmos L=0.13u W=0.4u AS=0.136p AD=0.136p
+ PS=1.48u PD=1.48u rfmode=0
M$70 VSS fclk_samp \$226 VSS sg13_lv_nmos L=0.13u W=0.4u AS=0.136p AD=0.136p
+ PS=1.48u PD=1.48u rfmode=0
M$71 VSS \$226 \$227 VSS sg13_lv_nmos L=0.13u W=0.4u AS=0.136p AD=0.136p
+ PS=1.48u PD=1.48u rfmode=0
M$72 \$260 VDD \$261 VSS sg13_lv_nmos L=0.13u W=0.5u AS=0.17p AD=0.17p PS=1.68u
+ PD=1.68u rfmode=0
M$73 \$261 \$226 VSS VSS sg13_lv_nmos L=0.13u W=0.5u AS=0.17p AD=0.17p PS=1.68u
+ PD=1.68u rfmode=0
M$74 VSS \$279 \$275 VSS sg13_lv_nmos L=0.13u W=0.4u AS=0.136p AD=0.136p
+ PS=1.48u PD=1.48u rfmode=0
M$75 \$288 \$295 VDD VSS sg13_lv_nmos L=0.13u W=1.3u AS=0.442p AD=0.442p
+ PS=3.28u PD=3.28u rfmode=0
M$76 VDD \$295 \$247 VSS sg13_lv_nmos L=0.13u W=1.3u AS=0.442p AD=0.442p
+ PS=3.28u PD=3.28u rfmode=0
M$77 \$295 \$247 VDD VSS sg13_lv_nmos L=0.13u W=1.3u AS=0.442p AD=0.442p
+ PS=3.28u PD=3.28u rfmode=0
M$78 VDD \$248 \$296 VSS sg13_lv_nmos L=0.13u W=1.3u AS=0.442p AD=0.442p
+ PS=3.28u PD=3.28u rfmode=0
M$79 \$248 \$296 VDD VSS sg13_lv_nmos L=0.13u W=1.3u AS=0.442p AD=0.442p
+ PS=3.28u PD=3.28u rfmode=0
M$80 VDD \$296 \$249 VSS sg13_lv_nmos L=0.13u W=1.3u AS=0.442p AD=0.442p
+ PS=3.28u PD=3.28u rfmode=0
M$81 \$34 \$338 VSS VSS sg13_lv_nmos L=0.13u W=0.74u AS=0.2886p AD=0.14875p
+ PS=2.26u PD=1.16u rfmode=0
M$82 VSS \$339 \$338 VSS sg13_lv_nmos L=0.13u W=0.55u AS=0.14875p AD=0.187p
+ PS=1.16u PD=1.78u rfmode=0
M$83 VSS Op \$340 VSS sg13_lv_nmos L=0.13u W=0.55u AS=0.14875p AD=0.187p
+ PS=1.16u PD=1.78u rfmode=0
M$84 VSS \$340 \$309 VSS sg13_lv_nmos L=0.13u W=0.74u AS=0.14875p AD=0.2886p
+ PS=1.16u PD=2.26u rfmode=0
M$85 VSS \$342 \$341 VSS sg13_lv_nmos L=0.13u W=0.55u AS=0.14875p AD=0.187p
+ PS=1.16u PD=1.78u rfmode=0
M$86 VSS \$341 clk_comp VSS sg13_lv_nmos L=0.13u W=0.74u AS=0.14875p AD=0.2886p
+ PS=1.16u PD=2.26u rfmode=0
M$87 \$321 \$363 VSS VSS sg13_lv_nmos L=0.13u W=0.74u AS=0.2886p AD=0.14875p
+ PS=2.26u PD=1.16u rfmode=0
M$88 VSS rst \$363 VSS sg13_lv_nmos L=0.13u W=0.55u AS=0.14875p AD=0.187p
+ PS=1.16u PD=1.78u rfmode=0
M$89 \$325 \$324 \$385 VSS sg13_lv_nmos L=0.13u W=0.42u AS=0.1428p AD=0.0609p
+ PS=1.52u PD=0.71u rfmode=0
M$90 \$385 \$367 VSS VSS sg13_lv_nmos L=0.13u W=0.42u AS=0.0609p AD=0.1626p
+ PS=0.71u PD=1.415u rfmode=0
M$91 VSS \$366 \$326 VSS sg13_lv_nmos L=0.13u W=0.74u AS=0.1626p AD=0.2516p
+ PS=1.415u PD=2.16u rfmode=0
M$92 \$299 Op \$302 VSS sg13_lv_nmos L=0.13u W=0.25u AS=0.1075p AD=0.0625p
+ PS=1.34u PD=0.74u rfmode=0
M$93 \$302 Om VSS VSS sg13_lv_nmos L=0.13u W=0.25u AS=0.0625p AD=0.1075p
+ PS=0.74u PD=1.34u rfmode=0
M$94 \$328 \$329 VSS VSS sg13_lv_nmos L=0.13u W=0.42u AS=0.1428p AD=0.0798p
+ PS=1.52u PD=0.8u rfmode=0
M$95 VSS \$367 \$387 VSS sg13_lv_nmos L=0.13u W=0.42u AS=0.0798p AD=0.0378p
+ PS=0.8u PD=0.6u rfmode=0
M$96 \$387 \$369 \$329 VSS sg13_lv_nmos L=0.13u W=0.42u AS=0.0378p AD=0.1428p
+ PS=0.6u PD=1.52u rfmode=0
M$97 \$330 \$369 VSS VSS sg13_lv_nmos L=0.13u W=0.74u AS=0.2516p AD=0.1406p
+ PS=2.16u PD=1.12u rfmode=0
M$98 VSS \$330 \$331 VSS sg13_lv_nmos L=0.13u W=0.74u AS=0.1406p AD=0.2516p
+ PS=1.12u PD=2.16u rfmode=0
M$99 \$332 \$553 VSS VSS sg13_lv_nmos L=0.15u W=0.74u AS=0.2516p AD=0.1406p
+ PS=2.16u PD=1.12u rfmode=0
M$100 VSS \$416 \$332 VSS sg13_lv_nmos L=0.15u W=0.74u AS=0.1406p AD=0.1406p
+ PS=1.12u PD=1.12u rfmode=0
M$101 \$332 \$370 \$333 VSS sg13_lv_nmos L=0.15u W=0.74u AS=0.1406p AD=0.2516p
+ PS=1.12u PD=2.16u rfmode=0
M$102 \$335 \$373 VSS VSS sg13_lv_nmos L=0.13u W=0.74u AS=0.2886p AD=0.14875p
+ PS=2.26u PD=1.16u rfmode=0
M$103 VSS \$660 \$373 VSS sg13_lv_nmos L=0.13u W=0.55u AS=0.14875p AD=0.187p
+ PS=1.16u PD=1.78u rfmode=0
M$104 VSS \$299 \$374 VSS sg13_lv_nmos L=0.13u W=0.55u AS=0.14875p AD=0.187p
+ PS=1.16u PD=1.78u rfmode=0
M$105 VSS \$374 \$336 VSS sg13_lv_nmos L=0.13u W=0.74u AS=0.14875p AD=0.2886p
+ PS=1.16u PD=2.26u rfmode=0
M$106 fclk_samp \$375 VSS VSS sg13_lv_nmos L=0.13u W=0.74u AS=0.2886p
+ AD=0.14875p PS=2.26u PD=1.16u rfmode=0
M$107 VSS \$370 \$375 VSS sg13_lv_nmos L=0.13u W=0.55u AS=0.14875p AD=0.187p
+ PS=1.16u PD=1.78u rfmode=0
M$108 \$372 \$376 VSS VSS sg13_lv_nmos L=0.13u W=0.74u AS=0.2886p AD=0.14875p
+ PS=2.26u PD=1.16u rfmode=0
M$109 VSS Om \$376 VSS sg13_lv_nmos L=0.13u W=0.55u AS=0.14875p AD=0.187p
+ PS=1.16u PD=1.78u rfmode=0
M$110 VSS \$378 \$377 VSS sg13_lv_nmos L=0.13u W=0.55u AS=0.14875p AD=0.187p
+ PS=1.16u PD=1.78u rfmode=0
M$111 VSS \$377 \$35 VSS sg13_lv_nmos L=0.13u W=0.74u AS=0.14875p AD=0.2886p
+ PS=1.16u PD=2.26u rfmode=0
M$112 VSS \$344 \$343 VSS sg13_lv_nmos L=0.13u W=0.55u AS=0.18945p AD=0.187p
+ PS=1.27u PD=1.78u rfmode=0
M$113 VSS \$344 \$379 VSS sg13_lv_nmos L=0.13u W=0.74u AS=0.18945p AD=0.13135p
+ PS=1.27u PD=1.095u rfmode=0
M$114 \$379 \$345 \$310 VSS sg13_lv_nmos L=0.13u W=0.74u AS=0.13135p AD=0.1628p
+ PS=1.095u PD=1.18u rfmode=0
M$115 \$310 \$339 \$380 VSS sg13_lv_nmos L=0.13u W=0.74u AS=0.1628p AD=0.3367p
+ PS=1.18u PD=1.65u rfmode=0
M$116 \$380 \$343 VSS VSS sg13_lv_nmos L=0.13u W=0.74u AS=0.3367p AD=0.148p
+ PS=1.65u PD=1.14u rfmode=0
M$117 VSS \$310 \$311 VSS sg13_lv_nmos L=0.13u W=0.74u AS=0.148p AD=0.4033p
+ PS=1.14u PD=2.57u rfmode=0
M$118 VSS \$313 \$312 VSS sg13_lv_nmos L=0.13u W=11.84u AS=2.3606p AD=2.2496p
+ PS=18.96u PD=17.92u rfmode=0
M$134 VSS fclk_in \$313 VSS sg13_lv_nmos L=0.13u W=4.44u AS=0.8436p AD=0.9546p
+ PS=6.72u PD=7.76u rfmode=0
M$140 VSS \$353 \$352 VSS sg13_lv_nmos L=0.13u W=0.74u AS=0.1898p AD=0.2516p
+ PS=1.36u PD=2.16u rfmode=0
M$141 VSS \$315 \$352 VSS sg13_lv_nmos L=0.13u W=0.74u AS=0.1898p AD=0.1406p
+ PS=1.36u PD=1.12u rfmode=0
M$142 \$352 \$351 \$354 VSS sg13_lv_nmos L=0.13u W=0.74u AS=0.1406p AD=0.2516p
+ PS=1.12u PD=2.16u rfmode=0
M$143 \$350 \$355 VSS VSS sg13_lv_nmos L=0.13u W=0.74u AS=0.2516p AD=0.1426p
+ PS=2.16u PD=1.16u rfmode=0
M$144 VSS \$356 \$355 VSS sg13_lv_nmos L=0.5u W=0.42u AS=0.1426p AD=0.1428p
+ PS=1.16u PD=1.52u rfmode=0
M$145 \$356 \$317 VSS VSS sg13_lv_nmos L=0.5u W=0.42u AS=0.1428p AD=0.0798p
+ PS=1.52u PD=0.8u rfmode=0
M$146 VSS \$357 \$317 VSS sg13_lv_nmos L=0.13u W=0.42u AS=0.0798p AD=0.1428p
+ PS=0.8u PD=1.52u rfmode=0
M$147 \$318 \$358 VSS VSS sg13_lv_nmos L=0.13u W=0.74u AS=0.2516p AD=0.1426p
+ PS=2.16u PD=1.16u rfmode=0
M$148 VSS \$359 \$358 VSS sg13_lv_nmos L=0.5u W=0.42u AS=0.1426p AD=0.1428p
+ PS=1.16u PD=1.52u rfmode=0
M$149 \$359 \$319 VSS VSS sg13_lv_nmos L=0.5u W=0.42u AS=0.1428p AD=0.0798p
+ PS=1.52u PD=0.8u rfmode=0
M$150 VSS \$354 \$319 VSS sg13_lv_nmos L=0.13u W=0.42u AS=0.0798p AD=0.1428p
+ PS=0.8u PD=1.52u rfmode=0
M$151 \$353 \$360 VSS VSS sg13_lv_nmos L=0.13u W=0.74u AS=0.2516p AD=0.1426p
+ PS=2.16u PD=1.16u rfmode=0
M$152 VSS \$361 \$360 VSS sg13_lv_nmos L=0.5u W=0.42u AS=0.1426p AD=0.1428p
+ PS=1.16u PD=1.52u rfmode=0
M$153 \$361 \$320 VSS VSS sg13_lv_nmos L=0.5u W=0.42u AS=0.1428p AD=0.0798p
+ PS=1.52u PD=0.8u rfmode=0
M$154 VSS \$362 \$320 VSS sg13_lv_nmos L=0.13u W=0.42u AS=0.0798p AD=0.1428p
+ PS=0.8u PD=1.52u rfmode=0
M$155 \$322 \$364 VSS VSS sg13_lv_nmos L=0.13u W=0.42u AS=0.1428p AD=0.0798p
+ PS=1.52u PD=0.8u rfmode=0
M$156 VSS \$322 \$323 VSS sg13_lv_nmos L=0.5u W=0.42u AS=0.0798p AD=0.1428p
+ PS=0.8u PD=1.52u rfmode=0
M$157 VSS \$323 \$365 VSS sg13_lv_nmos L=0.5u W=0.42u AS=0.1426p AD=0.1428p
+ PS=1.16u PD=1.52u rfmode=0
M$158 VSS \$365 \$324 VSS sg13_lv_nmos L=0.13u W=0.74u AS=0.1426p AD=0.2516p
+ PS=1.16u PD=2.16u rfmode=0
M$159 VSS \$622 \$367 VSS sg13_lv_nmos L=0.13u W=0.74u AS=0.2516p AD=0.2516p
+ PS=2.16u PD=2.16u rfmode=0
M$160 VSS \$309 \$371 VSS sg13_lv_nmos L=0.13u W=0.55u AS=0.17255p AD=0.187p
+ PS=1.25u PD=1.78u rfmode=0
M$161 VSS \$371 \$334 VSS sg13_lv_nmos L=0.13u W=0.74u AS=0.17255p AD=0.1406p
+ PS=1.25u PD=1.12u rfmode=0
M$162 \$334 \$372 VSS VSS sg13_lv_nmos L=0.13u W=0.74u AS=0.1406p AD=0.2516p
+ PS=1.12u PD=2.16u rfmode=0
M$163 VSS \$335 \$337 VSS sg13_lv_nmos L=0.13u W=0.74u AS=0.2516p AD=0.2516p
+ PS=2.16u PD=2.16u rfmode=0
M$164 VSS VDD VSS VSS sg13_lv_nmos L=1u W=249.9u AS=67.137p AD=67.137p
+ PS=700.64u PD=700.64u rfmode=0
M$172 VSS \$350 \$381 VSS sg13_lv_nmos L=0.13u W=0.74u AS=0.2886p AD=0.1406p
+ PS=2.26u PD=1.12u rfmode=0
M$173 \$381 \$347 \$382 VSS sg13_lv_nmos L=0.13u W=0.74u AS=0.1406p AD=0.1406p
+ PS=1.12u PD=1.12u rfmode=0
M$174 \$382 \$348 \$315 VSS sg13_lv_nmos L=0.13u W=0.74u AS=0.1406p AD=0.2516p
+ PS=1.12u PD=2.16u rfmode=0
M$175 VSS \$349 \$316 VSS sg13_lv_nmos L=0.13u W=0.74u AS=0.3108p AD=0.1628p
+ PS=2.32u PD=1.18u rfmode=0
M$176 \$316 \$350 \$383 VSS sg13_lv_nmos L=0.13u W=0.74u AS=0.1628p AD=0.0888p
+ PS=1.18u PD=0.98u rfmode=0
M$177 \$383 \$348 VSS VSS sg13_lv_nmos L=0.13u W=0.74u AS=0.0888p AD=0.15245p
+ PS=0.98u PD=1.17u rfmode=0
M$178 VSS \$350 \$349 VSS sg13_lv_nmos L=0.13u W=0.55u AS=0.15245p AD=0.174625p
+ PS=1.17u PD=1.185u rfmode=0
M$179 \$349 \$348 VSS VSS sg13_lv_nmos L=0.13u W=0.55u AS=0.174625p AD=0.374p
+ PS=1.185u PD=2.46u rfmode=0
M$180 VSS \$353 \$384 VSS sg13_lv_nmos L=0.13u W=0.64u AS=0.2272p AD=0.0784p
+ PS=1.99u PD=0.885u rfmode=0
M$181 \$384 \$315 \$351 VSS sg13_lv_nmos L=0.13u W=0.64u AS=0.0784p AD=0.2176p
+ PS=0.885u PD=1.96u rfmode=0
M$183 VSS \$367 \$386 VSS sg13_lv_nmos L=0.13u W=0.42u AS=0.1701p AD=0.0378p
+ PS=1.65u PD=0.6u rfmode=0
M$184 \$386 \$326 \$368 VSS sg13_lv_nmos L=0.13u W=0.42u AS=0.0378p AD=0.1428p
+ PS=0.6u PD=1.52u rfmode=0
M$185 \$325 \$327 \$366 VSS sg13_lv_nmos L=0.13u W=0.42u AS=0.1296p AD=0.0798p
+ PS=1.52u PD=0.8u rfmode=0
M$186 \$366 \$389 \$368 VSS sg13_lv_nmos L=0.13u W=0.42u AS=0.0798p AD=0.2373p
+ PS=0.8u PD=1.97u rfmode=0
M$187 VSS \$327 \$389 VSS sg13_lv_nmos L=0.13u W=0.74u AS=0.317325p AD=0.2516p
+ PS=1.805u PD=2.16u rfmode=0
M$188 VSS \$556 \$327 VSS sg13_lv_nmos L=0.13u W=0.74u AS=0.317325p AD=0.2516p
+ PS=1.805u PD=2.16u rfmode=0
M$189 \$369 \$327 \$328 VSS sg13_lv_nmos L=0.13u W=0.42u AS=0.12665p AD=0.1428p
+ PS=1.145u PD=1.52u rfmode=0
M$190 \$326 \$389 \$369 VSS sg13_lv_nmos L=0.13u W=0.74u AS=0.3473p AD=0.12665p
+ PS=2.71u PD=1.145u rfmode=0
M$217 \$429 \$433 \$431 VSS sg13_lv_nmos L=0.13u W=0.42u AS=0.1296p AD=0.0798p
+ PS=1.52u PD=0.8u rfmode=0
M$218 \$431 \$432 \$488 VSS sg13_lv_nmos L=0.13u W=0.42u AS=0.0798p AD=0.2373p
+ PS=0.8u PD=1.97u rfmode=0
M$219 \$436 \$440 \$438 VSS sg13_lv_nmos L=0.13u W=0.42u AS=0.1296p AD=0.0798p
+ PS=1.52u PD=0.8u rfmode=0
M$220 \$438 \$439 \$491 VSS sg13_lv_nmos L=0.13u W=0.42u AS=0.0798p AD=0.2373p
+ PS=0.8u PD=1.97u rfmode=0
M$221 \$442 \$446 \$444 VSS sg13_lv_nmos L=0.13u W=0.42u AS=0.1296p AD=0.0798p
+ PS=1.52u PD=0.8u rfmode=0
M$222 \$444 \$445 \$493 VSS sg13_lv_nmos L=0.13u W=0.42u AS=0.0798p AD=0.2373p
+ PS=0.8u PD=1.97u rfmode=0
M$223 \$451 \$455 \$453 VSS sg13_lv_nmos L=0.13u W=0.42u AS=0.1296p AD=0.0798p
+ PS=1.52u PD=0.8u rfmode=0
M$224 \$453 \$454 \$497 VSS sg13_lv_nmos L=0.13u W=0.42u AS=0.0798p AD=0.2373p
+ PS=0.8u PD=1.97u rfmode=0
M$225 \$457 \$461 \$459 VSS sg13_lv_nmos L=0.13u W=0.42u AS=0.1296p AD=0.0798p
+ PS=1.52u PD=0.8u rfmode=0
M$226 \$459 \$460 \$500 VSS sg13_lv_nmos L=0.13u W=0.42u AS=0.0798p AD=0.2373p
+ PS=0.8u PD=1.97u rfmode=0
M$227 \$466 \$470 \$468 VSS sg13_lv_nmos L=0.13u W=0.42u AS=0.1296p AD=0.0798p
+ PS=1.52u PD=0.8u rfmode=0
M$228 \$468 \$469 \$503 VSS sg13_lv_nmos L=0.13u W=0.42u AS=0.0798p AD=0.2373p
+ PS=0.8u PD=1.97u rfmode=0
M$229 \$432 \$433 VSS VSS sg13_lv_nmos L=0.13u W=0.74u AS=0.2516p AD=0.317325p
+ PS=2.16u PD=1.805u rfmode=0
M$230 VSS \$489 \$433 VSS sg13_lv_nmos L=0.13u W=0.74u AS=0.317325p AD=0.2516p
+ PS=1.805u PD=2.16u rfmode=0
M$231 \$505 \$433 \$490 VSS sg13_lv_nmos L=0.13u W=0.42u AS=0.1428p AD=0.12665p
+ PS=1.52u PD=1.145u rfmode=0
M$232 \$490 \$432 \$430 VSS sg13_lv_nmos L=0.13u W=0.74u AS=0.12665p AD=0.3473p
+ PS=1.145u PD=2.71u rfmode=0
M$233 \$439 \$440 VSS VSS sg13_lv_nmos L=0.13u W=0.74u AS=0.2516p AD=0.317325p
+ PS=2.16u PD=1.805u rfmode=0
M$234 VSS \$604 \$440 VSS sg13_lv_nmos L=0.13u W=0.74u AS=0.317325p AD=0.2516p
+ PS=1.805u PD=2.16u rfmode=0
M$235 \$506 \$440 \$492 VSS sg13_lv_nmos L=0.13u W=0.42u AS=0.1428p AD=0.12665p
+ PS=1.52u PD=1.145u rfmode=0
M$236 \$492 \$439 \$437 VSS sg13_lv_nmos L=0.13u W=0.74u AS=0.12665p AD=0.3473p
+ PS=1.145u PD=2.71u rfmode=0
M$237 \$445 \$446 VSS VSS sg13_lv_nmos L=0.13u W=0.74u AS=0.2516p AD=0.317325p
+ PS=2.16u PD=1.805u rfmode=0
M$238 VSS \$604 \$446 VSS sg13_lv_nmos L=0.13u W=0.74u AS=0.317325p AD=0.2516p
+ PS=1.805u PD=2.16u rfmode=0
M$239 \$507 \$446 \$494 VSS sg13_lv_nmos L=0.13u W=0.42u AS=0.1428p AD=0.12665p
+ PS=1.52u PD=1.145u rfmode=0
M$240 \$494 \$445 \$443 VSS sg13_lv_nmos L=0.13u W=0.74u AS=0.12665p AD=0.3473p
+ PS=1.145u PD=2.71u rfmode=0
M$241 \$454 \$455 VSS VSS sg13_lv_nmos L=0.13u W=0.74u AS=0.2516p AD=0.317325p
+ PS=2.16u PD=1.805u rfmode=0
M$242 VSS \$556 \$455 VSS sg13_lv_nmos L=0.13u W=0.74u AS=0.317325p AD=0.2516p
+ PS=1.805u PD=2.16u rfmode=0
M$243 \$509 \$455 \$498 VSS sg13_lv_nmos L=0.13u W=0.42u AS=0.1428p AD=0.12665p
+ PS=1.52u PD=1.145u rfmode=0
M$244 \$498 \$454 \$452 VSS sg13_lv_nmos L=0.13u W=0.74u AS=0.12665p AD=0.3473p
+ PS=1.145u PD=2.71u rfmode=0
M$245 VSS \$420 \$421 VSS sg13_lv_nmos L=0.13u W=0.74u AS=0.2516p AD=0.1406p
+ PS=2.16u PD=1.12u rfmode=0
M$246 \$421 \$344 \$534 VSS sg13_lv_nmos L=0.13u W=0.74u AS=0.1406p AD=0.1406p
+ PS=1.12u PD=1.12u rfmode=0
M$247 \$534 \$345 VSS VSS sg13_lv_nmos L=0.13u W=0.74u AS=0.1406p AD=0.2516p
+ PS=1.12u PD=2.16u rfmode=0
M$248 \$460 \$461 VSS VSS sg13_lv_nmos L=0.13u W=0.74u AS=0.2516p AD=0.317325p
+ PS=2.16u PD=1.805u rfmode=0
M$249 VSS \$501 \$461 VSS sg13_lv_nmos L=0.13u W=0.74u AS=0.317325p AD=0.2516p
+ PS=1.805u PD=2.16u rfmode=0
M$250 \$510 \$461 \$502 VSS sg13_lv_nmos L=0.13u W=0.42u AS=0.1428p AD=0.12665p
+ PS=1.52u PD=1.145u rfmode=0
M$251 \$502 \$460 \$458 VSS sg13_lv_nmos L=0.13u W=0.74u AS=0.12665p AD=0.3473p
+ PS=1.145u PD=2.71u rfmode=0
M$252 \$469 \$470 VSS VSS sg13_lv_nmos L=0.13u W=0.74u AS=0.2516p AD=0.317325p
+ PS=2.16u PD=1.805u rfmode=0
M$253 VSS \$501 \$470 VSS sg13_lv_nmos L=0.13u W=0.74u AS=0.317325p AD=0.2516p
+ PS=1.805u PD=2.16u rfmode=0
M$254 \$511 \$470 \$504 VSS sg13_lv_nmos L=0.13u W=0.42u AS=0.1428p AD=0.12665p
+ PS=1.52u PD=1.145u rfmode=0
M$255 \$504 \$469 \$467 VSS sg13_lv_nmos L=0.13u W=0.74u AS=0.12665p AD=0.3473p
+ PS=1.145u PD=2.71u rfmode=0
M$256 VSS \$427 \$408 VSS sg13_lv_nmos L=0.13u W=0.55u AS=0.14875p AD=0.187p
+ PS=1.16u PD=1.78u rfmode=0
M$257 \$33 \$408 VSS VSS sg13_lv_nmos L=0.13u W=0.74u AS=0.2886p AD=0.14875p
+ PS=2.26u PD=1.16u rfmode=0
M$270 \$409 \$428 VSS VSS sg13_lv_nmos L=0.13u W=0.74u AS=0.2516p AD=0.2516p
+ PS=2.16u PD=2.16u rfmode=0
M$271 VSS \$601 \$410 VSS sg13_lv_nmos L=0.13u W=0.55u AS=0.14875p AD=0.187p
+ PS=1.16u PD=1.78u rfmode=0
M$272 \$342 \$410 VSS VSS sg13_lv_nmos L=0.13u W=0.74u AS=0.2886p AD=0.14875p
+ PS=2.26u PD=1.16u rfmode=0
M$273 \$411 \$490 VSS VSS sg13_lv_nmos L=0.13u W=0.74u AS=0.2516p AD=0.1406p
+ PS=2.16u PD=1.12u rfmode=0
M$274 VSS \$411 \$339 VSS sg13_lv_nmos L=0.13u W=0.74u AS=0.1406p AD=0.2516p
+ PS=1.12u PD=2.16u rfmode=0
M$275 VSS \$435 \$412 VSS sg13_lv_nmos L=0.13u W=0.55u AS=0.14875p AD=0.187p
+ PS=1.16u PD=1.78u rfmode=0
M$276 \$428 \$412 VSS VSS sg13_lv_nmos L=0.13u W=0.74u AS=0.2886p AD=0.14875p
+ PS=2.26u PD=1.16u rfmode=0
M$277 \$413 \$492 VSS VSS sg13_lv_nmos L=0.13u W=0.74u AS=0.2516p AD=0.1406p
+ PS=2.16u PD=1.12u rfmode=0
M$278 VSS \$413 \$357 VSS sg13_lv_nmos L=0.13u W=0.74u AS=0.1406p AD=0.2516p
+ PS=1.12u PD=2.16u rfmode=0
M$279 \$414 \$494 VSS VSS sg13_lv_nmos L=0.13u W=0.74u AS=0.2516p AD=0.1406p
+ PS=2.16u PD=1.12u rfmode=0
M$280 VSS \$414 \$362 VSS sg13_lv_nmos L=0.13u W=0.74u AS=0.1406p AD=0.2516p
+ PS=1.12u PD=2.16u rfmode=0
M$281 \$449 \$415 VSS VSS sg13_lv_nmos L=0.5u W=0.42u AS=0.1428p AD=0.1426p
+ PS=1.52u PD=1.16u rfmode=0
M$282 VSS \$449 \$416 VSS sg13_lv_nmos L=0.13u W=0.74u AS=0.1426p AD=0.2516p
+ PS=1.16u PD=2.16u rfmode=0
M$283 VSS \$333 \$450 VSS sg13_lv_nmos L=0.13u W=0.55u AS=0.17255p AD=0.187p
+ PS=1.25u PD=1.78u rfmode=0
M$284 VSS \$324 \$417 VSS sg13_lv_nmos L=0.13u W=0.74u AS=0.2516p AD=0.1406p
+ PS=2.16u PD=1.12u rfmode=0
M$285 \$417 \$450 VSS VSS sg13_lv_nmos L=0.13u W=0.74u AS=0.1406p AD=0.17255p
+ PS=1.12u PD=1.25u rfmode=0
M$286 \$418 \$498 VSS VSS sg13_lv_nmos L=0.13u W=0.74u AS=0.2516p AD=0.1406p
+ PS=2.16u PD=1.12u rfmode=0
M$287 VSS \$418 \$419 VSS sg13_lv_nmos L=0.13u W=0.74u AS=0.1406p AD=0.2516p
+ PS=1.12u PD=2.16u rfmode=0
M$288 VSS \$344 \$420 VSS sg13_lv_nmos L=0.13u W=0.74u AS=0.2516p AD=0.1406p
+ PS=2.16u PD=1.12u rfmode=0
M$289 \$420 \$378 VSS VSS sg13_lv_nmos L=0.13u W=0.74u AS=0.1406p AD=0.2516p
+ PS=1.12u PD=2.16u rfmode=0
M$290 \$423 \$502 VSS VSS sg13_lv_nmos L=0.13u W=0.74u AS=0.2516p AD=0.1406p
+ PS=2.16u PD=1.12u rfmode=0
M$291 VSS \$423 \$378 VSS sg13_lv_nmos L=0.13u W=0.74u AS=0.1406p AD=0.2516p
+ PS=1.12u PD=2.16u rfmode=0
M$294 \$463 \$922 VSS VSS sg13_lv_nmos L=0.13u W=0.55u AS=0.187p AD=0.18945p
+ PS=1.78u PD=1.27u rfmode=0
M$295 VSS \$922 \$530 VSS sg13_lv_nmos L=0.13u W=0.74u AS=0.18945p AD=0.13135p
+ PS=1.27u PD=1.095u rfmode=0
M$296 \$530 \$626 \$464 VSS sg13_lv_nmos L=0.13u W=0.74u AS=0.13135p AD=0.1628p
+ PS=1.095u PD=1.18u rfmode=0
M$297 \$464 \$425 \$529 VSS sg13_lv_nmos L=0.13u W=0.74u AS=0.1628p AD=0.3367p
+ PS=1.18u PD=1.65u rfmode=0
M$298 \$529 \$463 VSS VSS sg13_lv_nmos L=0.13u W=0.74u AS=0.3367p AD=0.148p
+ PS=1.65u PD=1.14u rfmode=0
M$299 VSS \$464 \$465 VSS sg13_lv_nmos L=0.13u W=0.74u AS=0.148p AD=0.4033p
+ PS=1.14u PD=2.57u rfmode=0
M$300 \$424 \$504 VSS VSS sg13_lv_nmos L=0.13u W=0.74u AS=0.2516p AD=0.1406p
+ PS=2.16u PD=1.12u rfmode=0
M$301 VSS \$424 \$425 VSS sg13_lv_nmos L=0.13u W=0.74u AS=0.1406p AD=0.2516p
+ PS=1.12u PD=2.16u rfmode=0
M$312 \$426 \$425 VSS VSS sg13_lv_nmos L=0.13u W=0.55u AS=0.187p AD=0.14875p
+ PS=1.78u PD=1.16u rfmode=0
M$313 VSS \$426 \$36 VSS sg13_lv_nmos L=0.13u W=0.74u AS=0.14875p AD=0.2886p
+ PS=1.16u PD=2.26u rfmode=0
M$314 VSS \$428 \$538 VSS sg13_lv_nmos L=0.13u W=0.74u AS=0.2516p AD=0.2516p
+ PS=2.16u PD=2.16u rfmode=0
M$315 \$560 \$557 \$578 VSS sg13_lv_nmos L=0.13u W=0.42u AS=0.1428p AD=0.0609p
+ PS=1.52u PD=0.71u rfmode=0
M$316 \$578 \$538 VSS VSS sg13_lv_nmos L=0.13u W=0.42u AS=0.0609p AD=0.1626p
+ PS=0.71u PD=1.415u rfmode=0
M$317 VSS \$558 \$539 VSS sg13_lv_nmos L=0.13u W=0.74u AS=0.1626p AD=0.2516p
+ PS=1.415u PD=2.16u rfmode=0
M$318 VSS \$431 \$430 VSS sg13_lv_nmos L=0.13u W=0.74u AS=0.1626p AD=0.2516p
+ PS=1.415u PD=2.16u rfmode=0
M$319 \$429 \$311 \$513 VSS sg13_lv_nmos L=0.13u W=0.42u AS=0.1428p AD=0.0609p
+ PS=1.52u PD=0.71u rfmode=0
M$320 VSS \$409 \$513 VSS sg13_lv_nmos L=0.13u W=0.42u AS=0.1626p AD=0.0609p
+ PS=1.415u PD=0.71u rfmode=0
M$321 VSS \$409 \$514 VSS sg13_lv_nmos L=0.13u W=0.42u AS=0.1701p AD=0.0378p
+ PS=1.65u PD=0.6u rfmode=0
M$322 \$514 \$430 \$488 VSS sg13_lv_nmos L=0.13u W=0.42u AS=0.0378p AD=0.1428p
+ PS=0.6u PD=1.52u rfmode=0
M$323 \$541 \$542 VSS VSS sg13_lv_nmos L=0.13u W=0.42u AS=0.1428p AD=0.0798p
+ PS=1.52u PD=0.8u rfmode=0
M$324 VSS \$538 \$580 VSS sg13_lv_nmos L=0.13u W=0.42u AS=0.0798p AD=0.0378p
+ PS=0.8u PD=0.6u rfmode=0
M$325 \$580 \$562 \$542 VSS sg13_lv_nmos L=0.13u W=0.42u AS=0.0378p AD=0.1428p
+ PS=0.6u PD=1.52u rfmode=0
M$326 \$505 \$434 VSS VSS sg13_lv_nmos L=0.13u W=0.42u AS=0.1428p AD=0.0798p
+ PS=1.52u PD=0.8u rfmode=0
M$327 VSS \$409 \$515 VSS sg13_lv_nmos L=0.13u W=0.42u AS=0.0798p AD=0.0378p
+ PS=0.8u PD=0.6u rfmode=0
M$328 \$515 \$490 \$434 VSS sg13_lv_nmos L=0.13u W=0.42u AS=0.0378p AD=0.1428p
+ PS=0.6u PD=1.52u rfmode=0
M$329 \$543 \$562 VSS VSS sg13_lv_nmos L=0.13u W=0.74u AS=0.2516p AD=0.1406p
+ PS=2.16u PD=1.12u rfmode=0
M$330 VSS \$543 \$427 VSS sg13_lv_nmos L=0.13u W=0.74u AS=0.1406p AD=0.2516p
+ PS=1.12u PD=2.16u rfmode=0
M$331 VSS En \$563 VSS sg13_lv_nmos L=0.13u W=0.55u AS=0.14875p AD=0.187p
+ PS=1.16u PD=1.78u rfmode=0
M$332 VSS \$563 \$348 VSS sg13_lv_nmos L=0.13u W=0.74u AS=0.14875p AD=0.2886p
+ PS=1.16u PD=2.26u rfmode=0
M$333 VSS \$438 \$437 VSS sg13_lv_nmos L=0.13u W=0.74u AS=0.1626p AD=0.2516p
+ PS=1.415u PD=2.16u rfmode=0
M$334 \$436 \$316 \$517 VSS sg13_lv_nmos L=0.13u W=0.42u AS=0.1428p AD=0.0609p
+ PS=1.52u PD=0.71u rfmode=0
M$335 VSS \$406 \$517 VSS sg13_lv_nmos L=0.13u W=0.42u AS=0.1626p AD=0.0609p
+ PS=1.415u PD=0.71u rfmode=0
M$336 \$489 \$564 VSS VSS sg13_lv_nmos L=0.13u W=0.74u AS=0.2886p AD=0.14875p
+ PS=2.26u PD=1.16u rfmode=0
M$337 VSS \$740 \$564 VSS sg13_lv_nmos L=0.13u W=0.55u AS=0.14875p AD=0.187p
+ PS=1.16u PD=1.78u rfmode=0
M$338 VSS \$406 \$518 VSS sg13_lv_nmos L=0.13u W=0.42u AS=0.1701p AD=0.0378p
+ PS=1.65u PD=0.6u rfmode=0
M$339 \$518 \$437 \$491 VSS sg13_lv_nmos L=0.13u W=0.42u AS=0.0378p AD=0.1428p
+ PS=0.6u PD=1.52u rfmode=0
M$340 \$406 \$428 VSS VSS sg13_lv_nmos L=0.13u W=0.74u AS=0.2516p AD=0.2516p
+ PS=2.16u PD=2.16u rfmode=0
M$341 \$569 \$566 \$581 VSS sg13_lv_nmos L=0.13u W=0.42u AS=0.1428p AD=0.0609p
+ PS=1.52u PD=0.71u rfmode=0
M$342 \$581 \$565 VSS VSS sg13_lv_nmos L=0.13u W=0.42u AS=0.0609p AD=0.1626p
+ PS=0.71u PD=1.415u rfmode=0
M$343 VSS \$567 \$544 VSS sg13_lv_nmos L=0.13u W=0.74u AS=0.1626p AD=0.2516p
+ PS=1.415u PD=2.16u rfmode=0
M$344 \$506 \$441 VSS VSS sg13_lv_nmos L=0.13u W=0.42u AS=0.1428p AD=0.0798p
+ PS=1.52u PD=0.8u rfmode=0
M$345 VSS \$406 \$520 VSS sg13_lv_nmos L=0.13u W=0.42u AS=0.0798p AD=0.0378p
+ PS=0.8u PD=0.6u rfmode=0
M$346 \$520 \$492 \$441 VSS sg13_lv_nmos L=0.13u W=0.42u AS=0.0378p AD=0.1428p
+ PS=0.6u PD=1.52u rfmode=0
M$347 VSS \$444 \$443 VSS sg13_lv_nmos L=0.13u W=0.74u AS=0.1626p AD=0.2516p
+ PS=1.415u PD=2.16u rfmode=0
M$348 \$442 \$318 \$521 VSS sg13_lv_nmos L=0.13u W=0.42u AS=0.1428p AD=0.0609p
+ PS=1.52u PD=0.71u rfmode=0
M$349 VSS \$407 \$521 VSS sg13_lv_nmos L=0.13u W=0.42u AS=0.1626p AD=0.0609p
+ PS=1.415u PD=0.71u rfmode=0
M$350 \$546 \$547 VSS VSS sg13_lv_nmos L=0.13u W=0.42u AS=0.1428p AD=0.0798p
+ PS=1.52u PD=0.8u rfmode=0
M$351 VSS \$565 \$583 VSS sg13_lv_nmos L=0.13u W=0.42u AS=0.0798p AD=0.0378p
+ PS=0.8u PD=0.6u rfmode=0
M$352 \$583 \$571 \$547 VSS sg13_lv_nmos L=0.13u W=0.42u AS=0.0378p AD=0.1428p
+ PS=0.6u PD=1.52u rfmode=0
M$353 VSS \$407 \$522 VSS sg13_lv_nmos L=0.13u W=0.42u AS=0.1701p AD=0.0378p
+ PS=1.65u PD=0.6u rfmode=0
M$354 \$522 \$443 \$493 VSS sg13_lv_nmos L=0.13u W=0.42u AS=0.0378p AD=0.1428p
+ PS=0.6u PD=1.52u rfmode=0
M$355 \$548 \$571 VSS VSS sg13_lv_nmos L=0.13u W=0.74u AS=0.2516p AD=0.1406p
+ PS=2.16u PD=1.12u rfmode=0
M$356 VSS \$548 \$549 VSS sg13_lv_nmos L=0.13u W=0.74u AS=0.1406p AD=0.2516p
+ PS=1.12u PD=2.16u rfmode=0
M$357 \$347 \$572 VSS VSS sg13_lv_nmos L=0.13u W=0.74u AS=0.2516p AD=0.1426p
+ PS=2.16u PD=1.16u rfmode=0
M$358 VSS \$573 \$572 VSS sg13_lv_nmos L=0.5u W=0.42u AS=0.1426p AD=0.1428p
+ PS=1.16u PD=1.52u rfmode=0
M$359 \$573 \$550 VSS VSS sg13_lv_nmos L=0.5u W=0.42u AS=0.1428p AD=0.0798p
+ PS=1.52u PD=0.8u rfmode=0
M$360 VSS \$549 \$550 VSS sg13_lv_nmos L=0.13u W=0.42u AS=0.0798p AD=0.1428p
+ PS=0.8u PD=1.52u rfmode=0
M$361 \$507 \$447 VSS VSS sg13_lv_nmos L=0.13u W=0.42u AS=0.1428p AD=0.0798p
+ PS=1.52u PD=0.8u rfmode=0
M$362 VSS \$407 \$524 VSS sg13_lv_nmos L=0.13u W=0.42u AS=0.0798p AD=0.0378p
+ PS=0.8u PD=0.6u rfmode=0
M$363 \$524 \$494 \$447 VSS sg13_lv_nmos L=0.13u W=0.42u AS=0.0378p AD=0.1428p
+ PS=0.6u PD=1.52u rfmode=0
M$364 VSS \$552 \$551 VSS sg13_lv_nmos L=0.13u W=11.84u AS=2.3606p AD=2.2496p
+ PS=18.96u PD=17.92u rfmode=0
M$380 VSS \$664 \$552 VSS sg13_lv_nmos L=0.13u W=4.44u AS=0.8436p AD=0.9546p
+ PS=6.72u PD=7.76u rfmode=0
M$386 \$448 \$495 VSS VSS sg13_lv_nmos L=0.13u W=0.42u AS=0.1428p AD=0.0798p
+ PS=1.52u PD=0.8u rfmode=0
M$387 VSS \$448 \$415 VSS sg13_lv_nmos L=0.5u W=0.42u AS=0.0798p AD=0.1428p
+ PS=0.8u PD=1.52u rfmode=0
M$388 VSS \$453 \$452 VSS sg13_lv_nmos L=0.13u W=0.74u AS=0.1626p AD=0.2516p
+ PS=1.415u PD=2.16u rfmode=0
M$389 \$451 \$508 \$526 VSS sg13_lv_nmos L=0.13u W=0.42u AS=0.1428p AD=0.0609p
+ PS=1.52u PD=0.71u rfmode=0
M$390 VSS \$496 \$526 VSS sg13_lv_nmos L=0.13u W=0.42u AS=0.1626p AD=0.0609p
+ PS=1.415u PD=0.71u rfmode=0
M$391 VSS \$496 \$527 VSS sg13_lv_nmos L=0.13u W=0.42u AS=0.1701p AD=0.0378p
+ PS=1.65u PD=0.6u rfmode=0
M$392 \$527 \$452 \$497 VSS sg13_lv_nmos L=0.13u W=0.42u AS=0.0378p AD=0.1428p
+ PS=0.6u PD=1.52u rfmode=0
M$393 \$553 \$574 VSS VSS sg13_lv_nmos L=0.13u W=0.74u AS=0.2516p AD=0.1426p
+ PS=2.16u PD=1.16u rfmode=0
M$394 VSS \$575 \$574 VSS sg13_lv_nmos L=0.5u W=0.42u AS=0.1426p AD=0.1428p
+ PS=1.16u PD=1.52u rfmode=0
M$395 \$575 \$554 VSS VSS sg13_lv_nmos L=0.5u W=0.42u AS=0.1428p AD=0.0798p
+ PS=1.52u PD=0.8u rfmode=0
M$396 VSS \$419 \$554 VSS sg13_lv_nmos L=0.13u W=0.42u AS=0.0798p AD=0.1428p
+ PS=0.8u PD=1.52u rfmode=0
M$397 VSS \$551 \$555 VSS sg13_lv_nmos L=0.13u W=4.44u AS=0.9546p AD=0.8436p
+ PS=7.76u PD=6.72u rfmode=0
M$403 VSS \$555 \$556 VSS sg13_lv_nmos L=0.13u W=11.84u AS=2.2496p AD=2.3606p
+ PS=17.92u PD=18.96u rfmode=0
M$419 \$509 \$456 VSS VSS sg13_lv_nmos L=0.13u W=0.42u AS=0.1428p AD=0.0798p
+ PS=1.52u PD=0.8u rfmode=0
M$420 VSS \$496 \$531 VSS sg13_lv_nmos L=0.13u W=0.42u AS=0.0798p AD=0.0378p
+ PS=0.8u PD=0.6u rfmode=0
M$421 \$531 \$498 \$456 VSS sg13_lv_nmos L=0.13u W=0.42u AS=0.0378p AD=0.1428p
+ PS=0.6u PD=1.52u rfmode=0
M$422 VSS \$459 \$458 VSS sg13_lv_nmos L=0.13u W=0.74u AS=0.1626p AD=0.2516p
+ PS=1.415u PD=2.16u rfmode=0
M$423 \$457 \$421 \$535 VSS sg13_lv_nmos L=0.13u W=0.42u AS=0.1428p AD=0.0609p
+ PS=1.52u PD=0.71u rfmode=0
M$424 VSS \$499 \$535 VSS sg13_lv_nmos L=0.13u W=0.42u AS=0.1626p AD=0.0609p
+ PS=1.415u PD=0.71u rfmode=0
M$425 VSS \$499 \$536 VSS sg13_lv_nmos L=0.13u W=0.42u AS=0.1701p AD=0.0378p
+ PS=1.65u PD=0.6u rfmode=0
M$426 \$536 \$458 \$500 VSS sg13_lv_nmos L=0.13u W=0.42u AS=0.0378p AD=0.1428p
+ PS=0.6u PD=1.52u rfmode=0
M$427 \$345 \$576 \$584 VSS sg13_lv_nmos L=0.13u W=0.74u AS=0.333p AD=0.1406p
+ PS=2.38u PD=1.12u rfmode=0
M$428 \$584 \$309 VSS VSS sg13_lv_nmos L=0.13u W=0.74u AS=0.1406p AD=0.14505p
+ PS=1.12u PD=1.15u rfmode=0
M$429 VSS \$372 \$576 VSS sg13_lv_nmos L=0.13u W=0.55u AS=0.14505p AD=0.187p
+ PS=1.15u PD=1.78u rfmode=0
M$430 \$499 \$335 VSS VSS sg13_lv_nmos L=0.13u W=0.74u AS=0.2516p AD=0.2516p
+ PS=2.16u PD=2.16u rfmode=0
M$431 \$510 \$462 VSS VSS sg13_lv_nmos L=0.13u W=0.42u AS=0.1428p AD=0.0798p
+ PS=1.52u PD=0.8u rfmode=0
M$432 VSS \$499 \$537 VSS sg13_lv_nmos L=0.13u W=0.42u AS=0.0798p AD=0.0378p
+ PS=0.8u PD=0.6u rfmode=0
M$433 \$537 \$502 \$462 VSS sg13_lv_nmos L=0.13u W=0.42u AS=0.0378p AD=0.1428p
+ PS=0.6u PD=1.52u rfmode=0
M$434 VSS \$468 \$467 VSS sg13_lv_nmos L=0.13u W=0.74u AS=0.1626p AD=0.2516p
+ PS=1.415u PD=2.16u rfmode=0
M$435 \$466 \$465 \$528 VSS sg13_lv_nmos L=0.13u W=0.42u AS=0.1428p AD=0.0609p
+ PS=1.52u PD=0.71u rfmode=0
M$436 VSS \$337 \$528 VSS sg13_lv_nmos L=0.13u W=0.42u AS=0.1626p AD=0.0609p
+ PS=1.415u PD=0.71u rfmode=0
M$437 VSS \$337 \$523 VSS sg13_lv_nmos L=0.13u W=0.42u AS=0.1701p AD=0.0378p
+ PS=1.65u PD=0.6u rfmode=0
M$438 \$523 \$467 \$503 VSS sg13_lv_nmos L=0.13u W=0.42u AS=0.0378p AD=0.1428p
+ PS=0.6u PD=1.52u rfmode=0
M$439 \$501 \$577 VSS VSS sg13_lv_nmos L=0.13u W=0.74u AS=0.2886p AD=0.14875p
+ PS=2.26u PD=1.16u rfmode=0
M$440 VSS \$336 \$577 VSS sg13_lv_nmos L=0.13u W=0.55u AS=0.14875p AD=0.187p
+ PS=1.16u PD=1.78u rfmode=0
M$441 \$511 \$471 VSS VSS sg13_lv_nmos L=0.13u W=0.42u AS=0.1428p AD=0.0798p
+ PS=1.52u PD=0.8u rfmode=0
M$442 VSS \$337 \$519 VSS sg13_lv_nmos L=0.13u W=0.42u AS=0.0798p AD=0.0378p
+ PS=0.8u PD=0.6u rfmode=0
M$443 \$519 \$504 \$471 VSS sg13_lv_nmos L=0.13u W=0.42u AS=0.0378p AD=0.1428p
+ PS=0.6u PD=1.52u rfmode=0
M$459 VSS \$538 \$579 VSS sg13_lv_nmos L=0.13u W=0.42u AS=0.1701p AD=0.0378p
+ PS=1.65u PD=0.6u rfmode=0
M$460 \$579 \$539 \$559 VSS sg13_lv_nmos L=0.13u W=0.42u AS=0.0378p AD=0.1428p
+ PS=0.6u PD=1.52u rfmode=0
M$461 \$560 \$540 \$558 VSS sg13_lv_nmos L=0.13u W=0.42u AS=0.1296p AD=0.0798p
+ PS=1.52u PD=0.8u rfmode=0
M$462 \$558 \$561 \$559 VSS sg13_lv_nmos L=0.13u W=0.42u AS=0.0798p AD=0.2373p
+ PS=0.8u PD=1.97u rfmode=0
M$463 VSS \$540 \$561 VSS sg13_lv_nmos L=0.13u W=0.74u AS=0.317325p AD=0.2516p
+ PS=1.805u PD=2.16u rfmode=0
M$464 VSS \$489 \$540 VSS sg13_lv_nmos L=0.13u W=0.74u AS=0.317325p AD=0.2516p
+ PS=1.805u PD=2.16u rfmode=0
M$465 \$562 \$540 \$541 VSS sg13_lv_nmos L=0.13u W=0.42u AS=0.12665p AD=0.1428p
+ PS=1.145u PD=1.52u rfmode=0
M$466 \$539 \$561 \$562 VSS sg13_lv_nmos L=0.13u W=0.74u AS=0.3473p AD=0.12665p
+ PS=2.71u PD=1.145u rfmode=0
M$467 VSS \$565 \$582 VSS sg13_lv_nmos L=0.13u W=0.42u AS=0.1701p AD=0.0378p
+ PS=1.65u PD=0.6u rfmode=0
M$468 \$582 \$544 \$568 VSS sg13_lv_nmos L=0.13u W=0.42u AS=0.0378p AD=0.1428p
+ PS=0.6u PD=1.52u rfmode=0
M$469 \$569 \$545 \$567 VSS sg13_lv_nmos L=0.13u W=0.42u AS=0.1296p AD=0.0798p
+ PS=1.52u PD=0.8u rfmode=0
M$470 \$567 \$570 \$568 VSS sg13_lv_nmos L=0.13u W=0.42u AS=0.0798p AD=0.2373p
+ PS=0.8u PD=1.97u rfmode=0
M$471 VSS \$545 \$570 VSS sg13_lv_nmos L=0.13u W=0.74u AS=0.317325p AD=0.2516p
+ PS=1.805u PD=2.16u rfmode=0
M$472 VSS \$604 \$545 VSS sg13_lv_nmos L=0.13u W=0.74u AS=0.317325p AD=0.2516p
+ PS=1.805u PD=2.16u rfmode=0
M$473 \$571 \$545 \$546 VSS sg13_lv_nmos L=0.13u W=0.42u AS=0.12665p AD=0.1428p
+ PS=1.145u PD=1.52u rfmode=0
M$474 \$544 \$570 \$571 VSS sg13_lv_nmos L=0.13u W=0.74u AS=0.3473p AD=0.12665p
+ PS=2.71u PD=1.145u rfmode=0
M$475 \$608 \$553 \$645 VSS sg13_lv_nmos L=0.13u W=0.64u AS=0.2176p AD=0.1216p
+ PS=1.96u PD=1.02u rfmode=0
M$476 \$645 \$416 VSS VSS sg13_lv_nmos L=0.13u W=0.64u AS=0.1216p AD=0.1331p
+ PS=1.02u PD=1.12u rfmode=0
M$477 VSS \$608 \$508 VSS sg13_lv_nmos L=0.13u W=0.74u AS=0.1331p AD=0.2516p
+ PS=1.12u PD=2.16u rfmode=0
M$478 \$609 \$625 \$611 VSS sg13_lv_nmos L=0.13u W=0.42u AS=0.1296p AD=0.0798p
+ PS=1.52u PD=0.8u rfmode=0
M$479 \$611 \$612 \$624 VSS sg13_lv_nmos L=0.13u W=0.42u AS=0.0798p AD=0.2373p
+ PS=0.8u PD=1.97u rfmode=0
M$508 \$364 \$495 VSS VSS sg13_lv_nmos L=0.13u W=0.77u AS=0.2618p AD=0.1463p
+ PS=2.22u PD=1.15u rfmode=0
M$509 VSS \$370 \$364 VSS sg13_lv_nmos L=0.13u W=0.77u AS=0.1463p AD=0.1694p
+ PS=1.15u PD=1.21u rfmode=0
M$510 \$364 \$553 VSS VSS sg13_lv_nmos L=0.13u W=0.77u AS=0.1694p AD=0.2618p
+ PS=1.21u PD=2.22u rfmode=0
M$511 \$612 \$625 VSS VSS sg13_lv_nmos L=0.13u W=0.74u AS=0.2516p AD=0.317325p
+ PS=2.16u PD=1.805u rfmode=0
M$512 VSS \$556 \$625 VSS sg13_lv_nmos L=0.13u W=0.74u AS=0.317325p AD=0.2516p
+ PS=1.805u PD=2.16u rfmode=0
M$513 \$632 \$625 \$613 VSS sg13_lv_nmos L=0.13u W=0.42u AS=0.1428p AD=0.12665p
+ PS=1.52u PD=1.145u rfmode=0
M$514 \$613 \$612 \$610 VSS sg13_lv_nmos L=0.13u W=0.74u AS=0.12665p AD=0.3473p
+ PS=1.145u PD=2.71u rfmode=0
M$515 VSS \$312 \$600 VSS sg13_lv_nmos L=0.13u W=4.44u AS=0.9546p AD=0.8436p
+ PS=7.76u PD=6.72u rfmode=0
M$521 VSS \$600 \$601 VSS sg13_lv_nmos L=0.13u W=11.84u AS=2.2496p AD=2.3606p
+ PS=17.92u PD=18.96u rfmode=0
M$537 VSS \$603 \$598 VSS sg13_lv_nmos L=0.13u W=0.55u AS=0.18945p AD=0.187p
+ PS=1.27u PD=1.78u rfmode=0
M$538 \$602 \$621 VSS VSS sg13_lv_nmos L=0.13u W=0.74u AS=0.4033p AD=0.148p
+ PS=2.57u PD=1.14u rfmode=0
M$539 VSS \$598 \$636 VSS sg13_lv_nmos L=0.13u W=0.74u AS=0.148p AD=0.3367p
+ PS=1.14u PD=1.65u rfmode=0
M$540 \$636 \$677 \$621 VSS sg13_lv_nmos L=0.13u W=0.74u AS=0.3367p AD=0.1628p
+ PS=1.65u PD=1.18u rfmode=0
M$541 \$621 \$345 \$637 VSS sg13_lv_nmos L=0.13u W=0.74u AS=0.1628p AD=0.13135p
+ PS=1.18u PD=1.095u rfmode=0
M$542 \$637 \$603 VSS VSS sg13_lv_nmos L=0.13u W=0.74u AS=0.13135p AD=0.18945p
+ PS=1.095u PD=1.27u rfmode=0
M$543 VSS \$428 \$565 VSS sg13_lv_nmos L=0.13u W=0.74u AS=0.2516p AD=0.2516p
+ PS=2.16u PD=2.16u rfmode=0
M$544 VSS \$599 \$604 VSS sg13_lv_nmos L=0.13u W=11.84u AS=2.3606p AD=2.2496p
+ PS=18.96u PD=17.92u rfmode=0
M$560 VSS \$551 \$599 VSS sg13_lv_nmos L=0.13u W=4.44u AS=0.8436p AD=0.9546p
+ PS=6.72u PD=7.76u rfmode=0
M$566 VSS \$357 \$639 VSS sg13_lv_nmos L=0.13u W=0.74u AS=0.2516p AD=0.1406p
+ PS=2.16u PD=1.12u rfmode=0
M$567 \$639 \$347 \$640 VSS sg13_lv_nmos L=0.13u W=0.74u AS=0.1406p AD=0.1406p
+ PS=1.12u PD=1.12u rfmode=0
M$568 \$640 \$353 \$641 VSS sg13_lv_nmos L=0.13u W=0.74u AS=0.1406p AD=0.1406p
+ PS=1.12u PD=1.12u rfmode=0
M$569 \$641 \$348 \$495 VSS sg13_lv_nmos L=0.13u W=0.74u AS=0.1406p AD=0.2516p
+ PS=1.12u PD=2.16u rfmode=0
M$570 \$605 \$348 \$642 VSS sg13_lv_nmos L=0.13u W=0.74u AS=0.2516p AD=0.1406p
+ PS=2.16u PD=1.12u rfmode=0
M$571 \$642 \$370 VSS VSS sg13_lv_nmos L=0.13u W=0.74u AS=0.1406p AD=0.2516p
+ PS=1.12u PD=2.16u rfmode=0
M$572 \$606 \$685 VSS VSS sg13_lv_nmos L=0.13u W=0.55u AS=0.187p AD=0.18575p
+ PS=1.78u PD=1.26u rfmode=0
M$573 VSS \$348 \$643 VSS sg13_lv_nmos L=0.13u W=0.74u AS=0.18575p AD=0.1406p
+ PS=1.26u PD=1.12u rfmode=0
M$574 \$643 \$616 \$644 VSS sg13_lv_nmos L=0.13u W=0.74u AS=0.1406p AD=0.1406p
+ PS=1.12u PD=1.12u rfmode=0
M$575 \$644 \$606 \$607 VSS sg13_lv_nmos L=0.13u W=0.74u AS=0.1406p AD=0.3404p
+ PS=1.12u PD=2.4u rfmode=0
M$576 VSS \$622 \$496 VSS sg13_lv_nmos L=0.13u W=0.74u AS=0.2516p AD=0.2516p
+ PS=2.16u PD=2.16u rfmode=0
M$577 VSS \$335 \$619 VSS sg13_lv_nmos L=0.13u W=0.74u AS=0.2516p AD=0.2516p
+ PS=2.16u PD=2.16u rfmode=0
M$580 \$32 \$676 VSS VSS sg13_lv_nmos L=0.13u W=0.74u AS=0.2886p AD=0.14875p
+ PS=2.26u PD=1.16u rfmode=0
M$581 VSS \$677 \$676 VSS sg13_lv_nmos L=0.13u W=0.55u AS=0.14875p AD=0.187p
+ PS=1.16u PD=1.78u rfmode=0
M$594 \$653 \$602 \$702 VSS sg13_lv_nmos L=0.13u W=0.42u AS=0.1428p AD=0.0609p
+ PS=1.52u PD=0.71u rfmode=0
M$595 \$702 \$652 VSS VSS sg13_lv_nmos L=0.13u W=0.42u AS=0.0609p AD=0.1626p
+ PS=0.71u PD=1.415u rfmode=0
M$596 VSS \$679 \$654 VSS sg13_lv_nmos L=0.13u W=0.74u AS=0.1626p AD=0.2516p
+ PS=1.415u PD=2.16u rfmode=0
M$598 \$656 \$657 VSS VSS sg13_lv_nmos L=0.13u W=0.42u AS=0.1428p AD=0.0798p
+ PS=1.52u PD=0.8u rfmode=0
M$599 VSS \$652 \$704 VSS sg13_lv_nmos L=0.13u W=0.42u AS=0.0798p AD=0.0378p
+ PS=0.8u PD=0.6u rfmode=0
M$600 \$704 \$681 \$657 VSS sg13_lv_nmos L=0.13u W=0.42u AS=0.0378p AD=0.1428p
+ PS=0.6u PD=1.52u rfmode=0
M$601 \$658 \$681 VSS VSS sg13_lv_nmos L=0.13u W=0.74u AS=0.2516p AD=0.1406p
+ PS=2.16u PD=1.12u rfmode=0
M$602 VSS \$658 \$677 VSS sg13_lv_nmos L=0.13u W=0.74u AS=0.1406p AD=0.2516p
+ PS=1.12u PD=2.16u rfmode=0
M$603 \$660 \$686 VSS VSS sg13_lv_nmos L=0.13u W=0.74u AS=0.2886p AD=0.14875p
+ PS=2.26u PD=1.16u rfmode=0
M$604 VSS \$321 \$686 VSS sg13_lv_nmos L=0.13u W=0.55u AS=0.14875p AD=0.187p
+ PS=1.16u PD=1.78u rfmode=0
M$605 VSS \$660 \$687 VSS sg13_lv_nmos L=0.13u W=0.55u AS=0.14875p AD=0.187p
+ PS=1.16u PD=1.78u rfmode=0
M$606 VSS \$687 \$622 VSS sg13_lv_nmos L=0.13u W=0.74u AS=0.14875p AD=0.2886p
+ PS=1.16u PD=2.26u rfmode=0
M$607 \$661 \$370 VSS VSS sg13_lv_nmos L=0.15u W=0.74u AS=0.2516p AD=0.1406p
+ PS=2.16u PD=1.12u rfmode=0
M$608 VSS \$659 \$661 VSS sg13_lv_nmos L=0.15u W=0.74u AS=0.1406p AD=0.1406p
+ PS=1.12u PD=1.12u rfmode=0
M$609 \$661 \$348 \$662 VSS sg13_lv_nmos L=0.15u W=0.74u AS=0.1406p AD=0.2516p
+ PS=1.12u PD=2.16u rfmode=0
M$610 VSS \$611 \$610 VSS sg13_lv_nmos L=0.13u W=0.74u AS=0.1626p AD=0.2516p
+ PS=1.415u PD=2.16u rfmode=0
M$611 \$609 \$417 \$646 VSS sg13_lv_nmos L=0.13u W=0.42u AS=0.1428p AD=0.0609p
+ PS=1.52u PD=0.71u rfmode=0
M$612 VSS \$623 \$646 VSS sg13_lv_nmos L=0.13u W=0.42u AS=0.1626p AD=0.0609p
+ PS=1.415u PD=0.71u rfmode=0
M$613 VSS \$623 \$647 VSS sg13_lv_nmos L=0.13u W=0.42u AS=0.1701p AD=0.0378p
+ PS=1.65u PD=0.6u rfmode=0
M$614 \$647 \$610 \$624 VSS sg13_lv_nmos L=0.13u W=0.42u AS=0.0378p AD=0.1428p
+ PS=0.6u PD=1.52u rfmode=0
M$615 fdac_clk \$690 VSS VSS sg13_lv_nmos L=0.13u W=0.74u AS=0.2886p
+ AD=0.14875p PS=2.26u PD=1.16u rfmode=0
M$616 VSS \$331 \$690 VSS sg13_lv_nmos L=0.13u W=0.55u AS=0.14875p AD=0.187p
+ PS=1.16u PD=1.78u rfmode=0
M$617 \$632 \$614 VSS VSS sg13_lv_nmos L=0.13u W=0.42u AS=0.1428p AD=0.0798p
+ PS=1.52u PD=0.8u rfmode=0
M$618 VSS \$623 \$648 VSS sg13_lv_nmos L=0.13u W=0.42u AS=0.0798p AD=0.0378p
+ PS=0.8u PD=0.6u rfmode=0
M$619 \$648 \$613 \$614 VSS sg13_lv_nmos L=0.13u W=0.42u AS=0.0378p AD=0.1428p
+ PS=0.6u PD=1.52u rfmode=0
M$620 \$615 \$613 VSS VSS sg13_lv_nmos L=0.13u W=0.74u AS=0.2516p AD=0.1406p
+ PS=2.16u PD=1.12u rfmode=0
M$621 VSS \$615 \$616 VSS sg13_lv_nmos L=0.13u W=0.74u AS=0.1406p AD=0.2516p
+ PS=1.12u PD=2.16u rfmode=0
M$624 VSS \$626 \$618 VSS sg13_lv_nmos L=0.13u W=0.55u AS=0.14875p AD=0.187p
+ PS=1.16u PD=1.78u rfmode=0
M$625 \$617 \$618 VSS VSS sg13_lv_nmos L=0.13u W=0.74u AS=0.2886p AD=0.14875p
+ PS=2.26u PD=1.16u rfmode=0
M$626 \$670 \$669 \$711 VSS sg13_lv_nmos L=0.13u W=0.42u AS=0.1428p AD=0.0609p
+ PS=1.52u PD=0.71u rfmode=0
M$627 \$711 \$619 VSS VSS sg13_lv_nmos L=0.13u W=0.42u AS=0.0609p AD=0.1626p
+ PS=0.71u PD=1.415u rfmode=0
M$628 VSS \$696 \$671 VSS sg13_lv_nmos L=0.13u W=0.74u AS=0.1626p AD=0.2516p
+ PS=1.415u PD=2.16u rfmode=0
M$633 \$673 \$674 VSS VSS sg13_lv_nmos L=0.13u W=0.42u AS=0.1428p AD=0.0798p
+ PS=1.52u PD=0.8u rfmode=0
M$634 VSS \$619 \$708 VSS sg13_lv_nmos L=0.13u W=0.42u AS=0.0798p AD=0.0378p
+ PS=0.8u PD=0.6u rfmode=0
M$635 \$708 \$698 \$674 VSS sg13_lv_nmos L=0.13u W=0.42u AS=0.0378p AD=0.1428p
+ PS=0.6u PD=1.52u rfmode=0
M$638 \$675 \$698 VSS VSS sg13_lv_nmos L=0.13u W=0.74u AS=0.2516p AD=0.1406p
+ PS=2.16u PD=1.12u rfmode=0
M$639 VSS \$675 \$695 VSS sg13_lv_nmos L=0.13u W=0.74u AS=0.1406p AD=0.2516p
+ PS=1.12u PD=2.16u rfmode=0
M$666 VSS \$695 \$699 VSS sg13_lv_nmos L=0.13u W=0.55u AS=0.14875p AD=0.187p
+ PS=1.16u PD=1.78u rfmode=0
M$667 VSS \$699 \$37 VSS sg13_lv_nmos L=0.13u W=0.74u AS=0.14875p AD=0.2886p
+ PS=1.16u PD=2.26u rfmode=0
M$668 \$557 \$651 VSS VSS sg13_lv_nmos L=0.13u W=0.74u AS=0.4033p AD=0.148p
+ PS=2.57u PD=1.14u rfmode=0
M$669 VSS \$678 \$700 VSS sg13_lv_nmos L=0.13u W=0.74u AS=0.148p AD=0.3367p
+ PS=1.14u PD=1.65u rfmode=0
M$670 \$700 \$427 \$651 VSS sg13_lv_nmos L=0.13u W=0.74u AS=0.3367p AD=0.1628p
+ PS=1.65u PD=1.18u rfmode=0
M$671 \$651 \$345 \$701 VSS sg13_lv_nmos L=0.13u W=0.74u AS=0.1628p AD=0.13135p
+ PS=1.18u PD=1.095u rfmode=0
M$672 \$701 \$922 VSS VSS sg13_lv_nmos L=0.13u W=0.74u AS=0.13135p AD=0.18945p
+ PS=1.095u PD=1.27u rfmode=0
M$673 VSS \$922 \$678 VSS sg13_lv_nmos L=0.13u W=0.55u AS=0.18945p AD=0.187p
+ PS=1.27u PD=1.78u rfmode=0
M$674 VSS \$428 \$652 VSS sg13_lv_nmos L=0.13u W=0.74u AS=0.2516p AD=0.2516p
+ PS=2.16u PD=2.16u rfmode=0
M$675 \$659 \$685 VSS VSS sg13_lv_nmos L=0.13u W=0.74u AS=0.2516p AD=0.2516p
+ PS=2.16u PD=2.16u rfmode=0
M$676 VSS fclk_in \$663 VSS sg13_lv_nmos L=0.13u W=4.44u AS=0.9546p AD=0.8436p
+ PS=7.76u PD=6.72u rfmode=0
M$682 VSS \$663 \$664 VSS sg13_lv_nmos L=0.13u W=11.84u AS=2.2496p AD=2.3606p
+ PS=17.92u PD=18.96u rfmode=0
M$698 VSS \$435 \$666 VSS sg13_lv_nmos L=0.13u W=0.74u AS=0.2516p AD=0.2516p
+ PS=2.16u PD=2.16u rfmode=0
M$699 \$370 \$691 VSS VSS sg13_lv_nmos L=0.13u W=0.74u AS=0.2516p AD=0.2516p
+ PS=2.16u PD=2.16u rfmode=0
M$700 \$691 \$692 VSS VSS sg13_lv_nmos L=0.13u W=0.74u AS=0.2516p AD=0.1426p
+ PS=2.16u PD=1.16u rfmode=0
M$701 VSS \$693 \$692 VSS sg13_lv_nmos L=0.5u W=0.42u AS=0.1426p AD=0.1428p
+ PS=1.16u PD=1.52u rfmode=0
M$702 \$693 \$667 VSS VSS sg13_lv_nmos L=0.5u W=0.42u AS=0.1428p AD=0.0798p
+ PS=1.52u PD=0.8u rfmode=0
M$703 VSS \$616 \$667 VSS sg13_lv_nmos L=0.13u W=0.42u AS=0.0798p AD=0.1428p
+ PS=0.8u PD=1.52u rfmode=0
M$704 VSS \$603 \$694 VSS sg13_lv_nmos L=0.13u W=0.55u AS=0.18945p AD=0.187p
+ PS=1.27u PD=1.78u rfmode=0
M$705 VSS \$603 \$710 VSS sg13_lv_nmos L=0.13u W=0.74u AS=0.18945p AD=0.13135p
+ PS=1.27u PD=1.095u rfmode=0
M$706 \$710 \$617 \$668 VSS sg13_lv_nmos L=0.13u W=0.74u AS=0.13135p AD=0.1628p
+ PS=1.095u PD=1.18u rfmode=0
M$707 \$668 \$695 \$712 VSS sg13_lv_nmos L=0.13u W=0.74u AS=0.1628p AD=0.3367p
+ PS=1.18u PD=1.65u rfmode=0
M$708 \$712 \$694 VSS VSS sg13_lv_nmos L=0.13u W=0.74u AS=0.3367p AD=0.148p
+ PS=1.65u PD=1.14u rfmode=0
M$709 VSS \$668 \$669 VSS sg13_lv_nmos L=0.13u W=0.74u AS=0.148p AD=0.4033p
+ PS=1.14u PD=2.57u rfmode=0
M$725 VSS \$652 \$703 VSS sg13_lv_nmos L=0.13u W=0.42u AS=0.1701p AD=0.0378p
+ PS=1.65u PD=0.6u rfmode=0
M$726 \$703 \$654 \$680 VSS sg13_lv_nmos L=0.13u W=0.42u AS=0.0378p AD=0.1428p
+ PS=0.6u PD=1.52u rfmode=0
M$727 VSS \$655 \$713 VSS sg13_lv_nmos L=0.13u W=0.74u AS=0.317325p AD=0.2516p
+ PS=1.805u PD=2.16u rfmode=0
M$728 VSS \$489 \$655 VSS sg13_lv_nmos L=0.13u W=0.74u AS=0.317325p AD=0.2516p
+ PS=1.805u PD=2.16u rfmode=0
M$729 \$681 \$655 \$656 VSS sg13_lv_nmos L=0.13u W=0.42u AS=0.12665p AD=0.1428p
+ PS=1.145u PD=1.52u rfmode=0
M$730 \$654 \$713 \$681 VSS sg13_lv_nmos L=0.13u W=0.74u AS=0.3473p AD=0.12665p
+ PS=2.71u PD=1.145u rfmode=0
M$731 \$566 \$682 VSS VSS sg13_lv_nmos L=0.13u W=0.74u AS=0.2516p AD=0.1331p
+ PS=2.16u PD=1.12u rfmode=0
M$732 VSS \$684 \$705 VSS sg13_lv_nmos L=0.13u W=0.64u AS=0.1331p AD=0.1216p
+ PS=1.12u PD=1.02u rfmode=0
M$733 \$705 \$315 \$682 VSS sg13_lv_nmos L=0.13u W=0.64u AS=0.1216p AD=0.2176p
+ PS=1.02u PD=1.96u rfmode=0
M$734 \$684 \$683 VSS VSS sg13_lv_nmos L=0.13u W=0.74u AS=0.2351p AD=0.15745p
+ PS=2.16u PD=1.175u rfmode=0
M$735 VSS \$347 \$683 VSS sg13_lv_nmos L=0.13u W=0.64u AS=0.15745p AD=0.1216p
+ PS=1.175u PD=1.02u rfmode=0
M$736 \$683 \$348 \$706 VSS sg13_lv_nmos L=0.13u W=0.64u AS=0.1216p AD=0.0816p
+ PS=1.02u PD=0.895u rfmode=0
M$737 \$706 \$350 VSS VSS sg13_lv_nmos L=0.13u W=0.64u AS=0.0816p AD=0.2176p
+ PS=0.895u PD=1.96u rfmode=0
M$738 \$689 \$688 VSS VSS sg13_lv_nmos L=0.13u W=0.74u AS=0.2351p AD=0.15745p
+ PS=2.16u PD=1.175u rfmode=0
M$739 VSS \$798 \$688 VSS sg13_lv_nmos L=0.13u W=0.64u AS=0.15745p AD=0.1216p
+ PS=1.175u PD=1.02u rfmode=0
M$740 \$688 \$685 \$707 VSS sg13_lv_nmos L=0.13u W=0.64u AS=0.1216p AD=0.0816p
+ PS=1.02u PD=0.895u rfmode=0
M$741 \$707 \$605 VSS VSS sg13_lv_nmos L=0.13u W=0.64u AS=0.0816p AD=0.2176p
+ PS=0.895u PD=1.96u rfmode=0
M$742 VSS \$619 \$709 VSS sg13_lv_nmos L=0.13u W=0.42u AS=0.1701p AD=0.0378p
+ PS=1.65u PD=0.6u rfmode=0
M$743 \$709 \$671 \$697 VSS sg13_lv_nmos L=0.13u W=0.42u AS=0.0378p AD=0.1428p
+ PS=0.6u PD=1.52u rfmode=0
M$744 VSS \$672 \$716 VSS sg13_lv_nmos L=0.13u W=0.74u AS=0.317325p AD=0.2516p
+ PS=1.805u PD=2.16u rfmode=0
M$745 VSS \$501 \$672 VSS sg13_lv_nmos L=0.13u W=0.74u AS=0.317325p AD=0.2516p
+ PS=1.805u PD=2.16u rfmode=0
M$746 \$698 \$672 \$673 VSS sg13_lv_nmos L=0.13u W=0.42u AS=0.12665p AD=0.1428p
+ PS=1.145u PD=1.52u rfmode=0
M$747 \$671 \$716 \$698 VSS sg13_lv_nmos L=0.13u W=0.74u AS=0.3473p AD=0.12665p
+ PS=2.71u PD=1.145u rfmode=0
M$795 \$653 \$655 \$679 VSS sg13_lv_nmos L=0.13u W=0.42u AS=0.1296p AD=0.0798p
+ PS=1.52u PD=0.8u rfmode=0
M$796 \$679 \$713 \$680 VSS sg13_lv_nmos L=0.13u W=0.42u AS=0.0798p AD=0.2373p
+ PS=0.8u PD=1.97u rfmode=0
M$798 VSS \$739 \$729 VSS sg13_lv_nmos L=0.13u W=0.55u AS=0.18945p AD=0.187p
+ PS=1.27u PD=1.78u rfmode=0
M$799 \$728 \$763 VSS VSS sg13_lv_nmos L=0.13u W=0.74u AS=0.4033p AD=0.148p
+ PS=2.57u PD=1.14u rfmode=0
M$800 VSS \$729 \$772 VSS sg13_lv_nmos L=0.13u W=0.74u AS=0.148p AD=0.3367p
+ PS=1.14u PD=1.65u rfmode=0
M$801 \$772 \$738 \$763 VSS sg13_lv_nmos L=0.13u W=0.74u AS=0.3367p AD=0.1628p
+ PS=1.65u PD=1.18u rfmode=0
M$802 \$763 \$345 \$773 VSS sg13_lv_nmos L=0.13u W=0.74u AS=0.1628p AD=0.13135p
+ PS=1.18u PD=1.095u rfmode=0
M$803 \$773 \$739 VSS VSS sg13_lv_nmos L=0.13u W=0.74u AS=0.13135p AD=0.18945p
+ PS=1.095u PD=1.27u rfmode=0
M$808 \$407 \$622 VSS VSS sg13_lv_nmos L=0.13u W=0.74u AS=0.2516p AD=0.2516p
+ PS=2.16u PD=2.16u rfmode=0
M$809 VSS \$660 \$730 VSS sg13_lv_nmos L=0.13u W=0.55u AS=0.14875p AD=0.187p
+ PS=1.16u PD=1.78u rfmode=0
M$810 \$435 \$730 VSS VSS sg13_lv_nmos L=0.13u W=0.74u AS=0.2886p AD=0.14875p
+ PS=2.26u PD=1.16u rfmode=0
M$811 VSS \$742 \$743 VSS sg13_lv_nmos L=0.13u W=0.74u AS=0.1626p AD=0.2516p
+ PS=1.415u PD=2.16u rfmode=0
M$812 \$741 \$689 \$774 VSS sg13_lv_nmos L=0.13u W=0.42u AS=0.1428p AD=0.0609p
+ PS=1.52u PD=0.71u rfmode=0
M$813 VSS \$731 \$774 VSS sg13_lv_nmos L=0.13u W=0.42u AS=0.1626p AD=0.0609p
+ PS=1.415u PD=0.71u rfmode=0
M$814 VSS \$731 \$775 VSS sg13_lv_nmos L=0.13u W=0.42u AS=0.1701p AD=0.0378p
+ PS=1.65u PD=0.6u rfmode=0
M$815 \$775 \$743 \$764 VSS sg13_lv_nmos L=0.13u W=0.42u AS=0.0378p AD=0.1428p
+ PS=0.6u PD=1.52u rfmode=0
M$816 \$741 \$745 \$742 VSS sg13_lv_nmos L=0.13u W=0.42u AS=0.1296p AD=0.0798p
+ PS=1.52u PD=0.8u rfmode=0
M$817 \$742 \$744 \$764 VSS sg13_lv_nmos L=0.13u W=0.42u AS=0.0798p AD=0.2373p
+ PS=0.8u PD=1.97u rfmode=0
M$818 \$744 \$745 VSS VSS sg13_lv_nmos L=0.13u W=0.74u AS=0.2516p AD=0.317325p
+ PS=2.16u PD=1.805u rfmode=0
M$819 VSS \$740 \$745 VSS sg13_lv_nmos L=0.13u W=0.74u AS=0.317325p AD=0.2516p
+ PS=1.805u PD=2.16u rfmode=0
M$820 \$765 \$745 \$746 VSS sg13_lv_nmos L=0.13u W=0.42u AS=0.1428p AD=0.12665p
+ PS=1.52u PD=1.145u rfmode=0
M$821 \$746 \$744 \$743 VSS sg13_lv_nmos L=0.13u W=0.74u AS=0.12665p AD=0.3473p
+ PS=1.145u PD=2.71u rfmode=0
M$822 \$765 \$747 VSS VSS sg13_lv_nmos L=0.13u W=0.42u AS=0.1428p AD=0.0798p
+ PS=1.52u PD=0.8u rfmode=0
M$823 VSS \$731 \$776 VSS sg13_lv_nmos L=0.13u W=0.42u AS=0.0798p AD=0.0378p
+ PS=0.8u PD=0.6u rfmode=0
M$824 \$776 \$746 \$747 VSS sg13_lv_nmos L=0.13u W=0.42u AS=0.0378p AD=0.1428p
+ PS=0.6u PD=1.52u rfmode=0
M$825 \$732 \$746 VSS VSS sg13_lv_nmos L=0.13u W=0.74u AS=0.2516p AD=0.1406p
+ PS=2.16u PD=1.12u rfmode=0
M$826 VSS \$732 \$685 VSS sg13_lv_nmos L=0.13u W=0.74u AS=0.1406p AD=0.2516p
+ PS=1.12u PD=2.16u rfmode=0
M$827 VSS \$622 \$623 VSS sg13_lv_nmos L=0.13u W=0.74u AS=0.2516p AD=0.2516p
+ PS=2.16u PD=2.16u rfmode=0
M$828 VSS \$662 \$777 VSS sg13_lv_nmos L=0.13u W=0.74u AS=0.2516p AD=0.1406p
+ PS=2.16u PD=1.12u rfmode=0
M$829 \$777 \$748 \$733 VSS sg13_lv_nmos L=0.13u W=0.74u AS=0.1406p AD=0.2516p
+ PS=1.12u PD=2.16u rfmode=0
M$830 \$766 \$748 VSS VSS sg13_lv_nmos L=0.15u W=0.74u AS=0.2516p AD=0.1406p
+ PS=2.16u PD=1.12u rfmode=0
M$831 VSS \$818 \$766 VSS sg13_lv_nmos L=0.15u W=0.74u AS=0.1406p AD=0.1406p
+ PS=1.12u PD=1.12u rfmode=0
M$832 \$766 \$733 \$734 VSS sg13_lv_nmos L=0.15u W=0.74u AS=0.1406p AD=0.2516p
+ PS=1.12u PD=2.16u rfmode=0
M$833 VSS \$750 \$751 VSS sg13_lv_nmos L=0.13u W=0.74u AS=0.1626p AD=0.2516p
+ PS=1.415u PD=2.16u rfmode=0
M$834 \$749 \$734 \$778 VSS sg13_lv_nmos L=0.13u W=0.42u AS=0.1428p AD=0.0609p
+ PS=1.52u PD=0.71u rfmode=0
M$835 VSS \$666 \$778 VSS sg13_lv_nmos L=0.13u W=0.42u AS=0.1626p AD=0.0609p
+ PS=1.415u PD=0.71u rfmode=0
M$836 VSS \$666 \$779 VSS sg13_lv_nmos L=0.13u W=0.42u AS=0.1701p AD=0.0378p
+ PS=1.65u PD=0.6u rfmode=0
M$837 \$779 \$751 \$767 VSS sg13_lv_nmos L=0.13u W=0.42u AS=0.0378p AD=0.1428p
+ PS=0.6u PD=1.52u rfmode=0
M$838 \$749 \$753 \$750 VSS sg13_lv_nmos L=0.13u W=0.42u AS=0.1296p AD=0.0798p
+ PS=1.52u PD=0.8u rfmode=0
M$839 \$750 \$752 \$767 VSS sg13_lv_nmos L=0.13u W=0.42u AS=0.0798p AD=0.2373p
+ PS=0.8u PD=1.97u rfmode=0
M$840 \$752 \$753 VSS VSS sg13_lv_nmos L=0.13u W=0.74u AS=0.2516p AD=0.317325p
+ PS=2.16u PD=1.805u rfmode=0
M$841 VSS \$740 \$753 VSS sg13_lv_nmos L=0.13u W=0.74u AS=0.317325p AD=0.2516p
+ PS=1.805u PD=2.16u rfmode=0
M$842 \$768 \$753 \$754 VSS sg13_lv_nmos L=0.13u W=0.42u AS=0.1428p AD=0.12665p
+ PS=1.52u PD=1.145u rfmode=0
M$843 \$754 \$752 \$751 VSS sg13_lv_nmos L=0.13u W=0.74u AS=0.12665p AD=0.3473p
+ PS=1.145u PD=2.71u rfmode=0
M$844 \$768 \$755 VSS VSS sg13_lv_nmos L=0.13u W=0.42u AS=0.1428p AD=0.0798p
+ PS=1.52u PD=0.8u rfmode=0
M$845 VSS \$666 \$780 VSS sg13_lv_nmos L=0.13u W=0.42u AS=0.0798p AD=0.0378p
+ PS=0.8u PD=0.6u rfmode=0
M$846 \$780 \$754 \$755 VSS sg13_lv_nmos L=0.13u W=0.42u AS=0.0378p AD=0.1428p
+ PS=0.6u PD=1.52u rfmode=0
M$847 \$735 \$754 VSS VSS sg13_lv_nmos L=0.13u W=0.74u AS=0.2516p AD=0.1406p
+ PS=2.16u PD=1.12u rfmode=0
M$848 VSS \$735 \$748 VSS sg13_lv_nmos L=0.13u W=0.74u AS=0.1406p AD=0.2516p
+ PS=1.12u PD=2.16u rfmode=0
M$851 VSS \$334 \$736 VSS sg13_lv_nmos L=0.13u W=0.55u AS=0.14875p AD=0.187p
+ PS=1.16u PD=1.78u rfmode=0
M$852 \$626 \$736 VSS VSS sg13_lv_nmos L=0.13u W=0.74u AS=0.2886p AD=0.14875p
+ PS=2.26u PD=1.16u rfmode=0
M$855 \$670 \$672 \$696 VSS sg13_lv_nmos L=0.13u W=0.42u AS=0.1296p AD=0.0798p
+ PS=1.52u PD=0.8u rfmode=0
M$856 \$696 \$716 \$697 VSS sg13_lv_nmos L=0.13u W=0.42u AS=0.0798p AD=0.2373p
+ PS=0.8u PD=1.97u rfmode=0
M$858 VSS \$335 \$737 VSS sg13_lv_nmos L=0.13u W=0.74u AS=0.2516p AD=0.2516p
+ PS=2.16u PD=2.16u rfmode=0
M$909 VSS \$428 \$794 VSS sg13_lv_nmos L=0.13u W=0.74u AS=0.2516p AD=0.2516p
+ PS=2.16u PD=2.16u rfmode=0
M$910 \$781 \$728 \$809 VSS sg13_lv_nmos L=0.13u W=0.42u AS=0.1428p AD=0.0609p
+ PS=1.52u PD=0.71u rfmode=0
M$911 \$809 \$794 VSS VSS sg13_lv_nmos L=0.13u W=0.42u AS=0.0609p AD=0.1626p
+ PS=0.71u PD=1.415u rfmode=0
M$912 VSS \$815 \$782 VSS sg13_lv_nmos L=0.13u W=0.74u AS=0.1626p AD=0.2516p
+ PS=1.415u PD=2.16u rfmode=0
M$913 VSS \$794 \$810 VSS sg13_lv_nmos L=0.13u W=0.42u AS=0.1701p AD=0.0378p
+ PS=1.65u PD=0.6u rfmode=0
M$914 \$810 \$782 \$795 VSS sg13_lv_nmos L=0.13u W=0.42u AS=0.0378p AD=0.1428p
+ PS=0.6u PD=1.52u rfmode=0
M$915 VSS \$783 \$796 VSS sg13_lv_nmos L=0.13u W=0.74u AS=0.317325p AD=0.2516p
+ PS=1.805u PD=2.16u rfmode=0
M$916 VSS \$489 \$783 VSS sg13_lv_nmos L=0.13u W=0.74u AS=0.317325p AD=0.2516p
+ PS=1.805u PD=2.16u rfmode=0
M$917 \$797 \$783 \$784 VSS sg13_lv_nmos L=0.13u W=0.42u AS=0.12665p AD=0.1428p
+ PS=1.145u PD=1.52u rfmode=0
M$918 \$782 \$796 \$797 VSS sg13_lv_nmos L=0.13u W=0.74u AS=0.3473p AD=0.12665p
+ PS=2.71u PD=1.145u rfmode=0
M$919 \$784 \$785 VSS VSS sg13_lv_nmos L=0.13u W=0.42u AS=0.1428p AD=0.0798p
+ PS=1.52u PD=0.8u rfmode=0
M$920 VSS \$794 \$814 VSS sg13_lv_nmos L=0.13u W=0.42u AS=0.0798p AD=0.0378p
+ PS=0.8u PD=0.6u rfmode=0
M$921 \$814 \$797 \$785 VSS sg13_lv_nmos L=0.13u W=0.42u AS=0.0378p AD=0.1428p
+ PS=0.6u PD=1.52u rfmode=0
M$922 \$786 \$797 VSS VSS sg13_lv_nmos L=0.13u W=0.74u AS=0.2516p AD=0.1406p
+ PS=2.16u PD=1.12u rfmode=0
M$923 VSS \$786 \$738 VSS sg13_lv_nmos L=0.13u W=0.74u AS=0.1406p AD=0.2516p
+ PS=1.12u PD=2.16u rfmode=0
M$926 VSS \$435 \$731 VSS sg13_lv_nmos L=0.13u W=0.74u AS=0.2516p AD=0.2516p
+ PS=2.16u PD=2.16u rfmode=0
M$929 VSS \$816 \$798 VSS sg13_lv_nmos L=0.13u W=0.74u AS=0.2516p AD=0.1406p
+ PS=2.16u PD=1.12u rfmode=0
M$930 \$798 \$817 VSS VSS sg13_lv_nmos L=0.13u W=0.74u AS=0.1406p AD=0.2516p
+ PS=1.12u PD=2.16u rfmode=0
M$931 VSS \$845 \$739 VSS sg13_lv_nmos L=0.13u W=0.77u AS=0.2618p AD=0.1694p
+ PS=2.22u PD=1.21u rfmode=0
M$932 \$739 \$817 VSS VSS sg13_lv_nmos L=0.13u W=0.77u AS=0.1694p AD=0.1463p
+ PS=1.21u PD=1.15u rfmode=0
M$933 VSS \$818 \$739 VSS sg13_lv_nmos L=0.13u W=0.77u AS=0.1463p AD=0.2618p
+ PS=1.15u PD=2.22u rfmode=0
M$934 VSS \$818 \$787 VSS sg13_lv_nmos L=0.13u W=0.55u AS=0.187p AD=0.1045p
+ PS=1.78u PD=0.93u rfmode=0
M$935 \$787 \$799 VSS VSS sg13_lv_nmos L=0.13u W=0.55u AS=0.1045p AD=0.1469p
+ PS=0.93u PD=1.155u rfmode=0
M$936 VSS \$787 \$816 VSS sg13_lv_nmos L=0.13u W=0.74u AS=0.1469p AD=0.2516p
+ PS=1.155u PD=2.16u rfmode=0
M$937 VSS \$799 \$800 VSS sg13_lv_nmos L=0.13u W=0.74u AS=0.2516p AD=0.1406p
+ PS=2.16u PD=1.12u rfmode=0
M$938 \$800 \$818 VSS VSS sg13_lv_nmos L=0.13u W=0.74u AS=0.1406p AD=0.2516p
+ PS=1.12u PD=2.16u rfmode=0
M$941 \$818 \$801 VSS VSS sg13_lv_nmos L=0.13u W=0.74u AS=0.2886p AD=0.14875p
+ PS=2.26u PD=1.16u rfmode=0
M$942 VSS \$607 \$801 VSS sg13_lv_nmos L=0.13u W=0.55u AS=0.14875p AD=0.187p
+ PS=1.16u PD=1.78u rfmode=0
M$947 \$740 \$802 VSS VSS sg13_lv_nmos L=0.13u W=0.74u AS=0.2886p AD=0.14875p
+ PS=2.26u PD=1.16u rfmode=0
M$948 VSS \$336 \$802 VSS sg13_lv_nmos L=0.13u W=0.55u AS=0.14875p AD=0.187p
+ PS=1.16u PD=1.78u rfmode=0
M$954 VSS \$739 \$803 VSS sg13_lv_nmos L=0.13u W=0.74u AS=0.2516p AD=0.1406p
+ PS=2.16u PD=1.12u rfmode=0
M$955 \$803 \$819 VSS VSS sg13_lv_nmos L=0.13u W=0.74u AS=0.1406p AD=0.2516p
+ PS=1.12u PD=2.16u rfmode=0
M$956 VSS \$345 \$813 VSS sg13_lv_nmos L=0.13u W=0.74u AS=0.2516p AD=0.1406p
+ PS=2.16u PD=1.12u rfmode=0
M$957 \$813 \$739 \$804 VSS sg13_lv_nmos L=0.13u W=0.74u AS=0.1406p AD=0.1406p
+ PS=1.12u PD=1.12u rfmode=0
M$958 \$804 \$803 VSS VSS sg13_lv_nmos L=0.13u W=0.74u AS=0.1406p AD=0.2516p
+ PS=1.12u PD=2.16u rfmode=0
M$959 \$788 \$804 \$812 VSS sg13_lv_nmos L=0.13u W=0.42u AS=0.1428p AD=0.0609p
+ PS=1.52u PD=0.71u rfmode=0
M$960 \$812 \$737 VSS VSS sg13_lv_nmos L=0.13u W=0.42u AS=0.0609p AD=0.1626p
+ PS=0.71u PD=1.415u rfmode=0
M$961 VSS \$821 \$789 VSS sg13_lv_nmos L=0.13u W=0.74u AS=0.1626p AD=0.2516p
+ PS=1.415u PD=2.16u rfmode=0
M$962 VSS \$737 \$811 VSS sg13_lv_nmos L=0.13u W=0.42u AS=0.1701p AD=0.0378p
+ PS=1.65u PD=0.6u rfmode=0
M$963 \$811 \$789 \$805 VSS sg13_lv_nmos L=0.13u W=0.42u AS=0.0378p AD=0.1428p
+ PS=0.6u PD=1.52u rfmode=0
M$964 VSS \$790 \$806 VSS sg13_lv_nmos L=0.13u W=0.74u AS=0.317325p AD=0.2516p
+ PS=1.805u PD=2.16u rfmode=0
M$965 VSS \$501 \$790 VSS sg13_lv_nmos L=0.13u W=0.74u AS=0.317325p AD=0.2516p
+ PS=1.805u PD=2.16u rfmode=0
M$966 \$807 \$790 \$791 VSS sg13_lv_nmos L=0.13u W=0.42u AS=0.12665p AD=0.1428p
+ PS=1.145u PD=1.52u rfmode=0
M$967 \$789 \$806 \$807 VSS sg13_lv_nmos L=0.13u W=0.74u AS=0.3473p AD=0.12665p
+ PS=2.71u PD=1.145u rfmode=0
M$968 \$791 \$792 VSS VSS sg13_lv_nmos L=0.13u W=0.42u AS=0.1428p AD=0.0798p
+ PS=1.52u PD=0.8u rfmode=0
M$969 VSS \$737 \$808 VSS sg13_lv_nmos L=0.13u W=0.42u AS=0.0798p AD=0.0378p
+ PS=0.8u PD=0.6u rfmode=0
M$970 \$808 \$807 \$792 VSS sg13_lv_nmos L=0.13u W=0.42u AS=0.0378p AD=0.1428p
+ PS=0.6u PD=1.52u rfmode=0
M$971 \$793 \$807 VSS VSS sg13_lv_nmos L=0.13u W=0.74u AS=0.2516p AD=0.1406p
+ PS=2.16u PD=1.12u rfmode=0
M$972 VSS \$793 \$819 VSS sg13_lv_nmos L=0.13u W=0.74u AS=0.1406p AD=0.2516p
+ PS=1.12u PD=2.16u rfmode=0
M$996 VSS \$738 \$836 VSS sg13_lv_nmos L=0.13u W=0.55u AS=0.14875p AD=0.187p
+ PS=1.16u PD=1.78u rfmode=0
M$997 \$31 \$836 VSS VSS sg13_lv_nmos L=0.13u W=0.74u AS=0.2886p AD=0.14875p
+ PS=2.26u PD=1.16u rfmode=0
M$1012 VSS \$859 \$837 VSS sg13_lv_nmos L=0.13u W=0.74u AS=0.2516p AD=0.1406p
+ PS=2.16u PD=1.12u rfmode=0
M$1013 \$837 \$344 \$894 VSS sg13_lv_nmos L=0.13u W=0.74u AS=0.1406p AD=0.1406p
+ PS=1.12u PD=1.12u rfmode=0
M$1014 \$894 \$345 VSS VSS sg13_lv_nmos L=0.13u W=0.74u AS=0.1406p AD=0.2516p
+ PS=1.12u PD=2.16u rfmode=0
M$1023 \$781 \$783 \$815 VSS sg13_lv_nmos L=0.13u W=0.42u AS=0.1296p AD=0.0798p
+ PS=1.52u PD=0.8u rfmode=0
M$1024 \$815 \$796 \$795 VSS sg13_lv_nmos L=0.13u W=0.42u AS=0.0798p AD=0.2373p
+ PS=0.8u PD=1.97u rfmode=0
M$1026 \$839 \$739 VSS VSS sg13_lv_nmos L=0.13u W=0.55u AS=0.187p AD=0.14505p
+ PS=1.78u PD=1.15u rfmode=0
M$1027 VSS \$878 \$895 VSS sg13_lv_nmos L=0.13u W=0.74u AS=0.14505p AD=0.1406p
+ PS=1.15u PD=1.12u rfmode=0
M$1028 \$895 \$839 \$840 VSS sg13_lv_nmos L=0.13u W=0.74u AS=0.1406p AD=0.333p
+ PS=1.12u PD=2.38u rfmode=0
M$1029 VSS \$843 \$897 VSS sg13_lv_nmos L=0.13u W=0.42u AS=0.1701p AD=0.0378p
+ PS=1.65u PD=0.6u rfmode=0
M$1030 \$897 \$860 \$879 VSS sg13_lv_nmos L=0.13u W=0.42u AS=0.0378p AD=0.1428p
+ PS=0.6u PD=1.52u rfmode=0
M$1031 \$841 \$862 \$842 VSS sg13_lv_nmos L=0.13u W=0.42u AS=0.1296p AD=0.0798p
+ PS=1.52u PD=0.8u rfmode=0
M$1032 \$842 \$861 \$879 VSS sg13_lv_nmos L=0.13u W=0.42u AS=0.0798p AD=0.2373p
+ PS=0.8u PD=1.97u rfmode=0
M$1033 \$861 \$862 VSS VSS sg13_lv_nmos L=0.13u W=0.74u AS=0.2516p AD=0.317325p
+ PS=2.16u PD=1.805u rfmode=0
M$1034 VSS \$740 \$862 VSS sg13_lv_nmos L=0.13u W=0.74u AS=0.317325p AD=0.2516p
+ PS=1.805u PD=2.16u rfmode=0
M$1035 \$884 \$862 \$863 VSS sg13_lv_nmos L=0.13u W=0.42u AS=0.1428p
+ AD=0.12665p PS=1.52u PD=1.145u rfmode=0
M$1036 \$863 \$861 \$860 VSS sg13_lv_nmos L=0.13u W=0.74u AS=0.12665p
+ AD=0.3473p PS=1.145u PD=2.71u rfmode=0
M$1037 \$844 \$863 VSS VSS sg13_lv_nmos L=0.13u W=0.74u AS=0.2516p AD=0.1406p
+ PS=2.16u PD=1.12u rfmode=0
M$1038 VSS \$844 \$845 VSS sg13_lv_nmos L=0.13u W=0.74u AS=0.1406p AD=0.2516p
+ PS=1.12u PD=2.16u rfmode=0
M$1039 VSS \$662 \$899 VSS sg13_lv_nmos L=0.13u W=0.74u AS=0.2553p AD=0.13875p
+ PS=2.17u PD=1.115u rfmode=0
M$1040 \$899 \$845 \$878 VSS sg13_lv_nmos L=0.13u W=0.74u AS=0.13875p
+ AD=0.2664p PS=1.115u PD=1.46u rfmode=0
M$1041 \$878 \$817 \$900 VSS sg13_lv_nmos L=0.13u W=0.74u AS=0.2664p AD=0.0962p
+ PS=1.46u PD=1u rfmode=0
M$1042 \$900 \$800 VSS VSS sg13_lv_nmos L=0.13u W=0.74u AS=0.0962p AD=0.2516p
+ PS=1u PD=2.16u rfmode=0
M$1043 \$817 \$880 \$901 VSS sg13_lv_nmos L=0.13u W=0.74u AS=0.2516p AD=0.1406p
+ PS=2.16u PD=1.12u rfmode=0
M$1044 \$901 \$748 VSS VSS sg13_lv_nmos L=0.13u W=0.74u AS=0.1406p AD=0.2516p
+ PS=1.12u PD=2.16u rfmode=0
M$1045 VSS \$880 \$603 VSS sg13_lv_nmos L=0.13u W=0.77u AS=0.2618p AD=0.1694p
+ PS=2.22u PD=1.21u rfmode=0
M$1046 \$603 \$748 VSS VSS sg13_lv_nmos L=0.13u W=0.77u AS=0.1694p AD=0.1463p
+ PS=1.21u PD=1.15u rfmode=0
M$1047 VSS \$816 \$603 VSS sg13_lv_nmos L=0.13u W=0.77u AS=0.1463p AD=0.2618p
+ PS=1.15u PD=2.22u rfmode=0
M$1048 VSS \$662 \$902 VSS sg13_lv_nmos L=0.13u W=0.64u AS=0.2176p AD=0.0816p
+ PS=1.96u PD=0.895u rfmode=0
M$1049 \$902 \$880 \$848 VSS sg13_lv_nmos L=0.13u W=0.64u AS=0.0816p AD=0.1216p
+ PS=0.895u PD=1.02u rfmode=0
M$1050 \$848 \$865 VSS VSS sg13_lv_nmos L=0.13u W=0.64u AS=0.1216p AD=0.15745p
+ PS=1.02u PD=1.175u rfmode=0
M$1051 VSS \$848 \$849 VSS sg13_lv_nmos L=0.13u W=0.74u AS=0.15745p AD=0.2351p
+ PS=1.175u PD=2.16u rfmode=0
M$1052 \$850 \$335 VSS VSS sg13_lv_nmos L=0.13u W=0.74u AS=0.2516p AD=0.2516p
+ PS=2.16u PD=2.16u rfmode=0
M$1053 VSS \$850 \$904 VSS sg13_lv_nmos L=0.13u W=0.42u AS=0.1701p AD=0.0378p
+ PS=1.65u PD=0.6u rfmode=0
M$1054 \$904 \$866 \$881 VSS sg13_lv_nmos L=0.13u W=0.42u AS=0.0378p AD=0.1428p
+ PS=0.6u PD=1.52u rfmode=0
M$1055 \$851 \$868 \$852 VSS sg13_lv_nmos L=0.13u W=0.42u AS=0.1296p AD=0.0798p
+ PS=1.52u PD=0.8u rfmode=0
M$1056 \$852 \$867 \$881 VSS sg13_lv_nmos L=0.13u W=0.42u AS=0.0798p AD=0.2373p
+ PS=0.8u PD=1.97u rfmode=0
M$1057 \$867 \$868 VSS VSS sg13_lv_nmos L=0.13u W=0.74u AS=0.2516p AD=0.317325p
+ PS=2.16u PD=1.805u rfmode=0
M$1058 VSS \$740 \$868 VSS sg13_lv_nmos L=0.13u W=0.74u AS=0.317325p AD=0.2516p
+ PS=1.805u PD=2.16u rfmode=0
M$1059 \$885 \$868 \$869 VSS sg13_lv_nmos L=0.13u W=0.42u AS=0.1428p
+ AD=0.12665p PS=1.52u PD=1.145u rfmode=0
M$1060 \$869 \$867 \$866 VSS sg13_lv_nmos L=0.13u W=0.74u AS=0.12665p
+ AD=0.3473p PS=1.145u PD=2.71u rfmode=0
M$1061 \$853 \$869 VSS VSS sg13_lv_nmos L=0.13u W=0.74u AS=0.2516p AD=0.1406p
+ PS=2.16u PD=1.12u rfmode=0
M$1062 VSS \$853 \$880 VSS sg13_lv_nmos L=0.13u W=0.74u AS=0.1406p AD=0.2516p
+ PS=1.12u PD=2.16u rfmode=0
M$1063 VSS \$882 \$854 VSS sg13_lv_nmos L=0.13u W=0.74u AS=0.2516p AD=0.1406p
+ PS=2.16u PD=1.12u rfmode=0
M$1064 \$854 \$739 VSS VSS sg13_lv_nmos L=0.13u W=0.74u AS=0.1406p AD=0.2516p
+ PS=1.12u PD=2.16u rfmode=0
M$1065 VSS \$854 \$855 VSS sg13_lv_nmos L=0.13u W=0.74u AS=0.2516p AD=0.1406p
+ PS=2.16u PD=1.12u rfmode=0
M$1066 \$855 \$739 \$906 VSS sg13_lv_nmos L=0.13u W=0.74u AS=0.1406p AD=0.1406p
+ PS=1.12u PD=1.12u rfmode=0
M$1067 \$906 \$345 VSS VSS sg13_lv_nmos L=0.13u W=0.74u AS=0.1406p AD=0.2516p
+ PS=1.12u PD=2.16u rfmode=0
M$1072 \$788 \$790 \$821 VSS sg13_lv_nmos L=0.13u W=0.42u AS=0.1296p AD=0.0798p
+ PS=1.52u PD=0.8u rfmode=0
M$1073 \$821 \$806 \$805 VSS sg13_lv_nmos L=0.13u W=0.42u AS=0.0798p AD=0.2373p
+ PS=0.8u PD=1.97u rfmode=0
M$1080 VSS \$883 \$857 VSS sg13_lv_nmos L=0.13u W=0.74u AS=0.2516p AD=0.2516p
+ PS=2.16u PD=2.16u rfmode=0
M$1101 \$858 \$819 VSS VSS sg13_lv_nmos L=0.13u W=0.55u AS=0.187p AD=0.14875p
+ PS=1.78u PD=1.16u rfmode=0
M$1102 VSS \$858 \$38 VSS sg13_lv_nmos L=0.13u W=0.74u AS=0.14875p AD=0.2886p
+ PS=1.16u PD=2.26u rfmode=0
M$1117 VSS \$428 \$913 VSS sg13_lv_nmos L=0.13u W=0.74u AS=0.2516p AD=0.2516p
+ PS=2.16u PD=2.16u rfmode=0
M$1118 \$914 \$837 \$949 VSS sg13_lv_nmos L=0.13u W=0.42u AS=0.1428p AD=0.0609p
+ PS=1.52u PD=0.71u rfmode=0
M$1119 \$949 \$913 VSS VSS sg13_lv_nmos L=0.13u W=0.42u AS=0.0609p AD=0.1626p
+ PS=0.71u PD=1.415u rfmode=0
M$1120 VSS \$937 \$907 VSS sg13_lv_nmos L=0.13u W=0.74u AS=0.1626p AD=0.2516p
+ PS=1.415u PD=2.16u rfmode=0
M$1121 VSS \$913 \$950 VSS sg13_lv_nmos L=0.13u W=0.42u AS=0.1701p AD=0.0378p
+ PS=1.65u PD=0.6u rfmode=0
M$1122 \$950 \$907 \$915 VSS sg13_lv_nmos L=0.13u W=0.42u AS=0.0378p AD=0.1428p
+ PS=0.6u PD=1.52u rfmode=0
M$1123 \$938 \$908 \$916 VSS sg13_lv_nmos L=0.13u W=0.42u AS=0.12665p
+ AD=0.1428p PS=1.145u PD=1.52u rfmode=0
M$1124 \$907 \$964 \$938 VSS sg13_lv_nmos L=0.13u W=0.74u AS=0.3473p
+ AD=0.12665p PS=2.71u PD=1.145u rfmode=0
M$1125 \$916 \$917 VSS VSS sg13_lv_nmos L=0.13u W=0.42u AS=0.1428p AD=0.0798p
+ PS=1.52u PD=0.8u rfmode=0
M$1126 VSS \$913 \$951 VSS sg13_lv_nmos L=0.13u W=0.42u AS=0.0798p AD=0.0378p
+ PS=0.8u PD=0.6u rfmode=0
M$1127 \$951 \$938 \$917 VSS sg13_lv_nmos L=0.13u W=0.42u AS=0.0378p AD=0.1428p
+ PS=0.6u PD=1.52u rfmode=0
M$1128 \$918 \$938 VSS VSS sg13_lv_nmos L=0.13u W=0.74u AS=0.2516p AD=0.1406p
+ PS=2.16u PD=1.12u rfmode=0
M$1129 VSS \$918 \$919 VSS sg13_lv_nmos L=0.13u W=0.74u AS=0.1406p AD=0.2516p
+ PS=1.12u PD=2.16u rfmode=0
M$1133 VSS \$842 \$860 VSS sg13_lv_nmos L=0.13u W=0.74u AS=0.1626p AD=0.2516p
+ PS=1.415u PD=2.16u rfmode=0
M$1134 \$841 \$840 \$896 VSS sg13_lv_nmos L=0.13u W=0.42u AS=0.1428p AD=0.0609p
+ PS=1.52u PD=0.71u rfmode=0
M$1135 VSS \$843 \$896 VSS sg13_lv_nmos L=0.13u W=0.42u AS=0.1626p AD=0.0609p
+ PS=1.415u PD=0.71u rfmode=0
M$1136 VSS \$435 \$843 VSS sg13_lv_nmos L=0.13u W=0.74u AS=0.2516p AD=0.2516p
+ PS=2.16u PD=2.16u rfmode=0
M$1143 \$884 \$864 VSS VSS sg13_lv_nmos L=0.13u W=0.42u AS=0.1428p AD=0.0798p
+ PS=1.52u PD=0.8u rfmode=0
M$1144 VSS \$843 \$898 VSS sg13_lv_nmos L=0.13u W=0.42u AS=0.0798p AD=0.0378p
+ PS=0.8u PD=0.6u rfmode=0
M$1145 \$898 \$863 \$864 VSS sg13_lv_nmos L=0.13u W=0.42u AS=0.0378p AD=0.1428p
+ PS=0.6u PD=1.52u rfmode=0
M$1146 VSS \$799 \$344 VSS sg13_lv_nmos L=0.13u W=0.77u AS=0.2618p AD=0.1694p
+ PS=2.22u PD=1.21u rfmode=0
M$1147 \$344 \$818 VSS VSS sg13_lv_nmos L=0.13u W=0.77u AS=0.1694p AD=0.1463p
+ PS=1.21u PD=1.15u rfmode=0
M$1148 VSS \$941 \$344 VSS sg13_lv_nmos L=0.13u W=0.77u AS=0.1463p AD=0.2618p
+ PS=1.15u PD=2.22u rfmode=0
M$1149 VSS \$845 \$940 VSS sg13_lv_nmos L=0.13u W=0.77u AS=0.2618p AD=0.1694p
+ PS=2.22u PD=1.21u rfmode=0
M$1150 \$940 \$607 VSS VSS sg13_lv_nmos L=0.13u W=0.77u AS=0.1694p AD=0.1463p
+ PS=1.21u PD=1.15u rfmode=0
M$1151 VSS \$941 \$940 VSS sg13_lv_nmos L=0.13u W=0.77u AS=0.1463p AD=0.2618p
+ PS=1.15u PD=2.22u rfmode=0
M$1152 \$941 \$942 \$954 VSS sg13_lv_nmos L=0.13u W=0.74u AS=0.333p AD=0.1406p
+ PS=2.38u PD=1.12u rfmode=0
M$1153 \$954 \$880 VSS VSS sg13_lv_nmos L=0.13u W=0.74u AS=0.1406p AD=0.14505p
+ PS=1.12u PD=1.15u rfmode=0
M$1154 VSS \$748 \$942 VSS sg13_lv_nmos L=0.13u W=0.55u AS=0.14505p AD=0.187p
+ PS=1.15u PD=1.78u rfmode=0
M$1155 VSS \$880 \$943 VSS sg13_lv_nmos L=0.13u W=0.55u AS=0.14505p AD=0.187p
+ PS=1.15u PD=1.78u rfmode=0
M$1156 VSS \$748 \$957 VSS sg13_lv_nmos L=0.13u W=0.74u AS=0.14505p AD=0.1406p
+ PS=1.15u PD=1.12u rfmode=0
M$1157 \$957 \$943 \$921 VSS sg13_lv_nmos L=0.13u W=0.74u AS=0.1406p AD=0.333p
+ PS=1.12u PD=2.38u rfmode=0
M$1158 VSS \$921 \$922 VSS sg13_lv_nmos L=0.13u W=0.74u AS=0.2516p AD=0.1406p
+ PS=2.16u PD=1.12u rfmode=0
M$1159 \$922 \$816 VSS VSS sg13_lv_nmos L=0.13u W=0.74u AS=0.1406p AD=0.2516p
+ PS=1.12u PD=2.16u rfmode=0
M$1162 VSS \$852 \$866 VSS sg13_lv_nmos L=0.13u W=0.74u AS=0.1626p AD=0.2516p
+ PS=1.415u PD=2.16u rfmode=0
M$1163 \$851 \$849 \$903 VSS sg13_lv_nmos L=0.13u W=0.42u AS=0.1428p AD=0.0609p
+ PS=1.52u PD=0.71u rfmode=0
M$1164 VSS \$850 \$903 VSS sg13_lv_nmos L=0.13u W=0.42u AS=0.1626p AD=0.0609p
+ PS=1.415u PD=0.71u rfmode=0
M$1169 \$885 \$870 VSS VSS sg13_lv_nmos L=0.13u W=0.42u AS=0.1428p AD=0.0798p
+ PS=1.52u PD=0.8u rfmode=0
M$1170 VSS \$850 \$905 VSS sg13_lv_nmos L=0.13u W=0.42u AS=0.0798p AD=0.0378p
+ PS=0.8u PD=0.6u rfmode=0
M$1171 \$905 \$869 \$870 VSS sg13_lv_nmos L=0.13u W=0.42u AS=0.0378p AD=0.1428p
+ PS=0.6u PD=1.52u rfmode=0
M$1174 VSS \$335 \$923 VSS sg13_lv_nmos L=0.13u W=0.74u AS=0.2516p AD=0.2516p
+ PS=2.16u PD=2.16u rfmode=0
M$1175 \$924 \$855 \$961 VSS sg13_lv_nmos L=0.13u W=0.42u AS=0.1428p AD=0.0609p
+ PS=1.52u PD=0.71u rfmode=0
M$1176 \$961 \$923 VSS VSS sg13_lv_nmos L=0.13u W=0.42u AS=0.0609p AD=0.1626p
+ PS=0.71u PD=1.415u rfmode=0
M$1177 VSS \$944 \$909 VSS sg13_lv_nmos L=0.13u W=0.74u AS=0.1626p AD=0.2516p
+ PS=1.415u PD=2.16u rfmode=0
M$1178 VSS \$923 \$962 VSS sg13_lv_nmos L=0.13u W=0.42u AS=0.1701p AD=0.0378p
+ PS=1.65u PD=0.6u rfmode=0
M$1179 \$962 \$909 \$925 VSS sg13_lv_nmos L=0.13u W=0.42u AS=0.0378p AD=0.1428p
+ PS=0.6u PD=1.52u rfmode=0
M$1180 \$945 \$910 \$926 VSS sg13_lv_nmos L=0.13u W=0.42u AS=0.12665p
+ AD=0.1428p PS=1.145u PD=1.52u rfmode=0
M$1181 \$909 \$967 \$945 VSS sg13_lv_nmos L=0.13u W=0.74u AS=0.3473p
+ AD=0.12665p PS=2.71u PD=1.145u rfmode=0
M$1182 \$926 \$927 VSS VSS sg13_lv_nmos L=0.13u W=0.42u AS=0.1428p AD=0.0798p
+ PS=1.52u PD=0.8u rfmode=0
M$1183 VSS \$923 \$963 VSS sg13_lv_nmos L=0.13u W=0.42u AS=0.0798p AD=0.0378p
+ PS=0.8u PD=0.6u rfmode=0
M$1184 \$963 \$945 \$927 VSS sg13_lv_nmos L=0.13u W=0.42u AS=0.0378p AD=0.1428p
+ PS=0.6u PD=1.52u rfmode=0
M$1185 \$928 \$945 VSS VSS sg13_lv_nmos L=0.13u W=0.74u AS=0.2516p AD=0.1406p
+ PS=2.16u PD=1.12u rfmode=0
M$1186 VSS \$928 \$882 VSS sg13_lv_nmos L=0.13u W=0.74u AS=0.1406p AD=0.2516p
+ PS=1.12u PD=2.16u rfmode=0
M$1187 VSS \$940 \$929 VSS sg13_lv_nmos L=0.13u W=0.55u AS=0.18945p AD=0.187p
+ PS=1.27u PD=1.78u rfmode=0
M$1188 VSS \$940 \$960 VSS sg13_lv_nmos L=0.13u W=0.74u AS=0.18945p AD=0.13135p
+ PS=1.27u PD=1.095u rfmode=0
M$1189 \$960 \$617 \$930 VSS sg13_lv_nmos L=0.13u W=0.74u AS=0.13135p
+ AD=0.1628p PS=1.095u PD=1.18u rfmode=0
M$1190 \$930 \$946 \$959 VSS sg13_lv_nmos L=0.13u W=0.74u AS=0.1628p AD=0.3367p
+ PS=1.18u PD=1.65u rfmode=0
M$1191 \$959 \$929 VSS VSS sg13_lv_nmos L=0.13u W=0.74u AS=0.3367p AD=0.148p
+ PS=1.65u PD=1.14u rfmode=0
M$1192 VSS \$930 \$931 VSS sg13_lv_nmos L=0.13u W=0.74u AS=0.148p AD=0.4033p
+ PS=1.14u PD=2.57u rfmode=0
M$1193 \$932 \$931 \$958 VSS sg13_lv_nmos L=0.13u W=0.42u AS=0.1428p AD=0.0609p
+ PS=1.52u PD=0.71u rfmode=0
M$1194 \$958 \$857 VSS VSS sg13_lv_nmos L=0.13u W=0.42u AS=0.0609p AD=0.1626p
+ PS=0.71u PD=1.415u rfmode=0
M$1195 VSS \$947 \$911 VSS sg13_lv_nmos L=0.13u W=0.74u AS=0.1626p AD=0.2516p
+ PS=1.415u PD=2.16u rfmode=0
M$1196 VSS \$857 \$956 VSS sg13_lv_nmos L=0.13u W=0.42u AS=0.1701p AD=0.0378p
+ PS=1.65u PD=0.6u rfmode=0
M$1197 \$956 \$911 \$933 VSS sg13_lv_nmos L=0.13u W=0.42u AS=0.0378p AD=0.1428p
+ PS=0.6u PD=1.52u rfmode=0
M$1198 \$948 \$912 \$934 VSS sg13_lv_nmos L=0.13u W=0.42u AS=0.12665p
+ AD=0.1428p PS=1.145u PD=1.52u rfmode=0
M$1199 \$911 \$968 \$948 VSS sg13_lv_nmos L=0.13u W=0.74u AS=0.3473p
+ AD=0.12665p PS=2.71u PD=1.145u rfmode=0
M$1200 \$934 \$935 VSS VSS sg13_lv_nmos L=0.13u W=0.42u AS=0.1428p AD=0.0798p
+ PS=1.52u PD=0.8u rfmode=0
M$1201 VSS \$857 \$953 VSS sg13_lv_nmos L=0.13u W=0.42u AS=0.0798p AD=0.0378p
+ PS=0.8u PD=0.6u rfmode=0
M$1202 \$953 \$948 \$935 VSS sg13_lv_nmos L=0.13u W=0.42u AS=0.0378p AD=0.1428p
+ PS=0.6u PD=1.52u rfmode=0
M$1203 \$936 \$948 VSS VSS sg13_lv_nmos L=0.13u W=0.74u AS=0.2516p AD=0.1406p
+ PS=2.16u PD=1.12u rfmode=0
M$1204 VSS \$936 \$946 VSS sg13_lv_nmos L=0.13u W=0.74u AS=0.1406p AD=0.2516p
+ PS=1.12u PD=2.16u rfmode=0
M$1220 VSS \$1005 \$991 VSS sg13_lv_nmos L=0.13u W=0.55u AS=0.14875p AD=0.187p
+ PS=1.16u PD=1.78u rfmode=0
M$1221 \$30 \$991 VSS VSS sg13_lv_nmos L=0.13u W=0.74u AS=0.2886p AD=0.14875p
+ PS=2.26u PD=1.16u rfmode=0
M$1236 VSS \$344 \$859 VSS sg13_lv_nmos L=0.13u W=0.74u AS=0.2516p AD=0.1406p
+ PS=2.16u PD=1.12u rfmode=0
M$1237 \$859 \$919 VSS VSS sg13_lv_nmos L=0.13u W=0.74u AS=0.1406p AD=0.2516p
+ PS=1.12u PD=2.16u rfmode=0
M$1238 \$914 \$908 \$937 VSS sg13_lv_nmos L=0.13u W=0.42u AS=0.1296p AD=0.0798p
+ PS=1.52u PD=0.8u rfmode=0
M$1239 \$937 \$964 \$915 VSS sg13_lv_nmos L=0.13u W=0.42u AS=0.0798p AD=0.2373p
+ PS=0.8u PD=1.97u rfmode=0
M$1242 VSS \$908 \$964 VSS sg13_lv_nmos L=0.13u W=0.74u AS=0.317325p AD=0.2516p
+ PS=1.805u PD=2.16u rfmode=0
M$1243 VSS \$489 \$908 VSS sg13_lv_nmos L=0.13u W=0.74u AS=0.317325p AD=0.2516p
+ PS=1.805u PD=2.16u rfmode=0
M$1244 \$992 \$435 VSS VSS sg13_lv_nmos L=0.13u W=0.74u AS=0.2516p AD=0.2516p
+ PS=2.16u PD=2.16u rfmode=0
M$1245 \$1006 \$1010 \$1007 VSS sg13_lv_nmos L=0.13u W=0.42u AS=0.1296p
+ AD=0.0798p PS=1.52u PD=0.8u rfmode=0
M$1246 \$1007 \$1009 \$1030 VSS sg13_lv_nmos L=0.13u W=0.42u AS=0.0798p
+ AD=0.2373p PS=0.8u PD=1.97u rfmode=0
M$1247 \$1009 \$1010 VSS VSS sg13_lv_nmos L=0.13u W=0.74u AS=0.2516p
+ AD=0.317325p PS=2.16u PD=1.805u rfmode=0
M$1248 VSS \$489 \$1010 VSS sg13_lv_nmos L=0.13u W=0.74u AS=0.317325p
+ AD=0.2516p PS=1.805u PD=2.16u rfmode=0
M$1249 \$1031 \$1010 \$1011 VSS sg13_lv_nmos L=0.13u W=0.42u AS=0.1428p
+ AD=0.12665p PS=1.52u PD=1.145u rfmode=0
M$1250 \$1011 \$1009 \$1008 VSS sg13_lv_nmos L=0.13u W=0.74u AS=0.12665p
+ AD=0.3473p PS=1.145u PD=2.71u rfmode=0
M$1251 VSS \$939 \$920 VSS sg13_lv_nmos L=0.13u W=0.74u AS=0.2516p AD=0.1406p
+ PS=2.16u PD=1.12u rfmode=0
M$1252 \$920 \$626 \$952 VSS sg13_lv_nmos L=0.13u W=0.74u AS=0.1406p AD=0.1406p
+ PS=1.12u PD=1.12u rfmode=0
M$1253 \$952 \$940 VSS VSS sg13_lv_nmos L=0.13u W=0.74u AS=0.1406p AD=0.2516p
+ PS=1.12u PD=2.16u rfmode=0
M$1254 \$993 \$1011 VSS VSS sg13_lv_nmos L=0.13u W=0.74u AS=0.2516p AD=0.1406p
+ PS=2.16u PD=1.12u rfmode=0
M$1255 VSS \$993 \$1005 VSS sg13_lv_nmos L=0.13u W=0.74u AS=0.1406p AD=0.2516p
+ PS=1.12u PD=2.16u rfmode=0
M$1256 VSS \$1005 \$939 VSS sg13_lv_nmos L=0.13u W=0.74u AS=0.2516p AD=0.1406p
+ PS=2.16u PD=1.12u rfmode=0
M$1257 \$939 \$940 VSS VSS sg13_lv_nmos L=0.13u W=0.74u AS=0.1406p AD=0.2516p
+ PS=1.12u PD=2.16u rfmode=0
M$1266 \$799 \$845 VSS VSS sg13_lv_nmos L=0.13u W=0.74u AS=0.2516p AD=0.2516p
+ PS=2.16u PD=2.16u rfmode=0
M$1267 VSS \$845 \$994 VSS sg13_lv_nmos L=0.13u W=0.77u AS=0.2618p AD=0.1694p
+ PS=2.22u PD=1.21u rfmode=0
M$1268 \$994 \$880 VSS VSS sg13_lv_nmos L=0.13u W=0.77u AS=0.1694p AD=0.1463p
+ PS=1.21u PD=1.15u rfmode=0
M$1269 VSS \$818 \$994 VSS sg13_lv_nmos L=0.13u W=0.77u AS=0.1463p AD=0.2618p
+ PS=1.15u PD=2.22u rfmode=0
M$1270 VSS \$941 \$955 VSS sg13_lv_nmos L=0.13u W=0.74u AS=0.2516p AD=0.1406p
+ PS=2.16u PD=1.12u rfmode=0
M$1271 \$955 \$921 \$865 VSS sg13_lv_nmos L=0.13u W=0.74u AS=0.1406p AD=0.1406p
+ PS=1.12u PD=1.12u rfmode=0
M$1272 \$865 \$818 VSS VSS sg13_lv_nmos L=0.13u W=0.74u AS=0.1406p AD=0.2516p
+ PS=1.12u PD=2.16u rfmode=0
M$1273 VSS \$845 \$995 VSS sg13_lv_nmos L=0.13u W=0.77u AS=0.2618p AD=0.1694p
+ PS=2.22u PD=1.21u rfmode=0
M$1274 \$995 \$818 VSS VSS sg13_lv_nmos L=0.13u W=0.77u AS=0.1694p AD=0.1463p
+ PS=1.21u PD=1.15u rfmode=0
M$1275 VSS \$921 \$995 VSS sg13_lv_nmos L=0.13u W=0.77u AS=0.1463p AD=0.2618p
+ PS=1.15u PD=2.22u rfmode=0
M$1276 VSS \$921 \$996 VSS sg13_lv_nmos L=0.13u W=0.74u AS=0.2516p AD=0.1406p
+ PS=2.16u PD=1.12u rfmode=0
M$1277 \$996 \$626 VSS VSS sg13_lv_nmos L=0.13u W=0.74u AS=0.1406p AD=0.2516p
+ PS=1.12u PD=2.16u rfmode=0
M$1282 VSS \$880 \$997 VSS sg13_lv_nmos L=0.13u W=0.77u AS=0.2618p AD=0.1694p
+ PS=2.22u PD=1.21u rfmode=0
M$1283 \$997 \$748 VSS VSS sg13_lv_nmos L=0.13u W=0.77u AS=0.1694p AD=0.1463p
+ PS=1.21u PD=1.15u rfmode=0
M$1284 VSS \$617 \$997 VSS sg13_lv_nmos L=0.13u W=0.77u AS=0.1463p AD=0.2618p
+ PS=1.15u PD=2.22u rfmode=0
M$1285 \$1045 \$994 VSS VSS sg13_lv_nmos L=0.15u W=0.74u AS=0.2516p AD=0.1406p
+ PS=2.16u PD=1.12u rfmode=0
M$1286 VSS \$344 \$1045 VSS sg13_lv_nmos L=0.15u W=0.74u AS=0.1406p AD=0.1406p
+ PS=1.12u PD=1.12u rfmode=0
M$1287 \$1045 \$997 \$998 VSS sg13_lv_nmos L=0.15u W=0.74u AS=0.1406p
+ AD=0.2516p PS=1.12u PD=2.16u rfmode=0
M$1292 \$924 \$910 \$944 VSS sg13_lv_nmos L=0.13u W=0.42u AS=0.1296p AD=0.0798p
+ PS=1.52u PD=0.8u rfmode=0
M$1293 \$944 \$967 \$925 VSS sg13_lv_nmos L=0.13u W=0.42u AS=0.0798p AD=0.2373p
+ PS=0.8u PD=1.97u rfmode=0
M$1294 VSS \$940 \$1000 VSS sg13_lv_nmos L=0.13u W=0.55u AS=0.18945p AD=0.187p
+ PS=1.27u PD=1.78u rfmode=0
M$1295 \$999 \$1032 VSS VSS sg13_lv_nmos L=0.13u W=0.74u AS=0.4033p AD=0.148p
+ PS=2.57u PD=1.14u rfmode=0
M$1296 VSS \$1000 \$1058 VSS sg13_lv_nmos L=0.13u W=0.74u AS=0.148p AD=0.3367p
+ PS=1.14u PD=1.65u rfmode=0
M$1297 \$1058 \$1033 \$1032 VSS sg13_lv_nmos L=0.13u W=0.74u AS=0.3367p
+ AD=0.1628p PS=1.65u PD=1.18u rfmode=0
M$1298 \$1032 \$617 \$1057 VSS sg13_lv_nmos L=0.13u W=0.74u AS=0.1628p
+ AD=0.13135p PS=1.18u PD=1.095u rfmode=0
M$1299 \$1057 \$940 VSS VSS sg13_lv_nmos L=0.13u W=0.74u AS=0.13135p
+ AD=0.18945p PS=1.095u PD=1.27u rfmode=0
M$1300 VSS \$910 \$967 VSS sg13_lv_nmos L=0.13u W=0.74u AS=0.317325p AD=0.2516p
+ PS=1.805u PD=2.16u rfmode=0
M$1301 VSS \$501 \$910 VSS sg13_lv_nmos L=0.13u W=0.74u AS=0.317325p AD=0.2516p
+ PS=1.805u PD=2.16u rfmode=0
M$1304 \$1013 \$995 VSS VSS sg13_lv_nmos L=0.13u W=0.55u AS=0.187p AD=0.18945p
+ PS=1.78u PD=1.27u rfmode=0
M$1305 VSS \$995 \$1059 VSS sg13_lv_nmos L=0.13u W=0.74u AS=0.18945p
+ AD=0.13135p PS=1.27u PD=1.095u rfmode=0
M$1306 \$1059 \$617 \$1001 VSS sg13_lv_nmos L=0.13u W=0.74u AS=0.13135p
+ AD=0.1628p PS=1.095u PD=1.18u rfmode=0
M$1307 \$1001 \$1034 \$1060 VSS sg13_lv_nmos L=0.13u W=0.74u AS=0.1628p
+ AD=0.3367p PS=1.18u PD=1.65u rfmode=0
M$1308 \$1060 \$1013 VSS VSS sg13_lv_nmos L=0.13u W=0.74u AS=0.3367p AD=0.148p
+ PS=1.65u PD=1.14u rfmode=0
M$1309 VSS \$1001 \$1002 VSS sg13_lv_nmos L=0.13u W=0.74u AS=0.148p AD=0.4033p
+ PS=1.14u PD=2.57u rfmode=0
M$1310 \$1003 \$660 VSS VSS sg13_lv_nmos L=0.13u W=0.55u AS=0.187p AD=0.14875p
+ PS=1.78u PD=1.16u rfmode=0
M$1311 VSS \$1003 \$883 VSS sg13_lv_nmos L=0.13u W=0.74u AS=0.14875p AD=0.2886p
+ PS=1.16u PD=2.26u rfmode=0
M$1312 \$932 \$912 \$947 VSS sg13_lv_nmos L=0.13u W=0.42u AS=0.1296p AD=0.0798p
+ PS=1.52u PD=0.8u rfmode=0
M$1313 \$947 \$968 \$933 VSS sg13_lv_nmos L=0.13u W=0.42u AS=0.0798p AD=0.2373p
+ PS=0.8u PD=1.97u rfmode=0
M$1316 VSS \$912 \$968 VSS sg13_lv_nmos L=0.13u W=0.74u AS=0.317325p AD=0.2516p
+ PS=1.805u PD=2.16u rfmode=0
M$1317 VSS \$501 \$912 VSS sg13_lv_nmos L=0.13u W=0.74u AS=0.317325p AD=0.2516p
+ PS=1.805u PD=2.16u rfmode=0
M$1336 \$1004 \$946 VSS VSS sg13_lv_nmos L=0.13u W=0.55u AS=0.187p AD=0.14875p
+ PS=1.78u PD=1.16u rfmode=0
M$1337 VSS \$1004 \$39 VSS sg13_lv_nmos L=0.13u W=0.74u AS=0.14875p AD=0.2886p
+ PS=1.16u PD=2.26u rfmode=0
M$1358 VSS \$1007 \$1008 VSS sg13_lv_nmos L=0.13u W=0.74u AS=0.1626p AD=0.2516p
+ PS=1.415u PD=2.16u rfmode=0
M$1359 \$1006 \$920 \$1054 VSS sg13_lv_nmos L=0.13u W=0.42u AS=0.1428p
+ AD=0.0609p PS=1.52u PD=0.71u rfmode=0
M$1360 VSS \$992 \$1054 VSS sg13_lv_nmos L=0.13u W=0.42u AS=0.1626p AD=0.0609p
+ PS=1.415u PD=0.71u rfmode=0
M$1361 \$1061 \$1092 \$1108 VSS sg13_lv_nmos L=0.13u W=0.42u AS=0.1428p
+ AD=0.0609p PS=1.52u PD=0.71u rfmode=0
M$1362 \$1108 \$1119 VSS VSS sg13_lv_nmos L=0.13u W=0.42u AS=0.0609p AD=0.1626p
+ PS=0.71u PD=1.415u rfmode=0
M$1363 VSS \$1118 \$1046 VSS sg13_lv_nmos L=0.13u W=0.74u AS=0.1626p AD=0.2516p
+ PS=1.415u PD=2.16u rfmode=0
M$1364 VSS \$992 \$1055 VSS sg13_lv_nmos L=0.13u W=0.42u AS=0.1701p AD=0.0378p
+ PS=1.65u PD=0.6u rfmode=0
M$1365 \$1055 \$1008 \$1030 VSS sg13_lv_nmos L=0.13u W=0.42u AS=0.0378p
+ AD=0.1428p PS=0.6u PD=1.52u rfmode=0
M$1366 VSS \$1119 \$1109 VSS sg13_lv_nmos L=0.13u W=0.42u AS=0.1701p AD=0.0378p
+ PS=1.65u PD=0.6u rfmode=0
M$1367 \$1109 \$1046 \$1093 VSS sg13_lv_nmos L=0.13u W=0.42u AS=0.0378p
+ AD=0.1428p PS=0.6u PD=1.52u rfmode=0
M$1368 \$1094 \$1047 \$1062 VSS sg13_lv_nmos L=0.13u W=0.42u AS=0.12665p
+ AD=0.1428p PS=1.145u PD=1.52u rfmode=0
M$1369 \$1046 \$1120 \$1094 VSS sg13_lv_nmos L=0.13u W=0.74u AS=0.3473p
+ AD=0.12665p PS=2.71u PD=1.145u rfmode=0
M$1370 \$1031 \$1012 VSS VSS sg13_lv_nmos L=0.13u W=0.42u AS=0.1428p AD=0.0798p
+ PS=1.52u PD=0.8u rfmode=0
M$1371 VSS \$992 \$1056 VSS sg13_lv_nmos L=0.13u W=0.42u AS=0.0798p AD=0.0378p
+ PS=0.8u PD=0.6u rfmode=0
M$1372 \$1056 \$1011 \$1012 VSS sg13_lv_nmos L=0.13u W=0.42u AS=0.0378p
+ AD=0.1428p PS=0.6u PD=1.52u rfmode=0
M$1373 \$1062 \$1063 VSS VSS sg13_lv_nmos L=0.13u W=0.42u AS=0.1428p AD=0.0798p
+ PS=1.52u PD=0.8u rfmode=0
M$1374 VSS \$1119 \$1112 VSS sg13_lv_nmos L=0.13u W=0.42u AS=0.0798p AD=0.0378p
+ PS=0.8u PD=0.6u rfmode=0
M$1375 \$1112 \$1094 \$1063 VSS sg13_lv_nmos L=0.13u W=0.42u AS=0.0378p
+ AD=0.1428p PS=0.6u PD=1.52u rfmode=0
M$1376 \$1064 \$1094 VSS VSS sg13_lv_nmos L=0.13u W=0.74u AS=0.2516p AD=0.1406p
+ PS=2.16u PD=1.12u rfmode=0
M$1377 VSS \$1064 \$1065 VSS sg13_lv_nmos L=0.13u W=0.74u AS=0.1406p AD=0.2516p
+ PS=1.12u PD=2.16u rfmode=0
M$1378 VSS \$428 \$1066 VSS sg13_lv_nmos L=0.13u W=0.74u AS=0.2516p AD=0.2516p
+ PS=2.16u PD=2.16u rfmode=0
M$1383 \$1067 \$1068 VSS VSS sg13_lv_nmos L=0.13u W=0.74u AS=0.4033p AD=0.148p
+ PS=2.57u PD=1.14u rfmode=0
M$1384 VSS \$1121 \$1114 VSS sg13_lv_nmos L=0.13u W=0.74u AS=0.148p AD=0.3367p
+ PS=1.14u PD=1.65u rfmode=0
M$1385 \$1114 \$1095 \$1068 VSS sg13_lv_nmos L=0.13u W=0.74u AS=0.3367p
+ AD=0.1628p PS=1.65u PD=1.18u rfmode=0
M$1386 \$1068 \$626 \$1116 VSS sg13_lv_nmos L=0.13u W=0.74u AS=0.1628p
+ AD=0.13135p PS=1.18u PD=1.095u rfmode=0
M$1387 \$1116 \$603 VSS VSS sg13_lv_nmos L=0.13u W=0.74u AS=0.13135p
+ AD=0.18945p PS=1.095u PD=1.27u rfmode=0
M$1388 VSS \$603 \$1121 VSS sg13_lv_nmos L=0.13u W=0.55u AS=0.18945p AD=0.187p
+ PS=1.27u PD=1.78u rfmode=0
M$1393 VSS \$1122 \$1069 VSS sg13_lv_nmos L=0.13u W=0.74u AS=0.2516p AD=0.2516p
+ PS=2.16u PD=2.16u rfmode=0
M$1394 \$1070 \$1069 VSS VSS sg13_lv_nmos L=0.15u W=0.74u AS=0.2516p AD=0.1406p
+ PS=2.16u PD=1.12u rfmode=0
M$1395 VSS \$995 \$1070 VSS sg13_lv_nmos L=0.15u W=0.74u AS=0.1406p AD=0.1406p
+ PS=1.12u PD=1.12u rfmode=0
M$1396 \$1070 \$1123 \$1096 VSS sg13_lv_nmos L=0.15u W=0.74u AS=0.1406p
+ AD=0.2516p PS=1.12u PD=2.16u rfmode=0
M$1397 \$1123 \$996 \$1071 VSS sg13_lv_nmos L=0.15u W=0.74u AS=0.2516p
+ AD=0.1406p PS=2.16u PD=1.12u rfmode=0
M$1398 \$1071 \$344 VSS VSS sg13_lv_nmos L=0.15u W=0.74u AS=0.1406p AD=0.1406p
+ PS=1.12u PD=1.12u rfmode=0
M$1399 VSS \$994 \$1071 VSS sg13_lv_nmos L=0.15u W=0.74u AS=0.1406p AD=0.2516p
+ PS=1.12u PD=2.16u rfmode=0
M$1403 VSS \$994 \$1097 VSS sg13_lv_nmos L=0.13u W=0.55u AS=0.17255p AD=0.187p
+ PS=1.25u PD=1.78u rfmode=0
M$1404 VSS \$1097 \$1124 VSS sg13_lv_nmos L=0.13u W=0.74u AS=0.17255p
+ AD=0.1406p PS=1.25u PD=1.12u rfmode=0
M$1405 \$1124 \$748 VSS VSS sg13_lv_nmos L=0.13u W=0.74u AS=0.1406p AD=0.2516p
+ PS=1.12u PD=2.16u rfmode=0
M$1406 \$1072 \$1125 VSS VSS sg13_lv_nmos L=0.15u W=0.74u AS=0.2516p AD=0.1406p
+ PS=2.16u PD=1.12u rfmode=0
M$1407 VSS \$1124 \$1072 VSS sg13_lv_nmos L=0.15u W=0.74u AS=0.1406p AD=0.1406p
+ PS=1.12u PD=1.12u rfmode=0
M$1408 \$1072 \$998 \$1073 VSS sg13_lv_nmos L=0.15u W=0.74u AS=0.1406p
+ AD=0.2516p PS=1.12u PD=2.16u rfmode=0
M$1409 \$1074 \$335 VSS VSS sg13_lv_nmos L=0.13u W=0.74u AS=0.2516p AD=0.2516p
+ PS=2.16u PD=2.16u rfmode=0
M$1412 VSS \$335 \$1075 VSS sg13_lv_nmos L=0.13u W=0.74u AS=0.2516p AD=0.2516p
+ PS=2.16u PD=2.16u rfmode=0
M$1414 \$1076 \$999 \$1117 VSS sg13_lv_nmos L=0.13u W=0.42u AS=0.1428p
+ AD=0.0609p PS=1.52u PD=0.71u rfmode=0
M$1415 \$1117 \$1075 VSS VSS sg13_lv_nmos L=0.13u W=0.42u AS=0.0609p AD=0.1626p
+ PS=0.71u PD=1.415u rfmode=0
M$1416 VSS \$1126 \$1048 VSS sg13_lv_nmos L=0.13u W=0.74u AS=0.1626p AD=0.2516p
+ PS=1.415u PD=2.16u rfmode=0
M$1417 VSS \$1075 \$1115 VSS sg13_lv_nmos L=0.13u W=0.42u AS=0.1701p AD=0.0378p
+ PS=1.65u PD=0.6u rfmode=0
M$1418 \$1115 \$1048 \$1098 VSS sg13_lv_nmos L=0.13u W=0.42u AS=0.0378p
+ AD=0.1428p PS=0.6u PD=1.52u rfmode=0
M$1419 \$1099 \$1049 \$1077 VSS sg13_lv_nmos L=0.13u W=0.42u AS=0.12665p
+ AD=0.1428p PS=1.145u PD=1.52u rfmode=0
M$1420 \$1048 \$1127 \$1099 VSS sg13_lv_nmos L=0.13u W=0.74u AS=0.3473p
+ AD=0.12665p PS=2.71u PD=1.145u rfmode=0
M$1421 \$1077 \$1078 VSS VSS sg13_lv_nmos L=0.13u W=0.42u AS=0.1428p AD=0.0798p
+ PS=1.52u PD=0.8u rfmode=0
M$1422 VSS \$1075 \$1113 VSS sg13_lv_nmos L=0.13u W=0.42u AS=0.0798p AD=0.0378p
+ PS=0.8u PD=0.6u rfmode=0
M$1423 \$1113 \$1099 \$1078 VSS sg13_lv_nmos L=0.13u W=0.42u AS=0.0378p
+ AD=0.1428p PS=0.6u PD=1.52u rfmode=0
M$1425 \$1079 \$1099 VSS VSS sg13_lv_nmos L=0.13u W=0.74u AS=0.2516p AD=0.1406p
+ PS=2.16u PD=1.12u rfmode=0
M$1426 VSS \$1079 \$1033 VSS sg13_lv_nmos L=0.13u W=0.74u AS=0.1406p AD=0.2516p
+ PS=1.12u PD=2.16u rfmode=0
M$1427 \$1080 \$883 VSS VSS sg13_lv_nmos L=0.13u W=0.74u AS=0.2516p AD=0.2516p
+ PS=2.16u PD=2.16u rfmode=0
M$1428 VSS \$883 \$1081 VSS sg13_lv_nmos L=0.13u W=0.74u AS=0.2516p AD=0.2516p
+ PS=2.16u PD=2.16u rfmode=0
M$1429 \$1082 \$1002 \$1111 VSS sg13_lv_nmos L=0.13u W=0.42u AS=0.1428p
+ AD=0.0609p PS=1.52u PD=0.71u rfmode=0
M$1430 \$1111 \$1081 VSS VSS sg13_lv_nmos L=0.13u W=0.42u AS=0.0609p AD=0.1626p
+ PS=0.71u PD=1.415u rfmode=0
M$1431 VSS \$1128 \$1050 VSS sg13_lv_nmos L=0.13u W=0.74u AS=0.1626p AD=0.2516p
+ PS=1.415u PD=2.16u rfmode=0
M$1432 VSS \$1081 \$1110 VSS sg13_lv_nmos L=0.13u W=0.42u AS=0.1701p AD=0.0378p
+ PS=1.65u PD=0.6u rfmode=0
M$1433 \$1110 \$1050 \$1100 VSS sg13_lv_nmos L=0.13u W=0.42u AS=0.0378p
+ AD=0.1428p PS=0.6u PD=1.52u rfmode=0
M$1434 \$1101 \$1051 \$1083 VSS sg13_lv_nmos L=0.13u W=0.42u AS=0.12665p
+ AD=0.1428p PS=1.145u PD=1.52u rfmode=0
M$1435 \$1050 \$1129 \$1101 VSS sg13_lv_nmos L=0.13u W=0.74u AS=0.3473p
+ AD=0.12665p PS=2.71u PD=1.145u rfmode=0
M$1436 \$1083 \$1084 VSS VSS sg13_lv_nmos L=0.13u W=0.42u AS=0.1428p AD=0.0798p
+ PS=1.52u PD=0.8u rfmode=0
M$1437 VSS \$1081 \$1107 VSS sg13_lv_nmos L=0.13u W=0.42u AS=0.0798p AD=0.0378p
+ PS=0.8u PD=0.6u rfmode=0
M$1438 \$1107 \$1101 \$1084 VSS sg13_lv_nmos L=0.13u W=0.42u AS=0.0378p
+ AD=0.1428p PS=0.6u PD=1.52u rfmode=0
M$1439 \$1085 \$1101 VSS VSS sg13_lv_nmos L=0.13u W=0.74u AS=0.2516p AD=0.1406p
+ PS=2.16u PD=1.12u rfmode=0
M$1440 VSS \$1085 \$1034 VSS sg13_lv_nmos L=0.13u W=0.74u AS=0.1406p AD=0.2516p
+ PS=1.12u PD=2.16u rfmode=0
M$1442 VSS \$883 \$1086 VSS sg13_lv_nmos L=0.13u W=0.74u AS=0.2516p AD=0.2516p
+ PS=2.16u PD=2.16u rfmode=0
M$1443 \$1087 \$1288 \$1106 VSS sg13_lv_nmos L=0.13u W=0.42u AS=0.1428p
+ AD=0.0609p PS=1.52u PD=0.71u rfmode=0
M$1444 \$1106 \$1086 VSS VSS sg13_lv_nmos L=0.13u W=0.42u AS=0.0609p AD=0.1626p
+ PS=0.71u PD=1.415u rfmode=0
M$1445 VSS \$1131 \$1052 VSS sg13_lv_nmos L=0.13u W=0.74u AS=0.1626p AD=0.2516p
+ PS=1.415u PD=2.16u rfmode=0
M$1446 VSS \$1086 \$1105 VSS sg13_lv_nmos L=0.13u W=0.42u AS=0.1701p AD=0.0378p
+ PS=1.65u PD=0.6u rfmode=0
M$1447 \$1105 \$1052 \$1102 VSS sg13_lv_nmos L=0.13u W=0.42u AS=0.0378p
+ AD=0.1428p PS=0.6u PD=1.52u rfmode=0
M$1448 \$1103 \$1053 \$1088 VSS sg13_lv_nmos L=0.13u W=0.42u AS=0.12665p
+ AD=0.1428p PS=1.145u PD=1.52u rfmode=0
M$1449 \$1052 \$1132 \$1103 VSS sg13_lv_nmos L=0.13u W=0.74u AS=0.3473p
+ AD=0.12665p PS=2.71u PD=1.145u rfmode=0
M$1450 \$1088 \$1089 VSS VSS sg13_lv_nmos L=0.13u W=0.42u AS=0.1428p AD=0.0798p
+ PS=1.52u PD=0.8u rfmode=0
M$1451 VSS \$1086 \$1104 VSS sg13_lv_nmos L=0.13u W=0.42u AS=0.0798p AD=0.0378p
+ PS=0.8u PD=0.6u rfmode=0
M$1452 \$1104 \$1103 \$1089 VSS sg13_lv_nmos L=0.13u W=0.42u AS=0.0378p
+ AD=0.1428p PS=0.6u PD=1.52u rfmode=0
M$1453 \$1090 \$1103 VSS VSS sg13_lv_nmos L=0.13u W=0.74u AS=0.2516p AD=0.1406p
+ PS=2.16u PD=1.12u rfmode=0
M$1454 VSS \$1090 \$1091 VSS sg13_lv_nmos L=0.13u W=0.74u AS=0.1406p AD=0.2516p
+ PS=1.12u PD=2.16u rfmode=0
M$1480 VSS \$435 \$1119 VSS sg13_lv_nmos L=0.13u W=0.74u AS=0.2516p AD=0.2516p
+ PS=2.16u PD=2.16u rfmode=0
M$1481 \$1061 \$1047 \$1118 VSS sg13_lv_nmos L=0.13u W=0.42u AS=0.1296p
+ AD=0.0798p PS=1.52u PD=0.8u rfmode=0
M$1482 \$1118 \$1120 \$1093 VSS sg13_lv_nmos L=0.13u W=0.42u AS=0.0798p
+ AD=0.2373p PS=0.8u PD=1.97u rfmode=0
M$1483 VSS \$922 \$1154 VSS sg13_lv_nmos L=0.13u W=0.55u AS=0.18945p AD=0.187p
+ PS=1.27u PD=1.78u rfmode=0
M$1484 \$1092 \$1232 VSS VSS sg13_lv_nmos L=0.13u W=0.74u AS=0.4033p AD=0.148p
+ PS=2.57u PD=1.14u rfmode=0
M$1485 VSS \$1154 \$1249 VSS sg13_lv_nmos L=0.13u W=0.74u AS=0.148p AD=0.3367p
+ PS=1.14u PD=1.65u rfmode=0
M$1486 \$1249 \$1065 \$1232 VSS sg13_lv_nmos L=0.13u W=0.74u AS=0.3367p
+ AD=0.1628p PS=1.65u PD=1.18u rfmode=0
M$1487 \$1232 \$626 \$1250 VSS sg13_lv_nmos L=0.13u W=0.74u AS=0.1628p
+ AD=0.13135p PS=1.18u PD=1.095u rfmode=0
M$1488 \$1250 \$922 VSS VSS sg13_lv_nmos L=0.13u W=0.74u AS=0.13135p
+ AD=0.18945p PS=1.095u PD=1.27u rfmode=0
M$1489 VSS \$1047 \$1120 VSS sg13_lv_nmos L=0.13u W=0.74u AS=0.317325p
+ AD=0.2516p PS=1.805u PD=2.16u rfmode=0
M$1490 VSS \$489 \$1047 VSS sg13_lv_nmos L=0.13u W=0.74u AS=0.317325p
+ AD=0.2516p PS=1.805u PD=2.16u rfmode=0
M$1491 \$1168 \$1172 \$1170 VSS sg13_lv_nmos L=0.13u W=0.42u AS=0.1296p
+ AD=0.0798p PS=1.52u PD=0.8u rfmode=0
M$1492 \$1170 \$1171 \$1233 VSS sg13_lv_nmos L=0.13u W=0.42u AS=0.0798p
+ AD=0.2373p PS=0.8u PD=1.97u rfmode=0
M$1493 \$1171 \$1172 VSS VSS sg13_lv_nmos L=0.13u W=0.74u AS=0.2516p
+ AD=0.317325p PS=2.16u PD=1.805u rfmode=0
M$1494 VSS \$489 \$1172 VSS sg13_lv_nmos L=0.13u W=0.74u AS=0.317325p
+ AD=0.2516p PS=1.805u PD=2.16u rfmode=0
M$1495 \$1240 \$1172 \$1173 VSS sg13_lv_nmos L=0.13u W=0.42u AS=0.1428p
+ AD=0.12665p PS=1.52u PD=1.145u rfmode=0
M$1496 \$1173 \$1171 \$1169 VSS sg13_lv_nmos L=0.13u W=0.74u AS=0.12665p
+ AD=0.3473p PS=1.145u PD=2.71u rfmode=0
M$1497 \$1155 \$1173 VSS VSS sg13_lv_nmos L=0.13u W=0.74u AS=0.2516p AD=0.1406p
+ PS=2.16u PD=1.12u rfmode=0
M$1498 VSS \$1155 \$1293 VSS sg13_lv_nmos L=0.13u W=0.74u AS=0.1406p AD=0.2516p
+ PS=1.12u PD=2.16u rfmode=0
M$1499 \$1175 \$1179 \$1177 VSS sg13_lv_nmos L=0.13u W=0.42u AS=0.1296p
+ AD=0.0798p PS=1.52u PD=0.8u rfmode=0
M$1500 \$1177 \$1178 \$1234 VSS sg13_lv_nmos L=0.13u W=0.42u AS=0.0798p
+ AD=0.2373p PS=0.8u PD=1.97u rfmode=0
M$1501 \$1178 \$1179 VSS VSS sg13_lv_nmos L=0.13u W=0.74u AS=0.2516p
+ AD=0.317325p PS=2.16u PD=1.805u rfmode=0
M$1502 VSS \$740 \$1179 VSS sg13_lv_nmos L=0.13u W=0.74u AS=0.317325p
+ AD=0.2516p PS=1.805u PD=2.16u rfmode=0
M$1503 \$1241 \$1179 \$1180 VSS sg13_lv_nmos L=0.13u W=0.42u AS=0.1428p
+ AD=0.12665p PS=1.52u PD=1.145u rfmode=0
M$1504 \$1180 \$1178 \$1176 VSS sg13_lv_nmos L=0.13u W=0.74u AS=0.12665p
+ AD=0.3473p PS=1.145u PD=2.71u rfmode=0
M$1505 \$1157 \$1180 VSS VSS sg13_lv_nmos L=0.13u W=0.74u AS=0.2516p AD=0.1406p
+ PS=2.16u PD=1.12u rfmode=0
M$1506 VSS \$1157 \$1095 VSS sg13_lv_nmos L=0.13u W=0.74u AS=0.1406p AD=0.2516p
+ PS=1.12u PD=2.16u rfmode=0
M$1507 \$1182 \$1186 \$1184 VSS sg13_lv_nmos L=0.13u W=0.42u AS=0.1296p
+ AD=0.0798p PS=1.52u PD=0.8u rfmode=0
M$1508 \$1184 \$1185 \$1235 VSS sg13_lv_nmos L=0.13u W=0.42u AS=0.0798p
+ AD=0.2373p PS=0.8u PD=1.97u rfmode=0
M$1509 \$1185 \$1186 VSS VSS sg13_lv_nmos L=0.13u W=0.74u AS=0.2516p
+ AD=0.317325p PS=2.16u PD=1.805u rfmode=0
M$1510 VSS \$740 \$1186 VSS sg13_lv_nmos L=0.13u W=0.74u AS=0.317325p
+ AD=0.2516p PS=1.805u PD=2.16u rfmode=0
M$1511 \$1242 \$1186 \$1187 VSS sg13_lv_nmos L=0.13u W=0.42u AS=0.1428p
+ AD=0.12665p PS=1.52u PD=1.145u rfmode=0
M$1512 \$1187 \$1185 \$1183 VSS sg13_lv_nmos L=0.13u W=0.74u AS=0.12665p
+ AD=0.3473p PS=1.145u PD=2.71u rfmode=0
M$1513 \$1159 \$1187 VSS VSS sg13_lv_nmos L=0.13u W=0.74u AS=0.2516p AD=0.1406p
+ PS=2.16u PD=1.12u rfmode=0
M$1514 VSS \$1159 \$1122 VSS sg13_lv_nmos L=0.13u W=0.74u AS=0.1406p AD=0.2516p
+ PS=1.12u PD=2.16u rfmode=0
M$1515 \$1189 \$1193 \$1191 VSS sg13_lv_nmos L=0.13u W=0.42u AS=0.1296p
+ AD=0.0798p PS=1.52u PD=0.8u rfmode=0
M$1516 \$1191 \$1192 \$1236 VSS sg13_lv_nmos L=0.13u W=0.42u AS=0.0798p
+ AD=0.2373p PS=0.8u PD=1.97u rfmode=0
M$1517 \$1192 \$1193 VSS VSS sg13_lv_nmos L=0.13u W=0.74u AS=0.2516p
+ AD=0.317325p PS=2.16u PD=1.805u rfmode=0
M$1518 VSS \$501 \$1193 VSS sg13_lv_nmos L=0.13u W=0.74u AS=0.317325p
+ AD=0.2516p PS=1.805u PD=2.16u rfmode=0
M$1519 \$1243 \$1193 \$1194 VSS sg13_lv_nmos L=0.13u W=0.42u AS=0.1428p
+ AD=0.12665p PS=1.52u PD=1.145u rfmode=0
M$1520 \$1194 \$1192 \$1190 VSS sg13_lv_nmos L=0.13u W=0.74u AS=0.12665p
+ AD=0.3473p PS=1.145u PD=2.71u rfmode=0
M$1521 \$1160 \$1194 VSS VSS sg13_lv_nmos L=0.13u W=0.74u AS=0.2516p AD=0.1406p
+ PS=2.16u PD=1.12u rfmode=0
M$1522 VSS \$1160 \$1161 VSS sg13_lv_nmos L=0.13u W=0.74u AS=0.1406p AD=0.2516p
+ PS=1.12u PD=2.16u rfmode=0
M$1523 \$1076 \$1049 \$1126 VSS sg13_lv_nmos L=0.13u W=0.42u AS=0.1296p
+ AD=0.0798p PS=1.52u PD=0.8u rfmode=0
M$1524 \$1126 \$1127 \$1098 VSS sg13_lv_nmos L=0.13u W=0.42u AS=0.0798p
+ AD=0.2373p PS=0.8u PD=1.97u rfmode=0
M$1527 VSS \$1049 \$1127 VSS sg13_lv_nmos L=0.13u W=0.74u AS=0.317325p
+ AD=0.2516p PS=1.805u PD=2.16u rfmode=0
M$1528 VSS \$501 \$1049 VSS sg13_lv_nmos L=0.13u W=0.74u AS=0.317325p
+ AD=0.2516p PS=1.805u PD=2.16u rfmode=0
M$1529 \$1196 \$995 VSS VSS sg13_lv_nmos L=0.13u W=0.55u AS=0.187p AD=0.18945p
+ PS=1.78u PD=1.27u rfmode=0
M$1530 VSS \$995 \$1266 VSS sg13_lv_nmos L=0.13u W=0.74u AS=0.18945p
+ AD=0.13135p PS=1.27u PD=1.095u rfmode=0
M$1531 \$1266 \$617 \$1197 VSS sg13_lv_nmos L=0.13u W=0.74u AS=0.13135p
+ AD=0.1628p PS=1.095u PD=1.18u rfmode=0
M$1532 \$1197 \$1237 \$1267 VSS sg13_lv_nmos L=0.13u W=0.74u AS=0.1628p
+ AD=0.3367p PS=1.18u PD=1.65u rfmode=0
M$1533 \$1267 \$1196 VSS VSS sg13_lv_nmos L=0.13u W=0.74u AS=0.3367p AD=0.148p
+ PS=1.65u PD=1.14u rfmode=0
M$1534 VSS \$1197 \$1162 VSS sg13_lv_nmos L=0.13u W=0.74u AS=0.148p AD=0.4033p
+ PS=1.14u PD=2.57u rfmode=0
M$1535 \$1198 \$1202 \$1200 VSS sg13_lv_nmos L=0.13u W=0.42u AS=0.1296p
+ AD=0.0798p PS=1.52u PD=0.8u rfmode=0
M$1536 \$1200 \$1201 \$1238 VSS sg13_lv_nmos L=0.13u W=0.42u AS=0.0798p
+ AD=0.2373p PS=0.8u PD=1.97u rfmode=0
M$1537 \$1201 \$1202 VSS VSS sg13_lv_nmos L=0.13u W=0.74u AS=0.2516p
+ AD=0.317325p PS=2.16u PD=1.805u rfmode=0
M$1538 VSS \$1130 \$1202 VSS sg13_lv_nmos L=0.13u W=0.74u AS=0.317325p
+ AD=0.2516p PS=1.805u PD=2.16u rfmode=0
M$1539 \$1244 \$1202 \$1203 VSS sg13_lv_nmos L=0.13u W=0.42u AS=0.1428p
+ AD=0.12665p PS=1.52u PD=1.145u rfmode=0
M$1540 \$1203 \$1201 \$1199 VSS sg13_lv_nmos L=0.13u W=0.74u AS=0.12665p
+ AD=0.3473p PS=1.145u PD=2.71u rfmode=0
M$1541 \$1082 \$1051 \$1128 VSS sg13_lv_nmos L=0.13u W=0.42u AS=0.1296p
+ AD=0.0798p PS=1.52u PD=0.8u rfmode=0
M$1542 \$1128 \$1129 \$1100 VSS sg13_lv_nmos L=0.13u W=0.42u AS=0.0798p
+ AD=0.2373p PS=0.8u PD=1.97u rfmode=0
M$1543 VSS \$1051 \$1129 VSS sg13_lv_nmos L=0.13u W=0.74u AS=0.317325p
+ AD=0.2516p PS=1.805u PD=2.16u rfmode=0
M$1544 VSS \$1130 \$1051 VSS sg13_lv_nmos L=0.13u W=0.74u AS=0.317325p
+ AD=0.2516p PS=1.805u PD=2.16u rfmode=0
M$1545 \$1163 \$1203 VSS VSS sg13_lv_nmos L=0.13u W=0.74u AS=0.2516p AD=0.1406p
+ PS=2.16u PD=1.12u rfmode=0
M$1546 VSS \$1163 \$1237 VSS sg13_lv_nmos L=0.13u W=0.74u AS=0.1406p AD=0.2516p
+ PS=1.12u PD=2.16u rfmode=0
M$1549 \$1205 \$1124 VSS VSS sg13_lv_nmos L=0.13u W=0.55u AS=0.187p AD=0.18945p
+ PS=1.78u PD=1.27u rfmode=0
M$1550 VSS \$1124 \$1273 VSS sg13_lv_nmos L=0.13u W=0.74u AS=0.18945p
+ AD=0.13135p PS=1.27u PD=1.095u rfmode=0
M$1551 \$1273 \$617 \$1206 VSS sg13_lv_nmos L=0.13u W=0.74u AS=0.13135p
+ AD=0.1628p PS=1.095u PD=1.18u rfmode=0
M$1552 \$1206 \$1167 \$1274 VSS sg13_lv_nmos L=0.13u W=0.74u AS=0.1628p
+ AD=0.3367p PS=1.18u PD=1.65u rfmode=0
M$1553 \$1274 \$1205 VSS VSS sg13_lv_nmos L=0.13u W=0.74u AS=0.3367p AD=0.148p
+ PS=1.65u PD=1.14u rfmode=0
M$1554 VSS \$1206 \$1164 VSS sg13_lv_nmos L=0.13u W=0.74u AS=0.148p AD=0.4033p
+ PS=1.14u PD=2.57u rfmode=0
M$1555 \$1207 \$1211 \$1209 VSS sg13_lv_nmos L=0.13u W=0.42u AS=0.1296p
+ AD=0.0798p PS=1.52u PD=0.8u rfmode=0
M$1556 \$1209 \$1210 \$1239 VSS sg13_lv_nmos L=0.13u W=0.42u AS=0.0798p
+ AD=0.2373p PS=0.8u PD=1.97u rfmode=0
M$1557 \$1087 \$1053 \$1131 VSS sg13_lv_nmos L=0.13u W=0.42u AS=0.1296p
+ AD=0.0798p PS=1.52u PD=0.8u rfmode=0
M$1558 \$1131 \$1132 \$1102 VSS sg13_lv_nmos L=0.13u W=0.42u AS=0.0798p
+ AD=0.2373p PS=0.8u PD=1.97u rfmode=0
M$1559 VSS \$1053 \$1132 VSS sg13_lv_nmos L=0.13u W=0.74u AS=0.317325p
+ AD=0.2516p PS=1.805u PD=2.16u rfmode=0
M$1560 VSS \$1130 \$1053 VSS sg13_lv_nmos L=0.13u W=0.74u AS=0.317325p
+ AD=0.2516p PS=1.805u PD=2.16u rfmode=0
M$1561 \$1210 \$1211 VSS VSS sg13_lv_nmos L=0.13u W=0.74u AS=0.2516p
+ AD=0.317325p PS=2.16u PD=1.805u rfmode=0
M$1562 VSS \$1130 \$1211 VSS sg13_lv_nmos L=0.13u W=0.74u AS=0.317325p
+ AD=0.2516p PS=1.805u PD=2.16u rfmode=0
M$1563 \$1245 \$1211 \$1212 VSS sg13_lv_nmos L=0.13u W=0.42u AS=0.1428p
+ AD=0.12665p PS=1.52u PD=1.145u rfmode=0
M$1564 \$1212 \$1210 \$1208 VSS sg13_lv_nmos L=0.13u W=0.74u AS=0.12665p
+ AD=0.3473p PS=1.145u PD=2.71u rfmode=0
M$1565 \$1166 \$1212 VSS VSS sg13_lv_nmos L=0.13u W=0.74u AS=0.2516p AD=0.1406p
+ PS=2.16u PD=1.12u rfmode=0
M$1566 VSS \$1166 \$1167 VSS sg13_lv_nmos L=0.13u W=0.74u AS=0.1406p AD=0.2516p
+ PS=1.12u PD=2.16u rfmode=0
M$1571 \$29 \$1290 VSS VSS sg13_lv_nmos L=0.13u W=0.74u AS=0.2886p AD=0.14875p
+ PS=2.26u PD=1.16u rfmode=0
M$1572 VSS \$1122 \$1290 VSS sg13_lv_nmos L=0.13u W=0.55u AS=0.14875p AD=0.187p
+ PS=1.16u PD=1.78u rfmode=0
M$1573 \$28 \$1291 VSS VSS sg13_lv_nmos L=0.13u W=0.74u AS=0.2886p AD=0.14875p
+ PS=2.26u PD=1.16u rfmode=0
M$1574 VSS \$1161 \$1291 VSS sg13_lv_nmos L=0.13u W=0.55u AS=0.14875p AD=0.187p
+ PS=1.16u PD=1.78u rfmode=0
M$1577 D0 \$1292 VSS VSS sg13_lv_nmos L=0.13u W=0.74u AS=0.2886p AD=0.14875p
+ PS=2.26u PD=1.16u rfmode=0
M$1578 VSS \$1293 \$1292 VSS sg13_lv_nmos L=0.13u W=0.55u AS=0.14875p AD=0.187p
+ PS=1.16u PD=1.78u rfmode=0
M$1589 D1 \$1294 VSS VSS sg13_lv_nmos L=0.13u W=0.74u AS=0.2886p AD=0.14875p
+ PS=2.26u PD=1.16u rfmode=0
M$1590 VSS \$919 \$1294 VSS sg13_lv_nmos L=0.13u W=0.55u AS=0.14875p AD=0.187p
+ PS=1.16u PD=1.78u rfmode=0
M$1601 VSS \$1170 \$1169 VSS sg13_lv_nmos L=0.13u W=0.74u AS=0.1626p AD=0.2516p
+ PS=1.415u PD=2.16u rfmode=0
M$1602 \$1168 \$1279 \$1251 VSS sg13_lv_nmos L=0.13u W=0.42u AS=0.1428p
+ AD=0.0609p PS=1.52u PD=0.71u rfmode=0
M$1603 VSS \$1066 \$1251 VSS sg13_lv_nmos L=0.13u W=0.42u AS=0.1626p AD=0.0609p
+ PS=1.415u PD=0.71u rfmode=0
M$1604 D2 \$1295 VSS VSS sg13_lv_nmos L=0.13u W=0.74u AS=0.2886p AD=0.14875p
+ PS=2.26u PD=1.16u rfmode=0
M$1605 VSS \$1065 \$1295 VSS sg13_lv_nmos L=0.13u W=0.55u AS=0.14875p AD=0.187p
+ PS=1.16u PD=1.78u rfmode=0
M$1606 VSS \$1066 \$1252 VSS sg13_lv_nmos L=0.13u W=0.42u AS=0.1701p AD=0.0378p
+ PS=1.65u PD=0.6u rfmode=0
M$1607 \$1252 \$1169 \$1233 VSS sg13_lv_nmos L=0.13u W=0.42u AS=0.0378p
+ AD=0.1428p PS=0.6u PD=1.52u rfmode=0
M$1608 \$1279 \$1280 VSS VSS sg13_lv_nmos L=0.13u W=0.74u AS=0.4033p AD=0.148p
+ PS=2.57u PD=1.14u rfmode=0
M$1609 VSS \$1281 \$1306 VSS sg13_lv_nmos L=0.13u W=0.74u AS=0.148p AD=0.3367p
+ PS=1.14u PD=1.65u rfmode=0
M$1610 \$1306 \$1293 \$1280 VSS sg13_lv_nmos L=0.13u W=0.74u AS=0.3367p
+ AD=0.1628p PS=1.65u PD=1.18u rfmode=0
M$1611 \$1280 \$626 \$1307 VSS sg13_lv_nmos L=0.13u W=0.74u AS=0.1628p
+ AD=0.13135p PS=1.18u PD=1.095u rfmode=0
M$1612 \$1307 \$798 VSS VSS sg13_lv_nmos L=0.13u W=0.74u AS=0.13135p
+ AD=0.18945p PS=1.095u PD=1.27u rfmode=0
M$1613 VSS \$798 \$1281 VSS sg13_lv_nmos L=0.13u W=0.55u AS=0.18945p AD=0.187p
+ PS=1.27u PD=1.78u rfmode=0
M$1616 \$1240 \$1174 VSS VSS sg13_lv_nmos L=0.13u W=0.42u AS=0.1428p AD=0.0798p
+ PS=1.52u PD=0.8u rfmode=0
M$1617 VSS \$1066 \$1253 VSS sg13_lv_nmos L=0.13u W=0.42u AS=0.0798p AD=0.0378p
+ PS=0.8u PD=0.6u rfmode=0
M$1618 \$1253 \$1173 \$1174 VSS sg13_lv_nmos L=0.13u W=0.42u AS=0.0378p
+ AD=0.1428p PS=0.6u PD=1.52u rfmode=0
M$1620 VSS \$1177 \$1176 VSS sg13_lv_nmos L=0.13u W=0.74u AS=0.1626p AD=0.2516p
+ PS=1.415u PD=2.16u rfmode=0
M$1621 \$1175 \$1067 \$1254 VSS sg13_lv_nmos L=0.13u W=0.42u AS=0.1428p
+ AD=0.0609p PS=1.52u PD=0.71u rfmode=0
M$1622 VSS \$1156 \$1254 VSS sg13_lv_nmos L=0.13u W=0.42u AS=0.1626p AD=0.0609p
+ PS=1.415u PD=0.71u rfmode=0
M$1623 VSS \$435 \$1156 VSS sg13_lv_nmos L=0.13u W=0.74u AS=0.2516p AD=0.2516p
+ PS=2.16u PD=2.16u rfmode=0
M$1624 VSS \$1156 \$1256 VSS sg13_lv_nmos L=0.13u W=0.42u AS=0.1701p AD=0.0378p
+ PS=1.65u PD=0.6u rfmode=0
M$1625 \$1256 \$1176 \$1234 VSS sg13_lv_nmos L=0.13u W=0.42u AS=0.0378p
+ AD=0.1428p PS=0.6u PD=1.52u rfmode=0
M$1629 D3 \$1296 VSS VSS sg13_lv_nmos L=0.13u W=0.74u AS=0.2886p AD=0.14875p
+ PS=2.26u PD=1.16u rfmode=0
M$1630 VSS \$1095 \$1296 VSS sg13_lv_nmos L=0.13u W=0.55u AS=0.14875p AD=0.187p
+ PS=1.16u PD=1.78u rfmode=0
M$1631 \$1241 \$1181 VSS VSS sg13_lv_nmos L=0.13u W=0.42u AS=0.1428p AD=0.0798p
+ PS=1.52u PD=0.8u rfmode=0
M$1632 VSS \$1156 \$1257 VSS sg13_lv_nmos L=0.13u W=0.42u AS=0.0798p AD=0.0378p
+ PS=0.8u PD=0.6u rfmode=0
M$1633 \$1257 \$1180 \$1181 VSS sg13_lv_nmos L=0.13u W=0.42u AS=0.0378p
+ AD=0.1428p PS=0.6u PD=1.52u rfmode=0
M$1636 VSS \$1184 \$1183 VSS sg13_lv_nmos L=0.13u W=0.74u AS=0.1626p AD=0.2516p
+ PS=1.415u PD=2.16u rfmode=0
M$1637 \$1182 \$1096 \$1258 VSS sg13_lv_nmos L=0.13u W=0.42u AS=0.1428p
+ AD=0.0609p PS=1.52u PD=0.71u rfmode=0
M$1638 VSS \$1158 \$1258 VSS sg13_lv_nmos L=0.13u W=0.42u AS=0.1626p AD=0.0609p
+ PS=1.415u PD=0.71u rfmode=0
M$1639 VSS \$435 \$1158 VSS sg13_lv_nmos L=0.13u W=0.74u AS=0.2516p AD=0.2516p
+ PS=2.16u PD=2.16u rfmode=0
M$1640 VSS \$1158 \$1259 VSS sg13_lv_nmos L=0.13u W=0.42u AS=0.1701p AD=0.0378p
+ PS=1.65u PD=0.6u rfmode=0
M$1641 \$1259 \$1183 \$1235 VSS sg13_lv_nmos L=0.13u W=0.42u AS=0.0378p
+ AD=0.1428p PS=0.6u PD=1.52u rfmode=0
M$1646 \$1242 \$1188 VSS VSS sg13_lv_nmos L=0.13u W=0.42u AS=0.1428p AD=0.0798p
+ PS=1.52u PD=0.8u rfmode=0
M$1647 VSS \$1158 \$1260 VSS sg13_lv_nmos L=0.13u W=0.42u AS=0.0798p AD=0.0378p
+ PS=0.8u PD=0.6u rfmode=0
M$1648 \$1260 \$1187 \$1188 VSS sg13_lv_nmos L=0.13u W=0.42u AS=0.0378p
+ AD=0.1428p PS=0.6u PD=1.52u rfmode=0
M$1651 VSS \$1191 \$1190 VSS sg13_lv_nmos L=0.13u W=0.74u AS=0.1626p AD=0.2516p
+ PS=1.415u PD=2.16u rfmode=0
M$1652 \$1189 \$1073 \$1262 VSS sg13_lv_nmos L=0.13u W=0.42u AS=0.1428p
+ AD=0.0609p PS=1.52u PD=0.71u rfmode=0
M$1653 VSS \$1074 \$1262 VSS sg13_lv_nmos L=0.13u W=0.42u AS=0.1626p AD=0.0609p
+ PS=1.415u PD=0.71u rfmode=0
M$1654 VSS \$1161 \$1125 VSS sg13_lv_nmos L=0.13u W=0.74u AS=0.2516p AD=0.2516p
+ PS=2.16u PD=2.16u rfmode=0
M$1655 D4 \$1297 VSS VSS sg13_lv_nmos L=0.13u W=0.74u AS=0.2886p AD=0.14875p
+ PS=2.26u PD=1.16u rfmode=0
M$1656 VSS \$882 \$1297 VSS sg13_lv_nmos L=0.13u W=0.55u AS=0.14875p AD=0.187p
+ PS=1.16u PD=1.78u rfmode=0
M$1657 VSS \$1074 \$1263 VSS sg13_lv_nmos L=0.13u W=0.42u AS=0.1701p AD=0.0378p
+ PS=1.65u PD=0.6u rfmode=0
M$1658 \$1263 \$1190 \$1236 VSS sg13_lv_nmos L=0.13u W=0.42u AS=0.0378p
+ AD=0.1428p PS=0.6u PD=1.52u rfmode=0
M$1663 \$1243 \$1195 VSS VSS sg13_lv_nmos L=0.13u W=0.42u AS=0.1428p AD=0.0798p
+ PS=1.52u PD=0.8u rfmode=0
M$1664 VSS \$1074 \$1264 VSS sg13_lv_nmos L=0.13u W=0.42u AS=0.0798p AD=0.0378p
+ PS=0.8u PD=0.6u rfmode=0
M$1665 \$1264 \$1194 \$1195 VSS sg13_lv_nmos L=0.13u W=0.42u AS=0.0378p
+ AD=0.1428p PS=0.6u PD=1.52u rfmode=0
M$1672 D5 \$1298 VSS VSS sg13_lv_nmos L=0.13u W=0.74u AS=0.2886p AD=0.14875p
+ PS=2.26u PD=1.16u rfmode=0
M$1673 VSS \$1033 \$1298 VSS sg13_lv_nmos L=0.13u W=0.55u AS=0.14875p AD=0.187p
+ PS=1.16u PD=1.78u rfmode=0
M$1674 VSS \$1200 \$1199 VSS sg13_lv_nmos L=0.13u W=0.74u AS=0.1626p AD=0.2516p
+ PS=1.415u PD=2.16u rfmode=0
M$1675 \$1198 \$1162 \$1268 VSS sg13_lv_nmos L=0.13u W=0.42u AS=0.1428p
+ AD=0.0609p PS=1.52u PD=0.71u rfmode=0
M$1676 VSS \$1080 \$1268 VSS sg13_lv_nmos L=0.13u W=0.42u AS=0.1626p AD=0.0609p
+ PS=1.415u PD=0.71u rfmode=0
M$1679 VSS \$1080 \$1269 VSS sg13_lv_nmos L=0.13u W=0.42u AS=0.1701p AD=0.0378p
+ PS=1.65u PD=0.6u rfmode=0
M$1680 \$1269 \$1199 \$1238 VSS sg13_lv_nmos L=0.13u W=0.42u AS=0.0378p
+ AD=0.1428p PS=0.6u PD=1.52u rfmode=0
M$1682 \$1130 \$1299 VSS VSS sg13_lv_nmos L=0.13u W=0.74u AS=0.2886p
+ AD=0.14875p PS=2.26u PD=1.16u rfmode=0
M$1683 VSS \$336 \$1299 VSS sg13_lv_nmos L=0.13u W=0.55u AS=0.14875p AD=0.187p
+ PS=1.16u PD=1.78u rfmode=0
M$1686 \$1244 \$1204 VSS VSS sg13_lv_nmos L=0.13u W=0.42u AS=0.1428p AD=0.0798p
+ PS=1.52u PD=0.8u rfmode=0
M$1687 VSS \$1080 \$1270 VSS sg13_lv_nmos L=0.13u W=0.42u AS=0.0798p AD=0.0378p
+ PS=0.8u PD=0.6u rfmode=0
M$1688 \$1270 \$1203 \$1204 VSS sg13_lv_nmos L=0.13u W=0.42u AS=0.0378p
+ AD=0.1428p PS=0.6u PD=1.52u rfmode=0
M$1691 VSS \$1237 \$1300 VSS sg13_lv_nmos L=0.13u W=0.55u AS=0.14875p AD=0.187p
+ PS=1.16u PD=1.78u rfmode=0
M$1692 VSS \$1300 D6 VSS sg13_lv_nmos L=0.13u W=0.74u AS=0.14875p AD=0.2886p
+ PS=1.16u PD=2.26u rfmode=0
M$1693 VSS \$1124 \$1286 VSS sg13_lv_nmos L=0.13u W=0.55u AS=0.18945p AD=0.187p
+ PS=1.27u PD=1.78u rfmode=0
M$1694 VSS \$1124 \$1305 VSS sg13_lv_nmos L=0.13u W=0.74u AS=0.18945p
+ AD=0.13135p PS=1.27u PD=1.095u rfmode=0
M$1695 \$1305 \$617 \$1287 VSS sg13_lv_nmos L=0.13u W=0.74u AS=0.13135p
+ AD=0.1628p PS=1.095u PD=1.18u rfmode=0
M$1696 \$1287 \$1091 \$1304 VSS sg13_lv_nmos L=0.13u W=0.74u AS=0.1628p
+ AD=0.3367p PS=1.18u PD=1.65u rfmode=0
M$1697 \$1304 \$1286 VSS VSS sg13_lv_nmos L=0.13u W=0.74u AS=0.3367p AD=0.148p
+ PS=1.65u PD=1.14u rfmode=0
M$1698 VSS \$1287 \$1288 VSS sg13_lv_nmos L=0.13u W=0.74u AS=0.148p AD=0.4033p
+ PS=1.14u PD=2.57u rfmode=0
M$1699 VSS \$1209 \$1208 VSS sg13_lv_nmos L=0.13u W=0.74u AS=0.1626p AD=0.2516p
+ PS=1.415u PD=2.16u rfmode=0
M$1700 \$1207 \$1164 \$1275 VSS sg13_lv_nmos L=0.13u W=0.42u AS=0.1428p
+ AD=0.0609p PS=1.52u PD=0.71u rfmode=0
M$1701 VSS \$1165 \$1275 VSS sg13_lv_nmos L=0.13u W=0.42u AS=0.1626p AD=0.0609p
+ PS=1.415u PD=0.71u rfmode=0
M$1702 VSS \$883 \$1165 VSS sg13_lv_nmos L=0.13u W=0.74u AS=0.2516p AD=0.2516p
+ PS=2.16u PD=2.16u rfmode=0
M$1703 VSS \$1165 \$1271 VSS sg13_lv_nmos L=0.13u W=0.42u AS=0.1701p AD=0.0378p
+ PS=1.65u PD=0.6u rfmode=0
M$1704 \$1271 \$1208 \$1239 VSS sg13_lv_nmos L=0.13u W=0.42u AS=0.0378p
+ AD=0.1428p PS=0.6u PD=1.52u rfmode=0
M$1709 \$1245 \$1213 VSS VSS sg13_lv_nmos L=0.13u W=0.42u AS=0.1428p AD=0.0798p
+ PS=1.52u PD=0.8u rfmode=0
M$1710 VSS \$1165 \$1255 VSS sg13_lv_nmos L=0.13u W=0.42u AS=0.0798p AD=0.0378p
+ PS=0.8u PD=0.6u rfmode=0
M$1711 \$1255 \$1212 \$1213 VSS sg13_lv_nmos L=0.13u W=0.42u AS=0.0378p
+ AD=0.1428p PS=0.6u PD=1.52u rfmode=0
M$1716 D7 \$1301 VSS VSS sg13_lv_nmos L=0.13u W=0.74u AS=0.2886p AD=0.14875p
+ PS=2.26u PD=1.16u rfmode=0
M$1717 VSS \$1167 \$1301 VSS sg13_lv_nmos L=0.13u W=0.55u AS=0.14875p AD=0.187p
+ PS=1.16u PD=1.78u rfmode=0
M$1718 VSS \$1091 \$1302 VSS sg13_lv_nmos L=0.13u W=0.55u AS=0.14875p AD=0.187p
+ PS=1.16u PD=1.78u rfmode=0
M$1719 VSS \$1302 \$41 VSS sg13_lv_nmos L=0.13u W=0.74u AS=0.14875p AD=0.2886p
+ PS=1.16u PD=2.26u rfmode=0
M$1721 VSS \$1034 \$1303 VSS sg13_lv_nmos L=0.13u W=0.55u AS=0.14875p AD=0.187p
+ PS=1.16u PD=1.78u rfmode=0
M$1722 VSS \$1303 \$40 VSS sg13_lv_nmos L=0.13u W=0.74u AS=0.14875p AD=0.2886p
+ PS=1.16u PD=2.26u rfmode=0
M$1723 VDD \$29 \$16 VDD sg13_lv_pmos L=0.13u W=2u AS=0.68p AD=0.68p PS=4.68u
+ PD=4.68u rfmode=0
M$1724 \$17 \$40 VDD VDD sg13_lv_pmos L=0.13u W=2u AS=0.68p AD=0.68p PS=4.68u
+ PD=4.68u rfmode=0
M$1725 VSS \$71 \$16 VDD sg13_lv_pmos L=0.13u W=2u AS=0.68p AD=0.68p PS=4.68u
+ PD=4.68u rfmode=0
M$1726 \$17 \$82 VSS VDD sg13_lv_pmos L=0.13u W=2u AS=0.68p AD=0.68p PS=4.68u
+ PD=4.68u rfmode=0
M$1727 VDD \$28 \$6 VDD sg13_lv_pmos L=0.13u W=2u AS=0.68p AD=0.68p PS=4.68u
+ PD=4.68u rfmode=0
M$1728 VSS \$70 \$6 VDD sg13_lv_pmos L=0.13u W=2u AS=0.68p AD=0.68p PS=4.68u
+ PD=4.68u rfmode=0
M$1729 VDD \$34 \$21 VDD sg13_lv_pmos L=0.13u W=2u AS=0.68p AD=0.68p PS=4.68u
+ PD=4.68u rfmode=0
M$1730 \$22 \$35 VDD VDD sg13_lv_pmos L=0.13u W=2u AS=0.68p AD=0.68p PS=4.68u
+ PD=4.68u rfmode=0
M$1731 \$8 \$83 VSS VDD sg13_lv_pmos L=0.13u W=2u AS=0.68p AD=0.68p PS=4.68u
+ PD=4.68u rfmode=0
M$1732 \$8 \$41 VDD VDD sg13_lv_pmos L=0.13u W=2u AS=0.68p AD=0.68p PS=4.68u
+ PD=4.68u rfmode=0
M$1733 VDD \$30 \$18 VDD sg13_lv_pmos L=0.13u W=2u AS=0.68p AD=0.68p PS=4.68u
+ PD=4.68u rfmode=0
M$1734 VSS \$72 \$18 VDD sg13_lv_pmos L=0.13u W=2u AS=0.68p AD=0.68p PS=4.68u
+ PD=4.68u rfmode=0
M$1735 VDD \$31 \$19 VDD sg13_lv_pmos L=0.13u W=2u AS=0.68p AD=0.68p PS=4.68u
+ PD=4.68u rfmode=0
M$1736 VSS \$73 \$19 VDD sg13_lv_pmos L=0.13u W=2u AS=0.68p AD=0.68p PS=4.68u
+ PD=4.68u rfmode=0
M$1737 VDD \$32 \$25 VDD sg13_lv_pmos L=0.13u W=2u AS=0.68p AD=0.68p PS=4.68u
+ PD=4.68u rfmode=0
M$1738 VSS \$74 \$25 VDD sg13_lv_pmos L=0.13u W=2u AS=0.68p AD=0.68p PS=4.68u
+ PD=4.68u rfmode=0
M$1739 VSS \$76 \$21 VDD sg13_lv_pmos L=0.13u W=2u AS=0.68p AD=0.68p PS=4.68u
+ PD=4.68u rfmode=0
M$1740 \$22 \$77 VSS VDD sg13_lv_pmos L=0.13u W=2u AS=0.68p AD=0.68p PS=4.68u
+ PD=4.68u rfmode=0
M$1741 \$26 \$79 VSS VDD sg13_lv_pmos L=0.13u W=2u AS=0.68p AD=0.68p PS=4.68u
+ PD=4.68u rfmode=0
M$1742 \$26 \$37 VDD VDD sg13_lv_pmos L=0.13u W=2u AS=0.68p AD=0.68p PS=4.68u
+ PD=4.68u rfmode=0
M$1743 \$20 \$80 VSS VDD sg13_lv_pmos L=0.13u W=2u AS=0.68p AD=0.68p PS=4.68u
+ PD=4.68u rfmode=0
M$1744 \$20 \$38 VDD VDD sg13_lv_pmos L=0.13u W=2u AS=0.68p AD=0.68p PS=4.68u
+ PD=4.68u rfmode=0
M$1745 \$27 \$81 VSS VDD sg13_lv_pmos L=0.13u W=2u AS=0.68p AD=0.68p PS=4.68u
+ PD=4.68u rfmode=0
M$1746 \$27 \$39 VDD VDD sg13_lv_pmos L=0.13u W=2u AS=0.68p AD=0.68p PS=4.68u
+ PD=4.68u rfmode=0
M$1747 VDD \$28 \$70 VDD sg13_lv_pmos L=0.13u W=0.8u AS=0.272p AD=0.272p
+ PS=2.28u PD=2.28u rfmode=0
M$1748 VDD \$29 \$71 VDD sg13_lv_pmos L=0.13u W=0.8u AS=0.272p AD=0.272p
+ PS=2.28u PD=2.28u rfmode=0
M$1749 VDD \$30 \$72 VDD sg13_lv_pmos L=0.13u W=0.8u AS=0.272p AD=0.272p
+ PS=2.28u PD=2.28u rfmode=0
M$1750 VDD \$31 \$73 VDD sg13_lv_pmos L=0.13u W=0.8u AS=0.272p AD=0.272p
+ PS=2.28u PD=2.28u rfmode=0
M$1751 VDD \$32 \$74 VDD sg13_lv_pmos L=0.13u W=0.8u AS=0.272p AD=0.272p
+ PS=2.28u PD=2.28u rfmode=0
M$1752 VDD \$33 \$23 VDD sg13_lv_pmos L=0.13u W=2u AS=0.68p AD=0.68p PS=4.68u
+ PD=4.68u rfmode=0
M$1753 VDD \$33 \$75 VDD sg13_lv_pmos L=0.13u W=0.8u AS=0.272p AD=0.272p
+ PS=2.28u PD=2.28u rfmode=0
M$1754 VSS \$75 \$23 VDD sg13_lv_pmos L=0.13u W=2u AS=0.68p AD=0.68p PS=4.68u
+ PD=4.68u rfmode=0
M$1755 VDD \$34 \$76 VDD sg13_lv_pmos L=0.13u W=0.8u AS=0.272p AD=0.272p
+ PS=2.28u PD=2.28u rfmode=0
M$1756 \$219 clk_comp \$200 \$198 sg13_lv_pmos L=0.3u W=18u AS=4.095p AD=4.095p
+ PS=24.32u PD=24.32u rfmode=0
M$1760 \$200 bias VDD \$198 sg13_lv_pmos L=0.3u W=18u AS=4.095p AD=4.095p
+ PS=24.32u PD=24.32u rfmode=0
M$1764 \$77 \$35 VDD VDD sg13_lv_pmos L=0.13u W=0.8u AS=0.272p AD=0.272p
+ PS=2.28u PD=2.28u rfmode=0
M$1765 \$24 \$78 VSS VDD sg13_lv_pmos L=0.13u W=2u AS=0.68p AD=0.68p PS=4.68u
+ PD=4.68u rfmode=0
M$1766 \$78 \$36 VDD VDD sg13_lv_pmos L=0.13u W=0.8u AS=0.272p AD=0.272p
+ PS=2.28u PD=2.28u rfmode=0
M$1767 \$24 \$36 VDD VDD sg13_lv_pmos L=0.13u W=2u AS=0.68p AD=0.68p PS=4.68u
+ PD=4.68u rfmode=0
M$1768 \$79 \$37 VDD VDD sg13_lv_pmos L=0.13u W=0.8u AS=0.272p AD=0.272p
+ PS=2.28u PD=2.28u rfmode=0
M$1769 \$80 \$38 VDD VDD sg13_lv_pmos L=0.13u W=0.8u AS=0.272p AD=0.272p
+ PS=2.28u PD=2.28u rfmode=0
M$1770 \$81 \$39 VDD VDD sg13_lv_pmos L=0.13u W=0.8u AS=0.272p AD=0.272p
+ PS=2.28u PD=2.28u rfmode=0
M$1771 \$82 \$40 VDD VDD sg13_lv_pmos L=0.13u W=0.8u AS=0.272p AD=0.272p
+ PS=2.28u PD=2.28u rfmode=0
M$1772 \$83 \$41 VDD VDD sg13_lv_pmos L=0.13u W=0.8u AS=0.272p AD=0.272p
+ PS=2.28u PD=2.28u rfmode=0
M$1773 Op \$201 VDD \$198 sg13_lv_pmos L=0.2u W=8u AS=2.12p AD=2.12p PS=13.06u
+ PD=13.06u rfmode=0
M$1775 Om \$202 VDD \$198 sg13_lv_pmos L=0.2u W=8u AS=2.12p AD=2.12p PS=13.06u
+ PD=13.06u rfmode=0
M$1777 \$225 \$223 VDD VDD sg13_lv_pmos L=0.13u W=0.8u AS=0.272p AD=0.272p
+ PS=2.28u PD=2.28u rfmode=0
M$1778 \$223 fclk_samp VDD VDD sg13_lv_pmos L=0.13u W=0.8u AS=0.272p AD=0.272p
+ PS=2.28u PD=2.28u rfmode=0
M$1779 VDD fclk_samp \$226 VDD sg13_lv_pmos L=0.13u W=0.8u AS=0.272p AD=0.272p
+ PS=2.28u PD=2.28u rfmode=0
M$1780 VDD \$226 \$227 VDD sg13_lv_pmos L=0.13u W=0.8u AS=0.272p AD=0.272p
+ PS=2.28u PD=2.28u rfmode=0
M$1781 \$219 \$9 \$201 \$198 sg13_lv_pmos L=0.2u W=32u AS=8.48p AD=8.48p
+ PS=52.24u PD=52.24u rfmode=0
M$1783 \$219 \$7 \$202 \$198 sg13_lv_pmos L=0.2u W=32u AS=8.48p AD=8.48p
+ PS=52.24u PD=52.24u rfmode=0
M$1793 \$258 \$274 \$288 \$288 sg13_lv_pmos L=0.13u W=0.5u AS=0.17p AD=0.17p
+ PS=1.68u PD=1.68u rfmode=0
M$1794 \$274 \$278 VDD VDD sg13_lv_pmos L=0.13u W=0.8u AS=0.272p AD=0.272p
+ PS=2.28u PD=2.28u rfmode=0
M$1795 VDD \$278 \$234 VDD sg13_lv_pmos L=0.13u W=0.5u AS=0.17p AD=0.17p
+ PS=1.68u PD=1.68u rfmode=0
M$1796 \$238 \$279 VDD VDD sg13_lv_pmos L=0.13u W=0.5u AS=0.17p AD=0.17p
+ PS=1.68u PD=1.68u rfmode=0
M$1797 VDD \$279 \$275 VDD sg13_lv_pmos L=0.13u W=0.8u AS=0.272p AD=0.272p
+ PS=2.28u PD=2.28u rfmode=0
M$1798 \$249 \$275 \$260 \$249 sg13_lv_pmos L=0.13u W=0.5u AS=0.17p AD=0.17p
+ PS=1.68u PD=1.68u rfmode=0
M$1801 VDD Op \$299 VDD sg13_lv_pmos L=0.13u W=0.5u AS=0.17p AD=0.095p PS=1.68u
+ PD=0.88u rfmode=0
M$1802 \$299 Om VDD VDD sg13_lv_pmos L=0.13u W=0.5u AS=0.095p AD=0.17p PS=0.88u
+ PD=1.68u rfmode=0
M$1805 \$389 \$327 VDD VDD sg13_lv_pmos L=0.13u W=1.12u AS=0.3864p AD=0.41165p
+ PS=2.93u PD=2.12u rfmode=0
M$1806 VDD \$556 \$327 VDD sg13_lv_pmos L=0.13u W=1.12u AS=0.41165p AD=0.4088p
+ PS=2.12u PD=2.97u rfmode=0
M$1807 \$34 \$338 VDD VDD sg13_lv_pmos L=0.13u W=1.12u AS=0.42p AD=0.2114p
+ PS=2.99u PD=1.54u rfmode=0
M$1808 VDD \$339 \$338 VDD sg13_lv_pmos L=0.13u W=0.84u AS=0.2114p AD=0.2856p
+ PS=1.54u PD=2.36u rfmode=0
M$1809 VDD Op \$340 VDD sg13_lv_pmos L=0.13u W=0.84u AS=0.2114p AD=0.2856p
+ PS=1.54u PD=2.36u rfmode=0
M$1810 VDD \$340 \$309 VDD sg13_lv_pmos L=0.13u W=1.12u AS=0.2114p AD=0.42p
+ PS=1.54u PD=2.99u rfmode=0
M$1811 VDD \$342 \$341 VDD sg13_lv_pmos L=0.13u W=0.84u AS=0.2114p AD=0.2856p
+ PS=1.54u PD=2.36u rfmode=0
M$1812 VDD \$341 clk_comp VDD sg13_lv_pmos L=0.13u W=1.12u AS=0.2114p AD=0.42p
+ PS=1.54u PD=2.99u rfmode=0
M$1813 \$343 \$344 VDD VDD sg13_lv_pmos L=0.13u W=0.84u AS=0.2856p AD=0.253p
+ PS=2.36u PD=1.53u rfmode=0
M$1814 VDD \$344 \$392 VDD sg13_lv_pmos L=0.13u W=1u AS=0.253p AD=0.3325p
+ PS=1.53u PD=1.665u rfmode=0
M$1815 \$392 \$339 \$310 VDD sg13_lv_pmos L=0.13u W=1u AS=0.3325p AD=0.2225p
+ PS=1.665u PD=1.445u rfmode=0
M$1816 \$310 \$345 \$393 VDD sg13_lv_pmos L=0.13u W=1u AS=0.2225p AD=0.2975p
+ PS=1.445u PD=1.595u rfmode=0
M$1817 \$393 \$343 VDD VDD sg13_lv_pmos L=0.13u W=1u AS=0.2975p AD=0.2198p
+ PS=1.595u PD=1.52u rfmode=0
M$1818 VDD \$310 \$311 VDD sg13_lv_pmos L=0.13u W=1.12u AS=0.2198p AD=0.6048p
+ PS=1.52u PD=3.32u rfmode=0
M$1819 VDD \$313 \$312 VDD sg13_lv_pmos L=0.13u W=17.92u AS=3.5896p AD=3.4048p
+ PS=25.45u PD=24u rfmode=0
M$1835 VDD fclk_in \$313 VDD sg13_lv_pmos L=0.13u W=6.72u AS=1.2768p AD=1.4448p
+ PS=9u PD=10.42u rfmode=0
M$1841 \$316 \$349 \$388 VDD sg13_lv_pmos L=0.13u W=1.12u AS=0.3808p AD=0.2128p
+ PS=2.92u PD=1.5u rfmode=0
M$1842 \$388 \$350 VDD VDD sg13_lv_pmos L=0.13u W=1.12u AS=0.2128p AD=0.2128p
+ PS=1.5u PD=1.5u rfmode=0
M$1843 VDD \$348 \$388 VDD sg13_lv_pmos L=0.13u W=1.12u AS=0.2128p AD=0.3808p
+ PS=1.5u PD=2.92u rfmode=0
M$1844 VDD \$353 \$351 VDD sg13_lv_pmos L=0.13u W=0.84u AS=0.4536p AD=0.1596p
+ PS=2.76u PD=1.22u rfmode=0
M$1845 VDD \$315 \$351 VDD sg13_lv_pmos L=0.13u W=0.84u AS=0.2891p AD=0.1596p
+ PS=1.695u PD=1.22u rfmode=0
M$1846 VDD \$353 \$398 VDD sg13_lv_pmos L=0.13u W=1.12u AS=0.2891p AD=0.1428p
+ PS=1.695u PD=1.375u rfmode=0
M$1847 \$398 \$315 \$354 VDD sg13_lv_pmos L=0.13u W=1.12u AS=0.1428p AD=0.2408p
+ PS=1.375u PD=1.55u rfmode=0
M$1848 \$354 \$351 VDD VDD sg13_lv_pmos L=0.13u W=1.12u AS=0.2408p AD=0.3808p
+ PS=1.55u PD=2.92u rfmode=0
M$1849 VDD \$356 \$355 VDD sg13_lv_pmos L=0.5u W=1u AS=0.2254p AD=0.34p
+ PS=1.53u PD=2.68u rfmode=0
M$1850 \$350 \$355 VDD VDD sg13_lv_pmos L=0.13u W=1.12u AS=0.4256p AD=0.2254p
+ PS=3u PD=1.53u rfmode=0
M$1851 VDD \$359 \$358 VDD sg13_lv_pmos L=0.5u W=1u AS=0.2254p AD=0.34p
+ PS=1.53u PD=2.68u rfmode=0
M$1852 \$318 \$358 VDD VDD sg13_lv_pmos L=0.13u W=1.12u AS=0.4256p AD=0.2254p
+ PS=3u PD=1.53u rfmode=0
M$1853 VDD \$361 \$360 VDD sg13_lv_pmos L=0.5u W=1u AS=0.2254p AD=0.34p
+ PS=1.53u PD=2.68u rfmode=0
M$1854 \$353 \$360 VDD VDD sg13_lv_pmos L=0.13u W=1.12u AS=0.4256p AD=0.2254p
+ PS=3u PD=1.53u rfmode=0
M$1855 \$321 \$363 VDD VDD sg13_lv_pmos L=0.13u W=1.12u AS=0.42p AD=0.2114p
+ PS=2.99u PD=1.54u rfmode=0
M$1856 VDD rst \$363 VDD sg13_lv_pmos L=0.13u W=0.84u AS=0.2114p AD=0.2856p
+ PS=1.54u PD=2.36u rfmode=0
M$1857 \$365 \$323 VDD VDD sg13_lv_pmos L=0.5u W=1u AS=0.34p AD=0.2254p
+ PS=2.68u PD=1.53u rfmode=0
M$1858 VDD \$365 \$324 VDD sg13_lv_pmos L=0.13u W=1.12u AS=0.2254p AD=0.4256p
+ PS=1.53u PD=3u rfmode=0
M$1859 \$330 \$369 VDD VDD sg13_lv_pmos L=0.13u W=1.12u AS=0.3864p AD=0.2128p
+ PS=2.93u PD=1.5u rfmode=0
M$1860 VDD \$330 \$331 VDD sg13_lv_pmos L=0.13u W=1.12u AS=0.2128p AD=0.3808p
+ PS=1.5u PD=2.92u rfmode=0
M$1861 \$371 \$309 VDD VDD sg13_lv_pmos L=0.13u W=0.84u AS=0.2856p AD=0.2618p
+ PS=2.36u PD=1.63u rfmode=0
M$1862 VDD \$371 \$403 VDD sg13_lv_pmos L=0.13u W=1.12u AS=0.2618p AD=0.1176p
+ PS=1.63u PD=1.33u rfmode=0
M$1863 \$403 \$372 \$334 VDD sg13_lv_pmos L=0.13u W=1.12u AS=0.1176p AD=0.3808p
+ PS=1.33u PD=2.92u rfmode=0
M$1864 \$335 \$373 VDD VDD sg13_lv_pmos L=0.13u W=1.12u AS=0.42p AD=0.2114p
+ PS=2.99u PD=1.54u rfmode=0
M$1865 VDD \$660 \$373 VDD sg13_lv_pmos L=0.13u W=0.84u AS=0.2114p AD=0.2856p
+ PS=1.54u PD=2.36u rfmode=0
M$1866 VDD \$299 \$374 VDD sg13_lv_pmos L=0.13u W=0.84u AS=0.2114p AD=0.2856p
+ PS=1.54u PD=2.36u rfmode=0
M$1867 VDD \$374 \$336 VDD sg13_lv_pmos L=0.13u W=1.12u AS=0.2114p AD=0.42p
+ PS=1.54u PD=2.99u rfmode=0
M$1868 fclk_samp \$375 VDD VDD sg13_lv_pmos L=0.13u W=1.12u AS=0.42p AD=0.2114p
+ PS=2.99u PD=1.54u rfmode=0
M$1869 VDD \$370 \$375 VDD sg13_lv_pmos L=0.13u W=0.84u AS=0.2114p AD=0.2856p
+ PS=1.54u PD=2.36u rfmode=0
M$1870 \$372 \$376 VDD VDD sg13_lv_pmos L=0.13u W=1.12u AS=0.42p AD=0.2114p
+ PS=2.99u PD=1.54u rfmode=0
M$1871 VDD Om \$376 VDD sg13_lv_pmos L=0.13u W=0.84u AS=0.2114p AD=0.2856p
+ PS=1.54u PD=2.36u rfmode=0
M$1872 VDD \$378 \$377 VDD sg13_lv_pmos L=0.13u W=0.84u AS=0.2114p AD=0.2856p
+ PS=1.54u PD=2.36u rfmode=0
M$1873 VDD \$377 \$35 VDD sg13_lv_pmos L=0.13u W=1.12u AS=0.2114p AD=0.42p
+ PS=1.54u PD=2.99u rfmode=0
M$1874 VDD VSS VDD VDD sg13_lv_pmos L=1u W=595u AS=159.85p AD=159.85p
+ PS=1226.7u PD=1226.7u rfmode=0
M$1882 VDD \$350 \$315 VDD sg13_lv_pmos L=0.13u W=1.12u AS=0.3808p AD=0.2128p
+ PS=2.92u PD=1.5u rfmode=0
M$1883 \$315 \$347 VDD VDD sg13_lv_pmos L=0.13u W=1.12u AS=0.2128p AD=0.2128p
+ PS=1.5u PD=1.5u rfmode=0
M$1884 VDD \$348 \$315 VDD sg13_lv_pmos L=0.13u W=1.12u AS=0.2128p AD=0.3808p
+ PS=1.5u PD=2.92u rfmode=0
M$1885 \$349 \$350 \$397 VDD sg13_lv_pmos L=0.13u W=1u AS=0.34p AD=0.1225p
+ PS=2.68u PD=1.245u rfmode=0
M$1886 \$397 \$348 VDD VDD sg13_lv_pmos L=0.13u W=1u AS=0.1225p AD=0.36p
+ PS=1.245u PD=2.72u rfmode=0
M$1887 VDD \$357 \$317 VDD sg13_lv_pmos L=0.13u W=0.42u AS=0.1523p AD=0.1428p
+ PS=1.38u PD=1.52u rfmode=0
M$1888 \$356 \$317 VDD VDD sg13_lv_pmos L=0.5u W=1u AS=0.34p AD=0.1523p
+ PS=2.68u PD=1.38u rfmode=0
M$1890 VDD \$354 \$319 VDD sg13_lv_pmos L=0.13u W=0.42u AS=0.1523p AD=0.1428p
+ PS=1.38u PD=1.52u rfmode=0
M$1891 \$359 \$319 VDD VDD sg13_lv_pmos L=0.5u W=1u AS=0.34p AD=0.1523p
+ PS=2.68u PD=1.38u rfmode=0
M$1892 VDD \$362 \$320 VDD sg13_lv_pmos L=0.13u W=0.42u AS=0.1523p AD=0.1428p
+ PS=1.38u PD=1.52u rfmode=0
M$1893 \$361 \$320 VDD VDD sg13_lv_pmos L=0.5u W=1u AS=0.34p AD=0.1523p
+ PS=2.68u PD=1.38u rfmode=0
M$1894 VDD \$364 \$322 VDD sg13_lv_pmos L=0.13u W=0.42u AS=0.1523p AD=0.1428p
+ PS=1.38u PD=1.52u rfmode=0
M$1895 VDD \$322 \$323 VDD sg13_lv_pmos L=0.5u W=1u AS=0.1523p AD=0.34p
+ PS=1.38u PD=2.68u rfmode=0
M$1896 VDD \$324 \$325 VDD sg13_lv_pmos L=0.13u W=0.42u AS=0.1428p AD=0.0798p
+ PS=1.52u PD=0.8u rfmode=0
M$1897 VDD \$367 \$325 VDD sg13_lv_pmos L=0.13u W=0.42u AS=0.3623875p
+ AD=0.0798p PS=2.605u PD=0.8u rfmode=0
M$1898 VDD \$366 \$326 VDD sg13_lv_pmos L=0.13u W=1u AS=0.3623875p AD=0.34p
+ PS=2.605u PD=2.68u rfmode=0
M$1899 \$369 \$389 \$390 VDD sg13_lv_pmos L=0.13u W=0.42u AS=0.2048p
+ AD=0.09345p PS=1.63u PD=0.865u rfmode=0
M$1900 \$390 \$329 VDD VDD sg13_lv_pmos L=0.13u W=0.42u AS=0.09345p AD=0.204p
+ PS=0.865u PD=1.835u rfmode=0
M$1901 VDD \$367 \$329 VDD sg13_lv_pmos L=0.13u W=0.42u AS=0.204p AD=0.0798p
+ PS=1.835u PD=0.8u rfmode=0
M$1902 \$329 \$369 VDD VDD sg13_lv_pmos L=0.13u W=0.42u AS=0.0798p AD=0.4659p
+ PS=0.8u PD=3.65u rfmode=0
M$1903 \$326 \$327 \$369 VDD sg13_lv_pmos L=0.13u W=1u AS=0.34p AD=0.2048p
+ PS=2.68u PD=1.63u rfmode=0
M$1904 VDD \$553 \$401 VDD sg13_lv_pmos L=0.15u W=1.12u AS=0.3808p AD=0.2128p
+ PS=2.92u PD=1.5u rfmode=0
M$1905 \$401 \$416 \$333 VDD sg13_lv_pmos L=0.15u W=1.12u AS=0.2128p AD=0.2128p
+ PS=1.5u PD=1.5u rfmode=0
M$1906 \$333 \$370 VDD VDD sg13_lv_pmos L=0.15u W=1.12u AS=0.2128p AD=0.3808p
+ PS=1.5u PD=2.92u rfmode=0
M$1907 VDD \$622 \$367 VDD sg13_lv_pmos L=0.13u W=1.12u AS=0.3808p AD=0.3808p
+ PS=2.92u PD=2.92u rfmode=0
M$1919 VDD \$335 \$337 VDD sg13_lv_pmos L=0.13u W=1.12u AS=0.3808p AD=0.3808p
+ PS=2.92u PD=2.92u rfmode=0
M$1935 VDD \$427 \$408 VDD sg13_lv_pmos L=0.13u W=0.84u AS=0.2114p AD=0.2856p
+ PS=1.54u PD=2.36u rfmode=0
M$1936 \$33 \$408 VDD VDD sg13_lv_pmos L=0.13u W=1.12u AS=0.42p AD=0.2114p
+ PS=2.99u PD=1.54u rfmode=0
M$1949 \$409 \$428 VDD VDD sg13_lv_pmos L=0.13u W=1.12u AS=0.3808p AD=0.3808p
+ PS=2.92u PD=2.92u rfmode=0
M$1950 VDD \$601 \$410 VDD sg13_lv_pmos L=0.13u W=0.84u AS=0.2114p AD=0.2856p
+ PS=1.54u PD=2.36u rfmode=0
M$1951 \$342 \$410 VDD VDD sg13_lv_pmos L=0.13u W=1.12u AS=0.42p AD=0.2114p
+ PS=2.99u PD=1.54u rfmode=0
M$1952 VDD \$311 \$429 VDD sg13_lv_pmos L=0.13u W=0.42u AS=0.1428p AD=0.0798p
+ PS=1.52u PD=0.8u rfmode=0
M$1953 VDD \$409 \$429 VDD sg13_lv_pmos L=0.13u W=0.42u AS=0.3623875p
+ AD=0.0798p PS=2.605u PD=0.8u rfmode=0
M$1954 VDD \$431 \$430 VDD sg13_lv_pmos L=0.13u W=1u AS=0.3623875p AD=0.34p
+ PS=2.605u PD=2.68u rfmode=0
M$1955 VDD \$409 \$431 VDD sg13_lv_pmos L=0.13u W=0.42u AS=0.1563p AD=0.147p
+ PS=1.22u PD=1.54u rfmode=0
M$1956 VDD \$430 \$472 VDD sg13_lv_pmos L=0.13u W=0.42u AS=0.1563p AD=0.063p
+ PS=1.22u PD=0.72u rfmode=0
M$1957 \$472 \$433 \$431 VDD sg13_lv_pmos L=0.13u W=0.42u AS=0.063p AD=0.0798p
+ PS=0.72u PD=0.8u rfmode=0
M$1958 \$431 \$432 \$429 VDD sg13_lv_pmos L=0.13u W=0.42u AS=0.0798p AD=0.1428p
+ PS=0.8u PD=1.52u rfmode=0
M$1959 VDD \$433 \$432 VDD sg13_lv_pmos L=0.13u W=1.12u AS=0.41165p AD=0.3864p
+ PS=2.12u PD=2.93u rfmode=0
M$1960 VDD \$489 \$433 VDD sg13_lv_pmos L=0.13u W=1.12u AS=0.41165p AD=0.4088p
+ PS=2.12u PD=2.97u rfmode=0
M$1961 \$430 \$433 \$490 VDD sg13_lv_pmos L=0.13u W=1u AS=0.34p AD=0.2048p
+ PS=2.68u PD=1.63u rfmode=0
M$1962 \$490 \$432 \$473 VDD sg13_lv_pmos L=0.13u W=0.42u AS=0.2048p
+ AD=0.09345p PS=1.63u PD=0.865u rfmode=0
M$1963 VDD \$434 \$473 VDD sg13_lv_pmos L=0.13u W=0.42u AS=0.204p AD=0.09345p
+ PS=1.835u PD=0.865u rfmode=0
M$1964 VDD \$409 \$434 VDD sg13_lv_pmos L=0.13u W=0.42u AS=0.204p AD=0.0798p
+ PS=1.835u PD=0.8u rfmode=0
M$1965 VDD \$490 \$434 VDD sg13_lv_pmos L=0.13u W=0.42u AS=0.4659p AD=0.0798p
+ PS=3.65u PD=0.8u rfmode=0
M$1966 \$411 \$490 VDD VDD sg13_lv_pmos L=0.13u W=1.12u AS=0.3864p AD=0.2128p
+ PS=2.93u PD=1.5u rfmode=0
M$1967 VDD \$411 \$339 VDD sg13_lv_pmos L=0.13u W=1.12u AS=0.2128p AD=0.3808p
+ PS=1.5u PD=2.92u rfmode=0
M$1968 VDD \$435 \$412 VDD sg13_lv_pmos L=0.13u W=0.84u AS=0.2114p AD=0.2856p
+ PS=1.54u PD=2.36u rfmode=0
M$1969 \$428 \$412 VDD VDD sg13_lv_pmos L=0.13u W=1.12u AS=0.42p AD=0.2114p
+ PS=2.99u PD=1.54u rfmode=0
M$1970 VDD \$316 \$436 VDD sg13_lv_pmos L=0.13u W=0.42u AS=0.1428p AD=0.0798p
+ PS=1.52u PD=0.8u rfmode=0
M$1971 VDD \$406 \$436 VDD sg13_lv_pmos L=0.13u W=0.42u AS=0.3623875p
+ AD=0.0798p PS=2.605u PD=0.8u rfmode=0
M$1972 VDD \$438 \$437 VDD sg13_lv_pmos L=0.13u W=1u AS=0.3623875p AD=0.34p
+ PS=2.605u PD=2.68u rfmode=0
M$1973 VDD \$406 \$438 VDD sg13_lv_pmos L=0.13u W=0.42u AS=0.1563p AD=0.147p
+ PS=1.22u PD=1.54u rfmode=0
M$1974 VDD \$437 \$474 VDD sg13_lv_pmos L=0.13u W=0.42u AS=0.1563p AD=0.063p
+ PS=1.22u PD=0.72u rfmode=0
M$1975 \$474 \$440 \$438 VDD sg13_lv_pmos L=0.13u W=0.42u AS=0.063p AD=0.0798p
+ PS=0.72u PD=0.8u rfmode=0
M$1976 \$438 \$439 \$436 VDD sg13_lv_pmos L=0.13u W=0.42u AS=0.0798p AD=0.1428p
+ PS=0.8u PD=1.52u rfmode=0
M$1977 VDD \$440 \$439 VDD sg13_lv_pmos L=0.13u W=1.12u AS=0.41165p AD=0.3864p
+ PS=2.12u PD=2.93u rfmode=0
M$1978 VDD \$604 \$440 VDD sg13_lv_pmos L=0.13u W=1.12u AS=0.41165p AD=0.4088p
+ PS=2.12u PD=2.97u rfmode=0
M$1979 \$437 \$440 \$492 VDD sg13_lv_pmos L=0.13u W=1u AS=0.34p AD=0.2048p
+ PS=2.68u PD=1.63u rfmode=0
M$1980 \$492 \$439 \$476 VDD sg13_lv_pmos L=0.13u W=0.42u AS=0.2048p
+ AD=0.09345p PS=1.63u PD=0.865u rfmode=0
M$1981 VDD \$441 \$476 VDD sg13_lv_pmos L=0.13u W=0.42u AS=0.204p AD=0.09345p
+ PS=1.835u PD=0.865u rfmode=0
M$1982 VDD \$406 \$441 VDD sg13_lv_pmos L=0.13u W=0.42u AS=0.204p AD=0.0798p
+ PS=1.835u PD=0.8u rfmode=0
M$1983 VDD \$492 \$441 VDD sg13_lv_pmos L=0.13u W=0.42u AS=0.4659p AD=0.0798p
+ PS=3.65u PD=0.8u rfmode=0
M$1984 \$413 \$492 VDD VDD sg13_lv_pmos L=0.13u W=1.12u AS=0.3864p AD=0.2128p
+ PS=2.93u PD=1.5u rfmode=0
M$1985 VDD \$413 \$357 VDD sg13_lv_pmos L=0.13u W=1.12u AS=0.2128p AD=0.3808p
+ PS=1.5u PD=2.92u rfmode=0
M$1986 VDD \$318 \$442 VDD sg13_lv_pmos L=0.13u W=0.42u AS=0.1428p AD=0.0798p
+ PS=1.52u PD=0.8u rfmode=0
M$1987 VDD \$407 \$442 VDD sg13_lv_pmos L=0.13u W=0.42u AS=0.3623875p
+ AD=0.0798p PS=2.605u PD=0.8u rfmode=0
M$1988 VDD \$444 \$443 VDD sg13_lv_pmos L=0.13u W=1u AS=0.3623875p AD=0.34p
+ PS=2.605u PD=2.68u rfmode=0
M$1989 VDD \$407 \$444 VDD sg13_lv_pmos L=0.13u W=0.42u AS=0.1563p AD=0.147p
+ PS=1.22u PD=1.54u rfmode=0
M$1990 VDD \$443 \$478 VDD sg13_lv_pmos L=0.13u W=0.42u AS=0.1563p AD=0.063p
+ PS=1.22u PD=0.72u rfmode=0
M$1991 \$478 \$446 \$444 VDD sg13_lv_pmos L=0.13u W=0.42u AS=0.063p AD=0.0798p
+ PS=0.72u PD=0.8u rfmode=0
M$1992 \$444 \$445 \$442 VDD sg13_lv_pmos L=0.13u W=0.42u AS=0.0798p AD=0.1428p
+ PS=0.8u PD=1.52u rfmode=0
M$1993 VDD \$446 \$445 VDD sg13_lv_pmos L=0.13u W=1.12u AS=0.41165p AD=0.3864p
+ PS=2.12u PD=2.93u rfmode=0
M$1994 VDD \$604 \$446 VDD sg13_lv_pmos L=0.13u W=1.12u AS=0.41165p AD=0.4088p
+ PS=2.12u PD=2.97u rfmode=0
M$1995 \$443 \$446 \$494 VDD sg13_lv_pmos L=0.13u W=1u AS=0.34p AD=0.2048p
+ PS=2.68u PD=1.63u rfmode=0
M$1996 \$494 \$445 \$480 VDD sg13_lv_pmos L=0.13u W=0.42u AS=0.2048p
+ AD=0.09345p PS=1.63u PD=0.865u rfmode=0
M$1997 VDD \$447 \$480 VDD sg13_lv_pmos L=0.13u W=0.42u AS=0.204p AD=0.09345p
+ PS=1.835u PD=0.865u rfmode=0
M$1998 VDD \$407 \$447 VDD sg13_lv_pmos L=0.13u W=0.42u AS=0.204p AD=0.0798p
+ PS=1.835u PD=0.8u rfmode=0
M$1999 VDD \$494 \$447 VDD sg13_lv_pmos L=0.13u W=0.42u AS=0.4659p AD=0.0798p
+ PS=3.65u PD=0.8u rfmode=0
M$2000 \$414 \$494 VDD VDD sg13_lv_pmos L=0.13u W=1.12u AS=0.3864p AD=0.2128p
+ PS=2.93u PD=1.5u rfmode=0
M$2001 VDD \$414 \$362 VDD sg13_lv_pmos L=0.13u W=1.12u AS=0.2128p AD=0.3808p
+ PS=1.5u PD=2.92u rfmode=0
M$2002 VDD \$495 \$448 VDD sg13_lv_pmos L=0.13u W=0.42u AS=0.1523p AD=0.1428p
+ PS=1.38u PD=1.52u rfmode=0
M$2003 VDD \$448 \$415 VDD sg13_lv_pmos L=0.5u W=1u AS=0.1523p AD=0.34p
+ PS=1.38u PD=2.68u rfmode=0
M$2004 VDD \$415 \$449 VDD sg13_lv_pmos L=0.5u W=1u AS=0.2254p AD=0.34p
+ PS=1.53u PD=2.68u rfmode=0
M$2005 VDD \$449 \$416 VDD sg13_lv_pmos L=0.13u W=1.12u AS=0.2254p AD=0.4256p
+ PS=1.53u PD=3u rfmode=0
M$2006 \$417 \$324 \$482 VDD sg13_lv_pmos L=0.13u W=1.12u AS=0.3808p AD=0.1176p
+ PS=2.92u PD=1.33u rfmode=0
M$2007 \$482 \$450 VDD VDD sg13_lv_pmos L=0.13u W=1.12u AS=0.1176p AD=0.2618p
+ PS=1.33u PD=1.63u rfmode=0
M$2008 VDD \$333 \$450 VDD sg13_lv_pmos L=0.13u W=0.84u AS=0.2618p AD=0.2856p
+ PS=1.63u PD=2.36u rfmode=0
M$2009 \$366 \$367 VDD VDD sg13_lv_pmos L=0.13u W=0.42u AS=0.147p AD=0.1563p
+ PS=1.54u PD=1.22u rfmode=0
M$2010 VDD \$326 \$400 VDD sg13_lv_pmos L=0.13u W=0.42u AS=0.1563p AD=0.063p
+ PS=1.22u PD=0.72u rfmode=0
M$2011 \$400 \$327 \$366 VDD sg13_lv_pmos L=0.13u W=0.42u AS=0.063p AD=0.0798p
+ PS=0.72u PD=0.8u rfmode=0
M$2012 \$366 \$389 \$325 VDD sg13_lv_pmos L=0.13u W=0.42u AS=0.0798p AD=0.1428p
+ PS=0.8u PD=1.52u rfmode=0
M$2013 VDD \$508 \$451 VDD sg13_lv_pmos L=0.13u W=0.42u AS=0.1428p AD=0.0798p
+ PS=1.52u PD=0.8u rfmode=0
M$2014 VDD \$496 \$451 VDD sg13_lv_pmos L=0.13u W=0.42u AS=0.3623875p
+ AD=0.0798p PS=2.605u PD=0.8u rfmode=0
M$2015 VDD \$453 \$452 VDD sg13_lv_pmos L=0.13u W=1u AS=0.3623875p AD=0.34p
+ PS=2.605u PD=2.68u rfmode=0
M$2016 VDD \$496 \$453 VDD sg13_lv_pmos L=0.13u W=0.42u AS=0.1563p AD=0.147p
+ PS=1.22u PD=1.54u rfmode=0
M$2017 VDD \$452 \$484 VDD sg13_lv_pmos L=0.13u W=0.42u AS=0.1563p AD=0.063p
+ PS=1.22u PD=0.72u rfmode=0
M$2018 \$484 \$455 \$453 VDD sg13_lv_pmos L=0.13u W=0.42u AS=0.063p AD=0.0798p
+ PS=0.72u PD=0.8u rfmode=0
M$2019 \$453 \$454 \$451 VDD sg13_lv_pmos L=0.13u W=0.42u AS=0.0798p AD=0.1428p
+ PS=0.8u PD=1.52u rfmode=0
M$2020 VDD \$455 \$454 VDD sg13_lv_pmos L=0.13u W=1.12u AS=0.41165p AD=0.3864p
+ PS=2.12u PD=2.93u rfmode=0
M$2021 VDD \$556 \$455 VDD sg13_lv_pmos L=0.13u W=1.12u AS=0.41165p AD=0.4088p
+ PS=2.12u PD=2.97u rfmode=0
M$2022 \$452 \$455 \$498 VDD sg13_lv_pmos L=0.13u W=1u AS=0.34p AD=0.2048p
+ PS=2.68u PD=1.63u rfmode=0
M$2023 \$498 \$454 \$486 VDD sg13_lv_pmos L=0.13u W=0.42u AS=0.2048p
+ AD=0.09345p PS=1.63u PD=0.865u rfmode=0
M$2024 VDD \$456 \$486 VDD sg13_lv_pmos L=0.13u W=0.42u AS=0.204p AD=0.09345p
+ PS=1.835u PD=0.865u rfmode=0
M$2025 VDD \$496 \$456 VDD sg13_lv_pmos L=0.13u W=0.42u AS=0.204p AD=0.0798p
+ PS=1.835u PD=0.8u rfmode=0
M$2026 VDD \$498 \$456 VDD sg13_lv_pmos L=0.13u W=0.42u AS=0.4659p AD=0.0798p
+ PS=3.65u PD=0.8u rfmode=0
M$2027 \$418 \$498 VDD VDD sg13_lv_pmos L=0.13u W=1.12u AS=0.3864p AD=0.2128p
+ PS=2.93u PD=1.5u rfmode=0
M$2028 VDD \$418 \$419 VDD sg13_lv_pmos L=0.13u W=1.12u AS=0.2128p AD=0.3808p
+ PS=1.5u PD=2.92u rfmode=0
M$2029 \$420 \$344 \$487 VDD sg13_lv_pmos L=0.13u W=1.12u AS=0.3808p AD=0.1176p
+ PS=2.92u PD=1.33u rfmode=0
M$2030 \$487 \$378 VDD VDD sg13_lv_pmos L=0.13u W=1.12u AS=0.1176p AD=0.4032p
+ PS=1.33u PD=2.96u rfmode=0
M$2031 \$421 \$420 \$422 VDD sg13_lv_pmos L=0.13u W=1.12u AS=0.3808p AD=0.2128p
+ PS=2.92u PD=1.5u rfmode=0
M$2032 \$422 \$344 VDD VDD sg13_lv_pmos L=0.13u W=1.12u AS=0.2128p AD=0.2128p
+ PS=1.5u PD=1.5u rfmode=0
M$2033 VDD \$345 \$422 VDD sg13_lv_pmos L=0.13u W=1.12u AS=0.2128p AD=0.3808p
+ PS=1.5u PD=2.92u rfmode=0
M$2034 VDD \$421 \$457 VDD sg13_lv_pmos L=0.13u W=0.42u AS=0.1428p AD=0.0798p
+ PS=1.52u PD=0.8u rfmode=0
M$2035 VDD \$499 \$457 VDD sg13_lv_pmos L=0.13u W=0.42u AS=0.3623875p
+ AD=0.0798p PS=2.605u PD=0.8u rfmode=0
M$2036 VDD \$459 \$458 VDD sg13_lv_pmos L=0.13u W=1u AS=0.3623875p AD=0.34p
+ PS=2.605u PD=2.68u rfmode=0
M$2037 VDD \$499 \$459 VDD sg13_lv_pmos L=0.13u W=0.42u AS=0.1563p AD=0.147p
+ PS=1.22u PD=1.54u rfmode=0
M$2038 VDD \$458 \$485 VDD sg13_lv_pmos L=0.13u W=0.42u AS=0.1563p AD=0.063p
+ PS=1.22u PD=0.72u rfmode=0
M$2039 \$485 \$461 \$459 VDD sg13_lv_pmos L=0.13u W=0.42u AS=0.063p AD=0.0798p
+ PS=0.72u PD=0.8u rfmode=0
M$2040 \$459 \$460 \$457 VDD sg13_lv_pmos L=0.13u W=0.42u AS=0.0798p AD=0.1428p
+ PS=0.8u PD=1.52u rfmode=0
M$2041 VDD \$461 \$460 VDD sg13_lv_pmos L=0.13u W=1.12u AS=0.41165p AD=0.3864p
+ PS=2.12u PD=2.93u rfmode=0
M$2042 VDD \$501 \$461 VDD sg13_lv_pmos L=0.13u W=1.12u AS=0.41165p AD=0.4088p
+ PS=2.12u PD=2.97u rfmode=0
M$2043 \$458 \$461 \$502 VDD sg13_lv_pmos L=0.13u W=1u AS=0.34p AD=0.2048p
+ PS=2.68u PD=1.63u rfmode=0
M$2044 \$502 \$460 \$483 VDD sg13_lv_pmos L=0.13u W=0.42u AS=0.2048p
+ AD=0.09345p PS=1.63u PD=0.865u rfmode=0
M$2045 VDD \$462 \$483 VDD sg13_lv_pmos L=0.13u W=0.42u AS=0.204p AD=0.09345p
+ PS=1.835u PD=0.865u rfmode=0
M$2046 VDD \$499 \$462 VDD sg13_lv_pmos L=0.13u W=0.42u AS=0.204p AD=0.0798p
+ PS=1.835u PD=0.8u rfmode=0
M$2047 VDD \$502 \$462 VDD sg13_lv_pmos L=0.13u W=0.42u AS=0.4659p AD=0.0798p
+ PS=3.65u PD=0.8u rfmode=0
M$2048 \$423 \$502 VDD VDD sg13_lv_pmos L=0.13u W=1.12u AS=0.3864p AD=0.2128p
+ PS=2.93u PD=1.5u rfmode=0
M$2049 VDD \$423 \$378 VDD sg13_lv_pmos L=0.13u W=1.12u AS=0.2128p AD=0.3808p
+ PS=1.5u PD=2.92u rfmode=0
M$2052 VDD \$922 \$463 VDD sg13_lv_pmos L=0.13u W=0.84u AS=0.253p AD=0.2856p
+ PS=1.53u PD=2.36u rfmode=0
M$2053 VDD \$922 \$481 VDD sg13_lv_pmos L=0.13u W=1u AS=0.253p AD=0.3325p
+ PS=1.53u PD=1.665u rfmode=0
M$2054 \$481 \$425 \$464 VDD sg13_lv_pmos L=0.13u W=1u AS=0.3325p AD=0.2225p
+ PS=1.665u PD=1.445u rfmode=0
M$2055 \$464 \$626 \$479 VDD sg13_lv_pmos L=0.13u W=1u AS=0.2225p AD=0.2975p
+ PS=1.445u PD=1.595u rfmode=0
M$2056 VDD \$463 \$479 VDD sg13_lv_pmos L=0.13u W=1u AS=0.2198p AD=0.2975p
+ PS=1.52u PD=1.595u rfmode=0
M$2057 VDD \$464 \$465 VDD sg13_lv_pmos L=0.13u W=1.12u AS=0.2198p AD=0.6048p
+ PS=1.52u PD=3.32u rfmode=0
M$2058 VDD \$465 \$466 VDD sg13_lv_pmos L=0.13u W=0.42u AS=0.1428p AD=0.0798p
+ PS=1.52u PD=0.8u rfmode=0
M$2059 VDD \$337 \$466 VDD sg13_lv_pmos L=0.13u W=0.42u AS=0.3623875p
+ AD=0.0798p PS=2.605u PD=0.8u rfmode=0
M$2060 VDD \$468 \$467 VDD sg13_lv_pmos L=0.13u W=1u AS=0.3623875p AD=0.34p
+ PS=2.605u PD=2.68u rfmode=0
M$2061 VDD \$337 \$468 VDD sg13_lv_pmos L=0.13u W=0.42u AS=0.1563p AD=0.147p
+ PS=1.22u PD=1.54u rfmode=0
M$2062 VDD \$467 \$477 VDD sg13_lv_pmos L=0.13u W=0.42u AS=0.1563p AD=0.063p
+ PS=1.22u PD=0.72u rfmode=0
M$2063 \$477 \$470 \$468 VDD sg13_lv_pmos L=0.13u W=0.42u AS=0.063p AD=0.0798p
+ PS=0.72u PD=0.8u rfmode=0
M$2064 \$468 \$469 \$466 VDD sg13_lv_pmos L=0.13u W=0.42u AS=0.0798p AD=0.1428p
+ PS=0.8u PD=1.52u rfmode=0
M$2065 VDD \$470 \$469 VDD sg13_lv_pmos L=0.13u W=1.12u AS=0.41165p AD=0.3864p
+ PS=2.12u PD=2.93u rfmode=0
M$2066 VDD \$501 \$470 VDD sg13_lv_pmos L=0.13u W=1.12u AS=0.41165p AD=0.4088p
+ PS=2.12u PD=2.97u rfmode=0
M$2067 \$467 \$470 \$504 VDD sg13_lv_pmos L=0.13u W=1u AS=0.34p AD=0.2048p
+ PS=2.68u PD=1.63u rfmode=0
M$2068 \$504 \$469 \$475 VDD sg13_lv_pmos L=0.13u W=0.42u AS=0.2048p
+ AD=0.09345p PS=1.63u PD=0.865u rfmode=0
M$2069 VDD \$471 \$475 VDD sg13_lv_pmos L=0.13u W=0.42u AS=0.204p AD=0.09345p
+ PS=1.835u PD=0.865u rfmode=0
M$2070 VDD \$337 \$471 VDD sg13_lv_pmos L=0.13u W=0.42u AS=0.204p AD=0.0798p
+ PS=1.835u PD=0.8u rfmode=0
M$2071 VDD \$504 \$471 VDD sg13_lv_pmos L=0.13u W=0.42u AS=0.4659p AD=0.0798p
+ PS=3.65u PD=0.8u rfmode=0
M$2072 \$424 \$504 VDD VDD sg13_lv_pmos L=0.13u W=1.12u AS=0.3864p AD=0.2128p
+ PS=2.93u PD=1.5u rfmode=0
M$2073 VDD \$424 \$425 VDD sg13_lv_pmos L=0.13u W=1.12u AS=0.2128p AD=0.3808p
+ PS=1.5u PD=2.92u rfmode=0
M$2085 \$426 \$425 VDD VDD sg13_lv_pmos L=0.13u W=0.84u AS=0.2856p AD=0.2114p
+ PS=2.36u PD=1.54u rfmode=0
M$2086 VDD \$426 \$36 VDD sg13_lv_pmos L=0.13u W=1.12u AS=0.2114p AD=0.42p
+ PS=1.54u PD=2.99u rfmode=0
M$2101 VDD \$428 \$538 VDD sg13_lv_pmos L=0.13u W=1.12u AS=0.3808p AD=0.3808p
+ PS=2.92u PD=2.92u rfmode=0
M$2102 VDD \$557 \$560 VDD sg13_lv_pmos L=0.13u W=0.42u AS=0.1428p AD=0.0798p
+ PS=1.52u PD=0.8u rfmode=0
M$2103 VDD \$538 \$560 VDD sg13_lv_pmos L=0.13u W=0.42u AS=0.3623875p
+ AD=0.0798p PS=2.605u PD=0.8u rfmode=0
M$2104 VDD \$558 \$539 VDD sg13_lv_pmos L=0.13u W=1u AS=0.3623875p AD=0.34p
+ PS=2.605u PD=2.68u rfmode=0
M$2105 \$561 \$540 VDD VDD sg13_lv_pmos L=0.13u W=1.12u AS=0.3864p AD=0.41165p
+ PS=2.93u PD=2.12u rfmode=0
M$2106 VDD \$489 \$540 VDD sg13_lv_pmos L=0.13u W=1.12u AS=0.41165p AD=0.4088p
+ PS=2.12u PD=2.97u rfmode=0
M$2107 \$562 \$561 \$589 VDD sg13_lv_pmos L=0.13u W=0.42u AS=0.2048p
+ AD=0.09345p PS=1.63u PD=0.865u rfmode=0
M$2108 \$589 \$542 VDD VDD sg13_lv_pmos L=0.13u W=0.42u AS=0.09345p AD=0.204p
+ PS=0.865u PD=1.835u rfmode=0
M$2109 VDD \$538 \$542 VDD sg13_lv_pmos L=0.13u W=0.42u AS=0.204p AD=0.0798p
+ PS=1.835u PD=0.8u rfmode=0
M$2110 \$542 \$562 VDD VDD sg13_lv_pmos L=0.13u W=0.42u AS=0.0798p AD=0.4659p
+ PS=0.8u PD=3.65u rfmode=0
M$2111 \$539 \$540 \$562 VDD sg13_lv_pmos L=0.13u W=1u AS=0.34p AD=0.2048p
+ PS=2.68u PD=1.63u rfmode=0
M$2112 \$543 \$562 VDD VDD sg13_lv_pmos L=0.13u W=1.12u AS=0.3864p AD=0.2128p
+ PS=2.93u PD=1.5u rfmode=0
M$2113 VDD \$543 \$427 VDD sg13_lv_pmos L=0.13u W=1.12u AS=0.2128p AD=0.3808p
+ PS=1.5u PD=2.92u rfmode=0
M$2114 VDD En \$563 VDD sg13_lv_pmos L=0.13u W=0.84u AS=0.2114p AD=0.2856p
+ PS=1.54u PD=2.36u rfmode=0
M$2115 VDD \$563 \$348 VDD sg13_lv_pmos L=0.13u W=1.12u AS=0.2114p AD=0.42p
+ PS=1.54u PD=2.99u rfmode=0
M$2116 \$489 \$564 VDD VDD sg13_lv_pmos L=0.13u W=1.12u AS=0.42p AD=0.2114p
+ PS=2.99u PD=1.54u rfmode=0
M$2117 VDD \$740 \$564 VDD sg13_lv_pmos L=0.13u W=0.84u AS=0.2114p AD=0.2856p
+ PS=1.54u PD=2.36u rfmode=0
M$2118 \$406 \$428 VDD VDD sg13_lv_pmos L=0.13u W=1.12u AS=0.3808p AD=0.3808p
+ PS=2.92u PD=2.92u rfmode=0
M$2119 VDD \$566 \$569 VDD sg13_lv_pmos L=0.13u W=0.42u AS=0.1428p AD=0.0798p
+ PS=1.52u PD=0.8u rfmode=0
M$2120 VDD \$565 \$569 VDD sg13_lv_pmos L=0.13u W=0.42u AS=0.3623875p
+ AD=0.0798p PS=2.605u PD=0.8u rfmode=0
M$2121 VDD \$567 \$544 VDD sg13_lv_pmos L=0.13u W=1u AS=0.3623875p AD=0.34p
+ PS=2.605u PD=2.68u rfmode=0
M$2122 \$570 \$545 VDD VDD sg13_lv_pmos L=0.13u W=1.12u AS=0.3864p AD=0.41165p
+ PS=2.93u PD=2.12u rfmode=0
M$2123 VDD \$604 \$545 VDD sg13_lv_pmos L=0.13u W=1.12u AS=0.41165p AD=0.4088p
+ PS=2.12u PD=2.97u rfmode=0
M$2124 \$571 \$570 \$596 VDD sg13_lv_pmos L=0.13u W=0.42u AS=0.2048p
+ AD=0.09345p PS=1.63u PD=0.865u rfmode=0
M$2125 \$596 \$547 VDD VDD sg13_lv_pmos L=0.13u W=0.42u AS=0.09345p AD=0.204p
+ PS=0.865u PD=1.835u rfmode=0
M$2126 VDD \$565 \$547 VDD sg13_lv_pmos L=0.13u W=0.42u AS=0.204p AD=0.0798p
+ PS=1.835u PD=0.8u rfmode=0
M$2127 \$547 \$571 VDD VDD sg13_lv_pmos L=0.13u W=0.42u AS=0.0798p AD=0.4659p
+ PS=0.8u PD=3.65u rfmode=0
M$2128 \$544 \$545 \$571 VDD sg13_lv_pmos L=0.13u W=1u AS=0.34p AD=0.2048p
+ PS=2.68u PD=1.63u rfmode=0
M$2129 \$548 \$571 VDD VDD sg13_lv_pmos L=0.13u W=1.12u AS=0.3864p AD=0.2128p
+ PS=2.93u PD=1.5u rfmode=0
M$2130 VDD \$548 \$549 VDD sg13_lv_pmos L=0.13u W=1.12u AS=0.2128p AD=0.3808p
+ PS=1.5u PD=2.92u rfmode=0
M$2131 VDD \$573 \$572 VDD sg13_lv_pmos L=0.5u W=1u AS=0.2254p AD=0.34p
+ PS=1.53u PD=2.68u rfmode=0
M$2132 \$347 \$572 VDD VDD sg13_lv_pmos L=0.13u W=1.12u AS=0.4256p AD=0.2254p
+ PS=3u PD=1.53u rfmode=0
M$2133 VDD \$549 \$550 VDD sg13_lv_pmos L=0.13u W=0.42u AS=0.1523p AD=0.1428p
+ PS=1.38u PD=1.52u rfmode=0
M$2134 \$573 \$550 VDD VDD sg13_lv_pmos L=0.5u W=1u AS=0.34p AD=0.1523p
+ PS=2.68u PD=1.38u rfmode=0
M$2135 VDD \$552 \$551 VDD sg13_lv_pmos L=0.13u W=17.92u AS=3.5896p AD=3.4048p
+ PS=25.45u PD=24u rfmode=0
M$2151 VDD \$664 \$552 VDD sg13_lv_pmos L=0.13u W=6.72u AS=1.2768p AD=1.4448p
+ PS=9u PD=10.42u rfmode=0
M$2157 VDD \$575 \$574 VDD sg13_lv_pmos L=0.5u W=1u AS=0.2254p AD=0.34p
+ PS=1.53u PD=2.68u rfmode=0
M$2158 \$553 \$574 VDD VDD sg13_lv_pmos L=0.13u W=1.12u AS=0.4256p AD=0.2254p
+ PS=3u PD=1.53u rfmode=0
M$2159 VDD \$419 \$554 VDD sg13_lv_pmos L=0.13u W=0.42u AS=0.1523p AD=0.1428p
+ PS=1.38u PD=1.52u rfmode=0
M$2160 \$575 \$554 VDD VDD sg13_lv_pmos L=0.5u W=1u AS=0.34p AD=0.1523p
+ PS=2.68u PD=1.38u rfmode=0
M$2161 VDD \$551 \$555 VDD sg13_lv_pmos L=0.13u W=6.72u AS=1.4448p AD=1.2768p
+ PS=10.42u PD=9u rfmode=0
M$2167 VDD \$555 \$556 VDD sg13_lv_pmos L=0.13u W=17.92u AS=3.4048p AD=3.5896p
+ PS=24u PD=25.45u rfmode=0
M$2183 VDD \$372 \$576 VDD sg13_lv_pmos L=0.13u W=0.84u AS=0.2198p AD=0.2856p
+ PS=1.53u PD=2.36u rfmode=0
M$2184 VDD \$576 \$345 VDD sg13_lv_pmos L=0.13u W=1.12u AS=0.3808p AD=0.2128p
+ PS=2.92u PD=1.5u rfmode=0
M$2185 \$345 \$309 VDD VDD sg13_lv_pmos L=0.13u W=1.12u AS=0.2128p AD=0.2198p
+ PS=1.5u PD=1.53u rfmode=0
M$2186 \$499 \$335 VDD VDD sg13_lv_pmos L=0.13u W=1.12u AS=0.3808p AD=0.3808p
+ PS=2.92u PD=2.92u rfmode=0
M$2200 \$501 \$577 VDD VDD sg13_lv_pmos L=0.13u W=1.12u AS=0.42p AD=0.2114p
+ PS=2.99u PD=1.54u rfmode=0
M$2201 VDD \$336 \$577 VDD sg13_lv_pmos L=0.13u W=0.84u AS=0.2114p AD=0.2856p
+ PS=1.54u PD=2.36u rfmode=0
M$2231 VDD \$312 \$600 VDD sg13_lv_pmos L=0.13u W=6.72u AS=1.4448p AD=1.2768p
+ PS=10.42u PD=9u rfmode=0
M$2237 VDD \$600 \$601 VDD sg13_lv_pmos L=0.13u W=17.92u AS=3.4048p AD=3.5896p
+ PS=24u PD=25.45u rfmode=0
M$2253 \$558 \$538 VDD VDD sg13_lv_pmos L=0.13u W=0.42u AS=0.147p AD=0.1563p
+ PS=1.54u PD=1.22u rfmode=0
M$2254 VDD \$539 \$588 VDD sg13_lv_pmos L=0.13u W=0.42u AS=0.1563p AD=0.063p
+ PS=1.22u PD=0.72u rfmode=0
M$2255 \$588 \$540 \$558 VDD sg13_lv_pmos L=0.13u W=0.42u AS=0.063p AD=0.0798p
+ PS=0.72u PD=0.8u rfmode=0
M$2256 \$558 \$561 \$560 VDD sg13_lv_pmos L=0.13u W=0.42u AS=0.0798p AD=0.1428p
+ PS=0.8u PD=1.52u rfmode=0
M$2257 \$602 \$621 VDD VDD sg13_lv_pmos L=0.13u W=1.12u AS=0.6048p AD=0.2198p
+ PS=3.32u PD=1.52u rfmode=0
M$2258 VDD \$598 \$627 VDD sg13_lv_pmos L=0.13u W=1u AS=0.2198p AD=0.2975p
+ PS=1.52u PD=1.595u rfmode=0
M$2259 \$627 \$345 \$621 VDD sg13_lv_pmos L=0.13u W=1u AS=0.2975p AD=0.2225p
+ PS=1.595u PD=1.445u rfmode=0
M$2260 \$621 \$677 \$628 VDD sg13_lv_pmos L=0.13u W=1u AS=0.2225p AD=0.3325p
+ PS=1.445u PD=1.665u rfmode=0
M$2261 \$628 \$603 VDD VDD sg13_lv_pmos L=0.13u W=1u AS=0.3325p AD=0.253p
+ PS=1.665u PD=1.53u rfmode=0
M$2262 VDD \$603 \$598 VDD sg13_lv_pmos L=0.13u W=0.84u AS=0.253p AD=0.2856p
+ PS=1.53u PD=2.36u rfmode=0
M$2264 VDD \$428 \$565 VDD sg13_lv_pmos L=0.13u W=1.12u AS=0.3808p AD=0.3808p
+ PS=2.92u PD=2.92u rfmode=0
M$2265 VDD \$599 \$604 VDD sg13_lv_pmos L=0.13u W=17.92u AS=3.5896p AD=3.4048p
+ PS=25.45u PD=24u rfmode=0
M$2281 VDD \$551 \$599 VDD sg13_lv_pmos L=0.13u W=6.72u AS=1.2768p AD=1.4448p
+ PS=9u PD=10.42u rfmode=0
M$2287 \$567 \$565 VDD VDD sg13_lv_pmos L=0.13u W=0.42u AS=0.147p AD=0.1563p
+ PS=1.54u PD=1.22u rfmode=0
M$2288 VDD \$544 \$595 VDD sg13_lv_pmos L=0.13u W=0.42u AS=0.1563p AD=0.063p
+ PS=1.22u PD=0.72u rfmode=0
M$2289 \$595 \$545 \$567 VDD sg13_lv_pmos L=0.13u W=0.42u AS=0.063p AD=0.0798p
+ PS=0.72u PD=0.8u rfmode=0
M$2290 \$567 \$570 \$569 VDD sg13_lv_pmos L=0.13u W=0.42u AS=0.0798p AD=0.1428p
+ PS=0.8u PD=1.52u rfmode=0
M$2291 VDD \$357 \$495 VDD sg13_lv_pmos L=0.13u W=1.12u AS=0.3808p AD=0.2128p
+ PS=2.92u PD=1.5u rfmode=0
M$2292 \$495 \$347 VDD VDD sg13_lv_pmos L=0.13u W=1.12u AS=0.2128p AD=0.2128p
+ PS=1.5u PD=1.5u rfmode=0
M$2293 VDD \$353 \$495 VDD sg13_lv_pmos L=0.13u W=1.12u AS=0.2128p AD=0.2128p
+ PS=1.5u PD=1.5u rfmode=0
M$2294 \$495 \$348 VDD VDD sg13_lv_pmos L=0.13u W=1.12u AS=0.2128p AD=0.3808p
+ PS=1.5u PD=2.92u rfmode=0
M$2295 VDD \$348 \$605 VDD sg13_lv_pmos L=0.13u W=1.12u AS=0.3808p AD=0.2128p
+ PS=2.92u PD=1.5u rfmode=0
M$2296 \$605 \$370 VDD VDD sg13_lv_pmos L=0.13u W=1.12u AS=0.2128p AD=0.3808p
+ PS=1.5u PD=2.92u rfmode=0
M$2297 \$364 \$495 \$629 VDD sg13_lv_pmos L=0.13u W=1.12u AS=0.3808p AD=0.2128p
+ PS=2.92u PD=1.5u rfmode=0
M$2298 \$629 \$370 \$630 VDD sg13_lv_pmos L=0.13u W=1.12u AS=0.2128p AD=0.2464p
+ PS=1.5u PD=1.56u rfmode=0
M$2299 \$630 \$553 VDD VDD sg13_lv_pmos L=0.13u W=1.12u AS=0.2464p AD=0.3808p
+ PS=1.56u PD=2.92u rfmode=0
M$2300 VDD \$685 \$606 VDD sg13_lv_pmos L=0.13u W=0.84u AS=0.2198p AD=0.2856p
+ PS=1.53u PD=2.36u rfmode=0
M$2301 VDD \$348 \$607 VDD sg13_lv_pmos L=0.13u W=1.12u AS=0.2198p AD=0.2128p
+ PS=1.53u PD=1.5u rfmode=0
M$2302 \$607 \$616 VDD VDD sg13_lv_pmos L=0.13u W=1.12u AS=0.2128p AD=0.2128p
+ PS=1.5u PD=1.5u rfmode=0
M$2303 VDD \$606 \$607 VDD sg13_lv_pmos L=0.13u W=1.12u AS=0.2128p AD=0.3808p
+ PS=1.5u PD=2.92u rfmode=0
M$2304 VDD \$553 \$608 VDD sg13_lv_pmos L=0.13u W=0.84u AS=0.2856p AD=0.1596p
+ PS=2.36u PD=1.22u rfmode=0
M$2305 \$608 \$416 VDD VDD sg13_lv_pmos L=0.13u W=0.84u AS=0.1596p AD=0.1918p
+ PS=1.22u PD=1.5u rfmode=0
M$2306 VDD \$608 \$508 VDD sg13_lv_pmos L=0.13u W=1.12u AS=0.1918p AD=0.3808p
+ PS=1.5u PD=2.92u rfmode=0
M$2307 VDD \$622 \$496 VDD sg13_lv_pmos L=0.13u W=1.12u AS=0.3808p AD=0.3808p
+ PS=2.92u PD=2.92u rfmode=0
M$2308 \$615 \$613 VDD VDD sg13_lv_pmos L=0.13u W=1.12u AS=0.3864p AD=0.2128p
+ PS=2.93u PD=1.5u rfmode=0
M$2309 VDD \$615 \$616 VDD sg13_lv_pmos L=0.13u W=1.12u AS=0.2128p AD=0.3808p
+ PS=1.5u PD=2.92u rfmode=0
M$2312 VDD \$626 \$618 VDD sg13_lv_pmos L=0.13u W=0.84u AS=0.2114p AD=0.2856p
+ PS=1.54u PD=2.36u rfmode=0
M$2313 \$617 \$618 VDD VDD sg13_lv_pmos L=0.13u W=1.12u AS=0.42p AD=0.2114p
+ PS=2.99u PD=1.54u rfmode=0
M$2314 VDD \$335 \$619 VDD sg13_lv_pmos L=0.13u W=1.12u AS=0.3808p AD=0.3808p
+ PS=2.92u PD=2.92u rfmode=0
M$2347 \$32 \$676 VDD VDD sg13_lv_pmos L=0.13u W=1.12u AS=0.42p AD=0.2114p
+ PS=2.99u PD=1.54u rfmode=0
M$2348 VDD \$677 \$676 VDD sg13_lv_pmos L=0.13u W=0.84u AS=0.2114p AD=0.2856p
+ PS=1.54u PD=2.36u rfmode=0
M$2363 VDD \$922 \$678 VDD sg13_lv_pmos L=0.13u W=0.84u AS=0.253p AD=0.2856p
+ PS=1.53u PD=2.36u rfmode=0
M$2364 VDD \$678 \$719 VDD sg13_lv_pmos L=0.13u W=1u AS=0.2198p AD=0.2975p
+ PS=1.52u PD=1.595u rfmode=0
M$2365 \$719 \$345 \$651 VDD sg13_lv_pmos L=0.13u W=1u AS=0.2975p AD=0.2225p
+ PS=1.595u PD=1.445u rfmode=0
M$2366 \$651 \$427 \$720 VDD sg13_lv_pmos L=0.13u W=1u AS=0.2225p AD=0.3325p
+ PS=1.445u PD=1.665u rfmode=0
M$2367 \$720 \$922 VDD VDD sg13_lv_pmos L=0.13u W=1u AS=0.3325p AD=0.253p
+ PS=1.665u PD=1.53u rfmode=0
M$2368 \$557 \$651 VDD VDD sg13_lv_pmos L=0.13u W=1.12u AS=0.6048p AD=0.2198p
+ PS=3.32u PD=1.52u rfmode=0
M$2370 VDD \$428 \$652 VDD sg13_lv_pmos L=0.13u W=1.12u AS=0.3808p AD=0.3808p
+ PS=2.92u PD=2.92u rfmode=0
M$2371 VDD \$602 \$653 VDD sg13_lv_pmos L=0.13u W=0.42u AS=0.1428p AD=0.0798p
+ PS=1.52u PD=0.8u rfmode=0
M$2372 VDD \$652 \$653 VDD sg13_lv_pmos L=0.13u W=0.42u AS=0.3623875p
+ AD=0.0798p PS=2.605u PD=0.8u rfmode=0
M$2373 VDD \$679 \$654 VDD sg13_lv_pmos L=0.13u W=1u AS=0.3623875p AD=0.34p
+ PS=2.605u PD=2.68u rfmode=0
M$2374 \$713 \$655 VDD VDD sg13_lv_pmos L=0.13u W=1.12u AS=0.3864p AD=0.41165p
+ PS=2.93u PD=2.12u rfmode=0
M$2375 VDD \$489 \$655 VDD sg13_lv_pmos L=0.13u W=1.12u AS=0.41165p AD=0.4088p
+ PS=2.12u PD=2.97u rfmode=0
M$2376 \$681 \$713 \$718 VDD sg13_lv_pmos L=0.13u W=0.42u AS=0.2048p
+ AD=0.09345p PS=1.63u PD=0.865u rfmode=0
M$2377 \$718 \$657 VDD VDD sg13_lv_pmos L=0.13u W=0.42u AS=0.09345p AD=0.204p
+ PS=0.865u PD=1.835u rfmode=0
M$2378 VDD \$652 \$657 VDD sg13_lv_pmos L=0.13u W=0.42u AS=0.204p AD=0.0798p
+ PS=1.835u PD=0.8u rfmode=0
M$2379 \$657 \$681 VDD VDD sg13_lv_pmos L=0.13u W=0.42u AS=0.0798p AD=0.4659p
+ PS=0.8u PD=3.65u rfmode=0
M$2380 \$654 \$655 \$681 VDD sg13_lv_pmos L=0.13u W=1u AS=0.34p AD=0.2048p
+ PS=2.68u PD=1.63u rfmode=0
M$2381 \$658 \$681 VDD VDD sg13_lv_pmos L=0.13u W=1.12u AS=0.3864p AD=0.2128p
+ PS=2.93u PD=1.5u rfmode=0
M$2382 VDD \$658 \$677 VDD sg13_lv_pmos L=0.13u W=1.12u AS=0.2128p AD=0.3808p
+ PS=1.5u PD=2.92u rfmode=0
M$2383 \$566 \$682 VDD VDD sg13_lv_pmos L=0.13u W=1.12u AS=0.3808p AD=0.1918p
+ PS=2.92u PD=1.5u rfmode=0
M$2384 VDD \$684 \$682 VDD sg13_lv_pmos L=0.13u W=0.84u AS=0.1918p AD=0.1596p
+ PS=1.5u PD=1.22u rfmode=0
M$2385 \$682 \$315 VDD VDD sg13_lv_pmos L=0.13u W=0.84u AS=0.1596p AD=0.2856p
+ PS=1.22u PD=2.36u rfmode=0
M$2386 \$684 \$683 VDD VDD sg13_lv_pmos L=0.13u W=1.12u AS=0.3808p AD=0.3808p
+ PS=2.92u PD=2.92u rfmode=0
M$2387 \$683 \$347 \$714 VDD sg13_lv_pmos L=0.13u W=1u AS=0.35p AD=0.2125p
+ PS=2.7u PD=1.425u rfmode=0
M$2388 \$714 \$348 VDD VDD sg13_lv_pmos L=0.13u W=1u AS=0.2125p AD=0.19p
+ PS=1.425u PD=1.38u rfmode=0
M$2389 VDD \$350 \$714 VDD sg13_lv_pmos L=0.13u W=1u AS=0.19p AD=0.34p PS=1.38u
+ PD=2.68u rfmode=0
M$2390 \$659 \$685 VDD VDD sg13_lv_pmos L=0.13u W=1.12u AS=0.3808p AD=0.3808p
+ PS=2.92u PD=2.92u rfmode=0
M$2391 \$660 \$686 VDD VDD sg13_lv_pmos L=0.13u W=1.12u AS=0.42p AD=0.2114p
+ PS=2.99u PD=1.54u rfmode=0
M$2392 VDD \$321 \$686 VDD sg13_lv_pmos L=0.13u W=0.84u AS=0.2114p AD=0.2856p
+ PS=1.54u PD=2.36u rfmode=0
M$2393 VDD \$660 \$687 VDD sg13_lv_pmos L=0.13u W=0.84u AS=0.2114p AD=0.2856p
+ PS=1.54u PD=2.36u rfmode=0
M$2394 VDD \$687 \$622 VDD sg13_lv_pmos L=0.13u W=1.12u AS=0.2114p AD=0.42p
+ PS=1.54u PD=2.99u rfmode=0
M$2395 \$689 \$688 VDD VDD sg13_lv_pmos L=0.13u W=1.12u AS=0.3808p AD=0.3808p
+ PS=2.92u PD=2.92u rfmode=0
M$2396 \$688 \$798 \$715 VDD sg13_lv_pmos L=0.13u W=1u AS=0.35p AD=0.2125p
+ PS=2.7u PD=1.425u rfmode=0
M$2397 \$715 \$685 VDD VDD sg13_lv_pmos L=0.13u W=1u AS=0.2125p AD=0.19p
+ PS=1.425u PD=1.38u rfmode=0
M$2398 VDD \$605 \$715 VDD sg13_lv_pmos L=0.13u W=1u AS=0.19p AD=0.34p PS=1.38u
+ PD=2.68u rfmode=0
M$2399 VDD \$370 \$723 VDD sg13_lv_pmos L=0.15u W=1.12u AS=0.3808p AD=0.2128p
+ PS=2.92u PD=1.5u rfmode=0
M$2400 \$723 \$659 \$662 VDD sg13_lv_pmos L=0.15u W=1.12u AS=0.2128p AD=0.2128p
+ PS=1.5u PD=1.5u rfmode=0
M$2401 \$662 \$348 VDD VDD sg13_lv_pmos L=0.15u W=1.12u AS=0.2128p AD=0.3808p
+ PS=1.5u PD=2.92u rfmode=0
M$2402 VDD fclk_in \$663 VDD sg13_lv_pmos L=0.13u W=6.72u AS=1.4448p AD=1.2768p
+ PS=10.42u PD=9u rfmode=0
M$2408 VDD \$663 \$664 VDD sg13_lv_pmos L=0.13u W=17.92u AS=3.4048p AD=3.5896p
+ PS=24u PD=25.45u rfmode=0
M$2424 VDD \$417 \$609 VDD sg13_lv_pmos L=0.13u W=0.42u AS=0.1428p AD=0.0798p
+ PS=1.52u PD=0.8u rfmode=0
M$2425 VDD \$623 \$609 VDD sg13_lv_pmos L=0.13u W=0.42u AS=0.3623875p
+ AD=0.0798p PS=2.605u PD=0.8u rfmode=0
M$2426 VDD \$611 \$610 VDD sg13_lv_pmos L=0.13u W=1u AS=0.3623875p AD=0.34p
+ PS=2.605u PD=2.68u rfmode=0
M$2427 VDD \$623 \$611 VDD sg13_lv_pmos L=0.13u W=0.42u AS=0.1563p AD=0.147p
+ PS=1.22u PD=1.54u rfmode=0
M$2428 VDD \$610 \$620 VDD sg13_lv_pmos L=0.13u W=0.42u AS=0.1563p AD=0.063p
+ PS=1.22u PD=0.72u rfmode=0
M$2429 \$620 \$625 \$611 VDD sg13_lv_pmos L=0.13u W=0.42u AS=0.063p AD=0.0798p
+ PS=0.72u PD=0.8u rfmode=0
M$2430 \$611 \$612 \$609 VDD sg13_lv_pmos L=0.13u W=0.42u AS=0.0798p AD=0.1428p
+ PS=0.8u PD=1.52u rfmode=0
M$2431 fdac_clk \$690 VDD VDD sg13_lv_pmos L=0.13u W=1.12u AS=0.42p AD=0.2114p
+ PS=2.99u PD=1.54u rfmode=0
M$2432 VDD \$331 \$690 VDD sg13_lv_pmos L=0.13u W=0.84u AS=0.2114p AD=0.2856p
+ PS=1.54u PD=2.36u rfmode=0
M$2433 VDD \$625 \$612 VDD sg13_lv_pmos L=0.13u W=1.12u AS=0.41165p AD=0.3864p
+ PS=2.12u PD=2.93u rfmode=0
M$2434 VDD \$556 \$625 VDD sg13_lv_pmos L=0.13u W=1.12u AS=0.41165p AD=0.4088p
+ PS=2.12u PD=2.97u rfmode=0
M$2435 VDD \$435 \$666 VDD sg13_lv_pmos L=0.13u W=1.12u AS=0.3808p AD=0.3808p
+ PS=2.92u PD=2.92u rfmode=0
M$2436 \$610 \$625 \$613 VDD sg13_lv_pmos L=0.13u W=1u AS=0.34p AD=0.2048p
+ PS=2.68u PD=1.63u rfmode=0
M$2437 \$613 \$612 \$631 VDD sg13_lv_pmos L=0.13u W=0.42u AS=0.2048p
+ AD=0.09345p PS=1.63u PD=0.865u rfmode=0
M$2438 VDD \$614 \$631 VDD sg13_lv_pmos L=0.13u W=0.42u AS=0.204p AD=0.09345p
+ PS=1.835u PD=0.865u rfmode=0
M$2439 VDD \$623 \$614 VDD sg13_lv_pmos L=0.13u W=0.42u AS=0.204p AD=0.0798p
+ PS=1.835u PD=0.8u rfmode=0
M$2440 VDD \$613 \$614 VDD sg13_lv_pmos L=0.13u W=0.42u AS=0.4659p AD=0.0798p
+ PS=3.65u PD=0.8u rfmode=0
M$2441 \$370 \$691 VDD VDD sg13_lv_pmos L=0.13u W=1.12u AS=0.3808p AD=0.3808p
+ PS=2.92u PD=2.92u rfmode=0
M$2442 VDD \$693 \$692 VDD sg13_lv_pmos L=0.5u W=1u AS=0.2254p AD=0.34p
+ PS=1.53u PD=2.68u rfmode=0
M$2443 \$691 \$692 VDD VDD sg13_lv_pmos L=0.13u W=1.12u AS=0.4256p AD=0.2254p
+ PS=3u PD=1.53u rfmode=0
M$2444 VDD \$616 \$667 VDD sg13_lv_pmos L=0.13u W=0.42u AS=0.1523p AD=0.1428p
+ PS=1.38u PD=1.52u rfmode=0
M$2445 \$693 \$667 VDD VDD sg13_lv_pmos L=0.5u W=1u AS=0.34p AD=0.1523p
+ PS=2.68u PD=1.38u rfmode=0
M$2446 \$694 \$603 VDD VDD sg13_lv_pmos L=0.13u W=0.84u AS=0.2856p AD=0.253p
+ PS=2.36u PD=1.53u rfmode=0
M$2447 VDD \$603 \$727 VDD sg13_lv_pmos L=0.13u W=1u AS=0.253p AD=0.3325p
+ PS=1.53u PD=1.665u rfmode=0
M$2448 \$727 \$695 \$668 VDD sg13_lv_pmos L=0.13u W=1u AS=0.3325p AD=0.2225p
+ PS=1.665u PD=1.445u rfmode=0
M$2449 \$668 \$617 \$726 VDD sg13_lv_pmos L=0.13u W=1u AS=0.2225p AD=0.2975p
+ PS=1.445u PD=1.595u rfmode=0
M$2450 \$726 \$694 VDD VDD sg13_lv_pmos L=0.13u W=1u AS=0.2975p AD=0.2198p
+ PS=1.595u PD=1.52u rfmode=0
M$2451 VDD \$668 \$669 VDD sg13_lv_pmos L=0.13u W=1.12u AS=0.2198p AD=0.6048p
+ PS=1.52u PD=3.32u rfmode=0
M$2452 VDD \$669 \$670 VDD sg13_lv_pmos L=0.13u W=0.42u AS=0.1428p AD=0.0798p
+ PS=1.52u PD=0.8u rfmode=0
M$2453 VDD \$619 \$670 VDD sg13_lv_pmos L=0.13u W=0.42u AS=0.3623875p
+ AD=0.0798p PS=2.605u PD=0.8u rfmode=0
M$2454 VDD \$696 \$671 VDD sg13_lv_pmos L=0.13u W=1u AS=0.3623875p AD=0.34p
+ PS=2.605u PD=2.68u rfmode=0
M$2455 \$716 \$672 VDD VDD sg13_lv_pmos L=0.13u W=1.12u AS=0.3864p AD=0.41165p
+ PS=2.93u PD=2.12u rfmode=0
M$2456 VDD \$501 \$672 VDD sg13_lv_pmos L=0.13u W=1.12u AS=0.41165p AD=0.4088p
+ PS=2.12u PD=2.97u rfmode=0
M$2457 \$698 \$716 \$717 VDD sg13_lv_pmos L=0.13u W=0.42u AS=0.2048p
+ AD=0.09345p PS=1.63u PD=0.865u rfmode=0
M$2458 \$717 \$674 VDD VDD sg13_lv_pmos L=0.13u W=0.42u AS=0.09345p AD=0.204p
+ PS=0.865u PD=1.835u rfmode=0
M$2459 VDD \$619 \$674 VDD sg13_lv_pmos L=0.13u W=0.42u AS=0.204p AD=0.0798p
+ PS=1.835u PD=0.8u rfmode=0
M$2460 \$674 \$698 VDD VDD sg13_lv_pmos L=0.13u W=0.42u AS=0.0798p AD=0.4659p
+ PS=0.8u PD=3.65u rfmode=0
M$2461 \$671 \$672 \$698 VDD sg13_lv_pmos L=0.13u W=1u AS=0.34p AD=0.2048p
+ PS=2.68u PD=1.63u rfmode=0
M$2462 \$675 \$698 VDD VDD sg13_lv_pmos L=0.13u W=1.12u AS=0.3864p AD=0.2128p
+ PS=2.93u PD=1.5u rfmode=0
M$2463 VDD \$675 \$695 VDD sg13_lv_pmos L=0.13u W=1.12u AS=0.2128p AD=0.3808p
+ PS=1.5u PD=2.92u rfmode=0
M$2489 VDD \$695 \$699 VDD sg13_lv_pmos L=0.13u W=0.84u AS=0.2114p AD=0.2856p
+ PS=1.54u PD=2.36u rfmode=0
M$2490 VDD \$699 \$37 VDD sg13_lv_pmos L=0.13u W=1.12u AS=0.2114p AD=0.42p
+ PS=1.54u PD=2.99u rfmode=0
M$2513 \$679 \$652 VDD VDD sg13_lv_pmos L=0.13u W=0.42u AS=0.147p AD=0.1563p
+ PS=1.54u PD=1.22u rfmode=0
M$2514 VDD \$654 \$721 VDD sg13_lv_pmos L=0.13u W=0.42u AS=0.1563p AD=0.063p
+ PS=1.22u PD=0.72u rfmode=0
M$2515 \$721 \$655 \$679 VDD sg13_lv_pmos L=0.13u W=0.42u AS=0.063p AD=0.0798p
+ PS=0.72u PD=0.8u rfmode=0
M$2516 \$679 \$713 \$653 VDD sg13_lv_pmos L=0.13u W=0.42u AS=0.0798p AD=0.1428p
+ PS=0.8u PD=1.52u rfmode=0
M$2518 \$728 \$763 VDD VDD sg13_lv_pmos L=0.13u W=1.12u AS=0.6048p AD=0.2198p
+ PS=3.32u PD=1.52u rfmode=0
M$2519 VDD \$729 \$756 VDD sg13_lv_pmos L=0.13u W=1u AS=0.2198p AD=0.2975p
+ PS=1.52u PD=1.595u rfmode=0
M$2520 \$756 \$345 \$763 VDD sg13_lv_pmos L=0.13u W=1u AS=0.2975p AD=0.2225p
+ PS=1.595u PD=1.445u rfmode=0
M$2521 \$763 \$738 \$757 VDD sg13_lv_pmos L=0.13u W=1u AS=0.2225p AD=0.3325p
+ PS=1.445u PD=1.665u rfmode=0
M$2522 \$757 \$739 VDD VDD sg13_lv_pmos L=0.13u W=1u AS=0.3325p AD=0.253p
+ PS=1.665u PD=1.53u rfmode=0
M$2523 VDD \$739 \$729 VDD sg13_lv_pmos L=0.13u W=0.84u AS=0.253p AD=0.2856p
+ PS=1.53u PD=2.36u rfmode=0
M$2528 \$407 \$622 VDD VDD sg13_lv_pmos L=0.13u W=1.12u AS=0.3808p AD=0.3808p
+ PS=2.92u PD=2.92u rfmode=0
M$2529 VDD \$660 \$730 VDD sg13_lv_pmos L=0.13u W=0.84u AS=0.2114p AD=0.2856p
+ PS=1.54u PD=2.36u rfmode=0
M$2530 \$435 \$730 VDD VDD sg13_lv_pmos L=0.13u W=1.12u AS=0.42p AD=0.2114p
+ PS=2.99u PD=1.54u rfmode=0
M$2531 VDD \$689 \$741 VDD sg13_lv_pmos L=0.13u W=0.42u AS=0.1428p AD=0.0798p
+ PS=1.52u PD=0.8u rfmode=0
M$2532 VDD \$731 \$741 VDD sg13_lv_pmos L=0.13u W=0.42u AS=0.3623875p
+ AD=0.0798p PS=2.605u PD=0.8u rfmode=0
M$2533 VDD \$742 \$743 VDD sg13_lv_pmos L=0.13u W=1u AS=0.3623875p AD=0.34p
+ PS=2.605u PD=2.68u rfmode=0
M$2534 VDD \$731 \$742 VDD sg13_lv_pmos L=0.13u W=0.42u AS=0.1563p AD=0.147p
+ PS=1.22u PD=1.54u rfmode=0
M$2535 VDD \$743 \$758 VDD sg13_lv_pmos L=0.13u W=0.42u AS=0.1563p AD=0.063p
+ PS=1.22u PD=0.72u rfmode=0
M$2536 \$758 \$745 \$742 VDD sg13_lv_pmos L=0.13u W=0.42u AS=0.063p AD=0.0798p
+ PS=0.72u PD=0.8u rfmode=0
M$2537 \$742 \$744 \$741 VDD sg13_lv_pmos L=0.13u W=0.42u AS=0.0798p AD=0.1428p
+ PS=0.8u PD=1.52u rfmode=0
M$2538 VDD \$745 \$744 VDD sg13_lv_pmos L=0.13u W=1.12u AS=0.41165p AD=0.3864p
+ PS=2.12u PD=2.93u rfmode=0
M$2539 VDD \$740 \$745 VDD sg13_lv_pmos L=0.13u W=1.12u AS=0.41165p AD=0.4088p
+ PS=2.12u PD=2.97u rfmode=0
M$2540 \$743 \$745 \$746 VDD sg13_lv_pmos L=0.13u W=1u AS=0.34p AD=0.2048p
+ PS=2.68u PD=1.63u rfmode=0
M$2541 \$746 \$744 \$759 VDD sg13_lv_pmos L=0.13u W=0.42u AS=0.2048p
+ AD=0.09345p PS=1.63u PD=0.865u rfmode=0
M$2542 VDD \$747 \$759 VDD sg13_lv_pmos L=0.13u W=0.42u AS=0.204p AD=0.09345p
+ PS=1.835u PD=0.865u rfmode=0
M$2543 VDD \$731 \$747 VDD sg13_lv_pmos L=0.13u W=0.42u AS=0.204p AD=0.0798p
+ PS=1.835u PD=0.8u rfmode=0
M$2544 VDD \$746 \$747 VDD sg13_lv_pmos L=0.13u W=0.42u AS=0.4659p AD=0.0798p
+ PS=3.65u PD=0.8u rfmode=0
M$2545 \$732 \$746 VDD VDD sg13_lv_pmos L=0.13u W=1.12u AS=0.3864p AD=0.2128p
+ PS=2.93u PD=1.5u rfmode=0
M$2546 VDD \$732 \$685 VDD sg13_lv_pmos L=0.13u W=1.12u AS=0.2128p AD=0.3808p
+ PS=1.5u PD=2.92u rfmode=0
M$2547 VDD \$622 \$623 VDD sg13_lv_pmos L=0.13u W=1.12u AS=0.3808p AD=0.3808p
+ PS=2.92u PD=2.92u rfmode=0
M$2548 VDD \$662 \$733 VDD sg13_lv_pmos L=0.13u W=1.12u AS=0.3808p AD=0.2128p
+ PS=2.92u PD=1.5u rfmode=0
M$2549 \$733 \$748 VDD VDD sg13_lv_pmos L=0.13u W=1.12u AS=0.2128p AD=0.3808p
+ PS=1.5u PD=2.92u rfmode=0
M$2550 VDD \$748 \$760 VDD sg13_lv_pmos L=0.15u W=1.12u AS=0.3808p AD=0.2128p
+ PS=2.92u PD=1.5u rfmode=0
M$2551 \$760 \$818 \$734 VDD sg13_lv_pmos L=0.15u W=1.12u AS=0.2128p AD=0.2128p
+ PS=1.5u PD=1.5u rfmode=0
M$2552 \$734 \$733 VDD VDD sg13_lv_pmos L=0.15u W=1.12u AS=0.2128p AD=0.3808p
+ PS=1.5u PD=2.92u rfmode=0
M$2553 VDD \$734 \$749 VDD sg13_lv_pmos L=0.13u W=0.42u AS=0.1428p AD=0.0798p
+ PS=1.52u PD=0.8u rfmode=0
M$2554 VDD \$666 \$749 VDD sg13_lv_pmos L=0.13u W=0.42u AS=0.3623875p
+ AD=0.0798p PS=2.605u PD=0.8u rfmode=0
M$2555 VDD \$750 \$751 VDD sg13_lv_pmos L=0.13u W=1u AS=0.3623875p AD=0.34p
+ PS=2.605u PD=2.68u rfmode=0
M$2556 VDD \$666 \$750 VDD sg13_lv_pmos L=0.13u W=0.42u AS=0.1563p AD=0.147p
+ PS=1.22u PD=1.54u rfmode=0
M$2557 VDD \$751 \$761 VDD sg13_lv_pmos L=0.13u W=0.42u AS=0.1563p AD=0.063p
+ PS=1.22u PD=0.72u rfmode=0
M$2558 \$761 \$753 \$750 VDD sg13_lv_pmos L=0.13u W=0.42u AS=0.063p AD=0.0798p
+ PS=0.72u PD=0.8u rfmode=0
M$2559 \$750 \$752 \$749 VDD sg13_lv_pmos L=0.13u W=0.42u AS=0.0798p AD=0.1428p
+ PS=0.8u PD=1.52u rfmode=0
M$2560 VDD \$753 \$752 VDD sg13_lv_pmos L=0.13u W=1.12u AS=0.41165p AD=0.3864p
+ PS=2.12u PD=2.93u rfmode=0
M$2561 VDD \$740 \$753 VDD sg13_lv_pmos L=0.13u W=1.12u AS=0.41165p AD=0.4088p
+ PS=2.12u PD=2.97u rfmode=0
M$2562 \$751 \$753 \$754 VDD sg13_lv_pmos L=0.13u W=1u AS=0.34p AD=0.2048p
+ PS=2.68u PD=1.63u rfmode=0
M$2563 \$754 \$752 \$762 VDD sg13_lv_pmos L=0.13u W=0.42u AS=0.2048p
+ AD=0.09345p PS=1.63u PD=0.865u rfmode=0
M$2564 VDD \$755 \$762 VDD sg13_lv_pmos L=0.13u W=0.42u AS=0.204p AD=0.09345p
+ PS=1.835u PD=0.865u rfmode=0
M$2565 VDD \$666 \$755 VDD sg13_lv_pmos L=0.13u W=0.42u AS=0.204p AD=0.0798p
+ PS=1.835u PD=0.8u rfmode=0
M$2566 VDD \$754 \$755 VDD sg13_lv_pmos L=0.13u W=0.42u AS=0.4659p AD=0.0798p
+ PS=3.65u PD=0.8u rfmode=0
M$2567 \$735 \$754 VDD VDD sg13_lv_pmos L=0.13u W=1.12u AS=0.3864p AD=0.2128p
+ PS=2.93u PD=1.5u rfmode=0
M$2568 VDD \$735 \$748 VDD sg13_lv_pmos L=0.13u W=1.12u AS=0.2128p AD=0.3808p
+ PS=1.5u PD=2.92u rfmode=0
M$2571 VDD \$334 \$736 VDD sg13_lv_pmos L=0.13u W=0.84u AS=0.2114p AD=0.2856p
+ PS=1.54u PD=2.36u rfmode=0
M$2572 \$626 \$736 VDD VDD sg13_lv_pmos L=0.13u W=1.12u AS=0.42p AD=0.2114p
+ PS=2.99u PD=1.54u rfmode=0
M$2575 \$696 \$619 VDD VDD sg13_lv_pmos L=0.13u W=0.42u AS=0.147p AD=0.1563p
+ PS=1.54u PD=1.22u rfmode=0
M$2576 VDD \$671 \$724 VDD sg13_lv_pmos L=0.13u W=0.42u AS=0.1563p AD=0.063p
+ PS=1.22u PD=0.72u rfmode=0
M$2577 \$724 \$672 \$696 VDD sg13_lv_pmos L=0.13u W=0.42u AS=0.063p AD=0.0798p
+ PS=0.72u PD=0.8u rfmode=0
M$2578 \$696 \$716 \$670 VDD sg13_lv_pmos L=0.13u W=0.42u AS=0.0798p AD=0.1428p
+ PS=0.8u PD=1.52u rfmode=0
M$2580 VDD \$335 \$737 VDD sg13_lv_pmos L=0.13u W=1.12u AS=0.3808p AD=0.3808p
+ PS=2.92u PD=2.92u rfmode=0
M$2631 VDD \$428 \$794 VDD sg13_lv_pmos L=0.13u W=1.12u AS=0.3808p AD=0.3808p
+ PS=2.92u PD=2.92u rfmode=0
M$2632 VDD \$728 \$781 VDD sg13_lv_pmos L=0.13u W=0.42u AS=0.1428p AD=0.0798p
+ PS=1.52u PD=0.8u rfmode=0
M$2633 VDD \$794 \$781 VDD sg13_lv_pmos L=0.13u W=0.42u AS=0.3623875p
+ AD=0.0798p PS=2.605u PD=0.8u rfmode=0
M$2634 VDD \$815 \$782 VDD sg13_lv_pmos L=0.13u W=1u AS=0.3623875p AD=0.34p
+ PS=2.605u PD=2.68u rfmode=0
M$2635 \$796 \$783 VDD VDD sg13_lv_pmos L=0.13u W=1.12u AS=0.3864p AD=0.41165p
+ PS=2.93u PD=2.12u rfmode=0
M$2636 VDD \$489 \$783 VDD sg13_lv_pmos L=0.13u W=1.12u AS=0.41165p AD=0.4088p
+ PS=2.12u PD=2.97u rfmode=0
M$2637 \$797 \$796 \$824 VDD sg13_lv_pmos L=0.13u W=0.42u AS=0.2048p
+ AD=0.09345p PS=1.63u PD=0.865u rfmode=0
M$2638 \$824 \$785 VDD VDD sg13_lv_pmos L=0.13u W=0.42u AS=0.09345p AD=0.204p
+ PS=0.865u PD=1.835u rfmode=0
M$2639 VDD \$794 \$785 VDD sg13_lv_pmos L=0.13u W=0.42u AS=0.204p AD=0.0798p
+ PS=1.835u PD=0.8u rfmode=0
M$2640 \$785 \$797 VDD VDD sg13_lv_pmos L=0.13u W=0.42u AS=0.0798p AD=0.4659p
+ PS=0.8u PD=3.65u rfmode=0
M$2641 \$782 \$783 \$797 VDD sg13_lv_pmos L=0.13u W=1u AS=0.34p AD=0.2048p
+ PS=2.68u PD=1.63u rfmode=0
M$2642 \$786 \$797 VDD VDD sg13_lv_pmos L=0.13u W=1.12u AS=0.3864p AD=0.2128p
+ PS=2.93u PD=1.5u rfmode=0
M$2643 VDD \$786 \$738 VDD sg13_lv_pmos L=0.13u W=1.12u AS=0.2128p AD=0.3808p
+ PS=1.5u PD=2.92u rfmode=0
M$2646 VDD \$435 \$731 VDD sg13_lv_pmos L=0.13u W=1.12u AS=0.3808p AD=0.3808p
+ PS=2.92u PD=2.92u rfmode=0
M$2649 \$798 \$816 \$827 VDD sg13_lv_pmos L=0.13u W=1.12u AS=0.3808p AD=0.1176p
+ PS=2.92u PD=1.33u rfmode=0
M$2650 \$827 \$817 VDD VDD sg13_lv_pmos L=0.13u W=1.12u AS=0.1176p AD=0.4032p
+ PS=1.33u PD=2.96u rfmode=0
M$2651 VDD \$845 \$828 VDD sg13_lv_pmos L=0.13u W=1.12u AS=0.3808p AD=0.2464p
+ PS=2.92u PD=1.56u rfmode=0
M$2652 \$828 \$817 \$829 VDD sg13_lv_pmos L=0.13u W=1.12u AS=0.2464p AD=0.2128p
+ PS=1.56u PD=1.5u rfmode=0
M$2653 \$829 \$818 \$739 VDD sg13_lv_pmos L=0.13u W=1.12u AS=0.2128p AD=0.3808p
+ PS=1.5u PD=2.92u rfmode=0
M$2654 VDD \$799 \$832 VDD sg13_lv_pmos L=0.13u W=1.12u AS=0.4032p AD=0.1176p
+ PS=2.96u PD=1.33u rfmode=0
M$2655 \$832 \$818 \$800 VDD sg13_lv_pmos L=0.13u W=1.12u AS=0.1176p AD=0.3808p
+ PS=1.33u PD=2.92u rfmode=0
M$2658 \$818 \$801 VDD VDD sg13_lv_pmos L=0.13u W=1.12u AS=0.42p AD=0.2114p
+ PS=2.99u PD=1.54u rfmode=0
M$2659 VDD \$607 \$801 VDD sg13_lv_pmos L=0.13u W=0.84u AS=0.2114p AD=0.2856p
+ PS=1.54u PD=2.36u rfmode=0
M$2664 \$740 \$802 VDD VDD sg13_lv_pmos L=0.13u W=1.12u AS=0.42p AD=0.2114p
+ PS=2.99u PD=1.54u rfmode=0
M$2665 VDD \$336 \$802 VDD sg13_lv_pmos L=0.13u W=0.84u AS=0.2114p AD=0.2856p
+ PS=1.54u PD=2.36u rfmode=0
M$2671 \$803 \$739 \$834 VDD sg13_lv_pmos L=0.13u W=1.12u AS=0.3808p AD=0.1176p
+ PS=2.92u PD=1.33u rfmode=0
M$2672 \$834 \$819 VDD VDD sg13_lv_pmos L=0.13u W=1.12u AS=0.1176p AD=0.4032p
+ PS=1.33u PD=2.96u rfmode=0
M$2673 \$820 \$345 VDD VDD sg13_lv_pmos L=0.13u W=1.12u AS=0.3808p AD=0.2128p
+ PS=2.92u PD=1.5u rfmode=0
M$2674 VDD \$739 \$820 VDD sg13_lv_pmos L=0.13u W=1.12u AS=0.2128p AD=0.2128p
+ PS=1.5u PD=1.5u rfmode=0
M$2675 \$820 \$803 \$804 VDD sg13_lv_pmos L=0.13u W=1.12u AS=0.2128p AD=0.3808p
+ PS=1.5u PD=2.92u rfmode=0
M$2676 VDD \$804 \$788 VDD sg13_lv_pmos L=0.13u W=0.42u AS=0.1428p AD=0.0798p
+ PS=1.52u PD=0.8u rfmode=0
M$2677 VDD \$737 \$788 VDD sg13_lv_pmos L=0.13u W=0.42u AS=0.3623875p
+ AD=0.0798p PS=2.605u PD=0.8u rfmode=0
M$2678 VDD \$821 \$789 VDD sg13_lv_pmos L=0.13u W=1u AS=0.3623875p AD=0.34p
+ PS=2.605u PD=2.68u rfmode=0
M$2679 \$806 \$790 VDD VDD sg13_lv_pmos L=0.13u W=1.12u AS=0.3864p AD=0.41165p
+ PS=2.93u PD=2.12u rfmode=0
M$2680 VDD \$501 \$790 VDD sg13_lv_pmos L=0.13u W=1.12u AS=0.41165p AD=0.4088p
+ PS=2.12u PD=2.97u rfmode=0
M$2681 \$807 \$806 \$831 VDD sg13_lv_pmos L=0.13u W=0.42u AS=0.2048p
+ AD=0.09345p PS=1.63u PD=0.865u rfmode=0
M$2682 \$831 \$792 VDD VDD sg13_lv_pmos L=0.13u W=0.42u AS=0.09345p AD=0.204p
+ PS=0.865u PD=1.835u rfmode=0
M$2683 VDD \$737 \$792 VDD sg13_lv_pmos L=0.13u W=0.42u AS=0.204p AD=0.0798p
+ PS=1.835u PD=0.8u rfmode=0
M$2684 \$792 \$807 VDD VDD sg13_lv_pmos L=0.13u W=0.42u AS=0.0798p AD=0.4659p
+ PS=0.8u PD=3.65u rfmode=0
M$2685 \$789 \$790 \$807 VDD sg13_lv_pmos L=0.13u W=1u AS=0.34p AD=0.2048p
+ PS=2.68u PD=1.63u rfmode=0
M$2686 \$793 \$807 VDD VDD sg13_lv_pmos L=0.13u W=1.12u AS=0.3864p AD=0.2128p
+ PS=2.93u PD=1.5u rfmode=0
M$2687 VDD \$793 \$819 VDD sg13_lv_pmos L=0.13u W=1.12u AS=0.2128p AD=0.3808p
+ PS=1.5u PD=2.92u rfmode=0
M$2711 VDD \$738 \$836 VDD sg13_lv_pmos L=0.13u W=0.84u AS=0.2114p AD=0.2856p
+ PS=1.54u PD=2.36u rfmode=0
M$2712 \$31 \$836 VDD VDD sg13_lv_pmos L=0.13u W=1.12u AS=0.42p AD=0.2114p
+ PS=2.99u PD=1.54u rfmode=0
M$2727 \$837 \$859 \$838 VDD sg13_lv_pmos L=0.13u W=1.12u AS=0.3808p AD=0.2128p
+ PS=2.92u PD=1.5u rfmode=0
M$2728 \$838 \$344 VDD VDD sg13_lv_pmos L=0.13u W=1.12u AS=0.2128p AD=0.2128p
+ PS=1.5u PD=1.5u rfmode=0
M$2729 VDD \$345 \$838 VDD sg13_lv_pmos L=0.13u W=1.12u AS=0.2128p AD=0.3808p
+ PS=1.5u PD=2.92u rfmode=0
M$2738 \$815 \$794 VDD VDD sg13_lv_pmos L=0.13u W=0.42u AS=0.147p AD=0.1563p
+ PS=1.54u PD=1.22u rfmode=0
M$2739 VDD \$782 \$823 VDD sg13_lv_pmos L=0.13u W=0.42u AS=0.1563p AD=0.063p
+ PS=1.22u PD=0.72u rfmode=0
M$2740 \$823 \$783 \$815 VDD sg13_lv_pmos L=0.13u W=0.42u AS=0.063p AD=0.0798p
+ PS=0.72u PD=0.8u rfmode=0
M$2741 \$815 \$796 \$781 VDD sg13_lv_pmos L=0.13u W=0.42u AS=0.0798p AD=0.1428p
+ PS=0.8u PD=1.52u rfmode=0
M$2743 VDD \$739 \$839 VDD sg13_lv_pmos L=0.13u W=0.84u AS=0.2198p AD=0.2856p
+ PS=1.53u PD=2.36u rfmode=0
M$2744 VDD \$878 \$840 VDD sg13_lv_pmos L=0.13u W=1.12u AS=0.2198p AD=0.2128p
+ PS=1.53u PD=1.5u rfmode=0
M$2745 \$840 \$839 VDD VDD sg13_lv_pmos L=0.13u W=1.12u AS=0.2128p AD=0.3808p
+ PS=1.5u PD=2.92u rfmode=0
M$2746 VDD \$862 \$861 VDD sg13_lv_pmos L=0.13u W=1.12u AS=0.41165p AD=0.3864p
+ PS=2.12u PD=2.93u rfmode=0
M$2747 VDD \$740 \$862 VDD sg13_lv_pmos L=0.13u W=1.12u AS=0.41165p AD=0.4088p
+ PS=2.12u PD=2.97u rfmode=0
M$2748 \$844 \$863 VDD VDD sg13_lv_pmos L=0.13u W=1.12u AS=0.3864p AD=0.2128p
+ PS=2.93u PD=1.5u rfmode=0
M$2749 VDD \$844 \$845 VDD sg13_lv_pmos L=0.13u W=1.12u AS=0.2128p AD=0.3808p
+ PS=1.5u PD=2.92u rfmode=0
M$2750 VDD \$817 \$846 VDD sg13_lv_pmos L=0.13u W=1.12u AS=0.3808p AD=0.2716p
+ PS=2.92u PD=1.605u rfmode=0
M$2751 \$846 \$662 \$878 VDD sg13_lv_pmos L=0.13u W=1.12u AS=0.2716p AD=0.2128p
+ PS=1.605u PD=1.5u rfmode=0
M$2752 \$878 \$845 \$846 VDD sg13_lv_pmos L=0.13u W=1.12u AS=0.2128p AD=0.2744p
+ PS=1.5u PD=1.61u rfmode=0
M$2753 \$846 \$800 VDD VDD sg13_lv_pmos L=0.13u W=1.12u AS=0.2744p AD=0.3808p
+ PS=1.61u PD=2.92u rfmode=0
M$2754 \$787 \$818 \$830 VDD sg13_lv_pmos L=0.13u W=0.84u AS=0.2856p AD=0.1596p
+ PS=2.36u PD=1.22u rfmode=0
M$2755 VDD \$799 \$830 VDD sg13_lv_pmos L=0.13u W=0.84u AS=0.2226p AD=0.1596p
+ PS=1.535u PD=1.22u rfmode=0
M$2756 VDD \$787 \$816 VDD sg13_lv_pmos L=0.13u W=1.12u AS=0.2226p AD=0.3976p
+ PS=1.535u PD=2.95u rfmode=0
M$2757 VDD \$880 \$817 VDD sg13_lv_pmos L=0.13u W=1.12u AS=0.3808p AD=0.2128p
+ PS=2.92u PD=1.5u rfmode=0
M$2758 \$817 \$748 VDD VDD sg13_lv_pmos L=0.13u W=1.12u AS=0.2128p AD=0.3808p
+ PS=1.5u PD=2.92u rfmode=0
M$2759 VDD \$880 \$874 VDD sg13_lv_pmos L=0.13u W=1.12u AS=0.3808p AD=0.2464p
+ PS=2.92u PD=1.56u rfmode=0
M$2760 \$874 \$748 \$873 VDD sg13_lv_pmos L=0.13u W=1.12u AS=0.2464p AD=0.2128p
+ PS=1.56u PD=1.5u rfmode=0
M$2761 \$873 \$816 \$603 VDD sg13_lv_pmos L=0.13u W=1.12u AS=0.2128p AD=0.3808p
+ PS=1.5u PD=2.92u rfmode=0
M$2762 \$847 \$662 VDD VDD sg13_lv_pmos L=0.13u W=1u AS=0.34p AD=0.19p PS=2.68u
+ PD=1.38u rfmode=0
M$2763 VDD \$880 \$847 VDD sg13_lv_pmos L=0.13u W=1u AS=0.19p AD=0.2125p
+ PS=1.38u PD=1.425u rfmode=0
M$2764 \$847 \$865 \$848 VDD sg13_lv_pmos L=0.13u W=1u AS=0.2125p AD=0.35p
+ PS=1.425u PD=2.7u rfmode=0
M$2765 VDD \$848 \$849 VDD sg13_lv_pmos L=0.13u W=1.12u AS=0.3808p AD=0.3808p
+ PS=2.92u PD=2.92u rfmode=0
M$2766 \$850 \$335 VDD VDD sg13_lv_pmos L=0.13u W=1.12u AS=0.3808p AD=0.3808p
+ PS=2.92u PD=2.92u rfmode=0
M$2767 VDD \$868 \$867 VDD sg13_lv_pmos L=0.13u W=1.12u AS=0.41165p AD=0.3864p
+ PS=2.12u PD=2.93u rfmode=0
M$2768 VDD \$740 \$868 VDD sg13_lv_pmos L=0.13u W=1.12u AS=0.41165p AD=0.4088p
+ PS=2.12u PD=2.97u rfmode=0
M$2769 \$853 \$869 VDD VDD sg13_lv_pmos L=0.13u W=1.12u AS=0.3864p AD=0.2128p
+ PS=2.93u PD=1.5u rfmode=0
M$2770 VDD \$853 \$880 VDD sg13_lv_pmos L=0.13u W=1.12u AS=0.2128p AD=0.3808p
+ PS=1.5u PD=2.92u rfmode=0
M$2771 VDD \$882 \$875 VDD sg13_lv_pmos L=0.13u W=1.12u AS=0.4032p AD=0.1176p
+ PS=2.96u PD=1.33u rfmode=0
M$2772 \$875 \$739 \$854 VDD sg13_lv_pmos L=0.13u W=1.12u AS=0.1176p AD=0.3808p
+ PS=1.33u PD=2.92u rfmode=0
M$2773 \$855 \$854 \$856 VDD sg13_lv_pmos L=0.13u W=1.12u AS=0.3808p AD=0.2128p
+ PS=2.92u PD=1.5u rfmode=0
M$2774 \$856 \$739 VDD VDD sg13_lv_pmos L=0.13u W=1.12u AS=0.2128p AD=0.2128p
+ PS=1.5u PD=1.5u rfmode=0
M$2775 VDD \$345 \$856 VDD sg13_lv_pmos L=0.13u W=1.12u AS=0.2128p AD=0.3808p
+ PS=1.5u PD=2.92u rfmode=0
M$2780 \$821 \$737 VDD VDD sg13_lv_pmos L=0.13u W=0.42u AS=0.147p AD=0.1563p
+ PS=1.54u PD=1.22u rfmode=0
M$2781 VDD \$789 \$833 VDD sg13_lv_pmos L=0.13u W=0.42u AS=0.1563p AD=0.063p
+ PS=1.22u PD=0.72u rfmode=0
M$2782 \$833 \$790 \$821 VDD sg13_lv_pmos L=0.13u W=0.42u AS=0.063p AD=0.0798p
+ PS=0.72u PD=0.8u rfmode=0
M$2783 \$821 \$806 \$788 VDD sg13_lv_pmos L=0.13u W=0.42u AS=0.0798p AD=0.1428p
+ PS=0.8u PD=1.52u rfmode=0
M$2790 VDD \$883 \$857 VDD sg13_lv_pmos L=0.13u W=1.12u AS=0.3808p AD=0.3808p
+ PS=2.92u PD=2.92u rfmode=0
M$2811 \$858 \$819 VDD VDD sg13_lv_pmos L=0.13u W=0.84u AS=0.2856p AD=0.2114p
+ PS=2.36u PD=1.54u rfmode=0
M$2812 VDD \$858 \$38 VDD sg13_lv_pmos L=0.13u W=1.12u AS=0.2114p AD=0.42p
+ PS=1.54u PD=2.99u rfmode=0
M$2827 VDD \$428 \$913 VDD sg13_lv_pmos L=0.13u W=1.12u AS=0.3808p AD=0.3808p
+ PS=2.92u PD=2.92u rfmode=0
M$2828 VDD \$837 \$914 VDD sg13_lv_pmos L=0.13u W=0.42u AS=0.1428p AD=0.0798p
+ PS=1.52u PD=0.8u rfmode=0
M$2829 VDD \$913 \$914 VDD sg13_lv_pmos L=0.13u W=0.42u AS=0.3623875p
+ AD=0.0798p PS=2.605u PD=0.8u rfmode=0
M$2830 VDD \$937 \$907 VDD sg13_lv_pmos L=0.13u W=1u AS=0.3623875p AD=0.34p
+ PS=2.605u PD=2.68u rfmode=0
M$2831 \$964 \$908 VDD VDD sg13_lv_pmos L=0.13u W=1.12u AS=0.3864p AD=0.41165p
+ PS=2.93u PD=2.12u rfmode=0
M$2832 VDD \$489 \$908 VDD sg13_lv_pmos L=0.13u W=1.12u AS=0.41165p AD=0.4088p
+ PS=2.12u PD=2.97u rfmode=0
M$2833 \$938 \$964 \$971 VDD sg13_lv_pmos L=0.13u W=0.42u AS=0.2048p
+ AD=0.09345p PS=1.63u PD=0.865u rfmode=0
M$2834 \$971 \$917 VDD VDD sg13_lv_pmos L=0.13u W=0.42u AS=0.09345p AD=0.204p
+ PS=0.865u PD=1.835u rfmode=0
M$2835 VDD \$913 \$917 VDD sg13_lv_pmos L=0.13u W=0.42u AS=0.204p AD=0.0798p
+ PS=1.835u PD=0.8u rfmode=0
M$2836 \$917 \$938 VDD VDD sg13_lv_pmos L=0.13u W=0.42u AS=0.0798p AD=0.4659p
+ PS=0.8u PD=3.65u rfmode=0
M$2837 \$907 \$908 \$938 VDD sg13_lv_pmos L=0.13u W=1u AS=0.34p AD=0.2048p
+ PS=2.68u PD=1.63u rfmode=0
M$2838 \$918 \$938 VDD VDD sg13_lv_pmos L=0.13u W=1.12u AS=0.3864p AD=0.2128p
+ PS=2.93u PD=1.5u rfmode=0
M$2839 VDD \$918 \$919 VDD sg13_lv_pmos L=0.13u W=1.12u AS=0.2128p AD=0.3808p
+ PS=1.5u PD=2.92u rfmode=0
M$2842 \$920 \$939 \$965 VDD sg13_lv_pmos L=0.13u W=1.12u AS=0.3808p AD=0.2128p
+ PS=2.92u PD=1.5u rfmode=0
M$2843 \$965 \$626 VDD VDD sg13_lv_pmos L=0.13u W=1.12u AS=0.2128p AD=0.2128p
+ PS=1.5u PD=1.5u rfmode=0
M$2844 VDD \$940 \$965 VDD sg13_lv_pmos L=0.13u W=1.12u AS=0.2128p AD=0.3808p
+ PS=1.5u PD=2.92u rfmode=0
M$2846 VDD \$840 \$841 VDD sg13_lv_pmos L=0.13u W=0.42u AS=0.1428p AD=0.0798p
+ PS=1.52u PD=0.8u rfmode=0
M$2847 VDD \$843 \$841 VDD sg13_lv_pmos L=0.13u W=0.42u AS=0.3623875p
+ AD=0.0798p PS=2.605u PD=0.8u rfmode=0
M$2848 VDD \$842 \$860 VDD sg13_lv_pmos L=0.13u W=1u AS=0.3623875p AD=0.34p
+ PS=2.605u PD=2.68u rfmode=0
M$2849 VDD \$435 \$843 VDD sg13_lv_pmos L=0.13u W=1.12u AS=0.3808p AD=0.3808p
+ PS=2.92u PD=2.92u rfmode=0
M$2852 VDD \$843 \$842 VDD sg13_lv_pmos L=0.13u W=0.42u AS=0.1563p AD=0.147p
+ PS=1.22u PD=1.54u rfmode=0
M$2853 VDD \$860 \$871 VDD sg13_lv_pmos L=0.13u W=0.42u AS=0.1563p AD=0.063p
+ PS=1.22u PD=0.72u rfmode=0
M$2854 \$871 \$862 \$842 VDD sg13_lv_pmos L=0.13u W=0.42u AS=0.063p AD=0.0798p
+ PS=0.72u PD=0.8u rfmode=0
M$2855 \$842 \$861 \$841 VDD sg13_lv_pmos L=0.13u W=0.42u AS=0.0798p AD=0.1428p
+ PS=0.8u PD=1.52u rfmode=0
M$2858 \$860 \$862 \$863 VDD sg13_lv_pmos L=0.13u W=1u AS=0.34p AD=0.2048p
+ PS=2.68u PD=1.63u rfmode=0
M$2859 \$863 \$861 \$872 VDD sg13_lv_pmos L=0.13u W=0.42u AS=0.2048p
+ AD=0.09345p PS=1.63u PD=0.865u rfmode=0
M$2860 VDD \$864 \$872 VDD sg13_lv_pmos L=0.13u W=0.42u AS=0.204p AD=0.09345p
+ PS=1.835u PD=0.865u rfmode=0
M$2861 VDD \$843 \$864 VDD sg13_lv_pmos L=0.13u W=0.42u AS=0.204p AD=0.0798p
+ PS=1.835u PD=0.8u rfmode=0
M$2862 VDD \$863 \$864 VDD sg13_lv_pmos L=0.13u W=0.42u AS=0.4659p AD=0.0798p
+ PS=3.65u PD=0.8u rfmode=0
M$2865 VDD \$799 \$980 VDD sg13_lv_pmos L=0.13u W=1.12u AS=0.3808p AD=0.2464p
+ PS=2.92u PD=1.56u rfmode=0
M$2866 \$980 \$818 \$982 VDD sg13_lv_pmos L=0.13u W=1.12u AS=0.2464p AD=0.2128p
+ PS=1.56u PD=1.5u rfmode=0
M$2867 \$982 \$941 \$344 VDD sg13_lv_pmos L=0.13u W=1.12u AS=0.2128p AD=0.3808p
+ PS=1.5u PD=2.92u rfmode=0
M$2868 VDD \$845 \$984 VDD sg13_lv_pmos L=0.13u W=1.12u AS=0.3808p AD=0.2464p
+ PS=2.92u PD=1.56u rfmode=0
M$2869 \$984 \$607 \$983 VDD sg13_lv_pmos L=0.13u W=1.12u AS=0.2464p AD=0.2128p
+ PS=1.56u PD=1.5u rfmode=0
M$2870 \$983 \$941 \$940 VDD sg13_lv_pmos L=0.13u W=1.12u AS=0.2128p AD=0.3808p
+ PS=1.5u PD=2.92u rfmode=0
M$2871 VDD \$748 \$942 VDD sg13_lv_pmos L=0.13u W=0.84u AS=0.2198p AD=0.2856p
+ PS=1.53u PD=2.36u rfmode=0
M$2872 VDD \$942 \$941 VDD sg13_lv_pmos L=0.13u W=1.12u AS=0.3808p AD=0.2128p
+ PS=2.92u PD=1.5u rfmode=0
M$2873 \$941 \$880 VDD VDD sg13_lv_pmos L=0.13u W=1.12u AS=0.2128p AD=0.2198p
+ PS=1.5u PD=1.53u rfmode=0
M$2874 \$966 \$941 VDD VDD sg13_lv_pmos L=0.13u W=1.12u AS=0.3808p AD=0.2128p
+ PS=2.92u PD=1.5u rfmode=0
M$2875 VDD \$921 \$966 VDD sg13_lv_pmos L=0.13u W=1.12u AS=0.2128p AD=0.2128p
+ PS=1.5u PD=1.5u rfmode=0
M$2876 \$966 \$818 \$865 VDD sg13_lv_pmos L=0.13u W=1.12u AS=0.2128p AD=0.3808p
+ PS=1.5u PD=2.92u rfmode=0
M$2877 \$943 \$880 VDD VDD sg13_lv_pmos L=0.13u W=0.84u AS=0.2856p AD=0.2198p
+ PS=2.36u PD=1.53u rfmode=0
M$2878 VDD \$748 \$921 VDD sg13_lv_pmos L=0.13u W=1.12u AS=0.2198p AD=0.2128p
+ PS=1.53u PD=1.5u rfmode=0
M$2879 \$921 \$943 VDD VDD sg13_lv_pmos L=0.13u W=1.12u AS=0.2128p AD=0.3808p
+ PS=1.5u PD=2.92u rfmode=0
M$2880 \$922 \$921 \$987 VDD sg13_lv_pmos L=0.13u W=1.12u AS=0.3808p AD=0.1176p
+ PS=2.92u PD=1.33u rfmode=0
M$2881 \$987 \$816 VDD VDD sg13_lv_pmos L=0.13u W=1.12u AS=0.1176p AD=0.4032p
+ PS=1.33u PD=2.96u rfmode=0
M$2884 VDD \$849 \$851 VDD sg13_lv_pmos L=0.13u W=0.42u AS=0.1428p AD=0.0798p
+ PS=1.52u PD=0.8u rfmode=0
M$2885 VDD \$850 \$851 VDD sg13_lv_pmos L=0.13u W=0.42u AS=0.3623875p
+ AD=0.0798p PS=2.605u PD=0.8u rfmode=0
M$2886 VDD \$852 \$866 VDD sg13_lv_pmos L=0.13u W=1u AS=0.3623875p AD=0.34p
+ PS=2.605u PD=2.68u rfmode=0
M$2887 VDD \$850 \$852 VDD sg13_lv_pmos L=0.13u W=0.42u AS=0.1563p AD=0.147p
+ PS=1.22u PD=1.54u rfmode=0
M$2888 VDD \$866 \$876 VDD sg13_lv_pmos L=0.13u W=0.42u AS=0.1563p AD=0.063p
+ PS=1.22u PD=0.72u rfmode=0
M$2889 \$876 \$868 \$852 VDD sg13_lv_pmos L=0.13u W=0.42u AS=0.063p AD=0.0798p
+ PS=0.72u PD=0.8u rfmode=0
M$2890 \$852 \$867 \$851 VDD sg13_lv_pmos L=0.13u W=0.42u AS=0.0798p AD=0.1428p
+ PS=0.8u PD=1.52u rfmode=0
M$2895 \$866 \$868 \$869 VDD sg13_lv_pmos L=0.13u W=1u AS=0.34p AD=0.2048p
+ PS=2.68u PD=1.63u rfmode=0
M$2896 \$869 \$867 \$877 VDD sg13_lv_pmos L=0.13u W=0.42u AS=0.2048p
+ AD=0.09345p PS=1.63u PD=0.865u rfmode=0
M$2897 VDD \$870 \$877 VDD sg13_lv_pmos L=0.13u W=0.42u AS=0.204p AD=0.09345p
+ PS=1.835u PD=0.865u rfmode=0
M$2898 VDD \$850 \$870 VDD sg13_lv_pmos L=0.13u W=0.42u AS=0.204p AD=0.0798p
+ PS=1.835u PD=0.8u rfmode=0
M$2899 VDD \$869 \$870 VDD sg13_lv_pmos L=0.13u W=0.42u AS=0.4659p AD=0.0798p
+ PS=3.65u PD=0.8u rfmode=0
M$2902 VDD \$335 \$923 VDD sg13_lv_pmos L=0.13u W=1.12u AS=0.3808p AD=0.3808p
+ PS=2.92u PD=2.92u rfmode=0
M$2903 VDD \$855 \$924 VDD sg13_lv_pmos L=0.13u W=0.42u AS=0.1428p AD=0.0798p
+ PS=1.52u PD=0.8u rfmode=0
M$2904 VDD \$923 \$924 VDD sg13_lv_pmos L=0.13u W=0.42u AS=0.3623875p
+ AD=0.0798p PS=2.605u PD=0.8u rfmode=0
M$2905 VDD \$944 \$909 VDD sg13_lv_pmos L=0.13u W=1u AS=0.3623875p AD=0.34p
+ PS=2.605u PD=2.68u rfmode=0
M$2906 \$967 \$910 VDD VDD sg13_lv_pmos L=0.13u W=1.12u AS=0.3864p AD=0.41165p
+ PS=2.93u PD=2.12u rfmode=0
M$2907 VDD \$501 \$910 VDD sg13_lv_pmos L=0.13u W=1.12u AS=0.41165p AD=0.4088p
+ PS=2.12u PD=2.97u rfmode=0
M$2908 \$945 \$967 \$988 VDD sg13_lv_pmos L=0.13u W=0.42u AS=0.2048p
+ AD=0.09345p PS=1.63u PD=0.865u rfmode=0
M$2909 \$988 \$927 VDD VDD sg13_lv_pmos L=0.13u W=0.42u AS=0.09345p AD=0.204p
+ PS=0.865u PD=1.835u rfmode=0
M$2910 VDD \$923 \$927 VDD sg13_lv_pmos L=0.13u W=0.42u AS=0.204p AD=0.0798p
+ PS=1.835u PD=0.8u rfmode=0
M$2911 \$927 \$945 VDD VDD sg13_lv_pmos L=0.13u W=0.42u AS=0.0798p AD=0.4659p
+ PS=0.8u PD=3.65u rfmode=0
M$2912 \$909 \$910 \$945 VDD sg13_lv_pmos L=0.13u W=1u AS=0.34p AD=0.2048p
+ PS=2.68u PD=1.63u rfmode=0
M$2913 \$928 \$945 VDD VDD sg13_lv_pmos L=0.13u W=1.12u AS=0.3864p AD=0.2128p
+ PS=2.93u PD=1.5u rfmode=0
M$2914 VDD \$928 \$882 VDD sg13_lv_pmos L=0.13u W=1.12u AS=0.2128p AD=0.3808p
+ PS=1.5u PD=2.92u rfmode=0
M$2915 \$929 \$940 VDD VDD sg13_lv_pmos L=0.13u W=0.84u AS=0.2856p AD=0.253p
+ PS=2.36u PD=1.53u rfmode=0
M$2916 VDD \$940 \$981 VDD sg13_lv_pmos L=0.13u W=1u AS=0.253p AD=0.3325p
+ PS=1.53u PD=1.665u rfmode=0
M$2917 \$981 \$946 \$930 VDD sg13_lv_pmos L=0.13u W=1u AS=0.3325p AD=0.2225p
+ PS=1.665u PD=1.445u rfmode=0
M$2918 \$930 \$617 \$977 VDD sg13_lv_pmos L=0.13u W=1u AS=0.2225p AD=0.2975p
+ PS=1.445u PD=1.595u rfmode=0
M$2919 \$977 \$929 VDD VDD sg13_lv_pmos L=0.13u W=1u AS=0.2975p AD=0.2198p
+ PS=1.595u PD=1.52u rfmode=0
M$2920 VDD \$930 \$931 VDD sg13_lv_pmos L=0.13u W=1.12u AS=0.2198p AD=0.6048p
+ PS=1.52u PD=3.32u rfmode=0
M$2921 VDD \$931 \$932 VDD sg13_lv_pmos L=0.13u W=0.42u AS=0.1428p AD=0.0798p
+ PS=1.52u PD=0.8u rfmode=0
M$2922 VDD \$857 \$932 VDD sg13_lv_pmos L=0.13u W=0.42u AS=0.3623875p
+ AD=0.0798p PS=2.605u PD=0.8u rfmode=0
M$2923 VDD \$947 \$911 VDD sg13_lv_pmos L=0.13u W=1u AS=0.3623875p AD=0.34p
+ PS=2.605u PD=2.68u rfmode=0
M$2924 \$968 \$912 VDD VDD sg13_lv_pmos L=0.13u W=1.12u AS=0.3864p AD=0.41165p
+ PS=2.93u PD=2.12u rfmode=0
M$2925 VDD \$501 \$912 VDD sg13_lv_pmos L=0.13u W=1.12u AS=0.41165p AD=0.4088p
+ PS=2.12u PD=2.97u rfmode=0
M$2926 \$948 \$968 \$972 VDD sg13_lv_pmos L=0.13u W=0.42u AS=0.2048p
+ AD=0.09345p PS=1.63u PD=0.865u rfmode=0
M$2927 \$972 \$935 VDD VDD sg13_lv_pmos L=0.13u W=0.42u AS=0.09345p AD=0.204p
+ PS=0.865u PD=1.835u rfmode=0
M$2928 VDD \$857 \$935 VDD sg13_lv_pmos L=0.13u W=0.42u AS=0.204p AD=0.0798p
+ PS=1.835u PD=0.8u rfmode=0
M$2929 \$935 \$948 VDD VDD sg13_lv_pmos L=0.13u W=0.42u AS=0.0798p AD=0.4659p
+ PS=0.8u PD=3.65u rfmode=0
M$2930 \$911 \$912 \$948 VDD sg13_lv_pmos L=0.13u W=1u AS=0.34p AD=0.2048p
+ PS=2.68u PD=1.63u rfmode=0
M$2931 \$936 \$948 VDD VDD sg13_lv_pmos L=0.13u W=1.12u AS=0.3864p AD=0.2128p
+ PS=2.93u PD=1.5u rfmode=0
M$2932 VDD \$936 \$946 VDD sg13_lv_pmos L=0.13u W=1.12u AS=0.2128p AD=0.3808p
+ PS=1.5u PD=2.92u rfmode=0
M$2948 VDD \$1005 \$991 VDD sg13_lv_pmos L=0.13u W=0.84u AS=0.2114p AD=0.2856p
+ PS=1.54u PD=2.36u rfmode=0
M$2949 \$30 \$991 VDD VDD sg13_lv_pmos L=0.13u W=1.12u AS=0.42p AD=0.2114p
+ PS=2.99u PD=1.54u rfmode=0
M$2964 \$937 \$913 VDD VDD sg13_lv_pmos L=0.13u W=0.42u AS=0.147p AD=0.1563p
+ PS=1.54u PD=1.22u rfmode=0
M$2965 VDD \$907 \$970 VDD sg13_lv_pmos L=0.13u W=0.42u AS=0.1563p AD=0.063p
+ PS=1.22u PD=0.72u rfmode=0
M$2966 \$970 \$908 \$937 VDD sg13_lv_pmos L=0.13u W=0.42u AS=0.063p AD=0.0798p
+ PS=0.72u PD=0.8u rfmode=0
M$2967 \$937 \$964 \$914 VDD sg13_lv_pmos L=0.13u W=0.42u AS=0.0798p AD=0.1428p
+ PS=0.8u PD=1.52u rfmode=0
M$2968 \$859 \$344 \$1014 VDD sg13_lv_pmos L=0.13u W=1.12u AS=0.3808p
+ AD=0.1176p PS=2.92u PD=1.33u rfmode=0
M$2969 \$1014 \$919 VDD VDD sg13_lv_pmos L=0.13u W=1.12u AS=0.1176p AD=0.4032p
+ PS=1.33u PD=2.96u rfmode=0
M$2972 \$992 \$435 VDD VDD sg13_lv_pmos L=0.13u W=1.12u AS=0.3808p AD=0.3808p
+ PS=2.92u PD=2.92u rfmode=0
M$2973 VDD \$920 \$1006 VDD sg13_lv_pmos L=0.13u W=0.42u AS=0.1428p AD=0.0798p
+ PS=1.52u PD=0.8u rfmode=0
M$2974 VDD \$992 \$1006 VDD sg13_lv_pmos L=0.13u W=0.42u AS=0.3623875p
+ AD=0.0798p PS=2.605u PD=0.8u rfmode=0
M$2975 VDD \$1007 \$1008 VDD sg13_lv_pmos L=0.13u W=1u AS=0.3623875p AD=0.34p
+ PS=2.605u PD=2.68u rfmode=0
M$2976 VDD \$1010 \$1009 VDD sg13_lv_pmos L=0.13u W=1.12u AS=0.41165p
+ AD=0.3864p PS=2.12u PD=2.93u rfmode=0
M$2977 VDD \$489 \$1010 VDD sg13_lv_pmos L=0.13u W=1.12u AS=0.41165p AD=0.4088p
+ PS=2.12u PD=2.97u rfmode=0
M$2978 \$1008 \$1010 \$1011 VDD sg13_lv_pmos L=0.13u W=1u AS=0.34p AD=0.2048p
+ PS=2.68u PD=1.63u rfmode=0
M$2979 \$1011 \$1009 \$1016 VDD sg13_lv_pmos L=0.13u W=0.42u AS=0.2048p
+ AD=0.09345p PS=1.63u PD=0.865u rfmode=0
M$2980 VDD \$1012 \$1016 VDD sg13_lv_pmos L=0.13u W=0.42u AS=0.204p AD=0.09345p
+ PS=1.835u PD=0.865u rfmode=0
M$2981 VDD \$992 \$1012 VDD sg13_lv_pmos L=0.13u W=0.42u AS=0.204p AD=0.0798p
+ PS=1.835u PD=0.8u rfmode=0
M$2982 VDD \$1011 \$1012 VDD sg13_lv_pmos L=0.13u W=0.42u AS=0.4659p AD=0.0798p
+ PS=3.65u PD=0.8u rfmode=0
M$2983 \$993 \$1011 VDD VDD sg13_lv_pmos L=0.13u W=1.12u AS=0.3864p AD=0.2128p
+ PS=2.93u PD=1.5u rfmode=0
M$2984 VDD \$993 \$1005 VDD sg13_lv_pmos L=0.13u W=1.12u AS=0.2128p AD=0.3808p
+ PS=1.5u PD=2.92u rfmode=0
M$2985 VDD \$1005 \$1017 VDD sg13_lv_pmos L=0.13u W=1.12u AS=0.4032p AD=0.1176p
+ PS=2.96u PD=1.33u rfmode=0
M$2986 \$1017 \$940 \$939 VDD sg13_lv_pmos L=0.13u W=1.12u AS=0.1176p
+ AD=0.3808p PS=1.33u PD=2.92u rfmode=0
M$2995 \$799 \$845 VDD VDD sg13_lv_pmos L=0.13u W=1.12u AS=0.3808p AD=0.3808p
+ PS=2.92u PD=2.92u rfmode=0
M$2996 VDD \$845 \$1020 VDD sg13_lv_pmos L=0.13u W=1.12u AS=0.3808p AD=0.2464p
+ PS=2.92u PD=1.56u rfmode=0
M$2997 \$1020 \$880 \$1021 VDD sg13_lv_pmos L=0.13u W=1.12u AS=0.2464p
+ AD=0.2128p PS=1.56u PD=1.5u rfmode=0
M$2998 \$1021 \$818 \$994 VDD sg13_lv_pmos L=0.13u W=1.12u AS=0.2128p
+ AD=0.3808p PS=1.5u PD=2.92u rfmode=0
M$2999 VDD \$845 \$1022 VDD sg13_lv_pmos L=0.13u W=1.12u AS=0.3808p AD=0.2464p
+ PS=2.92u PD=1.56u rfmode=0
M$3000 \$1022 \$818 \$1023 VDD sg13_lv_pmos L=0.13u W=1.12u AS=0.2464p
+ AD=0.2128p PS=1.56u PD=1.5u rfmode=0
M$3001 \$1023 \$921 \$995 VDD sg13_lv_pmos L=0.13u W=1.12u AS=0.2128p
+ AD=0.3808p PS=1.5u PD=2.92u rfmode=0
M$3002 VDD \$921 \$1024 VDD sg13_lv_pmos L=0.13u W=1.12u AS=0.4032p AD=0.1176p
+ PS=2.96u PD=1.33u rfmode=0
M$3003 \$1024 \$626 \$996 VDD sg13_lv_pmos L=0.13u W=1.12u AS=0.1176p
+ AD=0.3808p PS=1.33u PD=2.92u rfmode=0
M$3008 VDD \$880 \$1028 VDD sg13_lv_pmos L=0.13u W=1.12u AS=0.3808p AD=0.2464p
+ PS=2.92u PD=1.56u rfmode=0
M$3009 \$1028 \$748 \$1027 VDD sg13_lv_pmos L=0.13u W=1.12u AS=0.2464p
+ AD=0.2128p PS=1.56u PD=1.5u rfmode=0
M$3010 \$1027 \$617 \$997 VDD sg13_lv_pmos L=0.13u W=1.12u AS=0.2128p
+ AD=0.3808p PS=1.5u PD=2.92u rfmode=0
M$3011 VDD \$994 \$1029 VDD sg13_lv_pmos L=0.15u W=1.12u AS=0.3808p AD=0.2128p
+ PS=2.92u PD=1.5u rfmode=0
M$3012 \$1029 \$344 \$998 VDD sg13_lv_pmos L=0.15u W=1.12u AS=0.2128p
+ AD=0.2128p PS=1.5u PD=1.5u rfmode=0
M$3013 \$998 \$997 VDD VDD sg13_lv_pmos L=0.15u W=1.12u AS=0.2128p AD=0.3808p
+ PS=1.5u PD=2.92u rfmode=0
M$3019 \$944 \$923 VDD VDD sg13_lv_pmos L=0.13u W=0.42u AS=0.147p AD=0.1563p
+ PS=1.54u PD=1.22u rfmode=0
M$3020 VDD \$909 \$989 VDD sg13_lv_pmos L=0.13u W=0.42u AS=0.1563p AD=0.063p
+ PS=1.22u PD=0.72u rfmode=0
M$3021 \$989 \$910 \$944 VDD sg13_lv_pmos L=0.13u W=0.42u AS=0.063p AD=0.0798p
+ PS=0.72u PD=0.8u rfmode=0
M$3022 \$944 \$967 \$924 VDD sg13_lv_pmos L=0.13u W=0.42u AS=0.0798p AD=0.1428p
+ PS=0.8u PD=1.52u rfmode=0
M$3023 \$999 \$1032 VDD VDD sg13_lv_pmos L=0.13u W=1.12u AS=0.6048p AD=0.2198p
+ PS=3.32u PD=1.52u rfmode=0
M$3024 VDD \$1000 \$1026 VDD sg13_lv_pmos L=0.13u W=1u AS=0.2198p AD=0.2975p
+ PS=1.52u PD=1.595u rfmode=0
M$3025 \$1026 \$617 \$1032 VDD sg13_lv_pmos L=0.13u W=1u AS=0.2975p AD=0.2225p
+ PS=1.595u PD=1.445u rfmode=0
M$3026 \$1032 \$1033 \$1025 VDD sg13_lv_pmos L=0.13u W=1u AS=0.2225p AD=0.3325p
+ PS=1.445u PD=1.665u rfmode=0
M$3027 \$1025 \$940 VDD VDD sg13_lv_pmos L=0.13u W=1u AS=0.3325p AD=0.253p
+ PS=1.665u PD=1.53u rfmode=0
M$3028 VDD \$940 \$1000 VDD sg13_lv_pmos L=0.13u W=0.84u AS=0.253p AD=0.2856p
+ PS=1.53u PD=2.36u rfmode=0
M$3032 VDD \$995 \$1013 VDD sg13_lv_pmos L=0.13u W=0.84u AS=0.253p AD=0.2856p
+ PS=1.53u PD=2.36u rfmode=0
M$3033 VDD \$995 \$1019 VDD sg13_lv_pmos L=0.13u W=1u AS=0.253p AD=0.3325p
+ PS=1.53u PD=1.665u rfmode=0
M$3034 \$1019 \$1034 \$1001 VDD sg13_lv_pmos L=0.13u W=1u AS=0.3325p AD=0.2225p
+ PS=1.665u PD=1.445u rfmode=0
M$3035 \$1001 \$617 \$1018 VDD sg13_lv_pmos L=0.13u W=1u AS=0.2225p AD=0.2975p
+ PS=1.445u PD=1.595u rfmode=0
M$3036 VDD \$1013 \$1018 VDD sg13_lv_pmos L=0.13u W=1u AS=0.2198p AD=0.2975p
+ PS=1.52u PD=1.595u rfmode=0
M$3037 VDD \$1001 \$1002 VDD sg13_lv_pmos L=0.13u W=1.12u AS=0.2198p AD=0.6048p
+ PS=1.52u PD=3.32u rfmode=0
M$3038 \$1003 \$660 VDD VDD sg13_lv_pmos L=0.13u W=0.84u AS=0.2856p AD=0.2114p
+ PS=2.36u PD=1.54u rfmode=0
M$3039 VDD \$1003 \$883 VDD sg13_lv_pmos L=0.13u W=1.12u AS=0.2114p AD=0.42p
+ PS=1.54u PD=2.99u rfmode=0
M$3040 \$947 \$857 VDD VDD sg13_lv_pmos L=0.13u W=0.42u AS=0.147p AD=0.1563p
+ PS=1.54u PD=1.22u rfmode=0
M$3041 VDD \$911 \$975 VDD sg13_lv_pmos L=0.13u W=0.42u AS=0.1563p AD=0.063p
+ PS=1.22u PD=0.72u rfmode=0
M$3042 \$975 \$912 \$947 VDD sg13_lv_pmos L=0.13u W=0.42u AS=0.063p AD=0.0798p
+ PS=0.72u PD=0.8u rfmode=0
M$3043 \$947 \$968 \$932 VDD sg13_lv_pmos L=0.13u W=0.42u AS=0.0798p AD=0.1428p
+ PS=0.8u PD=1.52u rfmode=0
M$3064 \$1004 \$946 VDD VDD sg13_lv_pmos L=0.13u W=0.84u AS=0.2856p AD=0.2114p
+ PS=2.36u PD=1.54u rfmode=0
M$3065 VDD \$1004 \$39 VDD sg13_lv_pmos L=0.13u W=1.12u AS=0.2114p AD=0.42p
+ PS=1.54u PD=2.99u rfmode=0
M$3086 VDD \$1092 \$1061 VDD sg13_lv_pmos L=0.13u W=0.42u AS=0.1428p AD=0.0798p
+ PS=1.52u PD=0.8u rfmode=0
M$3087 VDD \$1119 \$1061 VDD sg13_lv_pmos L=0.13u W=0.42u AS=0.3623875p
+ AD=0.0798p PS=2.605u PD=0.8u rfmode=0
M$3088 VDD \$1118 \$1046 VDD sg13_lv_pmos L=0.13u W=1u AS=0.3623875p AD=0.34p
+ PS=2.605u PD=2.68u rfmode=0
M$3089 VDD \$992 \$1007 VDD sg13_lv_pmos L=0.13u W=0.42u AS=0.1563p AD=0.147p
+ PS=1.22u PD=1.54u rfmode=0
M$3090 VDD \$1008 \$1015 VDD sg13_lv_pmos L=0.13u W=0.42u AS=0.1563p AD=0.063p
+ PS=1.22u PD=0.72u rfmode=0
M$3091 \$1015 \$1010 \$1007 VDD sg13_lv_pmos L=0.13u W=0.42u AS=0.063p
+ AD=0.0798p PS=0.72u PD=0.8u rfmode=0
M$3092 \$1007 \$1009 \$1006 VDD sg13_lv_pmos L=0.13u W=0.42u AS=0.0798p
+ AD=0.1428p PS=0.8u PD=1.52u rfmode=0
M$3093 \$1120 \$1047 VDD VDD sg13_lv_pmos L=0.13u W=1.12u AS=0.3864p
+ AD=0.41165p PS=2.93u PD=2.12u rfmode=0
M$3094 VDD \$489 \$1047 VDD sg13_lv_pmos L=0.13u W=1.12u AS=0.41165p AD=0.4088p
+ PS=2.12u PD=2.97u rfmode=0
M$3095 \$1094 \$1120 \$1138 VDD sg13_lv_pmos L=0.13u W=0.42u AS=0.2048p
+ AD=0.09345p PS=1.63u PD=0.865u rfmode=0
M$3096 \$1138 \$1063 VDD VDD sg13_lv_pmos L=0.13u W=0.42u AS=0.09345p AD=0.204p
+ PS=0.865u PD=1.835u rfmode=0
M$3097 VDD \$1119 \$1063 VDD sg13_lv_pmos L=0.13u W=0.42u AS=0.204p AD=0.0798p
+ PS=1.835u PD=0.8u rfmode=0
M$3098 \$1063 \$1094 VDD VDD sg13_lv_pmos L=0.13u W=0.42u AS=0.0798p AD=0.4659p
+ PS=0.8u PD=3.65u rfmode=0
M$3099 \$1046 \$1047 \$1094 VDD sg13_lv_pmos L=0.13u W=1u AS=0.34p AD=0.2048p
+ PS=2.68u PD=1.63u rfmode=0
M$3100 \$1064 \$1094 VDD VDD sg13_lv_pmos L=0.13u W=1.12u AS=0.3864p AD=0.2128p
+ PS=2.93u PD=1.5u rfmode=0
M$3101 VDD \$1064 \$1065 VDD sg13_lv_pmos L=0.13u W=1.12u AS=0.2128p AD=0.3808p
+ PS=1.5u PD=2.92u rfmode=0
M$3102 VDD \$428 \$1066 VDD sg13_lv_pmos L=0.13u W=1.12u AS=0.3808p AD=0.3808p
+ PS=2.92u PD=2.92u rfmode=0
M$3107 VDD \$603 \$1121 VDD sg13_lv_pmos L=0.13u W=0.84u AS=0.253p AD=0.2856p
+ PS=1.53u PD=2.36u rfmode=0
M$3108 VDD \$1121 \$1141 VDD sg13_lv_pmos L=0.13u W=1u AS=0.2198p AD=0.2975p
+ PS=1.52u PD=1.595u rfmode=0
M$3109 \$1141 \$626 \$1068 VDD sg13_lv_pmos L=0.13u W=1u AS=0.2975p AD=0.2225p
+ PS=1.595u PD=1.445u rfmode=0
M$3110 \$1068 \$1095 \$1142 VDD sg13_lv_pmos L=0.13u W=1u AS=0.2225p AD=0.3325p
+ PS=1.445u PD=1.665u rfmode=0
M$3111 \$1142 \$603 VDD VDD sg13_lv_pmos L=0.13u W=1u AS=0.3325p AD=0.253p
+ PS=1.665u PD=1.53u rfmode=0
M$3112 \$1067 \$1068 VDD VDD sg13_lv_pmos L=0.13u W=1.12u AS=0.6048p AD=0.2198p
+ PS=3.32u PD=1.52u rfmode=0
M$3117 VDD \$1122 \$1069 VDD sg13_lv_pmos L=0.13u W=1.12u AS=0.3808p AD=0.3808p
+ PS=2.92u PD=2.92u rfmode=0
M$3118 VDD \$1069 \$1145 VDD sg13_lv_pmos L=0.15u W=1.12u AS=0.3808p AD=0.2128p
+ PS=2.92u PD=1.5u rfmode=0
M$3119 \$1145 \$995 \$1096 VDD sg13_lv_pmos L=0.15u W=1.12u AS=0.2128p
+ AD=0.2128p PS=1.5u PD=1.5u rfmode=0
M$3120 \$1096 \$1123 VDD VDD sg13_lv_pmos L=0.15u W=1.12u AS=0.2128p AD=0.3808p
+ PS=1.5u PD=2.92u rfmode=0
M$3121 VDD \$996 \$1123 VDD sg13_lv_pmos L=0.15u W=1.12u AS=0.3808p AD=0.2128p
+ PS=2.92u PD=1.5u rfmode=0
M$3122 \$1123 \$344 \$1146 VDD sg13_lv_pmos L=0.15u W=1.12u AS=0.2128p
+ AD=0.2128p PS=1.5u PD=1.5u rfmode=0
M$3123 \$1146 \$994 VDD VDD sg13_lv_pmos L=0.15u W=1.12u AS=0.2128p AD=0.3808p
+ PS=1.5u PD=2.92u rfmode=0
M$3127 \$1097 \$994 VDD VDD sg13_lv_pmos L=0.13u W=0.84u AS=0.2856p AD=0.2618p
+ PS=2.36u PD=1.63u rfmode=0
M$3128 VDD \$1097 \$1147 VDD sg13_lv_pmos L=0.13u W=1.12u AS=0.2618p AD=0.1176p
+ PS=1.63u PD=1.33u rfmode=0
M$3129 \$1147 \$748 \$1124 VDD sg13_lv_pmos L=0.13u W=1.12u AS=0.1176p
+ AD=0.3808p PS=1.33u PD=2.92u rfmode=0
M$3130 VDD \$1125 \$1150 VDD sg13_lv_pmos L=0.15u W=1.12u AS=0.3808p AD=0.2128p
+ PS=2.92u PD=1.5u rfmode=0
M$3131 \$1150 \$1124 \$1073 VDD sg13_lv_pmos L=0.15u W=1.12u AS=0.2128p
+ AD=0.2128p PS=1.5u PD=1.5u rfmode=0
M$3132 \$1073 \$998 VDD VDD sg13_lv_pmos L=0.15u W=1.12u AS=0.2128p AD=0.3808p
+ PS=1.5u PD=2.92u rfmode=0
M$3133 \$1074 \$335 VDD VDD sg13_lv_pmos L=0.13u W=1.12u AS=0.3808p AD=0.3808p
+ PS=2.92u PD=2.92u rfmode=0
M$3136 VDD \$335 \$1075 VDD sg13_lv_pmos L=0.13u W=1.12u AS=0.3808p AD=0.3808p
+ PS=2.92u PD=2.92u rfmode=0
M$3137 VDD \$999 \$1076 VDD sg13_lv_pmos L=0.13u W=0.42u AS=0.1428p AD=0.0798p
+ PS=1.52u PD=0.8u rfmode=0
M$3138 VDD \$1075 \$1076 VDD sg13_lv_pmos L=0.13u W=0.42u AS=0.3623875p
+ AD=0.0798p PS=2.605u PD=0.8u rfmode=0
M$3139 VDD \$1126 \$1048 VDD sg13_lv_pmos L=0.13u W=1u AS=0.3623875p AD=0.34p
+ PS=2.605u PD=2.68u rfmode=0
M$3140 \$1127 \$1049 VDD VDD sg13_lv_pmos L=0.13u W=1.12u AS=0.3864p
+ AD=0.41165p PS=2.93u PD=2.12u rfmode=0
M$3141 VDD \$501 \$1049 VDD sg13_lv_pmos L=0.13u W=1.12u AS=0.41165p AD=0.4088p
+ PS=2.12u PD=2.97u rfmode=0
M$3142 \$1099 \$1127 \$1152 VDD sg13_lv_pmos L=0.13u W=0.42u AS=0.2048p
+ AD=0.09345p PS=1.63u PD=0.865u rfmode=0
M$3143 \$1152 \$1078 VDD VDD sg13_lv_pmos L=0.13u W=0.42u AS=0.09345p AD=0.204p
+ PS=0.865u PD=1.835u rfmode=0
M$3144 VDD \$1075 \$1078 VDD sg13_lv_pmos L=0.13u W=0.42u AS=0.204p AD=0.0798p
+ PS=1.835u PD=0.8u rfmode=0
M$3145 \$1078 \$1099 VDD VDD sg13_lv_pmos L=0.13u W=0.42u AS=0.0798p AD=0.4659p
+ PS=0.8u PD=3.65u rfmode=0
M$3146 \$1048 \$1049 \$1099 VDD sg13_lv_pmos L=0.13u W=1u AS=0.34p AD=0.2048p
+ PS=2.68u PD=1.63u rfmode=0
M$3147 \$1079 \$1099 VDD VDD sg13_lv_pmos L=0.13u W=1.12u AS=0.3864p AD=0.2128p
+ PS=2.93u PD=1.5u rfmode=0
M$3148 VDD \$1079 \$1033 VDD sg13_lv_pmos L=0.13u W=1.12u AS=0.2128p AD=0.3808p
+ PS=1.5u PD=2.92u rfmode=0
M$3149 \$1080 \$883 VDD VDD sg13_lv_pmos L=0.13u W=1.12u AS=0.3808p AD=0.3808p
+ PS=2.92u PD=2.92u rfmode=0
M$3150 VDD \$883 \$1081 VDD sg13_lv_pmos L=0.13u W=1.12u AS=0.3808p AD=0.3808p
+ PS=2.92u PD=2.92u rfmode=0
M$3151 VDD \$1002 \$1082 VDD sg13_lv_pmos L=0.13u W=0.42u AS=0.1428p AD=0.0798p
+ PS=1.52u PD=0.8u rfmode=0
M$3152 VDD \$1081 \$1082 VDD sg13_lv_pmos L=0.13u W=0.42u AS=0.3623875p
+ AD=0.0798p PS=2.605u PD=0.8u rfmode=0
M$3153 VDD \$1128 \$1050 VDD sg13_lv_pmos L=0.13u W=1u AS=0.3623875p AD=0.34p
+ PS=2.605u PD=2.68u rfmode=0
M$3154 \$1129 \$1051 VDD VDD sg13_lv_pmos L=0.13u W=1.12u AS=0.3864p
+ AD=0.41165p PS=2.93u PD=2.12u rfmode=0
M$3155 VDD \$1130 \$1051 VDD sg13_lv_pmos L=0.13u W=1.12u AS=0.41165p
+ AD=0.4088p PS=2.12u PD=2.97u rfmode=0
M$3156 \$1101 \$1129 \$1140 VDD sg13_lv_pmos L=0.13u W=0.42u AS=0.2048p
+ AD=0.09345p PS=1.63u PD=0.865u rfmode=0
M$3157 \$1140 \$1084 VDD VDD sg13_lv_pmos L=0.13u W=0.42u AS=0.09345p AD=0.204p
+ PS=0.865u PD=1.835u rfmode=0
M$3158 VDD \$1081 \$1084 VDD sg13_lv_pmos L=0.13u W=0.42u AS=0.204p AD=0.0798p
+ PS=1.835u PD=0.8u rfmode=0
M$3159 \$1084 \$1101 VDD VDD sg13_lv_pmos L=0.13u W=0.42u AS=0.0798p AD=0.4659p
+ PS=0.8u PD=3.65u rfmode=0
M$3160 \$1050 \$1051 \$1101 VDD sg13_lv_pmos L=0.13u W=1u AS=0.34p AD=0.2048p
+ PS=2.68u PD=1.63u rfmode=0
M$3161 \$1085 \$1101 VDD VDD sg13_lv_pmos L=0.13u W=1.12u AS=0.3864p AD=0.2128p
+ PS=2.93u PD=1.5u rfmode=0
M$3162 VDD \$1085 \$1034 VDD sg13_lv_pmos L=0.13u W=1.12u AS=0.2128p AD=0.3808p
+ PS=1.5u PD=2.92u rfmode=0
M$3164 VDD \$883 \$1086 VDD sg13_lv_pmos L=0.13u W=1.12u AS=0.3808p AD=0.3808p
+ PS=2.92u PD=2.92u rfmode=0
M$3165 VDD \$1288 \$1087 VDD sg13_lv_pmos L=0.13u W=0.42u AS=0.1428p AD=0.0798p
+ PS=1.52u PD=0.8u rfmode=0
M$3166 VDD \$1086 \$1087 VDD sg13_lv_pmos L=0.13u W=0.42u AS=0.3623875p
+ AD=0.0798p PS=2.605u PD=0.8u rfmode=0
M$3167 VDD \$1131 \$1052 VDD sg13_lv_pmos L=0.13u W=1u AS=0.3623875p AD=0.34p
+ PS=2.605u PD=2.68u rfmode=0
M$3168 \$1132 \$1053 VDD VDD sg13_lv_pmos L=0.13u W=1.12u AS=0.3864p
+ AD=0.41165p PS=2.93u PD=2.12u rfmode=0
M$3169 VDD \$1130 \$1053 VDD sg13_lv_pmos L=0.13u W=1.12u AS=0.41165p
+ AD=0.4088p PS=2.12u PD=2.97u rfmode=0
M$3170 \$1103 \$1132 \$1134 VDD sg13_lv_pmos L=0.13u W=0.42u AS=0.2048p
+ AD=0.09345p PS=1.63u PD=0.865u rfmode=0
M$3171 \$1134 \$1089 VDD VDD sg13_lv_pmos L=0.13u W=0.42u AS=0.09345p AD=0.204p
+ PS=0.865u PD=1.835u rfmode=0
M$3172 VDD \$1086 \$1089 VDD sg13_lv_pmos L=0.13u W=0.42u AS=0.204p AD=0.0798p
+ PS=1.835u PD=0.8u rfmode=0
M$3173 \$1089 \$1103 VDD VDD sg13_lv_pmos L=0.13u W=0.42u AS=0.0798p AD=0.4659p
+ PS=0.8u PD=3.65u rfmode=0
M$3174 \$1052 \$1053 \$1103 VDD sg13_lv_pmos L=0.13u W=1u AS=0.34p AD=0.2048p
+ PS=2.68u PD=1.63u rfmode=0
M$3175 \$1090 \$1103 VDD VDD sg13_lv_pmos L=0.13u W=1.12u AS=0.3864p AD=0.2128p
+ PS=2.93u PD=1.5u rfmode=0
M$3176 VDD \$1090 \$1091 VDD sg13_lv_pmos L=0.13u W=1.12u AS=0.2128p AD=0.3808p
+ PS=1.5u PD=2.92u rfmode=0
M$3203 VDD \$435 \$1119 VDD sg13_lv_pmos L=0.13u W=1.12u AS=0.3808p AD=0.3808p
+ PS=2.92u PD=2.92u rfmode=0
M$3204 \$1118 \$1119 VDD VDD sg13_lv_pmos L=0.13u W=0.42u AS=0.147p AD=0.1563p
+ PS=1.54u PD=1.22u rfmode=0
M$3205 VDD \$1046 \$1137 VDD sg13_lv_pmos L=0.13u W=0.42u AS=0.1563p AD=0.063p
+ PS=1.22u PD=0.72u rfmode=0
M$3206 \$1137 \$1047 \$1118 VDD sg13_lv_pmos L=0.13u W=0.42u AS=0.063p
+ AD=0.0798p PS=0.72u PD=0.8u rfmode=0
M$3207 \$1118 \$1120 \$1061 VDD sg13_lv_pmos L=0.13u W=0.42u AS=0.0798p
+ AD=0.1428p PS=0.8u PD=1.52u rfmode=0
M$3208 \$1092 \$1232 VDD VDD sg13_lv_pmos L=0.13u W=1.12u AS=0.6048p AD=0.2198p
+ PS=3.32u PD=1.52u rfmode=0
M$3209 VDD \$1154 \$1215 VDD sg13_lv_pmos L=0.13u W=1u AS=0.2198p AD=0.2975p
+ PS=1.52u PD=1.595u rfmode=0
M$3210 \$1215 \$626 \$1232 VDD sg13_lv_pmos L=0.13u W=1u AS=0.2975p AD=0.2225p
+ PS=1.595u PD=1.445u rfmode=0
M$3211 \$1232 \$1065 \$1216 VDD sg13_lv_pmos L=0.13u W=1u AS=0.2225p AD=0.3325p
+ PS=1.445u PD=1.665u rfmode=0
M$3212 \$1216 \$922 VDD VDD sg13_lv_pmos L=0.13u W=1u AS=0.3325p AD=0.253p
+ PS=1.665u PD=1.53u rfmode=0
M$3213 VDD \$922 \$1154 VDD sg13_lv_pmos L=0.13u W=0.84u AS=0.253p AD=0.2856p
+ PS=1.53u PD=2.36u rfmode=0
M$3214 VDD \$1279 \$1168 VDD sg13_lv_pmos L=0.13u W=0.42u AS=0.1428p AD=0.0798p
+ PS=1.52u PD=0.8u rfmode=0
M$3215 VDD \$1066 \$1168 VDD sg13_lv_pmos L=0.13u W=0.42u AS=0.3623875p
+ AD=0.0798p PS=2.605u PD=0.8u rfmode=0
M$3216 VDD \$1170 \$1169 VDD sg13_lv_pmos L=0.13u W=1u AS=0.3623875p AD=0.34p
+ PS=2.605u PD=2.68u rfmode=0
M$3217 VDD \$1066 \$1170 VDD sg13_lv_pmos L=0.13u W=0.42u AS=0.1563p AD=0.147p
+ PS=1.22u PD=1.54u rfmode=0
M$3218 VDD \$1169 \$1217 VDD sg13_lv_pmos L=0.13u W=0.42u AS=0.1563p AD=0.063p
+ PS=1.22u PD=0.72u rfmode=0
M$3219 \$1217 \$1172 \$1170 VDD sg13_lv_pmos L=0.13u W=0.42u AS=0.063p
+ AD=0.0798p PS=0.72u PD=0.8u rfmode=0
M$3220 \$1170 \$1171 \$1168 VDD sg13_lv_pmos L=0.13u W=0.42u AS=0.0798p
+ AD=0.1428p PS=0.8u PD=1.52u rfmode=0
M$3221 VDD \$1172 \$1171 VDD sg13_lv_pmos L=0.13u W=1.12u AS=0.41165p
+ AD=0.3864p PS=2.12u PD=2.93u rfmode=0
M$3222 VDD \$489 \$1172 VDD sg13_lv_pmos L=0.13u W=1.12u AS=0.41165p AD=0.4088p
+ PS=2.12u PD=2.97u rfmode=0
M$3223 \$1169 \$1172 \$1173 VDD sg13_lv_pmos L=0.13u W=1u AS=0.34p AD=0.2048p
+ PS=2.68u PD=1.63u rfmode=0
M$3224 \$1173 \$1171 \$1219 VDD sg13_lv_pmos L=0.13u W=0.42u AS=0.2048p
+ AD=0.09345p PS=1.63u PD=0.865u rfmode=0
M$3225 VDD \$1174 \$1219 VDD sg13_lv_pmos L=0.13u W=0.42u AS=0.204p AD=0.09345p
+ PS=1.835u PD=0.865u rfmode=0
M$3226 VDD \$1066 \$1174 VDD sg13_lv_pmos L=0.13u W=0.42u AS=0.204p AD=0.0798p
+ PS=1.835u PD=0.8u rfmode=0
M$3227 VDD \$1173 \$1174 VDD sg13_lv_pmos L=0.13u W=0.42u AS=0.4659p AD=0.0798p
+ PS=3.65u PD=0.8u rfmode=0
M$3228 \$1155 \$1173 VDD VDD sg13_lv_pmos L=0.13u W=1.12u AS=0.3864p AD=0.2128p
+ PS=2.93u PD=1.5u rfmode=0
M$3229 VDD \$1155 \$1293 VDD sg13_lv_pmos L=0.13u W=1.12u AS=0.2128p AD=0.3808p
+ PS=1.5u PD=2.92u rfmode=0
M$3230 VDD \$1067 \$1175 VDD sg13_lv_pmos L=0.13u W=0.42u AS=0.1428p AD=0.0798p
+ PS=1.52u PD=0.8u rfmode=0
M$3231 VDD \$1156 \$1175 VDD sg13_lv_pmos L=0.13u W=0.42u AS=0.3623875p
+ AD=0.0798p PS=2.605u PD=0.8u rfmode=0
M$3232 VDD \$1177 \$1176 VDD sg13_lv_pmos L=0.13u W=1u AS=0.3623875p AD=0.34p
+ PS=2.605u PD=2.68u rfmode=0
M$3233 VDD \$1156 \$1177 VDD sg13_lv_pmos L=0.13u W=0.42u AS=0.1563p AD=0.147p
+ PS=1.22u PD=1.54u rfmode=0
M$3234 VDD \$1176 \$1222 VDD sg13_lv_pmos L=0.13u W=0.42u AS=0.1563p AD=0.063p
+ PS=1.22u PD=0.72u rfmode=0
M$3235 \$1222 \$1179 \$1177 VDD sg13_lv_pmos L=0.13u W=0.42u AS=0.063p
+ AD=0.0798p PS=0.72u PD=0.8u rfmode=0
M$3236 \$1177 \$1178 \$1175 VDD sg13_lv_pmos L=0.13u W=0.42u AS=0.0798p
+ AD=0.1428p PS=0.8u PD=1.52u rfmode=0
M$3237 VDD \$1179 \$1178 VDD sg13_lv_pmos L=0.13u W=1.12u AS=0.41165p
+ AD=0.3864p PS=2.12u PD=2.93u rfmode=0
M$3238 VDD \$740 \$1179 VDD sg13_lv_pmos L=0.13u W=1.12u AS=0.41165p AD=0.4088p
+ PS=2.12u PD=2.97u rfmode=0
M$3239 \$1176 \$1179 \$1180 VDD sg13_lv_pmos L=0.13u W=1u AS=0.34p AD=0.2048p
+ PS=2.68u PD=1.63u rfmode=0
M$3240 \$1180 \$1178 \$1223 VDD sg13_lv_pmos L=0.13u W=0.42u AS=0.2048p
+ AD=0.09345p PS=1.63u PD=0.865u rfmode=0
M$3241 VDD \$1181 \$1223 VDD sg13_lv_pmos L=0.13u W=0.42u AS=0.204p AD=0.09345p
+ PS=1.835u PD=0.865u rfmode=0
M$3242 VDD \$1156 \$1181 VDD sg13_lv_pmos L=0.13u W=0.42u AS=0.204p AD=0.0798p
+ PS=1.835u PD=0.8u rfmode=0
M$3243 VDD \$1180 \$1181 VDD sg13_lv_pmos L=0.13u W=0.42u AS=0.4659p AD=0.0798p
+ PS=3.65u PD=0.8u rfmode=0
M$3244 \$1157 \$1180 VDD VDD sg13_lv_pmos L=0.13u W=1.12u AS=0.3864p AD=0.2128p
+ PS=2.93u PD=1.5u rfmode=0
M$3245 VDD \$1157 \$1095 VDD sg13_lv_pmos L=0.13u W=1.12u AS=0.2128p AD=0.3808p
+ PS=1.5u PD=2.92u rfmode=0
M$3246 VDD \$1096 \$1182 VDD sg13_lv_pmos L=0.13u W=0.42u AS=0.1428p AD=0.0798p
+ PS=1.52u PD=0.8u rfmode=0
M$3247 VDD \$1158 \$1182 VDD sg13_lv_pmos L=0.13u W=0.42u AS=0.3623875p
+ AD=0.0798p PS=2.605u PD=0.8u rfmode=0
M$3248 VDD \$1184 \$1183 VDD sg13_lv_pmos L=0.13u W=1u AS=0.3623875p AD=0.34p
+ PS=2.605u PD=2.68u rfmode=0
M$3249 VDD \$1158 \$1184 VDD sg13_lv_pmos L=0.13u W=0.42u AS=0.1563p AD=0.147p
+ PS=1.22u PD=1.54u rfmode=0
M$3250 VDD \$1183 \$1224 VDD sg13_lv_pmos L=0.13u W=0.42u AS=0.1563p AD=0.063p
+ PS=1.22u PD=0.72u rfmode=0
M$3251 \$1224 \$1186 \$1184 VDD sg13_lv_pmos L=0.13u W=0.42u AS=0.063p
+ AD=0.0798p PS=0.72u PD=0.8u rfmode=0
M$3252 \$1184 \$1185 \$1182 VDD sg13_lv_pmos L=0.13u W=0.42u AS=0.0798p
+ AD=0.1428p PS=0.8u PD=1.52u rfmode=0
M$3253 VDD \$1186 \$1185 VDD sg13_lv_pmos L=0.13u W=1.12u AS=0.41165p
+ AD=0.3864p PS=2.12u PD=2.93u rfmode=0
M$3254 VDD \$740 \$1186 VDD sg13_lv_pmos L=0.13u W=1.12u AS=0.41165p AD=0.4088p
+ PS=2.12u PD=2.97u rfmode=0
M$3255 \$1183 \$1186 \$1187 VDD sg13_lv_pmos L=0.13u W=1u AS=0.34p AD=0.2048p
+ PS=2.68u PD=1.63u rfmode=0
M$3256 \$1187 \$1185 \$1226 VDD sg13_lv_pmos L=0.13u W=0.42u AS=0.2048p
+ AD=0.09345p PS=1.63u PD=0.865u rfmode=0
M$3257 VDD \$1188 \$1226 VDD sg13_lv_pmos L=0.13u W=0.42u AS=0.204p AD=0.09345p
+ PS=1.835u PD=0.865u rfmode=0
M$3258 VDD \$1158 \$1188 VDD sg13_lv_pmos L=0.13u W=0.42u AS=0.204p AD=0.0798p
+ PS=1.835u PD=0.8u rfmode=0
M$3259 VDD \$1187 \$1188 VDD sg13_lv_pmos L=0.13u W=0.42u AS=0.4659p AD=0.0798p
+ PS=3.65u PD=0.8u rfmode=0
M$3260 \$1159 \$1187 VDD VDD sg13_lv_pmos L=0.13u W=1.12u AS=0.3864p AD=0.2128p
+ PS=2.93u PD=1.5u rfmode=0
M$3261 VDD \$1159 \$1122 VDD sg13_lv_pmos L=0.13u W=1.12u AS=0.2128p AD=0.3808p
+ PS=1.5u PD=2.92u rfmode=0
M$3262 VDD \$1073 \$1189 VDD sg13_lv_pmos L=0.13u W=0.42u AS=0.1428p AD=0.0798p
+ PS=1.52u PD=0.8u rfmode=0
M$3263 VDD \$1074 \$1189 VDD sg13_lv_pmos L=0.13u W=0.42u AS=0.3623875p
+ AD=0.0798p PS=2.605u PD=0.8u rfmode=0
M$3264 VDD \$1191 \$1190 VDD sg13_lv_pmos L=0.13u W=1u AS=0.3623875p AD=0.34p
+ PS=2.605u PD=2.68u rfmode=0
M$3265 VDD \$1074 \$1191 VDD sg13_lv_pmos L=0.13u W=0.42u AS=0.1563p AD=0.147p
+ PS=1.22u PD=1.54u rfmode=0
M$3266 VDD \$1190 \$1228 VDD sg13_lv_pmos L=0.13u W=0.42u AS=0.1563p AD=0.063p
+ PS=1.22u PD=0.72u rfmode=0
M$3267 \$1228 \$1193 \$1191 VDD sg13_lv_pmos L=0.13u W=0.42u AS=0.063p
+ AD=0.0798p PS=0.72u PD=0.8u rfmode=0
M$3268 \$1191 \$1192 \$1189 VDD sg13_lv_pmos L=0.13u W=0.42u AS=0.0798p
+ AD=0.1428p PS=0.8u PD=1.52u rfmode=0
M$3269 VDD \$1193 \$1192 VDD sg13_lv_pmos L=0.13u W=1.12u AS=0.41165p
+ AD=0.3864p PS=2.12u PD=2.93u rfmode=0
M$3270 VDD \$501 \$1193 VDD sg13_lv_pmos L=0.13u W=1.12u AS=0.41165p AD=0.4088p
+ PS=2.12u PD=2.97u rfmode=0
M$3271 \$1190 \$1193 \$1194 VDD sg13_lv_pmos L=0.13u W=1u AS=0.34p AD=0.2048p
+ PS=2.68u PD=1.63u rfmode=0
M$3272 \$1194 \$1192 \$1231 VDD sg13_lv_pmos L=0.13u W=0.42u AS=0.2048p
+ AD=0.09345p PS=1.63u PD=0.865u rfmode=0
M$3273 VDD \$1195 \$1231 VDD sg13_lv_pmos L=0.13u W=0.42u AS=0.204p AD=0.09345p
+ PS=1.835u PD=0.865u rfmode=0
M$3274 VDD \$1074 \$1195 VDD sg13_lv_pmos L=0.13u W=0.42u AS=0.204p AD=0.0798p
+ PS=1.835u PD=0.8u rfmode=0
M$3275 VDD \$1194 \$1195 VDD sg13_lv_pmos L=0.13u W=0.42u AS=0.4659p AD=0.0798p
+ PS=3.65u PD=0.8u rfmode=0
M$3276 \$1160 \$1194 VDD VDD sg13_lv_pmos L=0.13u W=1.12u AS=0.3864p AD=0.2128p
+ PS=2.93u PD=1.5u rfmode=0
M$3277 VDD \$1160 \$1161 VDD sg13_lv_pmos L=0.13u W=1.12u AS=0.2128p AD=0.3808p
+ PS=1.5u PD=2.92u rfmode=0
M$3278 \$1126 \$1075 VDD VDD sg13_lv_pmos L=0.13u W=0.42u AS=0.147p AD=0.1563p
+ PS=1.54u PD=1.22u rfmode=0
M$3279 VDD \$1048 \$1153 VDD sg13_lv_pmos L=0.13u W=0.42u AS=0.1563p AD=0.063p
+ PS=1.22u PD=0.72u rfmode=0
M$3280 \$1153 \$1049 \$1126 VDD sg13_lv_pmos L=0.13u W=0.42u AS=0.063p
+ AD=0.0798p PS=0.72u PD=0.8u rfmode=0
M$3281 \$1126 \$1127 \$1076 VDD sg13_lv_pmos L=0.13u W=0.42u AS=0.0798p
+ AD=0.1428p PS=0.8u PD=1.52u rfmode=0
M$3284 VDD \$995 \$1196 VDD sg13_lv_pmos L=0.13u W=0.84u AS=0.253p AD=0.2856p
+ PS=1.53u PD=2.36u rfmode=0
M$3285 VDD \$995 \$1230 VDD sg13_lv_pmos L=0.13u W=1u AS=0.253p AD=0.3325p
+ PS=1.53u PD=1.665u rfmode=0
M$3286 \$1230 \$1237 \$1197 VDD sg13_lv_pmos L=0.13u W=1u AS=0.3325p AD=0.2225p
+ PS=1.665u PD=1.445u rfmode=0
M$3287 \$1197 \$617 \$1229 VDD sg13_lv_pmos L=0.13u W=1u AS=0.2225p AD=0.2975p
+ PS=1.445u PD=1.595u rfmode=0
M$3288 VDD \$1196 \$1229 VDD sg13_lv_pmos L=0.13u W=1u AS=0.2198p AD=0.2975p
+ PS=1.52u PD=1.595u rfmode=0
M$3289 VDD \$1197 \$1162 VDD sg13_lv_pmos L=0.13u W=1.12u AS=0.2198p AD=0.6048p
+ PS=1.52u PD=3.32u rfmode=0
M$3290 VDD \$1162 \$1198 VDD sg13_lv_pmos L=0.13u W=0.42u AS=0.1428p AD=0.0798p
+ PS=1.52u PD=0.8u rfmode=0
M$3291 VDD \$1080 \$1198 VDD sg13_lv_pmos L=0.13u W=0.42u AS=0.3623875p
+ AD=0.0798p PS=2.605u PD=0.8u rfmode=0
M$3292 VDD \$1200 \$1199 VDD sg13_lv_pmos L=0.13u W=1u AS=0.3623875p AD=0.34p
+ PS=2.605u PD=2.68u rfmode=0
M$3293 VDD \$1080 \$1200 VDD sg13_lv_pmos L=0.13u W=0.42u AS=0.1563p AD=0.147p
+ PS=1.22u PD=1.54u rfmode=0
M$3294 VDD \$1199 \$1227 VDD sg13_lv_pmos L=0.13u W=0.42u AS=0.1563p AD=0.063p
+ PS=1.22u PD=0.72u rfmode=0
M$3295 \$1227 \$1202 \$1200 VDD sg13_lv_pmos L=0.13u W=0.42u AS=0.063p
+ AD=0.0798p PS=0.72u PD=0.8u rfmode=0
M$3296 \$1200 \$1201 \$1198 VDD sg13_lv_pmos L=0.13u W=0.42u AS=0.0798p
+ AD=0.1428p PS=0.8u PD=1.52u rfmode=0
M$3297 VDD \$1202 \$1201 VDD sg13_lv_pmos L=0.13u W=1.12u AS=0.41165p
+ AD=0.3864p PS=2.12u PD=2.93u rfmode=0
M$3298 VDD \$1130 \$1202 VDD sg13_lv_pmos L=0.13u W=1.12u AS=0.41165p
+ AD=0.4088p PS=2.12u PD=2.97u rfmode=0
M$3299 \$1128 \$1081 VDD VDD sg13_lv_pmos L=0.13u W=0.42u AS=0.147p AD=0.1563p
+ PS=1.54u PD=1.22u rfmode=0
M$3300 VDD \$1050 \$1144 VDD sg13_lv_pmos L=0.13u W=0.42u AS=0.1563p AD=0.063p
+ PS=1.22u PD=0.72u rfmode=0
M$3301 \$1144 \$1051 \$1128 VDD sg13_lv_pmos L=0.13u W=0.42u AS=0.063p
+ AD=0.0798p PS=0.72u PD=0.8u rfmode=0
M$3302 \$1128 \$1129 \$1082 VDD sg13_lv_pmos L=0.13u W=0.42u AS=0.0798p
+ AD=0.1428p PS=0.8u PD=1.52u rfmode=0
M$3303 \$1199 \$1202 \$1203 VDD sg13_lv_pmos L=0.13u W=1u AS=0.34p AD=0.2048p
+ PS=2.68u PD=1.63u rfmode=0
M$3304 \$1203 \$1201 \$1225 VDD sg13_lv_pmos L=0.13u W=0.42u AS=0.2048p
+ AD=0.09345p PS=1.63u PD=0.865u rfmode=0
M$3305 VDD \$1204 \$1225 VDD sg13_lv_pmos L=0.13u W=0.42u AS=0.204p AD=0.09345p
+ PS=1.835u PD=0.865u rfmode=0
M$3306 VDD \$1080 \$1204 VDD sg13_lv_pmos L=0.13u W=0.42u AS=0.204p AD=0.0798p
+ PS=1.835u PD=0.8u rfmode=0
M$3307 VDD \$1203 \$1204 VDD sg13_lv_pmos L=0.13u W=0.42u AS=0.4659p AD=0.0798p
+ PS=3.65u PD=0.8u rfmode=0
M$3308 \$1163 \$1203 VDD VDD sg13_lv_pmos L=0.13u W=1.12u AS=0.3864p AD=0.2128p
+ PS=2.93u PD=1.5u rfmode=0
M$3309 VDD \$1163 \$1237 VDD sg13_lv_pmos L=0.13u W=1.12u AS=0.2128p AD=0.3808p
+ PS=1.5u PD=2.92u rfmode=0
M$3312 VDD \$1124 \$1205 VDD sg13_lv_pmos L=0.13u W=0.84u AS=0.253p AD=0.2856p
+ PS=1.53u PD=2.36u rfmode=0
M$3313 VDD \$1124 \$1221 VDD sg13_lv_pmos L=0.13u W=1u AS=0.253p AD=0.3325p
+ PS=1.53u PD=1.665u rfmode=0
M$3314 \$1221 \$1167 \$1206 VDD sg13_lv_pmos L=0.13u W=1u AS=0.3325p AD=0.2225p
+ PS=1.665u PD=1.445u rfmode=0
M$3315 \$1206 \$617 \$1220 VDD sg13_lv_pmos L=0.13u W=1u AS=0.2225p AD=0.2975p
+ PS=1.445u PD=1.595u rfmode=0
M$3316 VDD \$1205 \$1220 VDD sg13_lv_pmos L=0.13u W=1u AS=0.2198p AD=0.2975p
+ PS=1.52u PD=1.595u rfmode=0
M$3317 VDD \$1206 \$1164 VDD sg13_lv_pmos L=0.13u W=1.12u AS=0.2198p AD=0.6048p
+ PS=1.52u PD=3.32u rfmode=0
M$3318 VDD \$1164 \$1207 VDD sg13_lv_pmos L=0.13u W=0.42u AS=0.1428p AD=0.0798p
+ PS=1.52u PD=0.8u rfmode=0
M$3319 VDD \$1165 \$1207 VDD sg13_lv_pmos L=0.13u W=0.42u AS=0.3623875p
+ AD=0.0798p PS=2.605u PD=0.8u rfmode=0
M$3320 VDD \$1209 \$1208 VDD sg13_lv_pmos L=0.13u W=1u AS=0.3623875p AD=0.34p
+ PS=2.605u PD=2.68u rfmode=0
M$3321 \$1131 \$1086 VDD VDD sg13_lv_pmos L=0.13u W=0.42u AS=0.147p AD=0.1563p
+ PS=1.54u PD=1.22u rfmode=0
M$3322 VDD \$1052 \$1135 VDD sg13_lv_pmos L=0.13u W=0.42u AS=0.1563p AD=0.063p
+ PS=1.22u PD=0.72u rfmode=0
M$3323 \$1135 \$1053 \$1131 VDD sg13_lv_pmos L=0.13u W=0.42u AS=0.063p
+ AD=0.0798p PS=0.72u PD=0.8u rfmode=0
M$3324 \$1131 \$1132 \$1087 VDD sg13_lv_pmos L=0.13u W=0.42u AS=0.0798p
+ AD=0.1428p PS=0.8u PD=1.52u rfmode=0
M$3325 VDD \$1165 \$1209 VDD sg13_lv_pmos L=0.13u W=0.42u AS=0.1563p AD=0.147p
+ PS=1.22u PD=1.54u rfmode=0
M$3326 VDD \$1208 \$1218 VDD sg13_lv_pmos L=0.13u W=0.42u AS=0.1563p AD=0.063p
+ PS=1.22u PD=0.72u rfmode=0
M$3327 \$1218 \$1211 \$1209 VDD sg13_lv_pmos L=0.13u W=0.42u AS=0.063p
+ AD=0.0798p PS=0.72u PD=0.8u rfmode=0
M$3328 \$1209 \$1210 \$1207 VDD sg13_lv_pmos L=0.13u W=0.42u AS=0.0798p
+ AD=0.1428p PS=0.8u PD=1.52u rfmode=0
M$3329 VDD \$1211 \$1210 VDD sg13_lv_pmos L=0.13u W=1.12u AS=0.41165p
+ AD=0.3864p PS=2.12u PD=2.93u rfmode=0
M$3330 VDD \$1130 \$1211 VDD sg13_lv_pmos L=0.13u W=1.12u AS=0.41165p
+ AD=0.4088p PS=2.12u PD=2.97u rfmode=0
M$3331 \$1208 \$1211 \$1212 VDD sg13_lv_pmos L=0.13u W=1u AS=0.34p AD=0.2048p
+ PS=2.68u PD=1.63u rfmode=0
M$3332 \$1212 \$1210 \$1214 VDD sg13_lv_pmos L=0.13u W=0.42u AS=0.2048p
+ AD=0.09345p PS=1.63u PD=0.865u rfmode=0
M$3333 VDD \$1213 \$1214 VDD sg13_lv_pmos L=0.13u W=0.42u AS=0.204p AD=0.09345p
+ PS=1.835u PD=0.865u rfmode=0
M$3334 VDD \$1165 \$1213 VDD sg13_lv_pmos L=0.13u W=0.42u AS=0.204p AD=0.0798p
+ PS=1.835u PD=0.8u rfmode=0
M$3335 VDD \$1212 \$1213 VDD sg13_lv_pmos L=0.13u W=0.42u AS=0.4659p AD=0.0798p
+ PS=3.65u PD=0.8u rfmode=0
M$3336 \$1166 \$1212 VDD VDD sg13_lv_pmos L=0.13u W=1.12u AS=0.3864p AD=0.2128p
+ PS=2.93u PD=1.5u rfmode=0
M$3337 VDD \$1166 \$1167 VDD sg13_lv_pmos L=0.13u W=1.12u AS=0.2128p AD=0.3808p
+ PS=1.5u PD=2.92u rfmode=0
M$3343 \$29 \$1290 VDD VDD sg13_lv_pmos L=0.13u W=1.12u AS=0.42p AD=0.2114p
+ PS=2.99u PD=1.54u rfmode=0
M$3344 VDD \$1122 \$1290 VDD sg13_lv_pmos L=0.13u W=0.84u AS=0.2114p AD=0.2856p
+ PS=1.54u PD=2.36u rfmode=0
M$3345 \$28 \$1291 VDD VDD sg13_lv_pmos L=0.13u W=1.12u AS=0.42p AD=0.2114p
+ PS=2.99u PD=1.54u rfmode=0
M$3346 VDD \$1161 \$1291 VDD sg13_lv_pmos L=0.13u W=0.84u AS=0.2114p AD=0.2856p
+ PS=1.54u PD=2.36u rfmode=0
M$3349 D0 \$1292 VDD VDD sg13_lv_pmos L=0.13u W=1.12u AS=0.42p AD=0.2114p
+ PS=2.99u PD=1.54u rfmode=0
M$3350 VDD \$1293 \$1292 VDD sg13_lv_pmos L=0.13u W=0.84u AS=0.2114p AD=0.2856p
+ PS=1.54u PD=2.36u rfmode=0
M$3361 D1 \$1294 VDD VDD sg13_lv_pmos L=0.13u W=1.12u AS=0.42p AD=0.2114p
+ PS=2.99u PD=1.54u rfmode=0
M$3362 VDD \$919 \$1294 VDD sg13_lv_pmos L=0.13u W=0.84u AS=0.2114p AD=0.2856p
+ PS=1.54u PD=2.36u rfmode=0
M$3372 D2 \$1295 VDD VDD sg13_lv_pmos L=0.13u W=1.12u AS=0.42p AD=0.2114p
+ PS=2.99u PD=1.54u rfmode=0
M$3373 VDD \$1065 \$1295 VDD sg13_lv_pmos L=0.13u W=0.84u AS=0.2114p AD=0.2856p
+ PS=1.54u PD=2.36u rfmode=0
M$3374 VDD \$798 \$1281 VDD sg13_lv_pmos L=0.13u W=0.84u AS=0.253p AD=0.2856p
+ PS=1.53u PD=2.36u rfmode=0
M$3375 VDD \$1281 \$1314 VDD sg13_lv_pmos L=0.13u W=1u AS=0.2198p AD=0.2975p
+ PS=1.52u PD=1.595u rfmode=0
M$3376 \$1314 \$626 \$1280 VDD sg13_lv_pmos L=0.13u W=1u AS=0.2975p AD=0.2225p
+ PS=1.595u PD=1.445u rfmode=0
M$3377 \$1280 \$1293 \$1315 VDD sg13_lv_pmos L=0.13u W=1u AS=0.2225p AD=0.3325p
+ PS=1.445u PD=1.665u rfmode=0
M$3378 \$1315 \$798 VDD VDD sg13_lv_pmos L=0.13u W=1u AS=0.3325p AD=0.253p
+ PS=1.665u PD=1.53u rfmode=0
M$3379 \$1279 \$1280 VDD VDD sg13_lv_pmos L=0.13u W=1.12u AS=0.6048p AD=0.2198p
+ PS=3.32u PD=1.52u rfmode=0
M$3383 VDD \$435 \$1156 VDD sg13_lv_pmos L=0.13u W=1.12u AS=0.3808p AD=0.3808p
+ PS=2.92u PD=2.92u rfmode=0
M$3387 D3 \$1296 VDD VDD sg13_lv_pmos L=0.13u W=1.12u AS=0.42p AD=0.2114p
+ PS=2.99u PD=1.54u rfmode=0
M$3388 VDD \$1095 \$1296 VDD sg13_lv_pmos L=0.13u W=0.84u AS=0.2114p AD=0.2856p
+ PS=1.54u PD=2.36u rfmode=0
M$3391 VDD \$435 \$1158 VDD sg13_lv_pmos L=0.13u W=1.12u AS=0.3808p AD=0.3808p
+ PS=2.92u PD=2.92u rfmode=0
M$3398 VDD \$1161 \$1125 VDD sg13_lv_pmos L=0.13u W=1.12u AS=0.3808p AD=0.3808p
+ PS=2.92u PD=2.92u rfmode=0
M$3399 D4 \$1297 VDD VDD sg13_lv_pmos L=0.13u W=1.12u AS=0.42p AD=0.2114p
+ PS=2.99u PD=1.54u rfmode=0
M$3400 VDD \$882 \$1297 VDD sg13_lv_pmos L=0.13u W=0.84u AS=0.2114p AD=0.2856p
+ PS=1.54u PD=2.36u rfmode=0
M$3411 D5 \$1298 VDD VDD sg13_lv_pmos L=0.13u W=1.12u AS=0.42p AD=0.2114p
+ PS=2.99u PD=1.54u rfmode=0
M$3412 VDD \$1033 \$1298 VDD sg13_lv_pmos L=0.13u W=0.84u AS=0.2114p AD=0.2856p
+ PS=1.54u PD=2.36u rfmode=0
M$3416 \$1130 \$1299 VDD VDD sg13_lv_pmos L=0.13u W=1.12u AS=0.42p AD=0.2114p
+ PS=2.99u PD=1.54u rfmode=0
M$3417 VDD \$336 \$1299 VDD sg13_lv_pmos L=0.13u W=0.84u AS=0.2114p AD=0.2856p
+ PS=1.54u PD=2.36u rfmode=0
M$3422 VDD \$1237 \$1300 VDD sg13_lv_pmos L=0.13u W=0.84u AS=0.2114p AD=0.2856p
+ PS=1.54u PD=2.36u rfmode=0
M$3423 VDD \$1300 D6 VDD sg13_lv_pmos L=0.13u W=1.12u AS=0.2114p AD=0.42p
+ PS=1.54u PD=2.99u rfmode=0
M$3424 \$1286 \$1124 VDD VDD sg13_lv_pmos L=0.13u W=0.84u AS=0.2856p AD=0.253p
+ PS=2.36u PD=1.53u rfmode=0
M$3425 VDD \$1124 \$1311 VDD sg13_lv_pmos L=0.13u W=1u AS=0.253p AD=0.3325p
+ PS=1.53u PD=1.665u rfmode=0
M$3426 \$1311 \$1091 \$1287 VDD sg13_lv_pmos L=0.13u W=1u AS=0.3325p AD=0.2225p
+ PS=1.665u PD=1.445u rfmode=0
M$3427 \$1287 \$617 \$1310 VDD sg13_lv_pmos L=0.13u W=1u AS=0.2225p AD=0.2975p
+ PS=1.445u PD=1.595u rfmode=0
M$3428 \$1310 \$1286 VDD VDD sg13_lv_pmos L=0.13u W=1u AS=0.2975p AD=0.2198p
+ PS=1.595u PD=1.52u rfmode=0
M$3429 VDD \$1287 \$1288 VDD sg13_lv_pmos L=0.13u W=1.12u AS=0.2198p AD=0.6048p
+ PS=1.52u PD=3.32u rfmode=0
M$3430 VDD \$883 \$1165 VDD sg13_lv_pmos L=0.13u W=1.12u AS=0.3808p AD=0.3808p
+ PS=2.92u PD=2.92u rfmode=0
M$3439 D7 \$1301 VDD VDD sg13_lv_pmos L=0.13u W=1.12u AS=0.42p AD=0.2114p
+ PS=2.99u PD=1.54u rfmode=0
M$3440 VDD \$1167 \$1301 VDD sg13_lv_pmos L=0.13u W=0.84u AS=0.2114p AD=0.2856p
+ PS=1.54u PD=2.36u rfmode=0
M$3441 VDD \$1091 \$1302 VDD sg13_lv_pmos L=0.13u W=0.84u AS=0.2114p AD=0.2856p
+ PS=1.54u PD=2.36u rfmode=0
M$3442 VDD \$1302 \$41 VDD sg13_lv_pmos L=0.13u W=1.12u AS=0.2114p AD=0.42p
+ PS=1.54u PD=2.99u rfmode=0
M$3443 VDD \$1034 \$1303 VDD sg13_lv_pmos L=0.13u W=0.84u AS=0.2114p AD=0.2856p
+ PS=1.54u PD=2.36u rfmode=0
M$3444 VDD \$1303 \$40 VDD sg13_lv_pmos L=0.13u W=1.12u AS=0.2114p AD=0.42p
+ PS=1.54u PD=2.99u rfmode=0
C$3445 \$4 \$2 cap_cmim w=5.71u l=5.71u A=32.6041p P=22.84u m=40
C$3457 \$5 \$3 cap_cmim w=5.71u l=5.71u A=32.6041p P=22.84u m=40
C$3470 \$7 \$6 cap_cmim w=5.71u l=5.71u A=32.6041p P=22.84u m=64
C$3483 \$9 \$8 cap_cmim w=5.71u l=5.71u A=32.6041p P=22.84u m=64
C$3505 \$10 \$7 cap_cmim w=1.49u l=1.49u A=2.2201p P=5.96u m=1
C$3506 \$11 \$9 cap_cmim w=1.49u l=1.49u A=2.2201p P=5.96u m=1
C$3523 \$7 \$16 cap_cmim w=5.71u l=5.71u A=32.6041p P=22.84u m=32
C$3531 \$9 \$17 cap_cmim w=5.71u l=5.71u A=32.6041p P=22.84u m=32
C$3550 \$7 \$18 cap_cmim w=5.71u l=5.71u A=32.6041p P=22.84u m=16
C$3554 \$7 VDD cap_cmim w=5.71u l=5.71u A=32.6041p P=22.84u m=1
C$3555 \$9 VDD cap_cmim w=5.71u l=5.71u A=32.6041p P=22.84u m=1
C$3556 \$9 \$27 cap_cmim w=5.71u l=5.71u A=32.6041p P=22.84u m=16
C$3575 \$7 \$19 cap_cmim w=5.71u l=5.71u A=32.6041p P=22.84u m=8
C$3578 \$7 \$21 cap_cmim w=5.71u l=5.71u A=32.6041p P=22.84u m=1
C$3579 \$9 \$22 cap_cmim w=5.71u l=5.71u A=32.6041p P=22.84u m=1
C$3581 \$9 \$20 cap_cmim w=5.71u l=5.71u A=32.6041p P=22.84u m=8
C$3600 \$7 \$25 cap_cmim w=5.71u l=5.71u A=32.6041p P=22.84u m=4
C$3601 \$7 \$23 cap_cmim w=5.71u l=5.71u A=32.6041p P=22.84u m=2
C$3603 \$9 \$24 cap_cmim w=5.71u l=5.71u A=32.6041p P=22.84u m=2
C$3605 \$9 \$26 cap_cmim w=5.71u l=5.71u A=32.6041p P=22.84u m=4
C$3783 \$288 \$224 cap_cmim w=9.39u l=6.99u A=65.6361p P=32.76u m=1
C$3784 \$247 \$225 cap_cmim w=4.665u l=6.99u A=32.60835p P=23.31u m=1
C$3785 \$295 \$223 cap_cmim w=4.665u l=6.99u A=32.60835p P=23.31u m=1
C$3786 \$299 VSS cap_cmim w=3.59u l=3.59u A=12.8881p P=14.36u m=1
C$3787 \$296 \$226 cap_cmim w=4.665u l=6.99u A=32.60835p P=23.31u m=1
C$3788 \$248 \$227 cap_cmim w=4.665u l=6.99u A=32.60835p P=23.31u m=1
C$3789 \$249 \$228 cap_cmim w=9.39u l=6.99u A=65.6361p P=32.76u m=1
R$3790 VDD \$198 ntap1 A=15.376p P=99.2u
.ENDS SAR_ADC
