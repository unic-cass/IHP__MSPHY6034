* Extracted by KLayout with SG13G2 LVS runset on : 21/09/2026 21:59

.SUBCKT SAR_ADC VSS VDD clk_comp fclk_samp bias Op Om vin_neg vin_pos En rst
+ fclk_in fdac_clk D0 D1 D2 D3 D4 D5 D6 D7
M$1 VDD \$72 \$17 VSS sg13_lv_nmos L=0.13u W=1u AS=0.34p AD=0.34p PS=2.68u
+ PD=2.68u rfmode=0
M$2 \$28 \$83 VDD VSS sg13_lv_nmos L=0.13u W=1u AS=0.34p AD=0.34p PS=2.68u
+ PD=2.68u rfmode=0
M$3 VSS \$30 \$17 VSS sg13_lv_nmos L=0.13u W=1u AS=0.34p AD=0.34p PS=2.68u
+ PD=2.68u rfmode=0
M$4 \$28 \$39 VSS VSS sg13_lv_nmos L=0.13u W=1u AS=0.34p AD=0.34p PS=2.68u
+ PD=2.68u rfmode=0
M$5 VDD \$71 \$7 VSS sg13_lv_nmos L=0.13u W=1u AS=0.34p AD=0.34p PS=2.68u
+ PD=2.68u rfmode=0
M$6 VSS \$29 \$7 VSS sg13_lv_nmos L=0.13u W=1u AS=0.34p AD=0.34p PS=2.68u
+ PD=2.68u rfmode=0
M$7 VDD \$77 \$21 VSS sg13_lv_nmos L=0.13u W=1u AS=0.34p AD=0.34p PS=2.68u
+ PD=2.68u rfmode=0
M$8 \$22 \$78 VDD VSS sg13_lv_nmos L=0.13u W=1u AS=0.34p AD=0.34p PS=2.68u
+ PD=2.68u rfmode=0
M$9 \$9 \$40 VSS VSS sg13_lv_nmos L=0.13u W=1u AS=0.34p AD=0.34p PS=2.68u
+ PD=2.68u rfmode=0
M$10 \$9 \$84 VDD VSS sg13_lv_nmos L=0.13u W=1u AS=0.34p AD=0.34p PS=2.68u
+ PD=2.68u rfmode=0
M$11 VDD \$73 \$18 VSS sg13_lv_nmos L=0.13u W=1u AS=0.34p AD=0.34p PS=2.68u
+ PD=2.68u rfmode=0
M$12 VSS \$31 \$18 VSS sg13_lv_nmos L=0.13u W=1u AS=0.34p AD=0.34p PS=2.68u
+ PD=2.68u rfmode=0
M$13 VDD \$74 \$20 VSS sg13_lv_nmos L=0.13u W=1u AS=0.34p AD=0.34p PS=2.68u
+ PD=2.68u rfmode=0
M$14 VSS \$32 \$20 VSS sg13_lv_nmos L=0.13u W=1u AS=0.34p AD=0.34p PS=2.68u
+ PD=2.68u rfmode=0
M$15 VDD \$75 \$24 VSS sg13_lv_nmos L=0.13u W=1u AS=0.34p AD=0.34p PS=2.68u
+ PD=2.68u rfmode=0
M$16 VSS \$33 \$24 VSS sg13_lv_nmos L=0.13u W=1u AS=0.34p AD=0.34p PS=2.68u
+ PD=2.68u rfmode=0
M$17 VSS \$34 \$21 VSS sg13_lv_nmos L=0.13u W=1u AS=0.34p AD=0.34p PS=2.68u
+ PD=2.68u rfmode=0
M$18 \$22 \$35 VSS VSS sg13_lv_nmos L=0.13u W=1u AS=0.34p AD=0.34p PS=2.68u
+ PD=2.68u rfmode=0
M$19 \$27 \$36 VSS VSS sg13_lv_nmos L=0.13u W=1u AS=0.34p AD=0.34p PS=2.68u
+ PD=2.68u rfmode=0
M$20 \$27 \$80 VDD VSS sg13_lv_nmos L=0.13u W=1u AS=0.34p AD=0.34p PS=2.68u
+ PD=2.68u rfmode=0
M$21 \$23 \$37 VSS VSS sg13_lv_nmos L=0.13u W=1u AS=0.34p AD=0.34p PS=2.68u
+ PD=2.68u rfmode=0
M$22 \$23 \$81 VDD VSS sg13_lv_nmos L=0.13u W=1u AS=0.34p AD=0.34p PS=2.68u
+ PD=2.68u rfmode=0
M$23 \$19 \$38 VSS VSS sg13_lv_nmos L=0.13u W=1u AS=0.34p AD=0.34p PS=2.68u
+ PD=2.68u rfmode=0
M$24 \$19 \$82 VDD VSS sg13_lv_nmos L=0.13u W=1u AS=0.34p AD=0.34p PS=2.68u
+ PD=2.68u rfmode=0
M$25 VSS \$29 \$71 VSS sg13_lv_nmos L=0.13u W=0.4u AS=0.136p AD=0.136p PS=1.48u
+ PD=1.48u rfmode=0
M$26 VSS \$30 \$72 VSS sg13_lv_nmos L=0.13u W=0.4u AS=0.136p AD=0.136p PS=1.48u
+ PD=1.48u rfmode=0
M$27 VSS \$31 \$73 VSS sg13_lv_nmos L=0.13u W=0.4u AS=0.136p AD=0.136p PS=1.48u
+ PD=1.48u rfmode=0
M$28 VSS \$32 \$74 VSS sg13_lv_nmos L=0.13u W=0.4u AS=0.136p AD=0.136p PS=1.48u
+ PD=1.48u rfmode=0
M$29 VSS \$33 \$75 VSS sg13_lv_nmos L=0.13u W=0.4u AS=0.136p AD=0.136p PS=1.48u
+ PD=1.48u rfmode=0
M$30 VDD \$76 \$25 VSS sg13_lv_nmos L=0.13u W=1u AS=0.34p AD=0.34p PS=2.68u
+ PD=2.68u rfmode=0
M$31 VSS \$41 \$76 VSS sg13_lv_nmos L=0.13u W=0.4u AS=0.136p AD=0.136p PS=1.48u
+ PD=1.48u rfmode=0
M$32 VSS \$41 \$25 VSS sg13_lv_nmos L=0.13u W=1u AS=0.34p AD=0.34p PS=2.68u
+ PD=2.68u rfmode=0
M$33 VSS \$34 \$77 VSS sg13_lv_nmos L=0.13u W=0.4u AS=0.136p AD=0.136p PS=1.48u
+ PD=1.48u rfmode=0
M$35 VSS clk_comp \$202 VSS sg13_lv_nmos L=0.2u W=4u AS=0.76p AD=1.44p PS=4.38u
+ PD=4.72u rfmode=0
M$36 \$202 \$203 VSS VSS sg13_lv_nmos L=0.2u W=4u AS=1.44p AD=0.76p PS=4.72u
+ PD=4.38u rfmode=0
M$39 VSS \$202 \$203 VSS sg13_lv_nmos L=0.2u W=4u AS=0.76p AD=1.44p PS=4.38u
+ PD=4.72u rfmode=0
M$40 \$203 clk_comp VSS VSS sg13_lv_nmos L=0.2u W=4u AS=1.44p AD=0.76p PS=4.72u
+ PD=4.38u rfmode=0
M$42 \$78 \$35 VSS VSS sg13_lv_nmos L=0.13u W=0.4u AS=0.136p AD=0.136p PS=1.48u
+ PD=1.48u rfmode=0
M$43 \$26 \$42 VSS VSS sg13_lv_nmos L=0.13u W=1u AS=0.34p AD=0.34p PS=2.68u
+ PD=2.68u rfmode=0
M$44 \$79 \$42 VSS VSS sg13_lv_nmos L=0.13u W=0.4u AS=0.136p AD=0.136p PS=1.48u
+ PD=1.48u rfmode=0
M$45 \$26 \$79 VDD VSS sg13_lv_nmos L=0.13u W=1u AS=0.34p AD=0.34p PS=2.68u
+ PD=2.68u rfmode=0
M$46 \$80 \$36 VSS VSS sg13_lv_nmos L=0.13u W=0.4u AS=0.136p AD=0.136p PS=1.48u
+ PD=1.48u rfmode=0
M$47 \$81 \$37 VSS VSS sg13_lv_nmos L=0.13u W=0.4u AS=0.136p AD=0.136p PS=1.48u
+ PD=1.48u rfmode=0
M$48 \$82 \$38 VSS VSS sg13_lv_nmos L=0.13u W=0.4u AS=0.136p AD=0.136p PS=1.48u
+ PD=1.48u rfmode=0
M$49 \$83 \$39 VSS VSS sg13_lv_nmos L=0.13u W=0.4u AS=0.136p AD=0.136p PS=1.48u
+ PD=1.48u rfmode=0
M$50 \$84 \$40 VSS VSS sg13_lv_nmos L=0.13u W=0.4u AS=0.136p AD=0.136p PS=1.48u
+ PD=1.48u rfmode=0
M$51 \$11 \$260 vin_neg VSS sg13_lv_nmos L=0.13u W=2.5u AS=0.85p AD=0.85p
+ PS=5.68u PD=5.68u rfmode=0
M$52 vin_neg \$261 \$225 VSS sg13_lv_nmos L=0.13u W=3u AS=1.02p AD=1.02p
+ PS=6.68u PD=6.68u rfmode=0
M$53 Op \$202 VSS VSS sg13_lv_nmos L=0.2u W=4u AS=1.06p AD=1.06p PS=7.06u
+ PD=7.06u rfmode=0
M$55 Om \$203 VSS VSS sg13_lv_nmos L=0.2u W=4u AS=1.06p AD=1.06p PS=7.06u
+ PD=7.06u rfmode=0
M$57 \$229 \$239 vin_pos VSS sg13_lv_nmos L=0.13u W=3u AS=1.02p AD=1.02p
+ PS=6.68u PD=6.68u rfmode=0
M$58 vin_pos \$250 \$12 VSS sg13_lv_nmos L=0.13u W=2.5u AS=0.85p AD=0.85p
+ PS=5.68u PD=5.68u rfmode=0
M$59 \$261 VDD \$235 VSS sg13_lv_nmos L=0.13u W=3u AS=1.02p AD=1.02p PS=6.68u
+ PD=6.68u rfmode=0
M$60 \$235 \$224 VSS VSS sg13_lv_nmos L=0.13u W=3u AS=1.02p AD=1.02p PS=6.68u
+ PD=6.68u rfmode=0
M$61 VSS \$224 \$225 VSS sg13_lv_nmos L=0.4u W=1.3u AS=0.442p AD=0.442p
+ PS=3.28u PD=3.28u rfmode=0
M$62 \$229 \$227 VSS VSS sg13_lv_nmos L=0.4u W=1.3u AS=0.442p AD=0.442p
+ PS=3.28u PD=3.28u rfmode=0
M$63 VSS \$227 \$236 VSS sg13_lv_nmos L=0.13u W=3u AS=1.02p AD=1.02p PS=6.68u
+ PD=6.68u rfmode=0
M$64 \$236 VDD \$239 VSS sg13_lv_nmos L=0.13u W=3u AS=1.02p AD=1.02p PS=6.68u
+ PD=6.68u rfmode=0
M$65 \$278 \$274 VSS VSS sg13_lv_nmos L=0.13u W=0.4u AS=0.136p AD=0.136p
+ PS=1.48u PD=1.48u rfmode=0
M$66 VSS \$224 \$247 VSS sg13_lv_nmos L=0.13u W=0.5u AS=0.17p AD=0.17p PS=1.68u
+ PD=1.68u rfmode=0
M$67 \$247 VDD \$260 VSS sg13_lv_nmos L=0.13u W=0.5u AS=0.17p AD=0.17p PS=1.68u
+ PD=1.68u rfmode=0
M$68 \$226 \$224 VSS VSS sg13_lv_nmos L=0.13u W=0.4u AS=0.136p AD=0.136p
+ PS=1.48u PD=1.48u rfmode=0
M$69 \$224 fclk_samp VSS VSS sg13_lv_nmos L=0.13u W=0.4u AS=0.136p AD=0.136p
+ PS=1.48u PD=1.48u rfmode=0
M$70 VSS fclk_samp \$227 VSS sg13_lv_nmos L=0.13u W=0.4u AS=0.136p AD=0.136p
+ PS=1.48u PD=1.48u rfmode=0
M$71 VSS \$227 \$228 VSS sg13_lv_nmos L=0.13u W=0.4u AS=0.136p AD=0.136p
+ PS=1.48u PD=1.48u rfmode=0
M$72 \$250 VDD \$251 VSS sg13_lv_nmos L=0.13u W=0.5u AS=0.17p AD=0.17p PS=1.68u
+ PD=1.68u rfmode=0
M$73 \$251 \$227 VSS VSS sg13_lv_nmos L=0.13u W=0.5u AS=0.17p AD=0.17p PS=1.68u
+ PD=1.68u rfmode=0
M$74 VSS \$279 \$275 VSS sg13_lv_nmos L=0.13u W=0.4u AS=0.136p AD=0.136p
+ PS=1.48u PD=1.48u rfmode=0
M$75 \$280 \$295 VDD VSS sg13_lv_nmos L=0.13u W=1.3u AS=0.442p AD=0.442p
+ PS=3.28u PD=3.28u rfmode=0
M$76 VDD \$295 \$248 VSS sg13_lv_nmos L=0.13u W=1.3u AS=0.442p AD=0.442p
+ PS=3.28u PD=3.28u rfmode=0
M$77 \$295 \$248 VDD VSS sg13_lv_nmos L=0.13u W=1.3u AS=0.442p AD=0.442p
+ PS=3.28u PD=3.28u rfmode=0
M$78 VDD \$297 \$296 VSS sg13_lv_nmos L=0.13u W=1.3u AS=0.442p AD=0.442p
+ PS=3.28u PD=3.28u rfmode=0
M$79 \$297 \$296 VDD VSS sg13_lv_nmos L=0.13u W=1.3u AS=0.442p AD=0.442p
+ PS=3.28u PD=3.28u rfmode=0
M$80 VDD \$296 \$249 VSS sg13_lv_nmos L=0.13u W=1.3u AS=0.442p AD=0.442p
+ PS=3.28u PD=3.28u rfmode=0
M$81 \$34 \$345 VSS VSS sg13_lv_nmos L=0.13u W=0.74u AS=0.2886p AD=0.14875p
+ PS=2.26u PD=1.16u rfmode=0
M$82 VSS \$350 \$345 VSS sg13_lv_nmos L=0.13u W=0.55u AS=0.14875p AD=0.187p
+ PS=1.16u PD=1.78u rfmode=0
M$83 VSS Op \$346 VSS sg13_lv_nmos L=0.13u W=0.55u AS=0.14875p AD=0.187p
+ PS=1.16u PD=1.78u rfmode=0
M$84 VSS \$346 \$310 VSS sg13_lv_nmos L=0.13u W=0.74u AS=0.14875p AD=0.2886p
+ PS=1.16u PD=2.26u rfmode=0
M$85 VSS \$385 \$347 VSS sg13_lv_nmos L=0.13u W=0.55u AS=0.14875p AD=0.187p
+ PS=1.16u PD=1.78u rfmode=0
M$86 VSS \$347 clk_comp VSS sg13_lv_nmos L=0.13u W=0.74u AS=0.14875p AD=0.2886p
+ PS=1.16u PD=2.26u rfmode=0
M$87 \$325 \$364 VSS VSS sg13_lv_nmos L=0.13u W=0.74u AS=0.2886p AD=0.14875p
+ PS=2.26u PD=1.16u rfmode=0
M$88 VSS rst \$364 VSS sg13_lv_nmos L=0.13u W=0.55u AS=0.14875p AD=0.187p
+ PS=1.16u PD=1.78u rfmode=0
M$89 \$329 \$328 \$343 VSS sg13_lv_nmos L=0.13u W=0.42u AS=0.1428p AD=0.0609p
+ PS=1.52u PD=0.71u rfmode=0
M$90 \$343 \$368 VSS VSS sg13_lv_nmos L=0.13u W=0.42u AS=0.0609p AD=0.1626p
+ PS=0.71u PD=1.415u rfmode=0
M$91 VSS \$367 \$331 VSS sg13_lv_nmos L=0.13u W=0.74u AS=0.1626p AD=0.2516p
+ PS=1.415u PD=2.16u rfmode=0
M$92 \$302 Op \$303 VSS sg13_lv_nmos L=0.13u W=0.25u AS=0.1075p AD=0.0625p
+ PS=1.34u PD=0.74u rfmode=0
M$93 \$303 Om VSS VSS sg13_lv_nmos L=0.13u W=0.25u AS=0.0625p AD=0.1075p
+ PS=0.74u PD=1.34u rfmode=0
M$94 \$333 \$334 VSS VSS sg13_lv_nmos L=0.13u W=0.42u AS=0.1428p AD=0.0798p
+ PS=1.52u PD=0.8u rfmode=0
M$95 VSS \$368 \$344 VSS sg13_lv_nmos L=0.13u W=0.42u AS=0.0798p AD=0.0378p
+ PS=0.8u PD=0.6u rfmode=0
M$96 \$344 \$370 \$334 VSS sg13_lv_nmos L=0.13u W=0.42u AS=0.0378p AD=0.1428p
+ PS=0.6u PD=1.52u rfmode=0
M$97 \$335 \$370 VSS VSS sg13_lv_nmos L=0.13u W=0.74u AS=0.2516p AD=0.1406p
+ PS=2.16u PD=1.12u rfmode=0
M$98 VSS \$335 \$336 VSS sg13_lv_nmos L=0.13u W=0.74u AS=0.1406p AD=0.2516p
+ PS=1.12u PD=2.16u rfmode=0
M$99 \$337 \$566 VSS VSS sg13_lv_nmos L=0.15u W=0.74u AS=0.2516p AD=0.1406p
+ PS=2.16u PD=1.12u rfmode=0
M$100 VSS \$442 \$337 VSS sg13_lv_nmos L=0.15u W=0.74u AS=0.1406p AD=0.1406p
+ PS=1.12u PD=1.12u rfmode=0
M$101 \$337 \$389 \$338 VSS sg13_lv_nmos L=0.15u W=0.74u AS=0.1406p AD=0.2516p
+ PS=1.12u PD=2.16u rfmode=0
M$102 \$340 \$373 VSS VSS sg13_lv_nmos L=0.13u W=0.74u AS=0.2886p AD=0.14875p
+ PS=2.26u PD=1.16u rfmode=0
M$103 VSS \$667 \$373 VSS sg13_lv_nmos L=0.13u W=0.55u AS=0.14875p AD=0.187p
+ PS=1.16u PD=1.78u rfmode=0
M$104 VSS \$302 \$374 VSS sg13_lv_nmos L=0.13u W=0.55u AS=0.14875p AD=0.187p
+ PS=1.16u PD=1.78u rfmode=0
M$105 VSS \$374 \$341 VSS sg13_lv_nmos L=0.13u W=0.74u AS=0.14875p AD=0.2886p
+ PS=1.16u PD=2.26u rfmode=0
M$106 fclk_samp \$375 VSS VSS sg13_lv_nmos L=0.13u W=0.74u AS=0.2886p
+ AD=0.14875p PS=2.26u PD=1.16u rfmode=0
M$107 VSS \$389 \$375 VSS sg13_lv_nmos L=0.13u W=0.55u AS=0.14875p AD=0.187p
+ PS=1.16u PD=1.78u rfmode=0
M$108 \$372 \$376 VSS VSS sg13_lv_nmos L=0.13u W=0.74u AS=0.2886p AD=0.14875p
+ PS=2.26u PD=1.16u rfmode=0
M$109 VSS Om \$376 VSS sg13_lv_nmos L=0.13u W=0.55u AS=0.14875p AD=0.187p
+ PS=1.16u PD=1.78u rfmode=0
M$110 VSS \$465 \$377 VSS sg13_lv_nmos L=0.13u W=0.55u AS=0.14875p AD=0.187p
+ PS=1.16u PD=1.78u rfmode=0
M$111 VSS \$377 \$35 VSS sg13_lv_nmos L=0.13u W=0.74u AS=0.14875p AD=0.2886p
+ PS=1.16u PD=2.26u rfmode=0
M$112 VSS \$348 \$311 VSS sg13_lv_nmos L=0.13u W=0.55u AS=0.18945p AD=0.187p
+ PS=1.27u PD=1.78u rfmode=0
M$113 VSS \$348 \$378 VSS sg13_lv_nmos L=0.13u W=0.74u AS=0.18945p AD=0.13135p
+ PS=1.27u PD=1.095u rfmode=0
M$114 \$378 \$349 \$312 VSS sg13_lv_nmos L=0.13u W=0.74u AS=0.13135p AD=0.1628p
+ PS=1.095u PD=1.18u rfmode=0
M$115 \$312 \$350 \$379 VSS sg13_lv_nmos L=0.13u W=0.74u AS=0.1628p AD=0.3367p
+ PS=1.18u PD=1.65u rfmode=0
M$116 \$379 \$311 VSS VSS sg13_lv_nmos L=0.13u W=0.74u AS=0.3367p AD=0.148p
+ PS=1.65u PD=1.14u rfmode=0
M$117 VSS \$312 \$313 VSS sg13_lv_nmos L=0.13u W=0.74u AS=0.148p AD=0.4033p
+ PS=1.14u PD=2.57u rfmode=0
M$118 VSS \$315 \$314 VSS sg13_lv_nmos L=0.13u W=11.84u AS=2.3606p AD=2.2496p
+ PS=18.96u PD=17.92u rfmode=0
M$134 VSS fclk_in \$315 VSS sg13_lv_nmos L=0.13u W=4.44u AS=0.8436p AD=0.9546p
+ PS=6.72u PD=7.76u rfmode=0
M$140 VSS \$355 \$320 VSS sg13_lv_nmos L=0.13u W=0.74u AS=0.1898p AD=0.2516p
+ PS=1.36u PD=2.16u rfmode=0
M$141 VSS \$317 \$320 VSS sg13_lv_nmos L=0.13u W=0.74u AS=0.1898p AD=0.1406p
+ PS=1.36u PD=1.12u rfmode=0
M$142 \$320 \$319 \$387 VSS sg13_lv_nmos L=0.13u W=0.74u AS=0.1406p AD=0.2516p
+ PS=1.12u PD=2.16u rfmode=0
M$143 \$354 \$356 VSS VSS sg13_lv_nmos L=0.13u W=0.74u AS=0.2516p AD=0.1426p
+ PS=2.16u PD=1.16u rfmode=0
M$144 VSS \$357 \$356 VSS sg13_lv_nmos L=0.5u W=0.42u AS=0.1426p AD=0.1428p
+ PS=1.16u PD=1.52u rfmode=0
M$145 \$357 \$321 VSS VSS sg13_lv_nmos L=0.5u W=0.42u AS=0.1428p AD=0.0798p
+ PS=1.52u PD=0.8u rfmode=0
M$146 VSS \$358 \$321 VSS sg13_lv_nmos L=0.13u W=0.42u AS=0.0798p AD=0.1428p
+ PS=0.8u PD=1.52u rfmode=0
M$147 \$322 \$359 VSS VSS sg13_lv_nmos L=0.13u W=0.74u AS=0.2516p AD=0.1426p
+ PS=2.16u PD=1.16u rfmode=0
M$148 VSS \$360 \$359 VSS sg13_lv_nmos L=0.5u W=0.42u AS=0.1426p AD=0.1428p
+ PS=1.16u PD=1.52u rfmode=0
M$149 \$360 \$323 VSS VSS sg13_lv_nmos L=0.5u W=0.42u AS=0.1428p AD=0.0798p
+ PS=1.52u PD=0.8u rfmode=0
M$150 VSS \$387 \$323 VSS sg13_lv_nmos L=0.13u W=0.42u AS=0.0798p AD=0.1428p
+ PS=0.8u PD=1.52u rfmode=0
M$151 \$355 \$361 VSS VSS sg13_lv_nmos L=0.13u W=0.74u AS=0.2516p AD=0.1426p
+ PS=2.16u PD=1.16u rfmode=0
M$152 VSS \$362 \$361 VSS sg13_lv_nmos L=0.5u W=0.42u AS=0.1426p AD=0.1428p
+ PS=1.16u PD=1.52u rfmode=0
M$153 \$362 \$324 VSS VSS sg13_lv_nmos L=0.5u W=0.42u AS=0.1428p AD=0.0798p
+ PS=1.52u PD=0.8u rfmode=0
M$154 VSS \$363 \$324 VSS sg13_lv_nmos L=0.13u W=0.42u AS=0.0798p AD=0.1428p
+ PS=0.8u PD=1.52u rfmode=0
M$155 \$326 \$365 VSS VSS sg13_lv_nmos L=0.13u W=0.42u AS=0.1428p AD=0.0798p
+ PS=1.52u PD=0.8u rfmode=0
M$156 VSS \$326 \$327 VSS sg13_lv_nmos L=0.5u W=0.42u AS=0.0798p AD=0.1428p
+ PS=0.8u PD=1.52u rfmode=0
M$157 VSS \$327 \$366 VSS sg13_lv_nmos L=0.5u W=0.42u AS=0.1426p AD=0.1428p
+ PS=1.16u PD=1.52u rfmode=0
M$158 VSS \$366 \$328 VSS sg13_lv_nmos L=0.13u W=0.74u AS=0.1426p AD=0.2516p
+ PS=1.16u PD=2.16u rfmode=0
M$159 VSS \$629 \$368 VSS sg13_lv_nmos L=0.13u W=0.74u AS=0.2516p AD=0.2516p
+ PS=2.16u PD=2.16u rfmode=0
M$160 VSS \$310 \$371 VSS sg13_lv_nmos L=0.13u W=0.55u AS=0.17255p AD=0.187p
+ PS=1.25u PD=1.78u rfmode=0
M$161 VSS \$371 \$339 VSS sg13_lv_nmos L=0.13u W=0.74u AS=0.17255p AD=0.1406p
+ PS=1.25u PD=1.12u rfmode=0
M$162 \$339 \$372 VSS VSS sg13_lv_nmos L=0.13u W=0.74u AS=0.1406p AD=0.2516p
+ PS=1.12u PD=2.16u rfmode=0
M$163 VSS \$340 \$342 VSS sg13_lv_nmos L=0.13u W=0.74u AS=0.2516p AD=0.2516p
+ PS=2.16u PD=2.16u rfmode=0
M$164 VSS VDD VSS VSS sg13_lv_nmos L=1u W=249.9u AS=67.137p AD=67.137p
+ PS=700.64u PD=700.64u rfmode=0
M$172 VSS \$354 \$380 VSS sg13_lv_nmos L=0.13u W=0.74u AS=0.2886p AD=0.1406p
+ PS=2.26u PD=1.12u rfmode=0
M$173 \$380 \$351 \$381 VSS sg13_lv_nmos L=0.13u W=0.74u AS=0.1406p AD=0.1406p
+ PS=1.12u PD=1.12u rfmode=0
M$174 \$381 \$352 \$317 VSS sg13_lv_nmos L=0.13u W=0.74u AS=0.1406p AD=0.2516p
+ PS=1.12u PD=2.16u rfmode=0
M$175 VSS \$353 \$318 VSS sg13_lv_nmos L=0.13u W=0.74u AS=0.3108p AD=0.1628p
+ PS=2.32u PD=1.18u rfmode=0
M$176 \$318 \$354 \$382 VSS sg13_lv_nmos L=0.13u W=0.74u AS=0.1628p AD=0.0888p
+ PS=1.18u PD=0.98u rfmode=0
M$177 \$382 \$352 VSS VSS sg13_lv_nmos L=0.13u W=0.74u AS=0.0888p AD=0.15245p
+ PS=0.98u PD=1.17u rfmode=0
M$178 VSS \$354 \$353 VSS sg13_lv_nmos L=0.13u W=0.55u AS=0.15245p AD=0.174625p
+ PS=1.17u PD=1.185u rfmode=0
M$179 \$353 \$352 VSS VSS sg13_lv_nmos L=0.13u W=0.55u AS=0.174625p AD=0.374p
+ PS=1.185u PD=2.46u rfmode=0
M$180 VSS \$355 \$383 VSS sg13_lv_nmos L=0.13u W=0.64u AS=0.2272p AD=0.0784p
+ PS=1.99u PD=0.885u rfmode=0
M$181 \$383 \$317 \$319 VSS sg13_lv_nmos L=0.13u W=0.64u AS=0.0784p AD=0.2176p
+ PS=0.885u PD=1.96u rfmode=0
M$183 VSS \$368 \$384 VSS sg13_lv_nmos L=0.13u W=0.42u AS=0.1701p AD=0.0378p
+ PS=1.65u PD=0.6u rfmode=0
M$184 \$384 \$331 \$330 VSS sg13_lv_nmos L=0.13u W=0.42u AS=0.0378p AD=0.1428p
+ PS=0.6u PD=1.52u rfmode=0
M$185 \$329 \$332 \$367 VSS sg13_lv_nmos L=0.13u W=0.42u AS=0.1296p AD=0.0798p
+ PS=1.52u PD=0.8u rfmode=0
M$186 \$367 \$388 \$330 VSS sg13_lv_nmos L=0.13u W=0.42u AS=0.0798p AD=0.2373p
+ PS=0.8u PD=1.97u rfmode=0
M$187 VSS \$332 \$388 VSS sg13_lv_nmos L=0.13u W=0.74u AS=0.317325p AD=0.2516p
+ PS=1.805u PD=2.16u rfmode=0
M$188 VSS \$369 \$332 VSS sg13_lv_nmos L=0.13u W=0.74u AS=0.317325p AD=0.2516p
+ PS=1.805u PD=2.16u rfmode=0
M$189 \$370 \$332 \$333 VSS sg13_lv_nmos L=0.13u W=0.42u AS=0.12665p AD=0.1428p
+ PS=1.145u PD=1.52u rfmode=0
M$190 \$331 \$388 \$370 VSS sg13_lv_nmos L=0.13u W=0.74u AS=0.3473p AD=0.12665p
+ PS=2.71u PD=1.145u rfmode=0
M$217 \$411 \$415 \$413 VSS sg13_lv_nmos L=0.13u W=0.42u AS=0.1296p AD=0.0798p
+ PS=1.52u PD=0.8u rfmode=0
M$218 \$413 \$414 \$495 VSS sg13_lv_nmos L=0.13u W=0.42u AS=0.0798p AD=0.2373p
+ PS=0.8u PD=1.97u rfmode=0
M$219 \$421 \$426 \$423 VSS sg13_lv_nmos L=0.13u W=0.42u AS=0.1296p AD=0.0798p
+ PS=1.52u PD=0.8u rfmode=0
M$220 \$423 \$425 \$497 VSS sg13_lv_nmos L=0.13u W=0.42u AS=0.0798p AD=0.2373p
+ PS=0.8u PD=1.97u rfmode=0
M$221 \$430 \$435 \$432 VSS sg13_lv_nmos L=0.13u W=0.42u AS=0.1296p AD=0.0798p
+ PS=1.52u PD=0.8u rfmode=0
M$222 \$432 \$434 \$499 VSS sg13_lv_nmos L=0.13u W=0.42u AS=0.0798p AD=0.2373p
+ PS=0.8u PD=1.97u rfmode=0
M$223 \$445 \$449 \$447 VSS sg13_lv_nmos L=0.13u W=0.42u AS=0.1296p AD=0.0798p
+ PS=1.52u PD=0.8u rfmode=0
M$224 \$447 \$448 \$501 VSS sg13_lv_nmos L=0.13u W=0.42u AS=0.0798p AD=0.2373p
+ PS=0.8u PD=1.97u rfmode=0
M$225 \$457 \$461 \$459 VSS sg13_lv_nmos L=0.13u W=0.42u AS=0.1296p AD=0.0798p
+ PS=1.52u PD=0.8u rfmode=0
M$226 \$459 \$460 \$503 VSS sg13_lv_nmos L=0.13u W=0.42u AS=0.0798p AD=0.2373p
+ PS=0.8u PD=1.97u rfmode=0
M$227 \$469 \$473 \$471 VSS sg13_lv_nmos L=0.13u W=0.42u AS=0.1296p AD=0.0798p
+ PS=1.52u PD=0.8u rfmode=0
M$228 \$471 \$472 \$505 VSS sg13_lv_nmos L=0.13u W=0.42u AS=0.0798p AD=0.2373p
+ PS=0.8u PD=1.97u rfmode=0
M$229 \$414 \$415 VSS VSS sg13_lv_nmos L=0.13u W=0.74u AS=0.2516p AD=0.317325p
+ PS=2.16u PD=1.805u rfmode=0
M$230 VSS \$496 \$415 VSS sg13_lv_nmos L=0.13u W=0.74u AS=0.317325p AD=0.2516p
+ PS=1.805u PD=2.16u rfmode=0
M$231 \$506 \$415 \$416 VSS sg13_lv_nmos L=0.13u W=0.42u AS=0.1428p AD=0.12665p
+ PS=1.52u PD=1.145u rfmode=0
M$232 \$416 \$414 \$412 VSS sg13_lv_nmos L=0.13u W=0.74u AS=0.12665p AD=0.3473p
+ PS=1.145u PD=2.71u rfmode=0
M$233 \$425 \$426 VSS VSS sg13_lv_nmos L=0.13u W=0.74u AS=0.2516p AD=0.317325p
+ PS=2.16u PD=1.805u rfmode=0
M$234 VSS \$498 \$426 VSS sg13_lv_nmos L=0.13u W=0.74u AS=0.317325p AD=0.2516p
+ PS=1.805u PD=2.16u rfmode=0
M$235 \$507 \$426 \$427 VSS sg13_lv_nmos L=0.13u W=0.42u AS=0.1428p AD=0.12665p
+ PS=1.52u PD=1.145u rfmode=0
M$236 \$427 \$425 \$422 VSS sg13_lv_nmos L=0.13u W=0.74u AS=0.12665p AD=0.3473p
+ PS=1.145u PD=2.71u rfmode=0
M$237 \$434 \$435 VSS VSS sg13_lv_nmos L=0.13u W=0.74u AS=0.2516p AD=0.317325p
+ PS=2.16u PD=1.805u rfmode=0
M$238 VSS \$498 \$435 VSS sg13_lv_nmos L=0.13u W=0.74u AS=0.317325p AD=0.2516p
+ PS=1.805u PD=2.16u rfmode=0
M$239 \$508 \$435 \$436 VSS sg13_lv_nmos L=0.13u W=0.42u AS=0.1428p AD=0.12665p
+ PS=1.52u PD=1.145u rfmode=0
M$240 \$436 \$434 \$431 VSS sg13_lv_nmos L=0.13u W=0.74u AS=0.12665p AD=0.3473p
+ PS=1.145u PD=2.71u rfmode=0
M$241 \$448 \$449 VSS VSS sg13_lv_nmos L=0.13u W=0.74u AS=0.2516p AD=0.317325p
+ PS=2.16u PD=1.805u rfmode=0
M$242 VSS \$369 \$449 VSS sg13_lv_nmos L=0.13u W=0.74u AS=0.317325p AD=0.2516p
+ PS=1.805u PD=2.16u rfmode=0
M$243 \$510 \$449 \$450 VSS sg13_lv_nmos L=0.13u W=0.42u AS=0.1428p AD=0.12665p
+ PS=1.52u PD=1.145u rfmode=0
M$244 \$450 \$448 \$446 VSS sg13_lv_nmos L=0.13u W=0.74u AS=0.12665p AD=0.3473p
+ PS=1.145u PD=2.71u rfmode=0
M$245 VSS \$454 \$455 VSS sg13_lv_nmos L=0.13u W=0.74u AS=0.2516p AD=0.1406p
+ PS=2.16u PD=1.12u rfmode=0
M$246 \$455 \$348 \$530 VSS sg13_lv_nmos L=0.13u W=0.74u AS=0.1406p AD=0.1406p
+ PS=1.12u PD=1.12u rfmode=0
M$247 \$530 \$349 VSS VSS sg13_lv_nmos L=0.13u W=0.74u AS=0.1406p AD=0.2516p
+ PS=1.12u PD=2.16u rfmode=0
M$248 \$460 \$461 VSS VSS sg13_lv_nmos L=0.13u W=0.74u AS=0.2516p AD=0.317325p
+ PS=2.16u PD=1.805u rfmode=0
M$249 VSS \$504 \$461 VSS sg13_lv_nmos L=0.13u W=0.74u AS=0.317325p AD=0.2516p
+ PS=1.805u PD=2.16u rfmode=0
M$250 \$511 \$461 \$462 VSS sg13_lv_nmos L=0.13u W=0.42u AS=0.1428p AD=0.12665p
+ PS=1.52u PD=1.145u rfmode=0
M$251 \$462 \$460 \$458 VSS sg13_lv_nmos L=0.13u W=0.74u AS=0.12665p AD=0.3473p
+ PS=1.145u PD=2.71u rfmode=0
M$252 \$472 \$473 VSS VSS sg13_lv_nmos L=0.13u W=0.74u AS=0.2516p AD=0.317325p
+ PS=2.16u PD=1.805u rfmode=0
M$253 VSS \$504 \$473 VSS sg13_lv_nmos L=0.13u W=0.74u AS=0.317325p AD=0.2516p
+ PS=1.805u PD=2.16u rfmode=0
M$254 \$512 \$473 \$474 VSS sg13_lv_nmos L=0.13u W=0.42u AS=0.1428p AD=0.12665p
+ PS=1.52u PD=1.145u rfmode=0
M$255 \$474 \$472 \$470 VSS sg13_lv_nmos L=0.13u W=0.74u AS=0.12665p AD=0.3473p
+ PS=1.145u PD=2.71u rfmode=0
M$256 VSS \$406 \$407 VSS sg13_lv_nmos L=0.13u W=0.55u AS=0.14875p AD=0.187p
+ PS=1.16u PD=1.78u rfmode=0
M$257 \$41 \$407 VSS VSS sg13_lv_nmos L=0.13u W=0.74u AS=0.2886p AD=0.14875p
+ PS=2.26u PD=1.16u rfmode=0
M$270 \$408 \$409 VSS VSS sg13_lv_nmos L=0.13u W=0.74u AS=0.2516p AD=0.2516p
+ PS=2.16u PD=2.16u rfmode=0
M$271 VSS \$599 \$410 VSS sg13_lv_nmos L=0.13u W=0.55u AS=0.14875p AD=0.187p
+ PS=1.16u PD=1.78u rfmode=0
M$272 \$385 \$410 VSS VSS sg13_lv_nmos L=0.13u W=0.74u AS=0.2886p AD=0.14875p
+ PS=2.26u PD=1.16u rfmode=0
M$273 \$418 \$416 VSS VSS sg13_lv_nmos L=0.13u W=0.74u AS=0.2516p AD=0.1406p
+ PS=2.16u PD=1.12u rfmode=0
M$274 VSS \$418 \$350 VSS sg13_lv_nmos L=0.13u W=0.74u AS=0.1406p AD=0.2516p
+ PS=1.12u PD=2.16u rfmode=0
M$275 VSS \$419 \$420 VSS sg13_lv_nmos L=0.13u W=0.55u AS=0.14875p AD=0.187p
+ PS=1.16u PD=1.78u rfmode=0
M$276 \$409 \$420 VSS VSS sg13_lv_nmos L=0.13u W=0.74u AS=0.2886p AD=0.14875p
+ PS=2.26u PD=1.16u rfmode=0
M$277 \$429 \$427 VSS VSS sg13_lv_nmos L=0.13u W=0.74u AS=0.2516p AD=0.1406p
+ PS=2.16u PD=1.12u rfmode=0
M$278 VSS \$429 \$358 VSS sg13_lv_nmos L=0.13u W=0.74u AS=0.1406p AD=0.2516p
+ PS=1.12u PD=2.16u rfmode=0
M$279 \$438 \$436 VSS VSS sg13_lv_nmos L=0.13u W=0.74u AS=0.2516p AD=0.1406p
+ PS=2.16u PD=1.12u rfmode=0
M$280 VSS \$438 \$363 VSS sg13_lv_nmos L=0.13u W=0.74u AS=0.1406p AD=0.2516p
+ PS=1.12u PD=2.16u rfmode=0
M$281 \$441 \$440 VSS VSS sg13_lv_nmos L=0.5u W=0.42u AS=0.1428p AD=0.1426p
+ PS=1.52u PD=1.16u rfmode=0
M$282 VSS \$441 \$442 VSS sg13_lv_nmos L=0.13u W=0.74u AS=0.1426p AD=0.2516p
+ PS=1.16u PD=2.16u rfmode=0
M$283 VSS \$338 \$444 VSS sg13_lv_nmos L=0.13u W=0.55u AS=0.17255p AD=0.187p
+ PS=1.25u PD=1.78u rfmode=0
M$284 VSS \$328 \$443 VSS sg13_lv_nmos L=0.13u W=0.74u AS=0.2516p AD=0.1406p
+ PS=2.16u PD=1.12u rfmode=0
M$285 \$443 \$444 VSS VSS sg13_lv_nmos L=0.13u W=0.74u AS=0.1406p AD=0.17255p
+ PS=1.12u PD=1.25u rfmode=0
M$286 \$452 \$450 VSS VSS sg13_lv_nmos L=0.13u W=0.74u AS=0.2516p AD=0.1406p
+ PS=2.16u PD=1.12u rfmode=0
M$287 VSS \$452 \$453 VSS sg13_lv_nmos L=0.13u W=0.74u AS=0.1406p AD=0.2516p
+ PS=1.12u PD=2.16u rfmode=0
M$288 VSS \$348 \$454 VSS sg13_lv_nmos L=0.13u W=0.74u AS=0.2516p AD=0.1406p
+ PS=2.16u PD=1.12u rfmode=0
M$289 \$454 \$465 VSS VSS sg13_lv_nmos L=0.13u W=0.74u AS=0.1406p AD=0.2516p
+ PS=1.12u PD=2.16u rfmode=0
M$290 \$464 \$462 VSS VSS sg13_lv_nmos L=0.13u W=0.74u AS=0.2516p AD=0.1406p
+ PS=2.16u PD=1.12u rfmode=0
M$291 VSS \$464 \$465 VSS sg13_lv_nmos L=0.13u W=0.74u AS=0.1406p AD=0.2516p
+ PS=1.12u PD=2.16u rfmode=0
M$294 \$466 \$924 VSS VSS sg13_lv_nmos L=0.13u W=0.55u AS=0.187p AD=0.18945p
+ PS=1.78u PD=1.27u rfmode=0
M$295 VSS \$924 \$535 VSS sg13_lv_nmos L=0.13u W=0.74u AS=0.18945p AD=0.13135p
+ PS=1.27u PD=1.095u rfmode=0
M$296 \$535 \$619 \$467 VSS sg13_lv_nmos L=0.13u W=0.74u AS=0.13135p AD=0.1628p
+ PS=1.095u PD=1.18u rfmode=0
M$297 \$467 \$477 \$536 VSS sg13_lv_nmos L=0.13u W=0.74u AS=0.1628p AD=0.3367p
+ PS=1.18u PD=1.65u rfmode=0
M$298 \$536 \$466 VSS VSS sg13_lv_nmos L=0.13u W=0.74u AS=0.3367p AD=0.148p
+ PS=1.65u PD=1.14u rfmode=0
M$299 VSS \$467 \$468 VSS sg13_lv_nmos L=0.13u W=0.74u AS=0.148p AD=0.4033p
+ PS=1.14u PD=2.57u rfmode=0
M$300 \$476 \$474 VSS VSS sg13_lv_nmos L=0.13u W=0.74u AS=0.2516p AD=0.1406p
+ PS=2.16u PD=1.12u rfmode=0
M$301 VSS \$476 \$477 VSS sg13_lv_nmos L=0.13u W=0.74u AS=0.1406p AD=0.2516p
+ PS=1.12u PD=2.16u rfmode=0
M$312 \$478 \$477 VSS VSS sg13_lv_nmos L=0.13u W=0.55u AS=0.187p AD=0.14875p
+ PS=1.78u PD=1.16u rfmode=0
M$313 VSS \$478 \$42 VSS sg13_lv_nmos L=0.13u W=0.74u AS=0.14875p AD=0.2886p
+ PS=1.16u PD=2.26u rfmode=0
M$314 VSS \$409 \$539 VSS sg13_lv_nmos L=0.13u W=0.74u AS=0.2516p AD=0.2516p
+ PS=2.16u PD=2.16u rfmode=0
M$315 \$540 \$541 \$573 VSS sg13_lv_nmos L=0.13u W=0.42u AS=0.1428p AD=0.0609p
+ PS=1.52u PD=0.71u rfmode=0
M$316 \$573 \$539 VSS VSS sg13_lv_nmos L=0.13u W=0.42u AS=0.0609p AD=0.1626p
+ PS=0.71u PD=1.415u rfmode=0
M$317 VSS \$580 \$542 VSS sg13_lv_nmos L=0.13u W=0.74u AS=0.1626p AD=0.2516p
+ PS=1.415u PD=2.16u rfmode=0
M$318 VSS \$413 \$412 VSS sg13_lv_nmos L=0.13u W=0.74u AS=0.1626p AD=0.2516p
+ PS=1.415u PD=2.16u rfmode=0
M$319 \$411 \$313 \$514 VSS sg13_lv_nmos L=0.13u W=0.42u AS=0.1428p AD=0.0609p
+ PS=1.52u PD=0.71u rfmode=0
M$320 VSS \$408 \$514 VSS sg13_lv_nmos L=0.13u W=0.42u AS=0.1626p AD=0.0609p
+ PS=1.415u PD=0.71u rfmode=0
M$321 VSS \$408 \$515 VSS sg13_lv_nmos L=0.13u W=0.42u AS=0.1701p AD=0.0378p
+ PS=1.65u PD=0.6u rfmode=0
M$322 \$515 \$412 \$495 VSS sg13_lv_nmos L=0.13u W=0.42u AS=0.0378p AD=0.1428p
+ PS=0.6u PD=1.52u rfmode=0
M$323 \$545 \$547 VSS VSS sg13_lv_nmos L=0.13u W=0.42u AS=0.1428p AD=0.0798p
+ PS=1.52u PD=0.8u rfmode=0
M$324 VSS \$539 \$575 VSS sg13_lv_nmos L=0.13u W=0.42u AS=0.0798p AD=0.0378p
+ PS=0.8u PD=0.6u rfmode=0
M$325 \$575 \$546 \$547 VSS sg13_lv_nmos L=0.13u W=0.42u AS=0.0378p AD=0.1428p
+ PS=0.6u PD=1.52u rfmode=0
M$326 \$506 \$417 VSS VSS sg13_lv_nmos L=0.13u W=0.42u AS=0.1428p AD=0.0798p
+ PS=1.52u PD=0.8u rfmode=0
M$327 VSS \$408 \$516 VSS sg13_lv_nmos L=0.13u W=0.42u AS=0.0798p AD=0.0378p
+ PS=0.8u PD=0.6u rfmode=0
M$328 \$516 \$416 \$417 VSS sg13_lv_nmos L=0.13u W=0.42u AS=0.0378p AD=0.1428p
+ PS=0.6u PD=1.52u rfmode=0
M$329 \$548 \$546 VSS VSS sg13_lv_nmos L=0.13u W=0.74u AS=0.2516p AD=0.1406p
+ PS=2.16u PD=1.12u rfmode=0
M$330 VSS \$548 \$406 VSS sg13_lv_nmos L=0.13u W=0.74u AS=0.1406p AD=0.2516p
+ PS=1.12u PD=2.16u rfmode=0
M$331 VSS En \$549 VSS sg13_lv_nmos L=0.13u W=0.55u AS=0.14875p AD=0.187p
+ PS=1.16u PD=1.78u rfmode=0
M$332 VSS \$549 \$352 VSS sg13_lv_nmos L=0.13u W=0.74u AS=0.14875p AD=0.2886p
+ PS=1.16u PD=2.26u rfmode=0
M$333 VSS \$423 \$422 VSS sg13_lv_nmos L=0.13u W=0.74u AS=0.1626p AD=0.2516p
+ PS=1.415u PD=2.16u rfmode=0
M$334 \$421 \$318 \$518 VSS sg13_lv_nmos L=0.13u W=0.42u AS=0.1428p AD=0.0609p
+ PS=1.52u PD=0.71u rfmode=0
M$335 VSS \$424 \$518 VSS sg13_lv_nmos L=0.13u W=0.42u AS=0.1626p AD=0.0609p
+ PS=1.415u PD=0.71u rfmode=0
M$336 \$496 \$550 VSS VSS sg13_lv_nmos L=0.13u W=0.74u AS=0.2886p AD=0.14875p
+ PS=2.26u PD=1.16u rfmode=0
M$337 VSS \$762 \$550 VSS sg13_lv_nmos L=0.13u W=0.55u AS=0.14875p AD=0.187p
+ PS=1.16u PD=1.78u rfmode=0
M$338 VSS \$424 \$519 VSS sg13_lv_nmos L=0.13u W=0.42u AS=0.1701p AD=0.0378p
+ PS=1.65u PD=0.6u rfmode=0
M$339 \$519 \$422 \$497 VSS sg13_lv_nmos L=0.13u W=0.42u AS=0.0378p AD=0.1428p
+ PS=0.6u PD=1.52u rfmode=0
M$340 \$424 \$409 VSS VSS sg13_lv_nmos L=0.13u W=0.74u AS=0.2516p AD=0.2516p
+ PS=2.16u PD=2.16u rfmode=0
M$341 \$551 \$552 \$576 VSS sg13_lv_nmos L=0.13u W=0.42u AS=0.1428p AD=0.0609p
+ PS=1.52u PD=0.71u rfmode=0
M$342 \$576 \$582 VSS VSS sg13_lv_nmos L=0.13u W=0.42u AS=0.0609p AD=0.1626p
+ PS=0.71u PD=1.415u rfmode=0
M$343 VSS \$583 \$553 VSS sg13_lv_nmos L=0.13u W=0.74u AS=0.1626p AD=0.2516p
+ PS=1.415u PD=2.16u rfmode=0
M$344 \$507 \$428 VSS VSS sg13_lv_nmos L=0.13u W=0.42u AS=0.1428p AD=0.0798p
+ PS=1.52u PD=0.8u rfmode=0
M$345 VSS \$424 \$520 VSS sg13_lv_nmos L=0.13u W=0.42u AS=0.0798p AD=0.0378p
+ PS=0.8u PD=0.6u rfmode=0
M$346 \$520 \$427 \$428 VSS sg13_lv_nmos L=0.13u W=0.42u AS=0.0378p AD=0.1428p
+ PS=0.6u PD=1.52u rfmode=0
M$347 VSS \$432 \$431 VSS sg13_lv_nmos L=0.13u W=0.74u AS=0.1626p AD=0.2516p
+ PS=1.415u PD=2.16u rfmode=0
M$348 \$430 \$322 \$521 VSS sg13_lv_nmos L=0.13u W=0.42u AS=0.1428p AD=0.0609p
+ PS=1.52u PD=0.71u rfmode=0
M$349 VSS \$433 \$521 VSS sg13_lv_nmos L=0.13u W=0.42u AS=0.1626p AD=0.0609p
+ PS=1.415u PD=0.71u rfmode=0
M$350 \$556 \$558 VSS VSS sg13_lv_nmos L=0.13u W=0.42u AS=0.1428p AD=0.0798p
+ PS=1.52u PD=0.8u rfmode=0
M$351 VSS \$582 \$578 VSS sg13_lv_nmos L=0.13u W=0.42u AS=0.0798p AD=0.0378p
+ PS=0.8u PD=0.6u rfmode=0
M$352 \$578 \$557 \$558 VSS sg13_lv_nmos L=0.13u W=0.42u AS=0.0378p AD=0.1428p
+ PS=0.6u PD=1.52u rfmode=0
M$353 VSS \$433 \$522 VSS sg13_lv_nmos L=0.13u W=0.42u AS=0.1701p AD=0.0378p
+ PS=1.65u PD=0.6u rfmode=0
M$354 \$522 \$431 \$499 VSS sg13_lv_nmos L=0.13u W=0.42u AS=0.0378p AD=0.1428p
+ PS=0.6u PD=1.52u rfmode=0
M$355 \$559 \$557 VSS VSS sg13_lv_nmos L=0.13u W=0.74u AS=0.2516p AD=0.1406p
+ PS=2.16u PD=1.12u rfmode=0
M$356 VSS \$559 \$560 VSS sg13_lv_nmos L=0.13u W=0.74u AS=0.1406p AD=0.2516p
+ PS=1.12u PD=2.16u rfmode=0
M$357 \$351 \$561 VSS VSS sg13_lv_nmos L=0.13u W=0.74u AS=0.2516p AD=0.1426p
+ PS=2.16u PD=1.16u rfmode=0
M$358 VSS \$562 \$561 VSS sg13_lv_nmos L=0.5u W=0.42u AS=0.1426p AD=0.1428p
+ PS=1.16u PD=1.52u rfmode=0
M$359 \$562 \$563 VSS VSS sg13_lv_nmos L=0.5u W=0.42u AS=0.1428p AD=0.0798p
+ PS=1.52u PD=0.8u rfmode=0
M$360 VSS \$560 \$563 VSS sg13_lv_nmos L=0.13u W=0.42u AS=0.0798p AD=0.1428p
+ PS=0.8u PD=1.52u rfmode=0
M$361 \$508 \$437 VSS VSS sg13_lv_nmos L=0.13u W=0.42u AS=0.1428p AD=0.0798p
+ PS=1.52u PD=0.8u rfmode=0
M$362 VSS \$433 \$523 VSS sg13_lv_nmos L=0.13u W=0.42u AS=0.0798p AD=0.0378p
+ PS=0.8u PD=0.6u rfmode=0
M$363 \$523 \$436 \$437 VSS sg13_lv_nmos L=0.13u W=0.42u AS=0.0378p AD=0.1428p
+ PS=0.6u PD=1.52u rfmode=0
M$364 VSS \$564 \$565 VSS sg13_lv_nmos L=0.13u W=11.84u AS=2.3606p AD=2.2496p
+ PS=18.96u PD=17.92u rfmode=0
M$380 VSS \$675 \$564 VSS sg13_lv_nmos L=0.13u W=4.44u AS=0.8436p AD=0.9546p
+ PS=6.72u PD=7.76u rfmode=0
M$386 \$439 \$604 VSS VSS sg13_lv_nmos L=0.13u W=0.42u AS=0.1428p AD=0.0798p
+ PS=1.52u PD=0.8u rfmode=0
M$387 VSS \$439 \$440 VSS sg13_lv_nmos L=0.5u W=0.42u AS=0.0798p AD=0.1428p
+ PS=0.8u PD=1.52u rfmode=0
M$388 VSS \$447 \$446 VSS sg13_lv_nmos L=0.13u W=0.74u AS=0.1626p AD=0.2516p
+ PS=1.415u PD=2.16u rfmode=0
M$389 \$445 \$509 \$525 VSS sg13_lv_nmos L=0.13u W=0.42u AS=0.1428p AD=0.0609p
+ PS=1.52u PD=0.71u rfmode=0
M$390 VSS \$500 \$525 VSS sg13_lv_nmos L=0.13u W=0.42u AS=0.1626p AD=0.0609p
+ PS=1.415u PD=0.71u rfmode=0
M$391 VSS \$500 \$526 VSS sg13_lv_nmos L=0.13u W=0.42u AS=0.1701p AD=0.0378p
+ PS=1.65u PD=0.6u rfmode=0
M$392 \$526 \$446 \$501 VSS sg13_lv_nmos L=0.13u W=0.42u AS=0.0378p AD=0.1428p
+ PS=0.6u PD=1.52u rfmode=0
M$393 \$566 \$567 VSS VSS sg13_lv_nmos L=0.13u W=0.74u AS=0.2516p AD=0.1426p
+ PS=2.16u PD=1.16u rfmode=0
M$394 VSS \$568 \$567 VSS sg13_lv_nmos L=0.5u W=0.42u AS=0.1426p AD=0.1428p
+ PS=1.16u PD=1.52u rfmode=0
M$395 \$568 \$569 VSS VSS sg13_lv_nmos L=0.5u W=0.42u AS=0.1428p AD=0.0798p
+ PS=1.52u PD=0.8u rfmode=0
M$396 VSS \$453 \$569 VSS sg13_lv_nmos L=0.13u W=0.42u AS=0.0798p AD=0.1428p
+ PS=0.8u PD=1.52u rfmode=0
M$397 VSS \$565 \$570 VSS sg13_lv_nmos L=0.13u W=4.44u AS=0.9546p AD=0.8436p
+ PS=7.76u PD=6.72u rfmode=0
M$403 VSS \$570 \$369 VSS sg13_lv_nmos L=0.13u W=11.84u AS=2.2496p AD=2.3606p
+ PS=17.92u PD=18.96u rfmode=0
M$419 \$510 \$451 VSS VSS sg13_lv_nmos L=0.13u W=0.42u AS=0.1428p AD=0.0798p
+ PS=1.52u PD=0.8u rfmode=0
M$420 VSS \$500 \$528 VSS sg13_lv_nmos L=0.13u W=0.42u AS=0.0798p AD=0.0378p
+ PS=0.8u PD=0.6u rfmode=0
M$421 \$528 \$450 \$451 VSS sg13_lv_nmos L=0.13u W=0.42u AS=0.0378p AD=0.1428p
+ PS=0.6u PD=1.52u rfmode=0
M$422 VSS \$459 \$458 VSS sg13_lv_nmos L=0.13u W=0.74u AS=0.1626p AD=0.2516p
+ PS=1.415u PD=2.16u rfmode=0
M$423 \$457 \$455 \$531 VSS sg13_lv_nmos L=0.13u W=0.42u AS=0.1428p AD=0.0609p
+ PS=1.52u PD=0.71u rfmode=0
M$424 VSS \$502 \$531 VSS sg13_lv_nmos L=0.13u W=0.42u AS=0.1626p AD=0.0609p
+ PS=1.415u PD=0.71u rfmode=0
M$425 VSS \$502 \$532 VSS sg13_lv_nmos L=0.13u W=0.42u AS=0.1701p AD=0.0378p
+ PS=1.65u PD=0.6u rfmode=0
M$426 \$532 \$458 \$503 VSS sg13_lv_nmos L=0.13u W=0.42u AS=0.0378p AD=0.1428p
+ PS=0.6u PD=1.52u rfmode=0
M$427 \$349 \$571 \$579 VSS sg13_lv_nmos L=0.13u W=0.74u AS=0.333p AD=0.1406p
+ PS=2.38u PD=1.12u rfmode=0
M$428 \$579 \$310 VSS VSS sg13_lv_nmos L=0.13u W=0.74u AS=0.1406p AD=0.14505p
+ PS=1.12u PD=1.15u rfmode=0
M$429 VSS \$372 \$571 VSS sg13_lv_nmos L=0.13u W=0.55u AS=0.14505p AD=0.187p
+ PS=1.15u PD=1.78u rfmode=0
M$430 \$502 \$340 VSS VSS sg13_lv_nmos L=0.13u W=0.74u AS=0.2516p AD=0.2516p
+ PS=2.16u PD=2.16u rfmode=0
M$431 \$511 \$463 VSS VSS sg13_lv_nmos L=0.13u W=0.42u AS=0.1428p AD=0.0798p
+ PS=1.52u PD=0.8u rfmode=0
M$432 VSS \$502 \$533 VSS sg13_lv_nmos L=0.13u W=0.42u AS=0.0798p AD=0.0378p
+ PS=0.8u PD=0.6u rfmode=0
M$433 \$533 \$462 \$463 VSS sg13_lv_nmos L=0.13u W=0.42u AS=0.0378p AD=0.1428p
+ PS=0.6u PD=1.52u rfmode=0
M$434 VSS \$471 \$470 VSS sg13_lv_nmos L=0.13u W=0.74u AS=0.1626p AD=0.2516p
+ PS=1.415u PD=2.16u rfmode=0
M$435 \$469 \$468 \$537 VSS sg13_lv_nmos L=0.13u W=0.42u AS=0.1428p AD=0.0609p
+ PS=1.52u PD=0.71u rfmode=0
M$436 VSS \$342 \$537 VSS sg13_lv_nmos L=0.13u W=0.42u AS=0.1626p AD=0.0609p
+ PS=1.415u PD=0.71u rfmode=0
M$437 VSS \$342 \$538 VSS sg13_lv_nmos L=0.13u W=0.42u AS=0.1701p AD=0.0378p
+ PS=1.65u PD=0.6u rfmode=0
M$438 \$538 \$470 \$505 VSS sg13_lv_nmos L=0.13u W=0.42u AS=0.0378p AD=0.1428p
+ PS=0.6u PD=1.52u rfmode=0
M$439 \$504 \$572 VSS VSS sg13_lv_nmos L=0.13u W=0.74u AS=0.2886p AD=0.14875p
+ PS=2.26u PD=1.16u rfmode=0
M$440 VSS \$341 \$572 VSS sg13_lv_nmos L=0.13u W=0.55u AS=0.14875p AD=0.187p
+ PS=1.16u PD=1.78u rfmode=0
M$441 \$512 \$475 VSS VSS sg13_lv_nmos L=0.13u W=0.42u AS=0.1428p AD=0.0798p
+ PS=1.52u PD=0.8u rfmode=0
M$442 VSS \$342 \$527 VSS sg13_lv_nmos L=0.13u W=0.42u AS=0.0798p AD=0.0378p
+ PS=0.8u PD=0.6u rfmode=0
M$443 \$527 \$474 \$475 VSS sg13_lv_nmos L=0.13u W=0.42u AS=0.0378p AD=0.1428p
+ PS=0.6u PD=1.52u rfmode=0
M$459 VSS \$539 \$574 VSS sg13_lv_nmos L=0.13u W=0.42u AS=0.1701p AD=0.0378p
+ PS=1.65u PD=0.6u rfmode=0
M$460 \$574 \$542 \$543 VSS sg13_lv_nmos L=0.13u W=0.42u AS=0.0378p AD=0.1428p
+ PS=0.6u PD=1.52u rfmode=0
M$461 \$540 \$544 \$580 VSS sg13_lv_nmos L=0.13u W=0.42u AS=0.1296p AD=0.0798p
+ PS=1.52u PD=0.8u rfmode=0
M$462 \$580 \$581 \$543 VSS sg13_lv_nmos L=0.13u W=0.42u AS=0.0798p AD=0.2373p
+ PS=0.8u PD=1.97u rfmode=0
M$463 VSS \$544 \$581 VSS sg13_lv_nmos L=0.13u W=0.74u AS=0.317325p AD=0.2516p
+ PS=1.805u PD=2.16u rfmode=0
M$464 VSS \$496 \$544 VSS sg13_lv_nmos L=0.13u W=0.74u AS=0.317325p AD=0.2516p
+ PS=1.805u PD=2.16u rfmode=0
M$465 \$546 \$544 \$545 VSS sg13_lv_nmos L=0.13u W=0.42u AS=0.12665p AD=0.1428p
+ PS=1.145u PD=1.52u rfmode=0
M$466 \$542 \$581 \$546 VSS sg13_lv_nmos L=0.13u W=0.74u AS=0.3473p AD=0.12665p
+ PS=2.71u PD=1.145u rfmode=0
M$467 VSS \$582 \$577 VSS sg13_lv_nmos L=0.13u W=0.42u AS=0.1701p AD=0.0378p
+ PS=1.65u PD=0.6u rfmode=0
M$468 \$577 \$553 \$554 VSS sg13_lv_nmos L=0.13u W=0.42u AS=0.0378p AD=0.1428p
+ PS=0.6u PD=1.52u rfmode=0
M$469 \$551 \$555 \$583 VSS sg13_lv_nmos L=0.13u W=0.42u AS=0.1296p AD=0.0798p
+ PS=1.52u PD=0.8u rfmode=0
M$470 \$583 \$584 \$554 VSS sg13_lv_nmos L=0.13u W=0.42u AS=0.0798p AD=0.2373p
+ PS=0.8u PD=1.97u rfmode=0
M$471 VSS \$555 \$584 VSS sg13_lv_nmos L=0.13u W=0.74u AS=0.317325p AD=0.2516p
+ PS=1.805u PD=2.16u rfmode=0
M$472 VSS \$498 \$555 VSS sg13_lv_nmos L=0.13u W=0.74u AS=0.317325p AD=0.2516p
+ PS=1.805u PD=2.16u rfmode=0
M$473 \$557 \$555 \$556 VSS sg13_lv_nmos L=0.13u W=0.42u AS=0.12665p AD=0.1428p
+ PS=1.145u PD=1.52u rfmode=0
M$474 \$553 \$584 \$557 VSS sg13_lv_nmos L=0.13u W=0.74u AS=0.3473p AD=0.12665p
+ PS=2.71u PD=1.145u rfmode=0
M$475 \$610 \$566 \$641 VSS sg13_lv_nmos L=0.13u W=0.64u AS=0.2176p AD=0.1216p
+ PS=1.96u PD=1.02u rfmode=0
M$476 \$641 \$442 VSS VSS sg13_lv_nmos L=0.13u W=0.64u AS=0.1216p AD=0.1331p
+ PS=1.02u PD=1.12u rfmode=0
M$477 VSS \$610 \$509 VSS sg13_lv_nmos L=0.13u W=0.74u AS=0.1331p AD=0.2516p
+ PS=1.12u PD=2.16u rfmode=0
M$478 \$611 \$615 \$612 VSS sg13_lv_nmos L=0.13u W=0.42u AS=0.1296p AD=0.0798p
+ PS=1.52u PD=0.8u rfmode=0
M$479 \$612 \$614 \$630 VSS sg13_lv_nmos L=0.13u W=0.42u AS=0.0798p AD=0.2373p
+ PS=0.8u PD=1.97u rfmode=0
M$508 \$365 \$604 VSS VSS sg13_lv_nmos L=0.13u W=0.77u AS=0.2618p AD=0.1463p
+ PS=2.22u PD=1.15u rfmode=0
M$509 VSS \$389 \$365 VSS sg13_lv_nmos L=0.13u W=0.77u AS=0.1463p AD=0.1694p
+ PS=1.15u PD=1.21u rfmode=0
M$510 \$365 \$566 VSS VSS sg13_lv_nmos L=0.13u W=0.77u AS=0.1694p AD=0.2618p
+ PS=1.21u PD=2.22u rfmode=0
M$511 \$614 \$615 VSS VSS sg13_lv_nmos L=0.13u W=0.74u AS=0.2516p AD=0.317325p
+ PS=2.16u PD=1.805u rfmode=0
M$512 VSS \$369 \$615 VSS sg13_lv_nmos L=0.13u W=0.74u AS=0.317325p AD=0.2516p
+ PS=1.805u PD=2.16u rfmode=0
M$513 \$631 \$615 \$616 VSS sg13_lv_nmos L=0.13u W=0.42u AS=0.1428p AD=0.12665p
+ PS=1.52u PD=1.145u rfmode=0
M$514 \$616 \$614 \$613 VSS sg13_lv_nmos L=0.13u W=0.74u AS=0.12665p AD=0.3473p
+ PS=1.145u PD=2.71u rfmode=0
M$515 VSS \$314 \$598 VSS sg13_lv_nmos L=0.13u W=4.44u AS=0.9546p AD=0.8436p
+ PS=7.76u PD=6.72u rfmode=0
M$521 VSS \$598 \$599 VSS sg13_lv_nmos L=0.13u W=11.84u AS=2.2496p AD=2.3606p
+ PS=17.92u PD=18.96u rfmode=0
M$537 VSS \$602 \$601 VSS sg13_lv_nmos L=0.13u W=0.55u AS=0.18945p AD=0.187p
+ PS=1.27u PD=1.78u rfmode=0
M$538 \$600 \$628 VSS VSS sg13_lv_nmos L=0.13u W=0.74u AS=0.4033p AD=0.148p
+ PS=2.57u PD=1.14u rfmode=0
M$539 VSS \$601 \$646 VSS sg13_lv_nmos L=0.13u W=0.74u AS=0.148p AD=0.3367p
+ PS=1.14u PD=1.65u rfmode=0
M$540 \$646 \$710 \$628 VSS sg13_lv_nmos L=0.13u W=0.74u AS=0.3367p AD=0.1628p
+ PS=1.65u PD=1.18u rfmode=0
M$541 \$628 \$349 \$648 VSS sg13_lv_nmos L=0.13u W=0.74u AS=0.1628p AD=0.13135p
+ PS=1.18u PD=1.095u rfmode=0
M$542 \$648 \$602 VSS VSS sg13_lv_nmos L=0.13u W=0.74u AS=0.13135p AD=0.18945p
+ PS=1.095u PD=1.27u rfmode=0
M$543 VSS \$409 \$582 VSS sg13_lv_nmos L=0.13u W=0.74u AS=0.2516p AD=0.2516p
+ PS=2.16u PD=2.16u rfmode=0
M$544 VSS \$603 \$498 VSS sg13_lv_nmos L=0.13u W=11.84u AS=2.3606p AD=2.2496p
+ PS=18.96u PD=17.92u rfmode=0
M$560 VSS \$565 \$603 VSS sg13_lv_nmos L=0.13u W=4.44u AS=0.8436p AD=0.9546p
+ PS=6.72u PD=7.76u rfmode=0
M$566 VSS \$358 \$649 VSS sg13_lv_nmos L=0.13u W=0.74u AS=0.2516p AD=0.1406p
+ PS=2.16u PD=1.12u rfmode=0
M$567 \$649 \$351 \$647 VSS sg13_lv_nmos L=0.13u W=0.74u AS=0.1406p AD=0.1406p
+ PS=1.12u PD=1.12u rfmode=0
M$568 \$647 \$355 \$645 VSS sg13_lv_nmos L=0.13u W=0.74u AS=0.1406p AD=0.1406p
+ PS=1.12u PD=1.12u rfmode=0
M$569 \$645 \$352 \$604 VSS sg13_lv_nmos L=0.13u W=0.74u AS=0.1406p AD=0.2516p
+ PS=1.12u PD=2.16u rfmode=0
M$570 \$605 \$352 \$644 VSS sg13_lv_nmos L=0.13u W=0.74u AS=0.2516p AD=0.1406p
+ PS=2.16u PD=1.12u rfmode=0
M$571 \$644 \$389 VSS VSS sg13_lv_nmos L=0.13u W=0.74u AS=0.1406p AD=0.2516p
+ PS=1.12u PD=2.16u rfmode=0
M$572 \$606 \$666 VSS VSS sg13_lv_nmos L=0.13u W=0.55u AS=0.187p AD=0.18575p
+ PS=1.78u PD=1.26u rfmode=0
M$573 VSS \$352 \$642 VSS sg13_lv_nmos L=0.13u W=0.74u AS=0.18575p AD=0.1406p
+ PS=1.26u PD=1.12u rfmode=0
M$574 \$642 \$608 \$643 VSS sg13_lv_nmos L=0.13u W=0.74u AS=0.1406p AD=0.1406p
+ PS=1.12u PD=1.12u rfmode=0
M$575 \$643 \$606 \$607 VSS sg13_lv_nmos L=0.13u W=0.74u AS=0.1406p AD=0.3404p
+ PS=1.12u PD=2.4u rfmode=0
M$576 VSS \$629 \$500 VSS sg13_lv_nmos L=0.13u W=0.74u AS=0.2516p AD=0.2516p
+ PS=2.16u PD=2.16u rfmode=0
M$577 VSS \$340 \$621 VSS sg13_lv_nmos L=0.13u W=0.74u AS=0.2516p AD=0.2516p
+ PS=2.16u PD=2.16u rfmode=0
M$580 \$33 \$650 VSS VSS sg13_lv_nmos L=0.13u W=0.74u AS=0.2886p AD=0.14875p
+ PS=2.26u PD=1.16u rfmode=0
M$581 VSS \$710 \$650 VSS sg13_lv_nmos L=0.13u W=0.55u AS=0.14875p AD=0.187p
+ PS=1.16u PD=1.78u rfmode=0
M$594 \$654 \$600 \$699 VSS sg13_lv_nmos L=0.13u W=0.42u AS=0.1428p AD=0.0609p
+ PS=1.52u PD=0.71u rfmode=0
M$595 \$699 \$653 VSS VSS sg13_lv_nmos L=0.13u W=0.42u AS=0.0609p AD=0.1626p
+ PS=0.71u PD=1.415u rfmode=0
M$596 VSS \$711 \$655 VSS sg13_lv_nmos L=0.13u W=0.74u AS=0.1626p AD=0.2516p
+ PS=1.415u PD=2.16u rfmode=0
M$598 \$658 \$660 VSS VSS sg13_lv_nmos L=0.13u W=0.42u AS=0.1428p AD=0.0798p
+ PS=1.52u PD=0.8u rfmode=0
M$599 VSS \$653 \$701 VSS sg13_lv_nmos L=0.13u W=0.42u AS=0.0798p AD=0.0378p
+ PS=0.8u PD=0.6u rfmode=0
M$600 \$701 \$659 \$660 VSS sg13_lv_nmos L=0.13u W=0.42u AS=0.0378p AD=0.1428p
+ PS=0.6u PD=1.52u rfmode=0
M$601 \$661 \$659 VSS VSS sg13_lv_nmos L=0.13u W=0.74u AS=0.2516p AD=0.1406p
+ PS=2.16u PD=1.12u rfmode=0
M$602 VSS \$661 \$710 VSS sg13_lv_nmos L=0.13u W=0.74u AS=0.1406p AD=0.2516p
+ PS=1.12u PD=2.16u rfmode=0
M$603 \$667 \$668 VSS VSS sg13_lv_nmos L=0.13u W=0.74u AS=0.2886p AD=0.14875p
+ PS=2.26u PD=1.16u rfmode=0
M$604 VSS \$325 \$668 VSS sg13_lv_nmos L=0.13u W=0.55u AS=0.14875p AD=0.187p
+ PS=1.16u PD=1.78u rfmode=0
M$605 VSS \$667 \$669 VSS sg13_lv_nmos L=0.13u W=0.55u AS=0.14875p AD=0.187p
+ PS=1.16u PD=1.78u rfmode=0
M$606 VSS \$669 \$629 VSS sg13_lv_nmos L=0.13u W=0.74u AS=0.14875p AD=0.2886p
+ PS=1.16u PD=2.26u rfmode=0
M$607 \$672 \$389 VSS VSS sg13_lv_nmos L=0.15u W=0.74u AS=0.2516p AD=0.1406p
+ PS=2.16u PD=1.12u rfmode=0
M$608 VSS \$665 \$672 VSS sg13_lv_nmos L=0.15u W=0.74u AS=0.1406p AD=0.1406p
+ PS=1.12u PD=1.12u rfmode=0
M$609 \$672 \$352 \$673 VSS sg13_lv_nmos L=0.15u W=0.74u AS=0.1406p AD=0.2516p
+ PS=1.12u PD=2.16u rfmode=0
M$610 VSS \$612 \$613 VSS sg13_lv_nmos L=0.13u W=0.74u AS=0.1626p AD=0.2516p
+ PS=1.415u PD=2.16u rfmode=0
M$611 \$611 \$443 \$640 VSS sg13_lv_nmos L=0.13u W=0.42u AS=0.1428p AD=0.0609p
+ PS=1.52u PD=0.71u rfmode=0
M$612 VSS \$609 \$640 VSS sg13_lv_nmos L=0.13u W=0.42u AS=0.1626p AD=0.0609p
+ PS=1.415u PD=0.71u rfmode=0
M$613 VSS \$609 \$639 VSS sg13_lv_nmos L=0.13u W=0.42u AS=0.1701p AD=0.0378p
+ PS=1.65u PD=0.6u rfmode=0
M$614 \$639 \$613 \$630 VSS sg13_lv_nmos L=0.13u W=0.42u AS=0.0378p AD=0.1428p
+ PS=0.6u PD=1.52u rfmode=0
M$615 fdac_clk \$677 VSS VSS sg13_lv_nmos L=0.13u W=0.74u AS=0.2886p
+ AD=0.14875p PS=2.26u PD=1.16u rfmode=0
M$616 VSS \$336 \$677 VSS sg13_lv_nmos L=0.13u W=0.55u AS=0.14875p AD=0.187p
+ PS=1.16u PD=1.78u rfmode=0
M$617 \$631 \$617 VSS VSS sg13_lv_nmos L=0.13u W=0.42u AS=0.1428p AD=0.0798p
+ PS=1.52u PD=0.8u rfmode=0
M$618 VSS \$609 \$638 VSS sg13_lv_nmos L=0.13u W=0.42u AS=0.0798p AD=0.0378p
+ PS=0.8u PD=0.6u rfmode=0
M$619 \$638 \$616 \$617 VSS sg13_lv_nmos L=0.13u W=0.42u AS=0.0378p AD=0.1428p
+ PS=0.6u PD=1.52u rfmode=0
M$620 \$618 \$616 VSS VSS sg13_lv_nmos L=0.13u W=0.74u AS=0.2516p AD=0.1406p
+ PS=2.16u PD=1.12u rfmode=0
M$621 VSS \$618 \$608 VSS sg13_lv_nmos L=0.13u W=0.74u AS=0.1406p AD=0.2516p
+ PS=1.12u PD=2.16u rfmode=0
M$624 VSS \$619 \$620 VSS sg13_lv_nmos L=0.13u W=0.55u AS=0.14875p AD=0.187p
+ PS=1.16u PD=1.78u rfmode=0
M$625 \$685 \$620 VSS VSS sg13_lv_nmos L=0.13u W=0.74u AS=0.2886p AD=0.14875p
+ PS=2.26u PD=1.16u rfmode=0
M$626 \$688 \$687 \$708 VSS sg13_lv_nmos L=0.13u W=0.42u AS=0.1428p AD=0.0609p
+ PS=1.52u PD=0.71u rfmode=0
M$627 \$708 \$621 VSS VSS sg13_lv_nmos L=0.13u W=0.42u AS=0.0609p AD=0.1626p
+ PS=0.71u PD=1.415u rfmode=0
M$628 VSS \$715 \$689 VSS sg13_lv_nmos L=0.13u W=0.74u AS=0.1626p AD=0.2516p
+ PS=1.415u PD=2.16u rfmode=0
M$633 \$692 \$694 VSS VSS sg13_lv_nmos L=0.13u W=0.42u AS=0.1428p AD=0.0798p
+ PS=1.52u PD=0.8u rfmode=0
M$634 VSS \$621 \$705 VSS sg13_lv_nmos L=0.13u W=0.42u AS=0.0798p AD=0.0378p
+ PS=0.8u PD=0.6u rfmode=0
M$635 \$705 \$693 \$694 VSS sg13_lv_nmos L=0.13u W=0.42u AS=0.0378p AD=0.1428p
+ PS=0.6u PD=1.52u rfmode=0
M$638 \$695 \$693 VSS VSS sg13_lv_nmos L=0.13u W=0.74u AS=0.2516p AD=0.1406p
+ PS=2.16u PD=1.12u rfmode=0
M$639 VSS \$695 \$686 VSS sg13_lv_nmos L=0.13u W=0.74u AS=0.1406p AD=0.2516p
+ PS=1.12u PD=2.16u rfmode=0
M$666 VSS \$686 \$696 VSS sg13_lv_nmos L=0.13u W=0.55u AS=0.14875p AD=0.187p
+ PS=1.16u PD=1.78u rfmode=0
M$667 VSS \$696 \$36 VSS sg13_lv_nmos L=0.13u W=0.74u AS=0.14875p AD=0.2886p
+ PS=1.16u PD=2.26u rfmode=0
M$668 \$541 \$651 VSS VSS sg13_lv_nmos L=0.13u W=0.74u AS=0.4033p AD=0.148p
+ PS=2.57u PD=1.14u rfmode=0
M$669 VSS \$652 \$697 VSS sg13_lv_nmos L=0.13u W=0.74u AS=0.148p AD=0.3367p
+ PS=1.14u PD=1.65u rfmode=0
M$670 \$697 \$406 \$651 VSS sg13_lv_nmos L=0.13u W=0.74u AS=0.3367p AD=0.1628p
+ PS=1.65u PD=1.18u rfmode=0
M$671 \$651 \$349 \$698 VSS sg13_lv_nmos L=0.13u W=0.74u AS=0.1628p AD=0.13135p
+ PS=1.18u PD=1.095u rfmode=0
M$672 \$698 \$924 VSS VSS sg13_lv_nmos L=0.13u W=0.74u AS=0.13135p AD=0.18945p
+ PS=1.095u PD=1.27u rfmode=0
M$673 VSS \$924 \$652 VSS sg13_lv_nmos L=0.13u W=0.55u AS=0.18945p AD=0.187p
+ PS=1.27u PD=1.78u rfmode=0
M$674 VSS \$409 \$653 VSS sg13_lv_nmos L=0.13u W=0.74u AS=0.2516p AD=0.2516p
+ PS=2.16u PD=2.16u rfmode=0
M$675 \$665 \$666 VSS VSS sg13_lv_nmos L=0.13u W=0.74u AS=0.2516p AD=0.2516p
+ PS=2.16u PD=2.16u rfmode=0
M$676 VSS fclk_in \$674 VSS sg13_lv_nmos L=0.13u W=4.44u AS=0.9546p AD=0.8436p
+ PS=7.76u PD=6.72u rfmode=0
M$682 VSS \$674 \$675 VSS sg13_lv_nmos L=0.13u W=11.84u AS=2.2496p AD=2.3606p
+ PS=17.92u PD=18.96u rfmode=0
M$698 VSS \$419 \$678 VSS sg13_lv_nmos L=0.13u W=0.74u AS=0.2516p AD=0.2516p
+ PS=2.16u PD=2.16u rfmode=0
M$699 \$389 \$679 VSS VSS sg13_lv_nmos L=0.13u W=0.74u AS=0.2516p AD=0.2516p
+ PS=2.16u PD=2.16u rfmode=0
M$700 \$679 \$680 VSS VSS sg13_lv_nmos L=0.13u W=0.74u AS=0.2516p AD=0.1426p
+ PS=2.16u PD=1.16u rfmode=0
M$701 VSS \$681 \$680 VSS sg13_lv_nmos L=0.5u W=0.42u AS=0.1426p AD=0.1428p
+ PS=1.16u PD=1.52u rfmode=0
M$702 \$681 \$682 VSS VSS sg13_lv_nmos L=0.5u W=0.42u AS=0.1428p AD=0.0798p
+ PS=1.52u PD=0.8u rfmode=0
M$703 VSS \$608 \$682 VSS sg13_lv_nmos L=0.13u W=0.42u AS=0.0798p AD=0.1428p
+ PS=0.8u PD=1.52u rfmode=0
M$704 VSS \$602 \$683 VSS sg13_lv_nmos L=0.13u W=0.55u AS=0.18945p AD=0.187p
+ PS=1.27u PD=1.78u rfmode=0
M$705 VSS \$602 \$706 VSS sg13_lv_nmos L=0.13u W=0.74u AS=0.18945p AD=0.13135p
+ PS=1.27u PD=1.095u rfmode=0
M$706 \$706 \$685 \$684 VSS sg13_lv_nmos L=0.13u W=0.74u AS=0.13135p AD=0.1628p
+ PS=1.095u PD=1.18u rfmode=0
M$707 \$684 \$686 \$707 VSS sg13_lv_nmos L=0.13u W=0.74u AS=0.1628p AD=0.3367p
+ PS=1.18u PD=1.65u rfmode=0
M$708 \$707 \$683 VSS VSS sg13_lv_nmos L=0.13u W=0.74u AS=0.3367p AD=0.148p
+ PS=1.65u PD=1.14u rfmode=0
M$709 VSS \$684 \$687 VSS sg13_lv_nmos L=0.13u W=0.74u AS=0.148p AD=0.4033p
+ PS=1.14u PD=2.57u rfmode=0
M$725 VSS \$653 \$700 VSS sg13_lv_nmos L=0.13u W=0.42u AS=0.1701p AD=0.0378p
+ PS=1.65u PD=0.6u rfmode=0
M$726 \$700 \$655 \$656 VSS sg13_lv_nmos L=0.13u W=0.42u AS=0.0378p AD=0.1428p
+ PS=0.6u PD=1.52u rfmode=0
M$727 VSS \$657 \$712 VSS sg13_lv_nmos L=0.13u W=0.74u AS=0.317325p AD=0.2516p
+ PS=1.805u PD=2.16u rfmode=0
M$728 VSS \$496 \$657 VSS sg13_lv_nmos L=0.13u W=0.74u AS=0.317325p AD=0.2516p
+ PS=1.805u PD=2.16u rfmode=0
M$729 \$659 \$657 \$658 VSS sg13_lv_nmos L=0.13u W=0.42u AS=0.12665p AD=0.1428p
+ PS=1.145u PD=1.52u rfmode=0
M$730 \$655 \$712 \$659 VSS sg13_lv_nmos L=0.13u W=0.74u AS=0.3473p AD=0.12665p
+ PS=2.71u PD=1.145u rfmode=0
M$731 \$552 \$663 VSS VSS sg13_lv_nmos L=0.13u W=0.74u AS=0.2516p AD=0.1331p
+ PS=2.16u PD=1.12u rfmode=0
M$732 VSS \$662 \$702 VSS sg13_lv_nmos L=0.13u W=0.64u AS=0.1331p AD=0.1216p
+ PS=1.12u PD=1.02u rfmode=0
M$733 \$702 \$317 \$663 VSS sg13_lv_nmos L=0.13u W=0.64u AS=0.1216p AD=0.2176p
+ PS=1.02u PD=1.96u rfmode=0
M$734 \$662 \$664 VSS VSS sg13_lv_nmos L=0.13u W=0.74u AS=0.2351p AD=0.15745p
+ PS=2.16u PD=1.175u rfmode=0
M$735 VSS \$351 \$664 VSS sg13_lv_nmos L=0.13u W=0.64u AS=0.15745p AD=0.1216p
+ PS=1.175u PD=1.02u rfmode=0
M$736 \$664 \$352 \$703 VSS sg13_lv_nmos L=0.13u W=0.64u AS=0.1216p AD=0.0816p
+ PS=1.02u PD=0.895u rfmode=0
M$737 \$703 \$354 VSS VSS sg13_lv_nmos L=0.13u W=0.64u AS=0.0816p AD=0.2176p
+ PS=0.895u PD=1.96u rfmode=0
M$738 \$671 \$670 VSS VSS sg13_lv_nmos L=0.13u W=0.74u AS=0.2351p AD=0.15745p
+ PS=2.16u PD=1.175u rfmode=0
M$739 VSS \$791 \$670 VSS sg13_lv_nmos L=0.13u W=0.64u AS=0.15745p AD=0.1216p
+ PS=1.175u PD=1.02u rfmode=0
M$740 \$670 \$666 \$704 VSS sg13_lv_nmos L=0.13u W=0.64u AS=0.1216p AD=0.0816p
+ PS=1.02u PD=0.895u rfmode=0
M$741 \$704 \$605 VSS VSS sg13_lv_nmos L=0.13u W=0.64u AS=0.0816p AD=0.2176p
+ PS=0.895u PD=1.96u rfmode=0
M$742 VSS \$621 \$709 VSS sg13_lv_nmos L=0.13u W=0.42u AS=0.1701p AD=0.0378p
+ PS=1.65u PD=0.6u rfmode=0
M$743 \$709 \$689 \$690 VSS sg13_lv_nmos L=0.13u W=0.42u AS=0.0378p AD=0.1428p
+ PS=0.6u PD=1.52u rfmode=0
M$744 VSS \$691 \$716 VSS sg13_lv_nmos L=0.13u W=0.74u AS=0.317325p AD=0.2516p
+ PS=1.805u PD=2.16u rfmode=0
M$745 VSS \$504 \$691 VSS sg13_lv_nmos L=0.13u W=0.74u AS=0.317325p AD=0.2516p
+ PS=1.805u PD=2.16u rfmode=0
M$746 \$693 \$691 \$692 VSS sg13_lv_nmos L=0.13u W=0.42u AS=0.12665p AD=0.1428p
+ PS=1.145u PD=1.52u rfmode=0
M$747 \$689 \$716 \$693 VSS sg13_lv_nmos L=0.13u W=0.74u AS=0.3473p AD=0.12665p
+ PS=2.71u PD=1.145u rfmode=0
M$795 \$654 \$657 \$711 VSS sg13_lv_nmos L=0.13u W=0.42u AS=0.1296p AD=0.0798p
+ PS=1.52u PD=0.8u rfmode=0
M$796 \$711 \$712 \$656 VSS sg13_lv_nmos L=0.13u W=0.42u AS=0.0798p AD=0.2373p
+ PS=0.8u PD=1.97u rfmode=0
M$798 VSS \$731 \$729 VSS sg13_lv_nmos L=0.13u W=0.55u AS=0.18945p AD=0.187p
+ PS=1.27u PD=1.78u rfmode=0
M$799 \$728 \$761 VSS VSS sg13_lv_nmos L=0.13u W=0.74u AS=0.4033p AD=0.148p
+ PS=2.57u PD=1.14u rfmode=0
M$800 VSS \$729 \$777 VSS sg13_lv_nmos L=0.13u W=0.74u AS=0.148p AD=0.3367p
+ PS=1.14u PD=1.65u rfmode=0
M$801 \$777 \$730 \$761 VSS sg13_lv_nmos L=0.13u W=0.74u AS=0.3367p AD=0.1628p
+ PS=1.65u PD=1.18u rfmode=0
M$802 \$761 \$349 \$778 VSS sg13_lv_nmos L=0.13u W=0.74u AS=0.1628p AD=0.13135p
+ PS=1.18u PD=1.095u rfmode=0
M$803 \$778 \$731 VSS VSS sg13_lv_nmos L=0.13u W=0.74u AS=0.13135p AD=0.18945p
+ PS=1.095u PD=1.27u rfmode=0
M$808 \$433 \$629 VSS VSS sg13_lv_nmos L=0.13u W=0.74u AS=0.2516p AD=0.2516p
+ PS=2.16u PD=2.16u rfmode=0
M$809 VSS \$667 \$732 VSS sg13_lv_nmos L=0.13u W=0.55u AS=0.14875p AD=0.187p
+ PS=1.16u PD=1.78u rfmode=0
M$810 \$419 \$732 VSS VSS sg13_lv_nmos L=0.13u W=0.74u AS=0.2886p AD=0.14875p
+ PS=2.26u PD=1.16u rfmode=0
M$811 VSS \$734 \$735 VSS sg13_lv_nmos L=0.13u W=0.74u AS=0.1626p AD=0.2516p
+ PS=1.415u PD=2.16u rfmode=0
M$812 \$733 \$671 \$780 VSS sg13_lv_nmos L=0.13u W=0.42u AS=0.1428p AD=0.0609p
+ PS=1.52u PD=0.71u rfmode=0
M$813 VSS \$736 \$780 VSS sg13_lv_nmos L=0.13u W=0.42u AS=0.1626p AD=0.0609p
+ PS=1.415u PD=0.71u rfmode=0
M$814 VSS \$736 \$779 VSS sg13_lv_nmos L=0.13u W=0.42u AS=0.1701p AD=0.0378p
+ PS=1.65u PD=0.6u rfmode=0
M$815 \$779 \$735 \$763 VSS sg13_lv_nmos L=0.13u W=0.42u AS=0.0378p AD=0.1428p
+ PS=0.6u PD=1.52u rfmode=0
M$816 \$733 \$738 \$734 VSS sg13_lv_nmos L=0.13u W=0.42u AS=0.1296p AD=0.0798p
+ PS=1.52u PD=0.8u rfmode=0
M$817 \$734 \$737 \$763 VSS sg13_lv_nmos L=0.13u W=0.42u AS=0.0798p AD=0.2373p
+ PS=0.8u PD=1.97u rfmode=0
M$818 \$737 \$738 VSS VSS sg13_lv_nmos L=0.13u W=0.74u AS=0.2516p AD=0.317325p
+ PS=2.16u PD=1.805u rfmode=0
M$819 VSS \$762 \$738 VSS sg13_lv_nmos L=0.13u W=0.74u AS=0.317325p AD=0.2516p
+ PS=1.805u PD=2.16u rfmode=0
M$820 \$764 \$738 \$739 VSS sg13_lv_nmos L=0.13u W=0.42u AS=0.1428p AD=0.12665p
+ PS=1.52u PD=1.145u rfmode=0
M$821 \$739 \$737 \$735 VSS sg13_lv_nmos L=0.13u W=0.74u AS=0.12665p AD=0.3473p
+ PS=1.145u PD=2.71u rfmode=0
M$822 \$764 \$740 VSS VSS sg13_lv_nmos L=0.13u W=0.42u AS=0.1428p AD=0.0798p
+ PS=1.52u PD=0.8u rfmode=0
M$823 VSS \$736 \$776 VSS sg13_lv_nmos L=0.13u W=0.42u AS=0.0798p AD=0.0378p
+ PS=0.8u PD=0.6u rfmode=0
M$824 \$776 \$739 \$740 VSS sg13_lv_nmos L=0.13u W=0.42u AS=0.0378p AD=0.1428p
+ PS=0.6u PD=1.52u rfmode=0
M$825 \$741 \$739 VSS VSS sg13_lv_nmos L=0.13u W=0.74u AS=0.2516p AD=0.1406p
+ PS=2.16u PD=1.12u rfmode=0
M$826 VSS \$741 \$666 VSS sg13_lv_nmos L=0.13u W=0.74u AS=0.1406p AD=0.2516p
+ PS=1.12u PD=2.16u rfmode=0
M$827 VSS \$629 \$609 VSS sg13_lv_nmos L=0.13u W=0.74u AS=0.2516p AD=0.2516p
+ PS=2.16u PD=2.16u rfmode=0
M$828 VSS \$673 \$775 VSS sg13_lv_nmos L=0.13u W=0.74u AS=0.2516p AD=0.1406p
+ PS=2.16u PD=1.12u rfmode=0
M$829 \$775 \$765 \$742 VSS sg13_lv_nmos L=0.13u W=0.74u AS=0.1406p AD=0.2516p
+ PS=1.12u PD=2.16u rfmode=0
M$830 \$766 \$765 VSS VSS sg13_lv_nmos L=0.15u W=0.74u AS=0.2516p AD=0.1406p
+ PS=2.16u PD=1.12u rfmode=0
M$831 VSS \$794 \$766 VSS sg13_lv_nmos L=0.15u W=0.74u AS=0.1406p AD=0.1406p
+ PS=1.12u PD=1.12u rfmode=0
M$832 \$766 \$742 \$743 VSS sg13_lv_nmos L=0.15u W=0.74u AS=0.1406p AD=0.2516p
+ PS=1.12u PD=2.16u rfmode=0
M$833 VSS \$745 \$746 VSS sg13_lv_nmos L=0.13u W=0.74u AS=0.1626p AD=0.2516p
+ PS=1.415u PD=2.16u rfmode=0
M$834 \$744 \$743 \$774 VSS sg13_lv_nmos L=0.13u W=0.42u AS=0.1428p AD=0.0609p
+ PS=1.52u PD=0.71u rfmode=0
M$835 VSS \$678 \$774 VSS sg13_lv_nmos L=0.13u W=0.42u AS=0.1626p AD=0.0609p
+ PS=1.415u PD=0.71u rfmode=0
M$836 VSS \$678 \$773 VSS sg13_lv_nmos L=0.13u W=0.42u AS=0.1701p AD=0.0378p
+ PS=1.65u PD=0.6u rfmode=0
M$837 \$773 \$746 \$767 VSS sg13_lv_nmos L=0.13u W=0.42u AS=0.0378p AD=0.1428p
+ PS=0.6u PD=1.52u rfmode=0
M$838 \$744 \$748 \$745 VSS sg13_lv_nmos L=0.13u W=0.42u AS=0.1296p AD=0.0798p
+ PS=1.52u PD=0.8u rfmode=0
M$839 \$745 \$747 \$767 VSS sg13_lv_nmos L=0.13u W=0.42u AS=0.0798p AD=0.2373p
+ PS=0.8u PD=1.97u rfmode=0
M$840 \$747 \$748 VSS VSS sg13_lv_nmos L=0.13u W=0.74u AS=0.2516p AD=0.317325p
+ PS=2.16u PD=1.805u rfmode=0
M$841 VSS \$762 \$748 VSS sg13_lv_nmos L=0.13u W=0.74u AS=0.317325p AD=0.2516p
+ PS=1.805u PD=2.16u rfmode=0
M$842 \$768 \$748 \$749 VSS sg13_lv_nmos L=0.13u W=0.42u AS=0.1428p AD=0.12665p
+ PS=1.52u PD=1.145u rfmode=0
M$843 \$749 \$747 \$746 VSS sg13_lv_nmos L=0.13u W=0.74u AS=0.12665p AD=0.3473p
+ PS=1.145u PD=2.71u rfmode=0
M$844 \$768 \$750 VSS VSS sg13_lv_nmos L=0.13u W=0.42u AS=0.1428p AD=0.0798p
+ PS=1.52u PD=0.8u rfmode=0
M$845 VSS \$678 \$772 VSS sg13_lv_nmos L=0.13u W=0.42u AS=0.0798p AD=0.0378p
+ PS=0.8u PD=0.6u rfmode=0
M$846 \$772 \$749 \$750 VSS sg13_lv_nmos L=0.13u W=0.42u AS=0.0378p AD=0.1428p
+ PS=0.6u PD=1.52u rfmode=0
M$847 \$751 \$749 VSS VSS sg13_lv_nmos L=0.13u W=0.74u AS=0.2516p AD=0.1406p
+ PS=2.16u PD=1.12u rfmode=0
M$848 VSS \$751 \$765 VSS sg13_lv_nmos L=0.13u W=0.74u AS=0.1406p AD=0.2516p
+ PS=1.12u PD=2.16u rfmode=0
M$851 VSS \$339 \$752 VSS sg13_lv_nmos L=0.13u W=0.55u AS=0.14875p AD=0.187p
+ PS=1.16u PD=1.78u rfmode=0
M$852 \$619 \$752 VSS VSS sg13_lv_nmos L=0.13u W=0.74u AS=0.2886p AD=0.14875p
+ PS=2.26u PD=1.16u rfmode=0
M$855 \$688 \$691 \$715 VSS sg13_lv_nmos L=0.13u W=0.42u AS=0.1296p AD=0.0798p
+ PS=1.52u PD=0.8u rfmode=0
M$856 \$715 \$716 \$690 VSS sg13_lv_nmos L=0.13u W=0.42u AS=0.0798p AD=0.2373p
+ PS=0.8u PD=1.97u rfmode=0
M$858 VSS \$340 \$753 VSS sg13_lv_nmos L=0.13u W=0.74u AS=0.2516p AD=0.2516p
+ PS=2.16u PD=2.16u rfmode=0
M$909 VSS \$409 \$781 VSS sg13_lv_nmos L=0.13u W=0.74u AS=0.2516p AD=0.2516p
+ PS=2.16u PD=2.16u rfmode=0
M$910 \$782 \$728 \$810 VSS sg13_lv_nmos L=0.13u W=0.42u AS=0.1428p AD=0.0609p
+ PS=1.52u PD=0.71u rfmode=0
M$911 \$810 \$781 VSS VSS sg13_lv_nmos L=0.13u W=0.42u AS=0.0609p AD=0.1626p
+ PS=0.71u PD=1.415u rfmode=0
M$912 VSS \$817 \$783 VSS sg13_lv_nmos L=0.13u W=0.74u AS=0.1626p AD=0.2516p
+ PS=1.415u PD=2.16u rfmode=0
M$913 VSS \$781 \$811 VSS sg13_lv_nmos L=0.13u W=0.42u AS=0.1701p AD=0.0378p
+ PS=1.65u PD=0.6u rfmode=0
M$914 \$811 \$783 \$784 VSS sg13_lv_nmos L=0.13u W=0.42u AS=0.0378p AD=0.1428p
+ PS=0.6u PD=1.52u rfmode=0
M$915 VSS \$785 \$818 VSS sg13_lv_nmos L=0.13u W=0.74u AS=0.317325p AD=0.2516p
+ PS=1.805u PD=2.16u rfmode=0
M$916 VSS \$496 \$785 VSS sg13_lv_nmos L=0.13u W=0.74u AS=0.317325p AD=0.2516p
+ PS=1.805u PD=2.16u rfmode=0
M$917 \$787 \$785 \$786 VSS sg13_lv_nmos L=0.13u W=0.42u AS=0.12665p AD=0.1428p
+ PS=1.145u PD=1.52u rfmode=0
M$918 \$783 \$818 \$787 VSS sg13_lv_nmos L=0.13u W=0.74u AS=0.3473p AD=0.12665p
+ PS=2.71u PD=1.145u rfmode=0
M$919 \$786 \$788 VSS VSS sg13_lv_nmos L=0.13u W=0.42u AS=0.1428p AD=0.0798p
+ PS=1.52u PD=0.8u rfmode=0
M$920 VSS \$781 \$812 VSS sg13_lv_nmos L=0.13u W=0.42u AS=0.0798p AD=0.0378p
+ PS=0.8u PD=0.6u rfmode=0
M$921 \$812 \$787 \$788 VSS sg13_lv_nmos L=0.13u W=0.42u AS=0.0378p AD=0.1428p
+ PS=0.6u PD=1.52u rfmode=0
M$922 \$789 \$787 VSS VSS sg13_lv_nmos L=0.13u W=0.74u AS=0.2516p AD=0.1406p
+ PS=2.16u PD=1.12u rfmode=0
M$923 VSS \$789 \$730 VSS sg13_lv_nmos L=0.13u W=0.74u AS=0.1406p AD=0.2516p
+ PS=1.12u PD=2.16u rfmode=0
M$926 VSS \$419 \$736 VSS sg13_lv_nmos L=0.13u W=0.74u AS=0.2516p AD=0.2516p
+ PS=2.16u PD=2.16u rfmode=0
M$929 VSS \$790 \$791 VSS sg13_lv_nmos L=0.13u W=0.74u AS=0.2516p AD=0.1406p
+ PS=2.16u PD=1.12u rfmode=0
M$930 \$791 \$792 VSS VSS sg13_lv_nmos L=0.13u W=0.74u AS=0.1406p AD=0.2516p
+ PS=1.12u PD=2.16u rfmode=0
M$931 VSS \$851 \$731 VSS sg13_lv_nmos L=0.13u W=0.77u AS=0.2618p AD=0.1694p
+ PS=2.22u PD=1.21u rfmode=0
M$932 \$731 \$792 VSS VSS sg13_lv_nmos L=0.13u W=0.77u AS=0.1694p AD=0.1463p
+ PS=1.21u PD=1.15u rfmode=0
M$933 VSS \$794 \$731 VSS sg13_lv_nmos L=0.13u W=0.77u AS=0.1463p AD=0.2618p
+ PS=1.15u PD=2.22u rfmode=0
M$934 VSS \$794 \$795 VSS sg13_lv_nmos L=0.13u W=0.55u AS=0.187p AD=0.1045p
+ PS=1.78u PD=0.93u rfmode=0
M$935 \$795 \$793 VSS VSS sg13_lv_nmos L=0.13u W=0.55u AS=0.1045p AD=0.1469p
+ PS=0.93u PD=1.155u rfmode=0
M$936 VSS \$795 \$790 VSS sg13_lv_nmos L=0.13u W=0.74u AS=0.1469p AD=0.2516p
+ PS=1.155u PD=2.16u rfmode=0
M$937 VSS \$793 \$796 VSS sg13_lv_nmos L=0.13u W=0.74u AS=0.2516p AD=0.1406p
+ PS=2.16u PD=1.12u rfmode=0
M$938 \$796 \$794 VSS VSS sg13_lv_nmos L=0.13u W=0.74u AS=0.1406p AD=0.2516p
+ PS=1.12u PD=2.16u rfmode=0
M$941 \$794 \$797 VSS VSS sg13_lv_nmos L=0.13u W=0.74u AS=0.2886p AD=0.14875p
+ PS=2.26u PD=1.16u rfmode=0
M$942 VSS \$607 \$797 VSS sg13_lv_nmos L=0.13u W=0.55u AS=0.14875p AD=0.187p
+ PS=1.16u PD=1.78u rfmode=0
M$947 \$762 \$798 VSS VSS sg13_lv_nmos L=0.13u W=0.74u AS=0.2886p AD=0.14875p
+ PS=2.26u PD=1.16u rfmode=0
M$948 VSS \$341 \$798 VSS sg13_lv_nmos L=0.13u W=0.55u AS=0.14875p AD=0.187p
+ PS=1.16u PD=1.78u rfmode=0
M$954 VSS \$731 \$799 VSS sg13_lv_nmos L=0.13u W=0.74u AS=0.2516p AD=0.1406p
+ PS=2.16u PD=1.12u rfmode=0
M$955 \$799 \$800 VSS VSS sg13_lv_nmos L=0.13u W=0.74u AS=0.1406p AD=0.2516p
+ PS=1.12u PD=2.16u rfmode=0
M$956 VSS \$349 \$813 VSS sg13_lv_nmos L=0.13u W=0.74u AS=0.2516p AD=0.1406p
+ PS=2.16u PD=1.12u rfmode=0
M$957 \$813 \$731 \$801 VSS sg13_lv_nmos L=0.13u W=0.74u AS=0.1406p AD=0.1406p
+ PS=1.12u PD=1.12u rfmode=0
M$958 \$801 \$799 VSS VSS sg13_lv_nmos L=0.13u W=0.74u AS=0.1406p AD=0.2516p
+ PS=1.12u PD=2.16u rfmode=0
M$959 \$802 \$801 \$815 VSS sg13_lv_nmos L=0.13u W=0.42u AS=0.1428p AD=0.0609p
+ PS=1.52u PD=0.71u rfmode=0
M$960 \$815 \$753 VSS VSS sg13_lv_nmos L=0.13u W=0.42u AS=0.0609p AD=0.1626p
+ PS=0.71u PD=1.415u rfmode=0
M$961 VSS \$820 \$803 VSS sg13_lv_nmos L=0.13u W=0.74u AS=0.1626p AD=0.2516p
+ PS=1.415u PD=2.16u rfmode=0
M$962 VSS \$753 \$816 VSS sg13_lv_nmos L=0.13u W=0.42u AS=0.1701p AD=0.0378p
+ PS=1.65u PD=0.6u rfmode=0
M$963 \$816 \$803 \$804 VSS sg13_lv_nmos L=0.13u W=0.42u AS=0.0378p AD=0.1428p
+ PS=0.6u PD=1.52u rfmode=0
M$964 VSS \$805 \$821 VSS sg13_lv_nmos L=0.13u W=0.74u AS=0.317325p AD=0.2516p
+ PS=1.805u PD=2.16u rfmode=0
M$965 VSS \$504 \$805 VSS sg13_lv_nmos L=0.13u W=0.74u AS=0.317325p AD=0.2516p
+ PS=1.805u PD=2.16u rfmode=0
M$966 \$807 \$805 \$806 VSS sg13_lv_nmos L=0.13u W=0.42u AS=0.12665p AD=0.1428p
+ PS=1.145u PD=1.52u rfmode=0
M$967 \$803 \$821 \$807 VSS sg13_lv_nmos L=0.13u W=0.74u AS=0.3473p AD=0.12665p
+ PS=2.71u PD=1.145u rfmode=0
M$968 \$806 \$808 VSS VSS sg13_lv_nmos L=0.13u W=0.42u AS=0.1428p AD=0.0798p
+ PS=1.52u PD=0.8u rfmode=0
M$969 VSS \$753 \$814 VSS sg13_lv_nmos L=0.13u W=0.42u AS=0.0798p AD=0.0378p
+ PS=0.8u PD=0.6u rfmode=0
M$970 \$814 \$807 \$808 VSS sg13_lv_nmos L=0.13u W=0.42u AS=0.0378p AD=0.1428p
+ PS=0.6u PD=1.52u rfmode=0
M$971 \$809 \$807 VSS VSS sg13_lv_nmos L=0.13u W=0.74u AS=0.2516p AD=0.1406p
+ PS=2.16u PD=1.12u rfmode=0
M$972 VSS \$809 \$800 VSS sg13_lv_nmos L=0.13u W=0.74u AS=0.1406p AD=0.2516p
+ PS=1.12u PD=2.16u rfmode=0
M$996 VSS \$730 \$836 VSS sg13_lv_nmos L=0.13u W=0.55u AS=0.14875p AD=0.187p
+ PS=1.16u PD=1.78u rfmode=0
M$997 \$32 \$836 VSS VSS sg13_lv_nmos L=0.13u W=0.74u AS=0.2886p AD=0.14875p
+ PS=2.26u PD=1.16u rfmode=0
M$1012 VSS \$837 \$838 VSS sg13_lv_nmos L=0.13u W=0.74u AS=0.2516p AD=0.1406p
+ PS=2.16u PD=1.12u rfmode=0
M$1013 \$838 \$348 \$896 VSS sg13_lv_nmos L=0.13u W=0.74u AS=0.1406p AD=0.1406p
+ PS=1.12u PD=1.12u rfmode=0
M$1014 \$896 \$349 VSS VSS sg13_lv_nmos L=0.13u W=0.74u AS=0.1406p AD=0.2516p
+ PS=1.12u PD=2.16u rfmode=0
M$1023 \$782 \$785 \$817 VSS sg13_lv_nmos L=0.13u W=0.42u AS=0.1296p AD=0.0798p
+ PS=1.52u PD=0.8u rfmode=0
M$1024 \$817 \$818 \$784 VSS sg13_lv_nmos L=0.13u W=0.42u AS=0.0798p AD=0.2373p
+ PS=0.8u PD=1.97u rfmode=0
M$1026 \$840 \$731 VSS VSS sg13_lv_nmos L=0.13u W=0.55u AS=0.187p AD=0.14505p
+ PS=1.78u PD=1.15u rfmode=0
M$1027 VSS \$878 \$903 VSS sg13_lv_nmos L=0.13u W=0.74u AS=0.14505p AD=0.1406p
+ PS=1.15u PD=1.12u rfmode=0
M$1028 \$903 \$840 \$841 VSS sg13_lv_nmos L=0.13u W=0.74u AS=0.1406p AD=0.333p
+ PS=1.12u PD=2.38u rfmode=0
M$1029 VSS \$845 \$906 VSS sg13_lv_nmos L=0.13u W=0.42u AS=0.1701p AD=0.0378p
+ PS=1.65u PD=0.6u rfmode=0
M$1030 \$906 \$844 \$879 VSS sg13_lv_nmos L=0.13u W=0.42u AS=0.0378p AD=0.1428p
+ PS=0.6u PD=1.52u rfmode=0
M$1031 \$842 \$847 \$843 VSS sg13_lv_nmos L=0.13u W=0.42u AS=0.1296p AD=0.0798p
+ PS=1.52u PD=0.8u rfmode=0
M$1032 \$843 \$846 \$879 VSS sg13_lv_nmos L=0.13u W=0.42u AS=0.0798p AD=0.2373p
+ PS=0.8u PD=1.97u rfmode=0
M$1033 \$846 \$847 VSS VSS sg13_lv_nmos L=0.13u W=0.74u AS=0.2516p AD=0.317325p
+ PS=2.16u PD=1.805u rfmode=0
M$1034 VSS \$762 \$847 VSS sg13_lv_nmos L=0.13u W=0.74u AS=0.317325p AD=0.2516p
+ PS=1.805u PD=2.16u rfmode=0
M$1035 \$880 \$847 \$848 VSS sg13_lv_nmos L=0.13u W=0.42u AS=0.1428p
+ AD=0.12665p PS=1.52u PD=1.145u rfmode=0
M$1036 \$848 \$846 \$844 VSS sg13_lv_nmos L=0.13u W=0.74u AS=0.12665p
+ AD=0.3473p PS=1.145u PD=2.71u rfmode=0
M$1037 \$850 \$848 VSS VSS sg13_lv_nmos L=0.13u W=0.74u AS=0.2516p AD=0.1406p
+ PS=2.16u PD=1.12u rfmode=0
M$1038 VSS \$850 \$851 VSS sg13_lv_nmos L=0.13u W=0.74u AS=0.1406p AD=0.2516p
+ PS=1.12u PD=2.16u rfmode=0
M$1039 VSS \$673 \$902 VSS sg13_lv_nmos L=0.13u W=0.74u AS=0.2553p AD=0.13875p
+ PS=2.17u PD=1.115u rfmode=0
M$1040 \$902 \$851 \$878 VSS sg13_lv_nmos L=0.13u W=0.74u AS=0.13875p
+ AD=0.2664p PS=1.115u PD=1.46u rfmode=0
M$1041 \$878 \$792 \$901 VSS sg13_lv_nmos L=0.13u W=0.74u AS=0.2664p AD=0.0962p
+ PS=1.46u PD=1u rfmode=0
M$1042 \$901 \$796 VSS VSS sg13_lv_nmos L=0.13u W=0.74u AS=0.0962p AD=0.2516p
+ PS=1u PD=2.16u rfmode=0
M$1043 \$792 \$881 \$900 VSS sg13_lv_nmos L=0.13u W=0.74u AS=0.2516p AD=0.1406p
+ PS=2.16u PD=1.12u rfmode=0
M$1044 \$900 \$765 VSS VSS sg13_lv_nmos L=0.13u W=0.74u AS=0.1406p AD=0.2516p
+ PS=1.12u PD=2.16u rfmode=0
M$1045 VSS \$881 \$602 VSS sg13_lv_nmos L=0.13u W=0.77u AS=0.2618p AD=0.1694p
+ PS=2.22u PD=1.21u rfmode=0
M$1046 \$602 \$765 VSS VSS sg13_lv_nmos L=0.13u W=0.77u AS=0.1694p AD=0.1463p
+ PS=1.21u PD=1.15u rfmode=0
M$1047 VSS \$790 \$602 VSS sg13_lv_nmos L=0.13u W=0.77u AS=0.1463p AD=0.2618p
+ PS=1.15u PD=2.22u rfmode=0
M$1048 VSS \$673 \$899 VSS sg13_lv_nmos L=0.13u W=0.64u AS=0.2176p AD=0.0816p
+ PS=1.96u PD=0.895u rfmode=0
M$1049 \$899 \$881 \$855 VSS sg13_lv_nmos L=0.13u W=0.64u AS=0.0816p AD=0.1216p
+ PS=0.895u PD=1.02u rfmode=0
M$1050 \$855 \$854 VSS VSS sg13_lv_nmos L=0.13u W=0.64u AS=0.1216p AD=0.15745p
+ PS=1.02u PD=1.175u rfmode=0
M$1051 VSS \$855 \$856 VSS sg13_lv_nmos L=0.13u W=0.74u AS=0.15745p AD=0.2351p
+ PS=1.175u PD=2.16u rfmode=0
M$1052 \$857 \$340 VSS VSS sg13_lv_nmos L=0.13u W=0.74u AS=0.2516p AD=0.2516p
+ PS=2.16u PD=2.16u rfmode=0
M$1053 VSS \$857 \$897 VSS sg13_lv_nmos L=0.13u W=0.42u AS=0.1701p AD=0.0378p
+ PS=1.65u PD=0.6u rfmode=0
M$1054 \$897 \$860 \$882 VSS sg13_lv_nmos L=0.13u W=0.42u AS=0.0378p AD=0.1428p
+ PS=0.6u PD=1.52u rfmode=0
M$1055 \$858 \$862 \$859 VSS sg13_lv_nmos L=0.13u W=0.42u AS=0.1296p AD=0.0798p
+ PS=1.52u PD=0.8u rfmode=0
M$1056 \$859 \$861 \$882 VSS sg13_lv_nmos L=0.13u W=0.42u AS=0.0798p AD=0.2373p
+ PS=0.8u PD=1.97u rfmode=0
M$1057 \$861 \$862 VSS VSS sg13_lv_nmos L=0.13u W=0.74u AS=0.2516p AD=0.317325p
+ PS=2.16u PD=1.805u rfmode=0
M$1058 VSS \$762 \$862 VSS sg13_lv_nmos L=0.13u W=0.74u AS=0.317325p AD=0.2516p
+ PS=1.805u PD=2.16u rfmode=0
M$1059 \$883 \$862 \$863 VSS sg13_lv_nmos L=0.13u W=0.42u AS=0.1428p
+ AD=0.12665p PS=1.52u PD=1.145u rfmode=0
M$1060 \$863 \$861 \$860 VSS sg13_lv_nmos L=0.13u W=0.74u AS=0.12665p
+ AD=0.3473p PS=1.145u PD=2.71u rfmode=0
M$1061 \$865 \$863 VSS VSS sg13_lv_nmos L=0.13u W=0.74u AS=0.2516p AD=0.1406p
+ PS=2.16u PD=1.12u rfmode=0
M$1062 VSS \$865 \$881 VSS sg13_lv_nmos L=0.13u W=0.74u AS=0.1406p AD=0.2516p
+ PS=1.12u PD=2.16u rfmode=0
M$1063 VSS \$884 \$866 VSS sg13_lv_nmos L=0.13u W=0.74u AS=0.2516p AD=0.1406p
+ PS=2.16u PD=1.12u rfmode=0
M$1064 \$866 \$731 VSS VSS sg13_lv_nmos L=0.13u W=0.74u AS=0.1406p AD=0.2516p
+ PS=1.12u PD=2.16u rfmode=0
M$1065 VSS \$866 \$867 VSS sg13_lv_nmos L=0.13u W=0.74u AS=0.2516p AD=0.1406p
+ PS=2.16u PD=1.12u rfmode=0
M$1066 \$867 \$731 \$894 VSS sg13_lv_nmos L=0.13u W=0.74u AS=0.1406p AD=0.1406p
+ PS=1.12u PD=1.12u rfmode=0
M$1067 \$894 \$349 VSS VSS sg13_lv_nmos L=0.13u W=0.74u AS=0.1406p AD=0.2516p
+ PS=1.12u PD=2.16u rfmode=0
M$1072 \$802 \$805 \$820 VSS sg13_lv_nmos L=0.13u W=0.42u AS=0.1296p AD=0.0798p
+ PS=1.52u PD=0.8u rfmode=0
M$1073 \$820 \$821 \$804 VSS sg13_lv_nmos L=0.13u W=0.42u AS=0.0798p AD=0.2373p
+ PS=0.8u PD=1.97u rfmode=0
M$1080 VSS \$885 \$869 VSS sg13_lv_nmos L=0.13u W=0.74u AS=0.2516p AD=0.2516p
+ PS=2.16u PD=2.16u rfmode=0
M$1101 \$870 \$800 VSS VSS sg13_lv_nmos L=0.13u W=0.55u AS=0.187p AD=0.14875p
+ PS=1.78u PD=1.16u rfmode=0
M$1102 VSS \$870 \$37 VSS sg13_lv_nmos L=0.13u W=0.74u AS=0.14875p AD=0.2886p
+ PS=1.16u PD=2.26u rfmode=0
M$1117 VSS \$409 \$907 VSS sg13_lv_nmos L=0.13u W=0.74u AS=0.2516p AD=0.2516p
+ PS=2.16u PD=2.16u rfmode=0
M$1118 \$910 \$838 \$946 VSS sg13_lv_nmos L=0.13u W=0.42u AS=0.1428p AD=0.0609p
+ PS=1.52u PD=0.71u rfmode=0
M$1119 \$946 \$907 VSS VSS sg13_lv_nmos L=0.13u W=0.42u AS=0.0609p AD=0.1626p
+ PS=0.71u PD=1.415u rfmode=0
M$1120 VSS \$961 \$908 VSS sg13_lv_nmos L=0.13u W=0.74u AS=0.1626p AD=0.2516p
+ PS=1.415u PD=2.16u rfmode=0
M$1121 VSS \$907 \$947 VSS sg13_lv_nmos L=0.13u W=0.42u AS=0.1701p AD=0.0378p
+ PS=1.65u PD=0.6u rfmode=0
M$1122 \$947 \$908 \$909 VSS sg13_lv_nmos L=0.13u W=0.42u AS=0.0378p AD=0.1428p
+ PS=0.6u PD=1.52u rfmode=0
M$1123 \$913 \$911 \$912 VSS sg13_lv_nmos L=0.13u W=0.42u AS=0.12665p
+ AD=0.1428p PS=1.145u PD=1.52u rfmode=0
M$1124 \$908 \$962 \$913 VSS sg13_lv_nmos L=0.13u W=0.74u AS=0.3473p
+ AD=0.12665p PS=2.71u PD=1.145u rfmode=0
M$1125 \$912 \$915 VSS VSS sg13_lv_nmos L=0.13u W=0.42u AS=0.1428p AD=0.0798p
+ PS=1.52u PD=0.8u rfmode=0
M$1126 VSS \$907 \$948 VSS sg13_lv_nmos L=0.13u W=0.42u AS=0.0798p AD=0.0378p
+ PS=0.8u PD=0.6u rfmode=0
M$1127 \$948 \$913 \$915 VSS sg13_lv_nmos L=0.13u W=0.42u AS=0.0378p AD=0.1428p
+ PS=0.6u PD=1.52u rfmode=0
M$1128 \$916 \$913 VSS VSS sg13_lv_nmos L=0.13u W=0.74u AS=0.2516p AD=0.1406p
+ PS=2.16u PD=1.12u rfmode=0
M$1129 VSS \$916 \$917 VSS sg13_lv_nmos L=0.13u W=0.74u AS=0.1406p AD=0.2516p
+ PS=1.12u PD=2.16u rfmode=0
M$1133 VSS \$843 \$844 VSS sg13_lv_nmos L=0.13u W=0.74u AS=0.1626p AD=0.2516p
+ PS=1.415u PD=2.16u rfmode=0
M$1134 \$842 \$841 \$905 VSS sg13_lv_nmos L=0.13u W=0.42u AS=0.1428p AD=0.0609p
+ PS=1.52u PD=0.71u rfmode=0
M$1135 VSS \$845 \$905 VSS sg13_lv_nmos L=0.13u W=0.42u AS=0.1626p AD=0.0609p
+ PS=1.415u PD=0.71u rfmode=0
M$1136 VSS \$419 \$845 VSS sg13_lv_nmos L=0.13u W=0.74u AS=0.2516p AD=0.2516p
+ PS=2.16u PD=2.16u rfmode=0
M$1143 \$880 \$849 VSS VSS sg13_lv_nmos L=0.13u W=0.42u AS=0.1428p AD=0.0798p
+ PS=1.52u PD=0.8u rfmode=0
M$1144 VSS \$845 \$904 VSS sg13_lv_nmos L=0.13u W=0.42u AS=0.0798p AD=0.0378p
+ PS=0.8u PD=0.6u rfmode=0
M$1145 \$904 \$848 \$849 VSS sg13_lv_nmos L=0.13u W=0.42u AS=0.0378p AD=0.1428p
+ PS=0.6u PD=1.52u rfmode=0
M$1146 VSS \$793 \$348 VSS sg13_lv_nmos L=0.13u W=0.77u AS=0.2618p AD=0.1694p
+ PS=2.22u PD=1.21u rfmode=0
M$1147 \$348 \$794 VSS VSS sg13_lv_nmos L=0.13u W=0.77u AS=0.1694p AD=0.1463p
+ PS=1.21u PD=1.15u rfmode=0
M$1148 VSS \$920 \$348 VSS sg13_lv_nmos L=0.13u W=0.77u AS=0.1463p AD=0.2618p
+ PS=1.15u PD=2.22u rfmode=0
M$1149 VSS \$851 \$919 VSS sg13_lv_nmos L=0.13u W=0.77u AS=0.2618p AD=0.1694p
+ PS=2.22u PD=1.21u rfmode=0
M$1150 \$919 \$607 VSS VSS sg13_lv_nmos L=0.13u W=0.77u AS=0.1694p AD=0.1463p
+ PS=1.21u PD=1.15u rfmode=0
M$1151 VSS \$920 \$919 VSS sg13_lv_nmos L=0.13u W=0.77u AS=0.1463p AD=0.2618p
+ PS=1.15u PD=2.22u rfmode=0
M$1152 \$920 \$921 \$951 VSS sg13_lv_nmos L=0.13u W=0.74u AS=0.333p AD=0.1406p
+ PS=2.38u PD=1.12u rfmode=0
M$1153 \$951 \$881 VSS VSS sg13_lv_nmos L=0.13u W=0.74u AS=0.1406p AD=0.14505p
+ PS=1.12u PD=1.15u rfmode=0
M$1154 VSS \$765 \$921 VSS sg13_lv_nmos L=0.13u W=0.55u AS=0.14505p AD=0.187p
+ PS=1.15u PD=1.78u rfmode=0
M$1155 VSS \$881 \$923 VSS sg13_lv_nmos L=0.13u W=0.55u AS=0.14505p AD=0.187p
+ PS=1.15u PD=1.78u rfmode=0
M$1156 VSS \$765 \$955 VSS sg13_lv_nmos L=0.13u W=0.74u AS=0.14505p AD=0.1406p
+ PS=1.15u PD=1.12u rfmode=0
M$1157 \$955 \$923 \$922 VSS sg13_lv_nmos L=0.13u W=0.74u AS=0.1406p AD=0.333p
+ PS=1.12u PD=2.38u rfmode=0
M$1158 VSS \$922 \$924 VSS sg13_lv_nmos L=0.13u W=0.74u AS=0.2516p AD=0.1406p
+ PS=2.16u PD=1.12u rfmode=0
M$1159 \$924 \$790 VSS VSS sg13_lv_nmos L=0.13u W=0.74u AS=0.1406p AD=0.2516p
+ PS=1.12u PD=2.16u rfmode=0
M$1162 VSS \$859 \$860 VSS sg13_lv_nmos L=0.13u W=0.74u AS=0.1626p AD=0.2516p
+ PS=1.415u PD=2.16u rfmode=0
M$1163 \$858 \$856 \$898 VSS sg13_lv_nmos L=0.13u W=0.42u AS=0.1428p AD=0.0609p
+ PS=1.52u PD=0.71u rfmode=0
M$1164 VSS \$857 \$898 VSS sg13_lv_nmos L=0.13u W=0.42u AS=0.1626p AD=0.0609p
+ PS=1.415u PD=0.71u rfmode=0
M$1169 \$883 \$864 VSS VSS sg13_lv_nmos L=0.13u W=0.42u AS=0.1428p AD=0.0798p
+ PS=1.52u PD=0.8u rfmode=0
M$1170 VSS \$857 \$895 VSS sg13_lv_nmos L=0.13u W=0.42u AS=0.0798p AD=0.0378p
+ PS=0.8u PD=0.6u rfmode=0
M$1171 \$895 \$863 \$864 VSS sg13_lv_nmos L=0.13u W=0.42u AS=0.0378p AD=0.1428p
+ PS=0.6u PD=1.52u rfmode=0
M$1174 VSS \$340 \$925 VSS sg13_lv_nmos L=0.13u W=0.74u AS=0.2516p AD=0.2516p
+ PS=2.16u PD=2.16u rfmode=0
M$1175 \$928 \$867 \$958 VSS sg13_lv_nmos L=0.13u W=0.42u AS=0.1428p AD=0.0609p
+ PS=1.52u PD=0.71u rfmode=0
M$1176 \$958 \$925 VSS VSS sg13_lv_nmos L=0.13u W=0.42u AS=0.0609p AD=0.1626p
+ PS=0.71u PD=1.415u rfmode=0
M$1177 VSS \$965 \$926 VSS sg13_lv_nmos L=0.13u W=0.74u AS=0.1626p AD=0.2516p
+ PS=1.415u PD=2.16u rfmode=0
M$1178 VSS \$925 \$960 VSS sg13_lv_nmos L=0.13u W=0.42u AS=0.1701p AD=0.0378p
+ PS=1.65u PD=0.6u rfmode=0
M$1179 \$960 \$926 \$927 VSS sg13_lv_nmos L=0.13u W=0.42u AS=0.0378p AD=0.1428p
+ PS=0.6u PD=1.52u rfmode=0
M$1180 \$931 \$929 \$930 VSS sg13_lv_nmos L=0.13u W=0.42u AS=0.12665p
+ AD=0.1428p PS=1.145u PD=1.52u rfmode=0
M$1181 \$926 \$966 \$931 VSS sg13_lv_nmos L=0.13u W=0.74u AS=0.3473p
+ AD=0.12665p PS=2.71u PD=1.145u rfmode=0
M$1182 \$930 \$932 VSS VSS sg13_lv_nmos L=0.13u W=0.42u AS=0.1428p AD=0.0798p
+ PS=1.52u PD=0.8u rfmode=0
M$1183 VSS \$925 \$959 VSS sg13_lv_nmos L=0.13u W=0.42u AS=0.0798p AD=0.0378p
+ PS=0.8u PD=0.6u rfmode=0
M$1184 \$959 \$931 \$932 VSS sg13_lv_nmos L=0.13u W=0.42u AS=0.0378p AD=0.1428p
+ PS=0.6u PD=1.52u rfmode=0
M$1185 \$933 \$931 VSS VSS sg13_lv_nmos L=0.13u W=0.74u AS=0.2516p AD=0.1406p
+ PS=2.16u PD=1.12u rfmode=0
M$1186 VSS \$933 \$884 VSS sg13_lv_nmos L=0.13u W=0.74u AS=0.1406p AD=0.2516p
+ PS=1.12u PD=2.16u rfmode=0
M$1187 VSS \$919 \$934 VSS sg13_lv_nmos L=0.13u W=0.55u AS=0.18945p AD=0.187p
+ PS=1.27u PD=1.78u rfmode=0
M$1188 VSS \$919 \$957 VSS sg13_lv_nmos L=0.13u W=0.74u AS=0.18945p AD=0.13135p
+ PS=1.27u PD=1.095u rfmode=0
M$1189 \$957 \$685 \$935 VSS sg13_lv_nmos L=0.13u W=0.74u AS=0.13135p
+ AD=0.1628p PS=1.095u PD=1.18u rfmode=0
M$1190 \$935 \$936 \$956 VSS sg13_lv_nmos L=0.13u W=0.74u AS=0.1628p AD=0.3367p
+ PS=1.18u PD=1.65u rfmode=0
M$1191 \$956 \$934 VSS VSS sg13_lv_nmos L=0.13u W=0.74u AS=0.3367p AD=0.148p
+ PS=1.65u PD=1.14u rfmode=0
M$1192 VSS \$935 \$937 VSS sg13_lv_nmos L=0.13u W=0.74u AS=0.148p AD=0.4033p
+ PS=1.14u PD=2.57u rfmode=0
M$1193 \$940 \$937 \$954 VSS sg13_lv_nmos L=0.13u W=0.42u AS=0.1428p AD=0.0609p
+ PS=1.52u PD=0.71u rfmode=0
M$1194 \$954 \$869 VSS VSS sg13_lv_nmos L=0.13u W=0.42u AS=0.0609p AD=0.1626p
+ PS=0.71u PD=1.415u rfmode=0
M$1195 VSS \$967 \$938 VSS sg13_lv_nmos L=0.13u W=0.74u AS=0.1626p AD=0.2516p
+ PS=1.415u PD=2.16u rfmode=0
M$1196 VSS \$869 \$952 VSS sg13_lv_nmos L=0.13u W=0.42u AS=0.1701p AD=0.0378p
+ PS=1.65u PD=0.6u rfmode=0
M$1197 \$952 \$938 \$939 VSS sg13_lv_nmos L=0.13u W=0.42u AS=0.0378p AD=0.1428p
+ PS=0.6u PD=1.52u rfmode=0
M$1198 \$943 \$941 \$942 VSS sg13_lv_nmos L=0.13u W=0.42u AS=0.12665p
+ AD=0.1428p PS=1.145u PD=1.52u rfmode=0
M$1199 \$938 \$968 \$943 VSS sg13_lv_nmos L=0.13u W=0.74u AS=0.3473p
+ AD=0.12665p PS=2.71u PD=1.145u rfmode=0
M$1200 \$942 \$944 VSS VSS sg13_lv_nmos L=0.13u W=0.42u AS=0.1428p AD=0.0798p
+ PS=1.52u PD=0.8u rfmode=0
M$1201 VSS \$869 \$950 VSS sg13_lv_nmos L=0.13u W=0.42u AS=0.0798p AD=0.0378p
+ PS=0.8u PD=0.6u rfmode=0
M$1202 \$950 \$943 \$944 VSS sg13_lv_nmos L=0.13u W=0.42u AS=0.0378p AD=0.1428p
+ PS=0.6u PD=1.52u rfmode=0
M$1203 \$945 \$943 VSS VSS sg13_lv_nmos L=0.13u W=0.74u AS=0.2516p AD=0.1406p
+ PS=2.16u PD=1.12u rfmode=0
M$1204 VSS \$945 \$936 VSS sg13_lv_nmos L=0.13u W=0.74u AS=0.1406p AD=0.2516p
+ PS=1.12u PD=2.16u rfmode=0
M$1220 VSS \$991 \$992 VSS sg13_lv_nmos L=0.13u W=0.55u AS=0.14875p AD=0.187p
+ PS=1.16u PD=1.78u rfmode=0
M$1221 \$31 \$992 VSS VSS sg13_lv_nmos L=0.13u W=0.74u AS=0.2886p AD=0.14875p
+ PS=2.26u PD=1.16u rfmode=0
M$1236 VSS \$348 \$837 VSS sg13_lv_nmos L=0.13u W=0.74u AS=0.2516p AD=0.1406p
+ PS=2.16u PD=1.12u rfmode=0
M$1237 \$837 \$917 VSS VSS sg13_lv_nmos L=0.13u W=0.74u AS=0.1406p AD=0.2516p
+ PS=1.12u PD=2.16u rfmode=0
M$1238 \$910 \$911 \$961 VSS sg13_lv_nmos L=0.13u W=0.42u AS=0.1296p AD=0.0798p
+ PS=1.52u PD=0.8u rfmode=0
M$1239 \$961 \$962 \$909 VSS sg13_lv_nmos L=0.13u W=0.42u AS=0.0798p AD=0.2373p
+ PS=0.8u PD=1.97u rfmode=0
M$1242 VSS \$911 \$962 VSS sg13_lv_nmos L=0.13u W=0.74u AS=0.317325p AD=0.2516p
+ PS=1.805u PD=2.16u rfmode=0
M$1243 VSS \$496 \$911 VSS sg13_lv_nmos L=0.13u W=0.74u AS=0.317325p AD=0.2516p
+ PS=1.805u PD=2.16u rfmode=0
M$1244 \$993 \$419 VSS VSS sg13_lv_nmos L=0.13u W=0.74u AS=0.2516p AD=0.2516p
+ PS=2.16u PD=2.16u rfmode=0
M$1245 \$994 \$998 \$995 VSS sg13_lv_nmos L=0.13u W=0.42u AS=0.1296p AD=0.0798p
+ PS=1.52u PD=0.8u rfmode=0
M$1246 \$995 \$997 \$1031 VSS sg13_lv_nmos L=0.13u W=0.42u AS=0.0798p
+ AD=0.2373p PS=0.8u PD=1.97u rfmode=0
M$1247 \$997 \$998 VSS VSS sg13_lv_nmos L=0.13u W=0.74u AS=0.2516p AD=0.317325p
+ PS=2.16u PD=1.805u rfmode=0
M$1248 VSS \$496 \$998 VSS sg13_lv_nmos L=0.13u W=0.74u AS=0.317325p AD=0.2516p
+ PS=1.805u PD=2.16u rfmode=0
M$1249 \$1032 \$998 \$999 VSS sg13_lv_nmos L=0.13u W=0.42u AS=0.1428p
+ AD=0.12665p PS=1.52u PD=1.145u rfmode=0
M$1250 \$999 \$997 \$996 VSS sg13_lv_nmos L=0.13u W=0.74u AS=0.12665p
+ AD=0.3473p PS=1.145u PD=2.71u rfmode=0
M$1251 VSS \$918 \$914 VSS sg13_lv_nmos L=0.13u W=0.74u AS=0.2516p AD=0.1406p
+ PS=2.16u PD=1.12u rfmode=0
M$1252 \$914 \$619 \$949 VSS sg13_lv_nmos L=0.13u W=0.74u AS=0.1406p AD=0.1406p
+ PS=1.12u PD=1.12u rfmode=0
M$1253 \$949 \$919 VSS VSS sg13_lv_nmos L=0.13u W=0.74u AS=0.1406p AD=0.2516p
+ PS=1.12u PD=2.16u rfmode=0
M$1254 \$1001 \$999 VSS VSS sg13_lv_nmos L=0.13u W=0.74u AS=0.2516p AD=0.1406p
+ PS=2.16u PD=1.12u rfmode=0
M$1255 VSS \$1001 \$991 VSS sg13_lv_nmos L=0.13u W=0.74u AS=0.1406p AD=0.2516p
+ PS=1.12u PD=2.16u rfmode=0
M$1256 VSS \$991 \$918 VSS sg13_lv_nmos L=0.13u W=0.74u AS=0.2516p AD=0.1406p
+ PS=2.16u PD=1.12u rfmode=0
M$1257 \$918 \$919 VSS VSS sg13_lv_nmos L=0.13u W=0.74u AS=0.1406p AD=0.2516p
+ PS=1.12u PD=2.16u rfmode=0
M$1266 \$793 \$851 VSS VSS sg13_lv_nmos L=0.13u W=0.74u AS=0.2516p AD=0.2516p
+ PS=2.16u PD=2.16u rfmode=0
M$1267 VSS \$851 \$1002 VSS sg13_lv_nmos L=0.13u W=0.77u AS=0.2618p AD=0.1694p
+ PS=2.22u PD=1.21u rfmode=0
M$1268 \$1002 \$881 VSS VSS sg13_lv_nmos L=0.13u W=0.77u AS=0.1694p AD=0.1463p
+ PS=1.21u PD=1.15u rfmode=0
M$1269 VSS \$794 \$1002 VSS sg13_lv_nmos L=0.13u W=0.77u AS=0.1463p AD=0.2618p
+ PS=1.15u PD=2.22u rfmode=0
M$1270 VSS \$920 \$953 VSS sg13_lv_nmos L=0.13u W=0.74u AS=0.2516p AD=0.1406p
+ PS=2.16u PD=1.12u rfmode=0
M$1271 \$953 \$922 \$854 VSS sg13_lv_nmos L=0.13u W=0.74u AS=0.1406p AD=0.1406p
+ PS=1.12u PD=1.12u rfmode=0
M$1272 \$854 \$794 VSS VSS sg13_lv_nmos L=0.13u W=0.74u AS=0.1406p AD=0.2516p
+ PS=1.12u PD=2.16u rfmode=0
M$1273 VSS \$851 \$1003 VSS sg13_lv_nmos L=0.13u W=0.77u AS=0.2618p AD=0.1694p
+ PS=2.22u PD=1.21u rfmode=0
M$1274 \$1003 \$794 VSS VSS sg13_lv_nmos L=0.13u W=0.77u AS=0.1694p AD=0.1463p
+ PS=1.21u PD=1.15u rfmode=0
M$1275 VSS \$922 \$1003 VSS sg13_lv_nmos L=0.13u W=0.77u AS=0.1463p AD=0.2618p
+ PS=1.15u PD=2.22u rfmode=0
M$1276 VSS \$922 \$1004 VSS sg13_lv_nmos L=0.13u W=0.74u AS=0.2516p AD=0.1406p
+ PS=2.16u PD=1.12u rfmode=0
M$1277 \$1004 \$619 VSS VSS sg13_lv_nmos L=0.13u W=0.74u AS=0.1406p AD=0.2516p
+ PS=1.12u PD=2.16u rfmode=0
M$1282 VSS \$881 \$1005 VSS sg13_lv_nmos L=0.13u W=0.77u AS=0.2618p AD=0.1694p
+ PS=2.22u PD=1.21u rfmode=0
M$1283 \$1005 \$765 VSS VSS sg13_lv_nmos L=0.13u W=0.77u AS=0.1694p AD=0.1463p
+ PS=1.21u PD=1.15u rfmode=0
M$1284 VSS \$685 \$1005 VSS sg13_lv_nmos L=0.13u W=0.77u AS=0.1463p AD=0.2618p
+ PS=1.15u PD=2.22u rfmode=0
M$1285 \$1033 \$1002 VSS VSS sg13_lv_nmos L=0.15u W=0.74u AS=0.2516p AD=0.1406p
+ PS=2.16u PD=1.12u rfmode=0
M$1286 VSS \$348 \$1033 VSS sg13_lv_nmos L=0.15u W=0.74u AS=0.1406p AD=0.1406p
+ PS=1.12u PD=1.12u rfmode=0
M$1287 \$1033 \$1005 \$1006 VSS sg13_lv_nmos L=0.15u W=0.74u AS=0.1406p
+ AD=0.2516p PS=1.12u PD=2.16u rfmode=0
M$1292 \$928 \$929 \$965 VSS sg13_lv_nmos L=0.13u W=0.42u AS=0.1296p AD=0.0798p
+ PS=1.52u PD=0.8u rfmode=0
M$1293 \$965 \$966 \$927 VSS sg13_lv_nmos L=0.13u W=0.42u AS=0.0798p AD=0.2373p
+ PS=0.8u PD=1.97u rfmode=0
M$1294 VSS \$919 \$1008 VSS sg13_lv_nmos L=0.13u W=0.55u AS=0.18945p AD=0.187p
+ PS=1.27u PD=1.78u rfmode=0
M$1295 \$1007 \$1034 VSS VSS sg13_lv_nmos L=0.13u W=0.74u AS=0.4033p AD=0.148p
+ PS=2.57u PD=1.14u rfmode=0
M$1296 VSS \$1008 \$1048 VSS sg13_lv_nmos L=0.13u W=0.74u AS=0.148p AD=0.3367p
+ PS=1.14u PD=1.65u rfmode=0
M$1297 \$1048 \$1009 \$1034 VSS sg13_lv_nmos L=0.13u W=0.74u AS=0.3367p
+ AD=0.1628p PS=1.65u PD=1.18u rfmode=0
M$1298 \$1034 \$685 \$1049 VSS sg13_lv_nmos L=0.13u W=0.74u AS=0.1628p
+ AD=0.13135p PS=1.18u PD=1.095u rfmode=0
M$1299 \$1049 \$919 VSS VSS sg13_lv_nmos L=0.13u W=0.74u AS=0.13135p
+ AD=0.18945p PS=1.095u PD=1.27u rfmode=0
M$1300 VSS \$929 \$966 VSS sg13_lv_nmos L=0.13u W=0.74u AS=0.317325p AD=0.2516p
+ PS=1.805u PD=2.16u rfmode=0
M$1301 VSS \$504 \$929 VSS sg13_lv_nmos L=0.13u W=0.74u AS=0.317325p AD=0.2516p
+ PS=1.805u PD=2.16u rfmode=0
M$1304 \$1010 \$1003 VSS VSS sg13_lv_nmos L=0.13u W=0.55u AS=0.187p AD=0.18945p
+ PS=1.78u PD=1.27u rfmode=0
M$1305 VSS \$1003 \$1047 VSS sg13_lv_nmos L=0.13u W=0.74u AS=0.18945p
+ AD=0.13135p PS=1.27u PD=1.095u rfmode=0
M$1306 \$1047 \$685 \$1011 VSS sg13_lv_nmos L=0.13u W=0.74u AS=0.13135p
+ AD=0.1628p PS=1.095u PD=1.18u rfmode=0
M$1307 \$1011 \$1035 \$1046 VSS sg13_lv_nmos L=0.13u W=0.74u AS=0.1628p
+ AD=0.3367p PS=1.18u PD=1.65u rfmode=0
M$1308 \$1046 \$1010 VSS VSS sg13_lv_nmos L=0.13u W=0.74u AS=0.3367p AD=0.148p
+ PS=1.65u PD=1.14u rfmode=0
M$1309 VSS \$1011 \$1012 VSS sg13_lv_nmos L=0.13u W=0.74u AS=0.148p AD=0.4033p
+ PS=1.14u PD=2.57u rfmode=0
M$1310 \$1013 \$667 VSS VSS sg13_lv_nmos L=0.13u W=0.55u AS=0.187p AD=0.14875p
+ PS=1.78u PD=1.16u rfmode=0
M$1311 VSS \$1013 \$885 VSS sg13_lv_nmos L=0.13u W=0.74u AS=0.14875p AD=0.2886p
+ PS=1.16u PD=2.26u rfmode=0
M$1312 \$940 \$941 \$967 VSS sg13_lv_nmos L=0.13u W=0.42u AS=0.1296p AD=0.0798p
+ PS=1.52u PD=0.8u rfmode=0
M$1313 \$967 \$968 \$939 VSS sg13_lv_nmos L=0.13u W=0.42u AS=0.0798p AD=0.2373p
+ PS=0.8u PD=1.97u rfmode=0
M$1316 VSS \$941 \$968 VSS sg13_lv_nmos L=0.13u W=0.74u AS=0.317325p AD=0.2516p
+ PS=1.805u PD=2.16u rfmode=0
M$1317 VSS \$504 \$941 VSS sg13_lv_nmos L=0.13u W=0.74u AS=0.317325p AD=0.2516p
+ PS=1.805u PD=2.16u rfmode=0
M$1336 \$1014 \$936 VSS VSS sg13_lv_nmos L=0.13u W=0.55u AS=0.187p AD=0.14875p
+ PS=1.78u PD=1.16u rfmode=0
M$1337 VSS \$1014 \$38 VSS sg13_lv_nmos L=0.13u W=0.74u AS=0.14875p AD=0.2886p
+ PS=1.16u PD=2.26u rfmode=0
M$1358 VSS \$995 \$996 VSS sg13_lv_nmos L=0.13u W=0.74u AS=0.1626p AD=0.2516p
+ PS=1.415u PD=2.16u rfmode=0
M$1359 \$994 \$914 \$1050 VSS sg13_lv_nmos L=0.13u W=0.42u AS=0.1428p
+ AD=0.0609p PS=1.52u PD=0.71u rfmode=0
M$1360 VSS \$993 \$1050 VSS sg13_lv_nmos L=0.13u W=0.42u AS=0.1626p AD=0.0609p
+ PS=1.415u PD=0.71u rfmode=0
M$1361 \$1053 \$1054 \$1109 VSS sg13_lv_nmos L=0.13u W=0.42u AS=0.1428p
+ AD=0.0609p PS=1.52u PD=0.71u rfmode=0
M$1362 \$1109 \$1056 VSS VSS sg13_lv_nmos L=0.13u W=0.42u AS=0.0609p AD=0.1626p
+ PS=0.71u PD=1.415u rfmode=0
M$1363 VSS \$1122 \$1055 VSS sg13_lv_nmos L=0.13u W=0.74u AS=0.1626p AD=0.2516p
+ PS=1.415u PD=2.16u rfmode=0
M$1364 VSS \$993 \$1051 VSS sg13_lv_nmos L=0.13u W=0.42u AS=0.1701p AD=0.0378p
+ PS=1.65u PD=0.6u rfmode=0
M$1365 \$1051 \$996 \$1031 VSS sg13_lv_nmos L=0.13u W=0.42u AS=0.0378p
+ AD=0.1428p PS=0.6u PD=1.52u rfmode=0
M$1366 VSS \$1056 \$1110 VSS sg13_lv_nmos L=0.13u W=0.42u AS=0.1701p AD=0.0378p
+ PS=1.65u PD=0.6u rfmode=0
M$1367 \$1110 \$1055 \$1057 VSS sg13_lv_nmos L=0.13u W=0.42u AS=0.0378p
+ AD=0.1428p PS=0.6u PD=1.52u rfmode=0
M$1368 \$1060 \$1058 \$1059 VSS sg13_lv_nmos L=0.13u W=0.42u AS=0.12665p
+ AD=0.1428p PS=1.145u PD=1.52u rfmode=0
M$1369 \$1055 \$1123 \$1060 VSS sg13_lv_nmos L=0.13u W=0.74u AS=0.3473p
+ AD=0.12665p PS=2.71u PD=1.145u rfmode=0
M$1370 \$1032 \$1000 VSS VSS sg13_lv_nmos L=0.13u W=0.42u AS=0.1428p AD=0.0798p
+ PS=1.52u PD=0.8u rfmode=0
M$1371 VSS \$993 \$1052 VSS sg13_lv_nmos L=0.13u W=0.42u AS=0.0798p AD=0.0378p
+ PS=0.8u PD=0.6u rfmode=0
M$1372 \$1052 \$999 \$1000 VSS sg13_lv_nmos L=0.13u W=0.42u AS=0.0378p
+ AD=0.1428p PS=0.6u PD=1.52u rfmode=0
M$1373 \$1059 \$1061 VSS VSS sg13_lv_nmos L=0.13u W=0.42u AS=0.1428p AD=0.0798p
+ PS=1.52u PD=0.8u rfmode=0
M$1374 VSS \$1056 \$1111 VSS sg13_lv_nmos L=0.13u W=0.42u AS=0.0798p AD=0.0378p
+ PS=0.8u PD=0.6u rfmode=0
M$1375 \$1111 \$1060 \$1061 VSS sg13_lv_nmos L=0.13u W=0.42u AS=0.0378p
+ AD=0.1428p PS=0.6u PD=1.52u rfmode=0
M$1376 \$1062 \$1060 VSS VSS sg13_lv_nmos L=0.13u W=0.74u AS=0.2516p AD=0.1406p
+ PS=2.16u PD=1.12u rfmode=0
M$1377 VSS \$1062 \$1063 VSS sg13_lv_nmos L=0.13u W=0.74u AS=0.1406p AD=0.2516p
+ PS=1.12u PD=2.16u rfmode=0
M$1378 VSS \$409 \$1231 VSS sg13_lv_nmos L=0.13u W=0.74u AS=0.2516p AD=0.2516p
+ PS=2.16u PD=2.16u rfmode=0
M$1383 \$1064 \$1065 VSS VSS sg13_lv_nmos L=0.13u W=0.74u AS=0.4033p AD=0.148p
+ PS=2.57u PD=1.14u rfmode=0
M$1384 VSS \$1067 \$1114 VSS sg13_lv_nmos L=0.13u W=0.74u AS=0.148p AD=0.3367p
+ PS=1.14u PD=1.65u rfmode=0
M$1385 \$1114 \$1066 \$1065 VSS sg13_lv_nmos L=0.13u W=0.74u AS=0.3367p
+ AD=0.1628p PS=1.65u PD=1.18u rfmode=0
M$1386 \$1065 \$619 \$1115 VSS sg13_lv_nmos L=0.13u W=0.74u AS=0.1628p
+ AD=0.13135p PS=1.18u PD=1.095u rfmode=0
M$1387 \$1115 \$602 VSS VSS sg13_lv_nmos L=0.13u W=0.74u AS=0.13135p
+ AD=0.18945p PS=1.095u PD=1.27u rfmode=0
M$1388 VSS \$602 \$1067 VSS sg13_lv_nmos L=0.13u W=0.55u AS=0.18945p AD=0.187p
+ PS=1.27u PD=1.78u rfmode=0
M$1393 VSS \$1068 \$1069 VSS sg13_lv_nmos L=0.13u W=0.74u AS=0.2516p AD=0.2516p
+ PS=2.16u PD=2.16u rfmode=0
M$1394 \$1070 \$1069 VSS VSS sg13_lv_nmos L=0.15u W=0.74u AS=0.2516p AD=0.1406p
+ PS=2.16u PD=1.12u rfmode=0
M$1395 VSS \$1003 \$1070 VSS sg13_lv_nmos L=0.15u W=0.74u AS=0.1406p AD=0.1406p
+ PS=1.12u PD=1.12u rfmode=0
M$1396 \$1070 \$1071 \$1072 VSS sg13_lv_nmos L=0.15u W=0.74u AS=0.1406p
+ AD=0.2516p PS=1.12u PD=2.16u rfmode=0
M$1397 \$1071 \$1004 \$1073 VSS sg13_lv_nmos L=0.15u W=0.74u AS=0.2516p
+ AD=0.1406p PS=2.16u PD=1.12u rfmode=0
M$1398 \$1073 \$348 VSS VSS sg13_lv_nmos L=0.15u W=0.74u AS=0.1406p AD=0.1406p
+ PS=1.12u PD=1.12u rfmode=0
M$1399 VSS \$1002 \$1073 VSS sg13_lv_nmos L=0.15u W=0.74u AS=0.1406p AD=0.2516p
+ PS=1.12u PD=2.16u rfmode=0
M$1403 VSS \$1002 \$1074 VSS sg13_lv_nmos L=0.13u W=0.55u AS=0.17255p AD=0.187p
+ PS=1.25u PD=1.78u rfmode=0
M$1404 VSS \$1074 \$1124 VSS sg13_lv_nmos L=0.13u W=0.74u AS=0.17255p
+ AD=0.1406p PS=1.25u PD=1.12u rfmode=0
M$1405 \$1124 \$765 VSS VSS sg13_lv_nmos L=0.13u W=0.74u AS=0.1406p AD=0.2516p
+ PS=1.12u PD=2.16u rfmode=0
M$1406 \$1075 \$1125 VSS VSS sg13_lv_nmos L=0.15u W=0.74u AS=0.2516p AD=0.1406p
+ PS=2.16u PD=1.12u rfmode=0
M$1407 VSS \$1124 \$1075 VSS sg13_lv_nmos L=0.15u W=0.74u AS=0.1406p AD=0.1406p
+ PS=1.12u PD=1.12u rfmode=0
M$1408 \$1075 \$1006 \$1076 VSS sg13_lv_nmos L=0.15u W=0.74u AS=0.1406p
+ AD=0.2516p PS=1.12u PD=2.16u rfmode=0
M$1409 \$1077 \$340 VSS VSS sg13_lv_nmos L=0.13u W=0.74u AS=0.2516p AD=0.2516p
+ PS=2.16u PD=2.16u rfmode=0
M$1412 VSS \$340 \$1078 VSS sg13_lv_nmos L=0.13u W=0.74u AS=0.2516p AD=0.2516p
+ PS=2.16u PD=2.16u rfmode=0
M$1414 \$1079 \$1007 \$1118 VSS sg13_lv_nmos L=0.13u W=0.42u AS=0.1428p
+ AD=0.0609p PS=1.52u PD=0.71u rfmode=0
M$1415 \$1118 \$1078 VSS VSS sg13_lv_nmos L=0.13u W=0.42u AS=0.0609p AD=0.1626p
+ PS=0.71u PD=1.415u rfmode=0
M$1416 VSS \$1126 \$1080 VSS sg13_lv_nmos L=0.13u W=0.74u AS=0.1626p AD=0.2516p
+ PS=1.415u PD=2.16u rfmode=0
M$1417 VSS \$1078 \$1119 VSS sg13_lv_nmos L=0.13u W=0.42u AS=0.1701p AD=0.0378p
+ PS=1.65u PD=0.6u rfmode=0
M$1418 \$1119 \$1080 \$1081 VSS sg13_lv_nmos L=0.13u W=0.42u AS=0.0378p
+ AD=0.1428p PS=0.6u PD=1.52u rfmode=0
M$1419 \$1084 \$1082 \$1083 VSS sg13_lv_nmos L=0.13u W=0.42u AS=0.12665p
+ AD=0.1428p PS=1.145u PD=1.52u rfmode=0
M$1420 \$1080 \$1127 \$1084 VSS sg13_lv_nmos L=0.13u W=0.74u AS=0.3473p
+ AD=0.12665p PS=2.71u PD=1.145u rfmode=0
M$1421 \$1083 \$1085 VSS VSS sg13_lv_nmos L=0.13u W=0.42u AS=0.1428p AD=0.0798p
+ PS=1.52u PD=0.8u rfmode=0
M$1422 VSS \$1078 \$1121 VSS sg13_lv_nmos L=0.13u W=0.42u AS=0.0798p AD=0.0378p
+ PS=0.8u PD=0.6u rfmode=0
M$1423 \$1121 \$1084 \$1085 VSS sg13_lv_nmos L=0.13u W=0.42u AS=0.0378p
+ AD=0.1428p PS=0.6u PD=1.52u rfmode=0
M$1425 \$1086 \$1084 VSS VSS sg13_lv_nmos L=0.13u W=0.74u AS=0.2516p AD=0.1406p
+ PS=2.16u PD=1.12u rfmode=0
M$1426 VSS \$1086 \$1009 VSS sg13_lv_nmos L=0.13u W=0.74u AS=0.1406p AD=0.2516p
+ PS=1.12u PD=2.16u rfmode=0
M$1427 \$1087 \$885 VSS VSS sg13_lv_nmos L=0.13u W=0.74u AS=0.2516p AD=0.2516p
+ PS=2.16u PD=2.16u rfmode=0
M$1428 VSS \$885 \$1088 VSS sg13_lv_nmos L=0.13u W=0.74u AS=0.2516p AD=0.2516p
+ PS=2.16u PD=2.16u rfmode=0
M$1429 \$1089 \$1012 \$1120 VSS sg13_lv_nmos L=0.13u W=0.42u AS=0.1428p
+ AD=0.0609p PS=1.52u PD=0.71u rfmode=0
M$1430 \$1120 \$1088 VSS VSS sg13_lv_nmos L=0.13u W=0.42u AS=0.0609p AD=0.1626p
+ PS=0.71u PD=1.415u rfmode=0
M$1431 VSS \$1128 \$1090 VSS sg13_lv_nmos L=0.13u W=0.74u AS=0.1626p AD=0.2516p
+ PS=1.415u PD=2.16u rfmode=0
M$1432 VSS \$1088 \$1117 VSS sg13_lv_nmos L=0.13u W=0.42u AS=0.1701p AD=0.0378p
+ PS=1.65u PD=0.6u rfmode=0
M$1433 \$1117 \$1090 \$1091 VSS sg13_lv_nmos L=0.13u W=0.42u AS=0.0378p
+ AD=0.1428p PS=0.6u PD=1.52u rfmode=0
M$1434 \$1095 \$1092 \$1094 VSS sg13_lv_nmos L=0.13u W=0.42u AS=0.12665p
+ AD=0.1428p PS=1.145u PD=1.52u rfmode=0
M$1435 \$1090 \$1129 \$1095 VSS sg13_lv_nmos L=0.13u W=0.74u AS=0.3473p
+ AD=0.12665p PS=2.71u PD=1.145u rfmode=0
M$1436 \$1094 \$1096 VSS VSS sg13_lv_nmos L=0.13u W=0.42u AS=0.1428p AD=0.0798p
+ PS=1.52u PD=0.8u rfmode=0
M$1437 VSS \$1088 \$1116 VSS sg13_lv_nmos L=0.13u W=0.42u AS=0.0798p AD=0.0378p
+ PS=0.8u PD=0.6u rfmode=0
M$1438 \$1116 \$1095 \$1096 VSS sg13_lv_nmos L=0.13u W=0.42u AS=0.0378p
+ AD=0.1428p PS=0.6u PD=1.52u rfmode=0
M$1439 \$1097 \$1095 VSS VSS sg13_lv_nmos L=0.13u W=0.74u AS=0.2516p AD=0.1406p
+ PS=2.16u PD=1.12u rfmode=0
M$1440 VSS \$1097 \$1035 VSS sg13_lv_nmos L=0.13u W=0.74u AS=0.1406p AD=0.2516p
+ PS=1.12u PD=2.16u rfmode=0
M$1442 VSS \$885 \$1098 VSS sg13_lv_nmos L=0.13u W=0.74u AS=0.2516p AD=0.2516p
+ PS=2.16u PD=2.16u rfmode=0
M$1443 \$1099 \$1299 \$1113 VSS sg13_lv_nmos L=0.13u W=0.42u AS=0.1428p
+ AD=0.0609p PS=1.52u PD=0.71u rfmode=0
M$1444 \$1113 \$1098 VSS VSS sg13_lv_nmos L=0.13u W=0.42u AS=0.0609p AD=0.1626p
+ PS=0.71u PD=1.415u rfmode=0
M$1445 VSS \$1130 \$1100 VSS sg13_lv_nmos L=0.13u W=0.74u AS=0.1626p AD=0.2516p
+ PS=1.415u PD=2.16u rfmode=0
M$1446 VSS \$1098 \$1112 VSS sg13_lv_nmos L=0.13u W=0.42u AS=0.1701p AD=0.0378p
+ PS=1.65u PD=0.6u rfmode=0
M$1447 \$1112 \$1100 \$1101 VSS sg13_lv_nmos L=0.13u W=0.42u AS=0.0378p
+ AD=0.1428p PS=0.6u PD=1.52u rfmode=0
M$1448 \$1104 \$1102 \$1103 VSS sg13_lv_nmos L=0.13u W=0.42u AS=0.12665p
+ AD=0.1428p PS=1.145u PD=1.52u rfmode=0
M$1449 \$1100 \$1131 \$1104 VSS sg13_lv_nmos L=0.13u W=0.74u AS=0.3473p
+ AD=0.12665p PS=2.71u PD=1.145u rfmode=0
M$1450 \$1103 \$1105 VSS VSS sg13_lv_nmos L=0.13u W=0.42u AS=0.1428p AD=0.0798p
+ PS=1.52u PD=0.8u rfmode=0
M$1451 VSS \$1098 \$1108 VSS sg13_lv_nmos L=0.13u W=0.42u AS=0.0798p AD=0.0378p
+ PS=0.8u PD=0.6u rfmode=0
M$1452 \$1108 \$1104 \$1105 VSS sg13_lv_nmos L=0.13u W=0.42u AS=0.0378p
+ AD=0.1428p PS=0.6u PD=1.52u rfmode=0
M$1453 \$1106 \$1104 VSS VSS sg13_lv_nmos L=0.13u W=0.74u AS=0.2516p AD=0.1406p
+ PS=2.16u PD=1.12u rfmode=0
M$1454 VSS \$1106 \$1107 VSS sg13_lv_nmos L=0.13u W=0.74u AS=0.1406p AD=0.2516p
+ PS=1.12u PD=2.16u rfmode=0
M$1480 VSS \$419 \$1056 VSS sg13_lv_nmos L=0.13u W=0.74u AS=0.2516p AD=0.2516p
+ PS=2.16u PD=2.16u rfmode=0
M$1481 \$1053 \$1058 \$1122 VSS sg13_lv_nmos L=0.13u W=0.42u AS=0.1296p
+ AD=0.0798p PS=1.52u PD=0.8u rfmode=0
M$1482 \$1122 \$1123 \$1057 VSS sg13_lv_nmos L=0.13u W=0.42u AS=0.0798p
+ AD=0.2373p PS=0.8u PD=1.97u rfmode=0
M$1483 VSS \$924 \$1153 VSS sg13_lv_nmos L=0.13u W=0.55u AS=0.18945p AD=0.187p
+ PS=1.27u PD=1.78u rfmode=0
M$1484 \$1054 \$1230 VSS VSS sg13_lv_nmos L=0.13u W=0.74u AS=0.4033p AD=0.148p
+ PS=2.57u PD=1.14u rfmode=0
M$1485 VSS \$1153 \$1249 VSS sg13_lv_nmos L=0.13u W=0.74u AS=0.148p AD=0.3367p
+ PS=1.14u PD=1.65u rfmode=0
M$1486 \$1249 \$1063 \$1230 VSS sg13_lv_nmos L=0.13u W=0.74u AS=0.3367p
+ AD=0.1628p PS=1.65u PD=1.18u rfmode=0
M$1487 \$1230 \$619 \$1250 VSS sg13_lv_nmos L=0.13u W=0.74u AS=0.1628p
+ AD=0.13135p PS=1.18u PD=1.095u rfmode=0
M$1488 \$1250 \$924 VSS VSS sg13_lv_nmos L=0.13u W=0.74u AS=0.13135p
+ AD=0.18945p PS=1.095u PD=1.27u rfmode=0
M$1489 VSS \$1058 \$1123 VSS sg13_lv_nmos L=0.13u W=0.74u AS=0.317325p
+ AD=0.2516p PS=1.805u PD=2.16u rfmode=0
M$1490 VSS \$496 \$1058 VSS sg13_lv_nmos L=0.13u W=0.74u AS=0.317325p
+ AD=0.2516p PS=1.805u PD=2.16u rfmode=0
M$1491 \$1154 \$1158 \$1156 VSS sg13_lv_nmos L=0.13u W=0.42u AS=0.1296p
+ AD=0.0798p PS=1.52u PD=0.8u rfmode=0
M$1492 \$1156 \$1157 \$1234 VSS sg13_lv_nmos L=0.13u W=0.42u AS=0.0798p
+ AD=0.2373p PS=0.8u PD=1.97u rfmode=0
M$1493 \$1157 \$1158 VSS VSS sg13_lv_nmos L=0.13u W=0.74u AS=0.2516p
+ AD=0.317325p PS=2.16u PD=1.805u rfmode=0
M$1494 VSS \$496 \$1158 VSS sg13_lv_nmos L=0.13u W=0.74u AS=0.317325p
+ AD=0.2516p PS=1.805u PD=2.16u rfmode=0
M$1495 \$1235 \$1158 \$1159 VSS sg13_lv_nmos L=0.13u W=0.42u AS=0.1428p
+ AD=0.12665p PS=1.52u PD=1.145u rfmode=0
M$1496 \$1159 \$1157 \$1155 VSS sg13_lv_nmos L=0.13u W=0.74u AS=0.12665p
+ AD=0.3473p PS=1.145u PD=2.71u rfmode=0
M$1497 \$1161 \$1159 VSS VSS sg13_lv_nmos L=0.13u W=0.74u AS=0.2516p AD=0.1406p
+ PS=2.16u PD=1.12u rfmode=0
M$1498 VSS \$1161 \$1280 VSS sg13_lv_nmos L=0.13u W=0.74u AS=0.1406p AD=0.2516p
+ PS=1.12u PD=2.16u rfmode=0
M$1499 \$1162 \$1167 \$1164 VSS sg13_lv_nmos L=0.13u W=0.42u AS=0.1296p
+ AD=0.0798p PS=1.52u PD=0.8u rfmode=0
M$1500 \$1164 \$1166 \$1236 VSS sg13_lv_nmos L=0.13u W=0.42u AS=0.0798p
+ AD=0.2373p PS=0.8u PD=1.97u rfmode=0
M$1501 \$1166 \$1167 VSS VSS sg13_lv_nmos L=0.13u W=0.74u AS=0.2516p
+ AD=0.317325p PS=2.16u PD=1.805u rfmode=0
M$1502 VSS \$762 \$1167 VSS sg13_lv_nmos L=0.13u W=0.74u AS=0.317325p
+ AD=0.2516p PS=1.805u PD=2.16u rfmode=0
M$1503 \$1237 \$1167 \$1168 VSS sg13_lv_nmos L=0.13u W=0.42u AS=0.1428p
+ AD=0.12665p PS=1.52u PD=1.145u rfmode=0
M$1504 \$1168 \$1166 \$1163 VSS sg13_lv_nmos L=0.13u W=0.74u AS=0.12665p
+ AD=0.3473p PS=1.145u PD=2.71u rfmode=0
M$1505 \$1170 \$1168 VSS VSS sg13_lv_nmos L=0.13u W=0.74u AS=0.2516p AD=0.1406p
+ PS=2.16u PD=1.12u rfmode=0
M$1506 VSS \$1170 \$1066 VSS sg13_lv_nmos L=0.13u W=0.74u AS=0.1406p AD=0.2516p
+ PS=1.12u PD=2.16u rfmode=0
M$1507 \$1171 \$1176 \$1173 VSS sg13_lv_nmos L=0.13u W=0.42u AS=0.1296p
+ AD=0.0798p PS=1.52u PD=0.8u rfmode=0
M$1508 \$1173 \$1175 \$1238 VSS sg13_lv_nmos L=0.13u W=0.42u AS=0.0798p
+ AD=0.2373p PS=0.8u PD=1.97u rfmode=0
M$1509 \$1175 \$1176 VSS VSS sg13_lv_nmos L=0.13u W=0.74u AS=0.2516p
+ AD=0.317325p PS=2.16u PD=1.805u rfmode=0
M$1510 VSS \$762 \$1176 VSS sg13_lv_nmos L=0.13u W=0.74u AS=0.317325p
+ AD=0.2516p PS=1.805u PD=2.16u rfmode=0
M$1511 \$1239 \$1176 \$1177 VSS sg13_lv_nmos L=0.13u W=0.42u AS=0.1428p
+ AD=0.12665p PS=1.52u PD=1.145u rfmode=0
M$1512 \$1177 \$1175 \$1172 VSS sg13_lv_nmos L=0.13u W=0.74u AS=0.12665p
+ AD=0.3473p PS=1.145u PD=2.71u rfmode=0
M$1513 \$1179 \$1177 VSS VSS sg13_lv_nmos L=0.13u W=0.74u AS=0.2516p AD=0.1406p
+ PS=2.16u PD=1.12u rfmode=0
M$1514 VSS \$1179 \$1068 VSS sg13_lv_nmos L=0.13u W=0.74u AS=0.1406p AD=0.2516p
+ PS=1.12u PD=2.16u rfmode=0
M$1515 \$1180 \$1184 \$1182 VSS sg13_lv_nmos L=0.13u W=0.42u AS=0.1296p
+ AD=0.0798p PS=1.52u PD=0.8u rfmode=0
M$1516 \$1182 \$1183 \$1240 VSS sg13_lv_nmos L=0.13u W=0.42u AS=0.0798p
+ AD=0.2373p PS=0.8u PD=1.97u rfmode=0
M$1517 \$1183 \$1184 VSS VSS sg13_lv_nmos L=0.13u W=0.74u AS=0.2516p
+ AD=0.317325p PS=2.16u PD=1.805u rfmode=0
M$1518 VSS \$504 \$1184 VSS sg13_lv_nmos L=0.13u W=0.74u AS=0.317325p
+ AD=0.2516p PS=1.805u PD=2.16u rfmode=0
M$1519 \$1241 \$1184 \$1185 VSS sg13_lv_nmos L=0.13u W=0.42u AS=0.1428p
+ AD=0.12665p PS=1.52u PD=1.145u rfmode=0
M$1520 \$1185 \$1183 \$1181 VSS sg13_lv_nmos L=0.13u W=0.74u AS=0.12665p
+ AD=0.3473p PS=1.145u PD=2.71u rfmode=0
M$1521 \$1187 \$1185 VSS VSS sg13_lv_nmos L=0.13u W=0.74u AS=0.2516p AD=0.1406p
+ PS=2.16u PD=1.12u rfmode=0
M$1522 VSS \$1187 \$1188 VSS sg13_lv_nmos L=0.13u W=0.74u AS=0.1406p AD=0.2516p
+ PS=1.12u PD=2.16u rfmode=0
M$1523 \$1079 \$1082 \$1126 VSS sg13_lv_nmos L=0.13u W=0.42u AS=0.1296p
+ AD=0.0798p PS=1.52u PD=0.8u rfmode=0
M$1524 \$1126 \$1127 \$1081 VSS sg13_lv_nmos L=0.13u W=0.42u AS=0.0798p
+ AD=0.2373p PS=0.8u PD=1.97u rfmode=0
M$1527 VSS \$1082 \$1127 VSS sg13_lv_nmos L=0.13u W=0.74u AS=0.317325p
+ AD=0.2516p PS=1.805u PD=2.16u rfmode=0
M$1528 VSS \$504 \$1082 VSS sg13_lv_nmos L=0.13u W=0.74u AS=0.317325p
+ AD=0.2516p PS=1.805u PD=2.16u rfmode=0
M$1529 \$1189 \$1003 VSS VSS sg13_lv_nmos L=0.13u W=0.55u AS=0.187p AD=0.18945p
+ PS=1.78u PD=1.27u rfmode=0
M$1530 VSS \$1003 \$1266 VSS sg13_lv_nmos L=0.13u W=0.74u AS=0.18945p
+ AD=0.13135p PS=1.27u PD=1.095u rfmode=0
M$1531 \$1266 \$685 \$1190 VSS sg13_lv_nmos L=0.13u W=0.74u AS=0.13135p
+ AD=0.1628p PS=1.095u PD=1.18u rfmode=0
M$1532 \$1190 \$1200 \$1267 VSS sg13_lv_nmos L=0.13u W=0.74u AS=0.1628p
+ AD=0.3367p PS=1.18u PD=1.65u rfmode=0
M$1533 \$1267 \$1189 VSS VSS sg13_lv_nmos L=0.13u W=0.74u AS=0.3367p AD=0.148p
+ PS=1.65u PD=1.14u rfmode=0
M$1534 VSS \$1190 \$1191 VSS sg13_lv_nmos L=0.13u W=0.74u AS=0.148p AD=0.4033p
+ PS=1.14u PD=2.57u rfmode=0
M$1535 \$1192 \$1196 \$1194 VSS sg13_lv_nmos L=0.13u W=0.42u AS=0.1296p
+ AD=0.0798p PS=1.52u PD=0.8u rfmode=0
M$1536 \$1194 \$1195 \$1242 VSS sg13_lv_nmos L=0.13u W=0.42u AS=0.0798p
+ AD=0.2373p PS=0.8u PD=1.97u rfmode=0
M$1537 \$1195 \$1196 VSS VSS sg13_lv_nmos L=0.13u W=0.74u AS=0.2516p
+ AD=0.317325p PS=2.16u PD=1.805u rfmode=0
M$1538 VSS \$1093 \$1196 VSS sg13_lv_nmos L=0.13u W=0.74u AS=0.317325p
+ AD=0.2516p PS=1.805u PD=2.16u rfmode=0
M$1539 \$1243 \$1196 \$1197 VSS sg13_lv_nmos L=0.13u W=0.42u AS=0.1428p
+ AD=0.12665p PS=1.52u PD=1.145u rfmode=0
M$1540 \$1197 \$1195 \$1193 VSS sg13_lv_nmos L=0.13u W=0.74u AS=0.12665p
+ AD=0.3473p PS=1.145u PD=2.71u rfmode=0
M$1541 \$1089 \$1092 \$1128 VSS sg13_lv_nmos L=0.13u W=0.42u AS=0.1296p
+ AD=0.0798p PS=1.52u PD=0.8u rfmode=0
M$1542 \$1128 \$1129 \$1091 VSS sg13_lv_nmos L=0.13u W=0.42u AS=0.0798p
+ AD=0.2373p PS=0.8u PD=1.97u rfmode=0
M$1543 VSS \$1092 \$1129 VSS sg13_lv_nmos L=0.13u W=0.74u AS=0.317325p
+ AD=0.2516p PS=1.805u PD=2.16u rfmode=0
M$1544 VSS \$1093 \$1092 VSS sg13_lv_nmos L=0.13u W=0.74u AS=0.317325p
+ AD=0.2516p PS=1.805u PD=2.16u rfmode=0
M$1545 \$1199 \$1197 VSS VSS sg13_lv_nmos L=0.13u W=0.74u AS=0.2516p AD=0.1406p
+ PS=2.16u PD=1.12u rfmode=0
M$1546 VSS \$1199 \$1200 VSS sg13_lv_nmos L=0.13u W=0.74u AS=0.1406p AD=0.2516p
+ PS=1.12u PD=2.16u rfmode=0
M$1549 \$1201 \$1124 VSS VSS sg13_lv_nmos L=0.13u W=0.55u AS=0.187p AD=0.18945p
+ PS=1.78u PD=1.27u rfmode=0
M$1550 VSS \$1124 \$1274 VSS sg13_lv_nmos L=0.13u W=0.74u AS=0.18945p
+ AD=0.13135p PS=1.27u PD=1.095u rfmode=0
M$1551 \$1274 \$685 \$1202 VSS sg13_lv_nmos L=0.13u W=0.74u AS=0.13135p
+ AD=0.1628p PS=1.095u PD=1.18u rfmode=0
M$1552 \$1202 \$1232 \$1275 VSS sg13_lv_nmos L=0.13u W=0.74u AS=0.1628p
+ AD=0.3367p PS=1.18u PD=1.65u rfmode=0
M$1553 \$1275 \$1201 VSS VSS sg13_lv_nmos L=0.13u W=0.74u AS=0.3367p AD=0.148p
+ PS=1.65u PD=1.14u rfmode=0
M$1554 VSS \$1202 \$1203 VSS sg13_lv_nmos L=0.13u W=0.74u AS=0.148p AD=0.4033p
+ PS=1.14u PD=2.57u rfmode=0
M$1555 \$1099 \$1102 \$1130 VSS sg13_lv_nmos L=0.13u W=0.42u AS=0.1296p
+ AD=0.0798p PS=1.52u PD=0.8u rfmode=0
M$1556 \$1130 \$1131 \$1101 VSS sg13_lv_nmos L=0.13u W=0.42u AS=0.0798p
+ AD=0.2373p PS=0.8u PD=1.97u rfmode=0
M$1557 \$1204 \$1208 \$1206 VSS sg13_lv_nmos L=0.13u W=0.42u AS=0.1296p
+ AD=0.0798p PS=1.52u PD=0.8u rfmode=0
M$1558 \$1206 \$1207 \$1244 VSS sg13_lv_nmos L=0.13u W=0.42u AS=0.0798p
+ AD=0.2373p PS=0.8u PD=1.97u rfmode=0
M$1559 VSS \$1102 \$1131 VSS sg13_lv_nmos L=0.13u W=0.74u AS=0.317325p
+ AD=0.2516p PS=1.805u PD=2.16u rfmode=0
M$1560 VSS \$1093 \$1102 VSS sg13_lv_nmos L=0.13u W=0.74u AS=0.317325p
+ AD=0.2516p PS=1.805u PD=2.16u rfmode=0
M$1561 \$1207 \$1208 VSS VSS sg13_lv_nmos L=0.13u W=0.74u AS=0.2516p
+ AD=0.317325p PS=2.16u PD=1.805u rfmode=0
M$1562 VSS \$1093 \$1208 VSS sg13_lv_nmos L=0.13u W=0.74u AS=0.317325p
+ AD=0.2516p PS=1.805u PD=2.16u rfmode=0
M$1563 \$1245 \$1208 \$1209 VSS sg13_lv_nmos L=0.13u W=0.42u AS=0.1428p
+ AD=0.12665p PS=1.52u PD=1.145u rfmode=0
M$1564 \$1209 \$1207 \$1205 VSS sg13_lv_nmos L=0.13u W=0.74u AS=0.12665p
+ AD=0.3473p PS=1.145u PD=2.71u rfmode=0
M$1565 \$1211 \$1209 VSS VSS sg13_lv_nmos L=0.13u W=0.74u AS=0.2516p AD=0.1406p
+ PS=2.16u PD=1.12u rfmode=0
M$1566 VSS \$1211 \$1232 VSS sg13_lv_nmos L=0.13u W=0.74u AS=0.1406p AD=0.2516p
+ PS=1.12u PD=2.16u rfmode=0
M$1571 \$30 \$1276 VSS VSS sg13_lv_nmos L=0.13u W=0.74u AS=0.2886p AD=0.14875p
+ PS=2.26u PD=1.16u rfmode=0
M$1572 VSS \$1068 \$1276 VSS sg13_lv_nmos L=0.13u W=0.55u AS=0.14875p AD=0.187p
+ PS=1.16u PD=1.78u rfmode=0
M$1573 \$29 \$1277 VSS VSS sg13_lv_nmos L=0.13u W=0.74u AS=0.2886p AD=0.14875p
+ PS=2.26u PD=1.16u rfmode=0
M$1574 VSS \$1188 \$1277 VSS sg13_lv_nmos L=0.13u W=0.55u AS=0.14875p AD=0.187p
+ PS=1.16u PD=1.78u rfmode=0
M$1577 D0 \$1279 VSS VSS sg13_lv_nmos L=0.13u W=0.74u AS=0.2886p AD=0.14875p
+ PS=2.26u PD=1.16u rfmode=0
M$1578 VSS \$1280 \$1279 VSS sg13_lv_nmos L=0.13u W=0.55u AS=0.14875p AD=0.187p
+ PS=1.16u PD=1.78u rfmode=0
M$1589 D1 \$1282 VSS VSS sg13_lv_nmos L=0.13u W=0.74u AS=0.2886p AD=0.14875p
+ PS=2.26u PD=1.16u rfmode=0
M$1590 VSS \$917 \$1282 VSS sg13_lv_nmos L=0.13u W=0.55u AS=0.14875p AD=0.187p
+ PS=1.16u PD=1.78u rfmode=0
M$1601 VSS \$1156 \$1155 VSS sg13_lv_nmos L=0.13u W=0.74u AS=0.1626p AD=0.2516p
+ PS=1.415u PD=2.16u rfmode=0
M$1602 \$1154 \$1285 \$1251 VSS sg13_lv_nmos L=0.13u W=0.42u AS=0.1428p
+ AD=0.0609p PS=1.52u PD=0.71u rfmode=0
M$1603 VSS \$1231 \$1251 VSS sg13_lv_nmos L=0.13u W=0.42u AS=0.1626p AD=0.0609p
+ PS=1.415u PD=0.71u rfmode=0
M$1604 D2 \$1284 VSS VSS sg13_lv_nmos L=0.13u W=0.74u AS=0.2886p AD=0.14875p
+ PS=2.26u PD=1.16u rfmode=0
M$1605 VSS \$1063 \$1284 VSS sg13_lv_nmos L=0.13u W=0.55u AS=0.14875p AD=0.187p
+ PS=1.16u PD=1.78u rfmode=0
M$1606 VSS \$1231 \$1252 VSS sg13_lv_nmos L=0.13u W=0.42u AS=0.1701p AD=0.0378p
+ PS=1.65u PD=0.6u rfmode=0
M$1607 \$1252 \$1155 \$1234 VSS sg13_lv_nmos L=0.13u W=0.42u AS=0.0378p
+ AD=0.1428p PS=0.6u PD=1.52u rfmode=0
M$1608 \$1285 \$1286 VSS VSS sg13_lv_nmos L=0.13u W=0.74u AS=0.4033p AD=0.148p
+ PS=2.57u PD=1.14u rfmode=0
M$1609 VSS \$1287 \$1304 VSS sg13_lv_nmos L=0.13u W=0.74u AS=0.148p AD=0.3367p
+ PS=1.14u PD=1.65u rfmode=0
M$1610 \$1304 \$1280 \$1286 VSS sg13_lv_nmos L=0.13u W=0.74u AS=0.3367p
+ AD=0.1628p PS=1.65u PD=1.18u rfmode=0
M$1611 \$1286 \$619 \$1305 VSS sg13_lv_nmos L=0.13u W=0.74u AS=0.1628p
+ AD=0.13135p PS=1.18u PD=1.095u rfmode=0
M$1612 \$1305 \$791 VSS VSS sg13_lv_nmos L=0.13u W=0.74u AS=0.13135p
+ AD=0.18945p PS=1.095u PD=1.27u rfmode=0
M$1613 VSS \$791 \$1287 VSS sg13_lv_nmos L=0.13u W=0.55u AS=0.18945p AD=0.187p
+ PS=1.27u PD=1.78u rfmode=0
M$1616 \$1235 \$1160 VSS VSS sg13_lv_nmos L=0.13u W=0.42u AS=0.1428p AD=0.0798p
+ PS=1.52u PD=0.8u rfmode=0
M$1617 VSS \$1231 \$1254 VSS sg13_lv_nmos L=0.13u W=0.42u AS=0.0798p AD=0.0378p
+ PS=0.8u PD=0.6u rfmode=0
M$1618 \$1254 \$1159 \$1160 VSS sg13_lv_nmos L=0.13u W=0.42u AS=0.0378p
+ AD=0.1428p PS=0.6u PD=1.52u rfmode=0
M$1620 VSS \$1164 \$1163 VSS sg13_lv_nmos L=0.13u W=0.74u AS=0.1626p AD=0.2516p
+ PS=1.415u PD=2.16u rfmode=0
M$1621 \$1162 \$1064 \$1255 VSS sg13_lv_nmos L=0.13u W=0.42u AS=0.1428p
+ AD=0.0609p PS=1.52u PD=0.71u rfmode=0
M$1622 VSS \$1165 \$1255 VSS sg13_lv_nmos L=0.13u W=0.42u AS=0.1626p AD=0.0609p
+ PS=1.415u PD=0.71u rfmode=0
M$1623 VSS \$419 \$1165 VSS sg13_lv_nmos L=0.13u W=0.74u AS=0.2516p AD=0.2516p
+ PS=2.16u PD=2.16u rfmode=0
M$1624 VSS \$1165 \$1256 VSS sg13_lv_nmos L=0.13u W=0.42u AS=0.1701p AD=0.0378p
+ PS=1.65u PD=0.6u rfmode=0
M$1625 \$1256 \$1163 \$1236 VSS sg13_lv_nmos L=0.13u W=0.42u AS=0.0378p
+ AD=0.1428p PS=0.6u PD=1.52u rfmode=0
M$1629 D3 \$1289 VSS VSS sg13_lv_nmos L=0.13u W=0.74u AS=0.2886p AD=0.14875p
+ PS=2.26u PD=1.16u rfmode=0
M$1630 VSS \$1066 \$1289 VSS sg13_lv_nmos L=0.13u W=0.55u AS=0.14875p AD=0.187p
+ PS=1.16u PD=1.78u rfmode=0
M$1631 \$1237 \$1169 VSS VSS sg13_lv_nmos L=0.13u W=0.42u AS=0.1428p AD=0.0798p
+ PS=1.52u PD=0.8u rfmode=0
M$1632 VSS \$1165 \$1257 VSS sg13_lv_nmos L=0.13u W=0.42u AS=0.0798p AD=0.0378p
+ PS=0.8u PD=0.6u rfmode=0
M$1633 \$1257 \$1168 \$1169 VSS sg13_lv_nmos L=0.13u W=0.42u AS=0.0378p
+ AD=0.1428p PS=0.6u PD=1.52u rfmode=0
M$1636 VSS \$1173 \$1172 VSS sg13_lv_nmos L=0.13u W=0.74u AS=0.1626p AD=0.2516p
+ PS=1.415u PD=2.16u rfmode=0
M$1637 \$1171 \$1072 \$1258 VSS sg13_lv_nmos L=0.13u W=0.42u AS=0.1428p
+ AD=0.0609p PS=1.52u PD=0.71u rfmode=0
M$1638 VSS \$1174 \$1258 VSS sg13_lv_nmos L=0.13u W=0.42u AS=0.1626p AD=0.0609p
+ PS=1.415u PD=0.71u rfmode=0
M$1639 VSS \$419 \$1174 VSS sg13_lv_nmos L=0.13u W=0.74u AS=0.2516p AD=0.2516p
+ PS=2.16u PD=2.16u rfmode=0
M$1640 VSS \$1174 \$1259 VSS sg13_lv_nmos L=0.13u W=0.42u AS=0.1701p AD=0.0378p
+ PS=1.65u PD=0.6u rfmode=0
M$1641 \$1259 \$1172 \$1238 VSS sg13_lv_nmos L=0.13u W=0.42u AS=0.0378p
+ AD=0.1428p PS=0.6u PD=1.52u rfmode=0
M$1646 \$1239 \$1178 VSS VSS sg13_lv_nmos L=0.13u W=0.42u AS=0.1428p AD=0.0798p
+ PS=1.52u PD=0.8u rfmode=0
M$1647 VSS \$1174 \$1260 VSS sg13_lv_nmos L=0.13u W=0.42u AS=0.0798p AD=0.0378p
+ PS=0.8u PD=0.6u rfmode=0
M$1648 \$1260 \$1177 \$1178 VSS sg13_lv_nmos L=0.13u W=0.42u AS=0.0378p
+ AD=0.1428p PS=0.6u PD=1.52u rfmode=0
M$1651 VSS \$1182 \$1181 VSS sg13_lv_nmos L=0.13u W=0.74u AS=0.1626p AD=0.2516p
+ PS=1.415u PD=2.16u rfmode=0
M$1652 \$1180 \$1076 \$1262 VSS sg13_lv_nmos L=0.13u W=0.42u AS=0.1428p
+ AD=0.0609p PS=1.52u PD=0.71u rfmode=0
M$1653 VSS \$1077 \$1262 VSS sg13_lv_nmos L=0.13u W=0.42u AS=0.1626p AD=0.0609p
+ PS=1.415u PD=0.71u rfmode=0
M$1654 VSS \$1188 \$1125 VSS sg13_lv_nmos L=0.13u W=0.74u AS=0.2516p AD=0.2516p
+ PS=2.16u PD=2.16u rfmode=0
M$1655 D4 \$1291 VSS VSS sg13_lv_nmos L=0.13u W=0.74u AS=0.2886p AD=0.14875p
+ PS=2.26u PD=1.16u rfmode=0
M$1656 VSS \$884 \$1291 VSS sg13_lv_nmos L=0.13u W=0.55u AS=0.14875p AD=0.187p
+ PS=1.16u PD=1.78u rfmode=0
M$1657 VSS \$1077 \$1263 VSS sg13_lv_nmos L=0.13u W=0.42u AS=0.1701p AD=0.0378p
+ PS=1.65u PD=0.6u rfmode=0
M$1658 \$1263 \$1181 \$1240 VSS sg13_lv_nmos L=0.13u W=0.42u AS=0.0378p
+ AD=0.1428p PS=0.6u PD=1.52u rfmode=0
M$1663 \$1241 \$1186 VSS VSS sg13_lv_nmos L=0.13u W=0.42u AS=0.1428p AD=0.0798p
+ PS=1.52u PD=0.8u rfmode=0
M$1664 VSS \$1077 \$1264 VSS sg13_lv_nmos L=0.13u W=0.42u AS=0.0798p AD=0.0378p
+ PS=0.8u PD=0.6u rfmode=0
M$1665 \$1264 \$1185 \$1186 VSS sg13_lv_nmos L=0.13u W=0.42u AS=0.0378p
+ AD=0.1428p PS=0.6u PD=1.52u rfmode=0
M$1672 D5 \$1293 VSS VSS sg13_lv_nmos L=0.13u W=0.74u AS=0.2886p AD=0.14875p
+ PS=2.26u PD=1.16u rfmode=0
M$1673 VSS \$1009 \$1293 VSS sg13_lv_nmos L=0.13u W=0.55u AS=0.14875p AD=0.187p
+ PS=1.16u PD=1.78u rfmode=0
M$1674 VSS \$1194 \$1193 VSS sg13_lv_nmos L=0.13u W=0.74u AS=0.1626p AD=0.2516p
+ PS=1.415u PD=2.16u rfmode=0
M$1675 \$1192 \$1191 \$1268 VSS sg13_lv_nmos L=0.13u W=0.42u AS=0.1428p
+ AD=0.0609p PS=1.52u PD=0.71u rfmode=0
M$1676 VSS \$1087 \$1268 VSS sg13_lv_nmos L=0.13u W=0.42u AS=0.1626p AD=0.0609p
+ PS=1.415u PD=0.71u rfmode=0
M$1679 VSS \$1087 \$1269 VSS sg13_lv_nmos L=0.13u W=0.42u AS=0.1701p AD=0.0378p
+ PS=1.65u PD=0.6u rfmode=0
M$1680 \$1269 \$1193 \$1242 VSS sg13_lv_nmos L=0.13u W=0.42u AS=0.0378p
+ AD=0.1428p PS=0.6u PD=1.52u rfmode=0
M$1682 \$1093 \$1294 VSS VSS sg13_lv_nmos L=0.13u W=0.74u AS=0.2886p
+ AD=0.14875p PS=2.26u PD=1.16u rfmode=0
M$1683 VSS \$341 \$1294 VSS sg13_lv_nmos L=0.13u W=0.55u AS=0.14875p AD=0.187p
+ PS=1.16u PD=1.78u rfmode=0
M$1686 \$1243 \$1198 VSS VSS sg13_lv_nmos L=0.13u W=0.42u AS=0.1428p AD=0.0798p
+ PS=1.52u PD=0.8u rfmode=0
M$1687 VSS \$1087 \$1271 VSS sg13_lv_nmos L=0.13u W=0.42u AS=0.0798p AD=0.0378p
+ PS=0.8u PD=0.6u rfmode=0
M$1688 \$1271 \$1197 \$1198 VSS sg13_lv_nmos L=0.13u W=0.42u AS=0.0378p
+ AD=0.1428p PS=0.6u PD=1.52u rfmode=0
M$1691 VSS \$1200 \$1295 VSS sg13_lv_nmos L=0.13u W=0.55u AS=0.14875p AD=0.187p
+ PS=1.16u PD=1.78u rfmode=0
M$1692 VSS \$1295 D6 VSS sg13_lv_nmos L=0.13u W=0.74u AS=0.14875p AD=0.2886p
+ PS=1.16u PD=2.26u rfmode=0
M$1693 VSS \$1124 \$1297 VSS sg13_lv_nmos L=0.13u W=0.55u AS=0.18945p AD=0.187p
+ PS=1.27u PD=1.78u rfmode=0
M$1694 VSS \$1124 \$1307 VSS sg13_lv_nmos L=0.13u W=0.74u AS=0.18945p
+ AD=0.13135p PS=1.27u PD=1.095u rfmode=0
M$1695 \$1307 \$685 \$1298 VSS sg13_lv_nmos L=0.13u W=0.74u AS=0.13135p
+ AD=0.1628p PS=1.095u PD=1.18u rfmode=0
M$1696 \$1298 \$1107 \$1306 VSS sg13_lv_nmos L=0.13u W=0.74u AS=0.1628p
+ AD=0.3367p PS=1.18u PD=1.65u rfmode=0
M$1697 \$1306 \$1297 VSS VSS sg13_lv_nmos L=0.13u W=0.74u AS=0.3367p AD=0.148p
+ PS=1.65u PD=1.14u rfmode=0
M$1698 VSS \$1298 \$1299 VSS sg13_lv_nmos L=0.13u W=0.74u AS=0.148p AD=0.4033p
+ PS=1.14u PD=2.57u rfmode=0
M$1699 VSS \$1206 \$1205 VSS sg13_lv_nmos L=0.13u W=0.74u AS=0.1626p AD=0.2516p
+ PS=1.415u PD=2.16u rfmode=0
M$1700 \$1204 \$1203 \$1273 VSS sg13_lv_nmos L=0.13u W=0.42u AS=0.1428p
+ AD=0.0609p PS=1.52u PD=0.71u rfmode=0
M$1701 VSS \$1233 \$1273 VSS sg13_lv_nmos L=0.13u W=0.42u AS=0.1626p AD=0.0609p
+ PS=1.415u PD=0.71u rfmode=0
M$1702 VSS \$885 \$1233 VSS sg13_lv_nmos L=0.13u W=0.74u AS=0.2516p AD=0.2516p
+ PS=2.16u PD=2.16u rfmode=0
M$1703 VSS \$1233 \$1270 VSS sg13_lv_nmos L=0.13u W=0.42u AS=0.1701p AD=0.0378p
+ PS=1.65u PD=0.6u rfmode=0
M$1704 \$1270 \$1205 \$1244 VSS sg13_lv_nmos L=0.13u W=0.42u AS=0.0378p
+ AD=0.1428p PS=0.6u PD=1.52u rfmode=0
M$1709 \$1245 \$1210 VSS VSS sg13_lv_nmos L=0.13u W=0.42u AS=0.1428p AD=0.0798p
+ PS=1.52u PD=0.8u rfmode=0
M$1710 VSS \$1233 \$1253 VSS sg13_lv_nmos L=0.13u W=0.42u AS=0.0798p AD=0.0378p
+ PS=0.8u PD=0.6u rfmode=0
M$1711 \$1253 \$1209 \$1210 VSS sg13_lv_nmos L=0.13u W=0.42u AS=0.0378p
+ AD=0.1428p PS=0.6u PD=1.52u rfmode=0
M$1716 D7 \$1301 VSS VSS sg13_lv_nmos L=0.13u W=0.74u AS=0.2886p AD=0.14875p
+ PS=2.26u PD=1.16u rfmode=0
M$1717 VSS \$1232 \$1301 VSS sg13_lv_nmos L=0.13u W=0.55u AS=0.14875p AD=0.187p
+ PS=1.16u PD=1.78u rfmode=0
M$1718 VSS \$1107 \$1302 VSS sg13_lv_nmos L=0.13u W=0.55u AS=0.14875p AD=0.187p
+ PS=1.16u PD=1.78u rfmode=0
M$1719 VSS \$1302 \$40 VSS sg13_lv_nmos L=0.13u W=0.74u AS=0.14875p AD=0.2886p
+ PS=1.16u PD=2.26u rfmode=0
M$1721 VSS \$1035 \$1303 VSS sg13_lv_nmos L=0.13u W=0.55u AS=0.14875p AD=0.187p
+ PS=1.16u PD=1.78u rfmode=0
M$1722 VSS \$1303 \$39 VSS sg13_lv_nmos L=0.13u W=0.74u AS=0.14875p AD=0.2886p
+ PS=1.16u PD=2.26u rfmode=0
M$1723 VDD \$30 \$17 VDD sg13_lv_pmos L=0.13u W=2u AS=0.68p AD=0.68p PS=4.68u
+ PD=4.68u rfmode=0
M$1724 \$28 \$39 VDD VDD sg13_lv_pmos L=0.13u W=2u AS=0.68p AD=0.68p PS=4.68u
+ PD=4.68u rfmode=0
M$1725 VSS \$72 \$17 VDD sg13_lv_pmos L=0.13u W=2u AS=0.68p AD=0.68p PS=4.68u
+ PD=4.68u rfmode=0
M$1726 \$28 \$83 VSS VDD sg13_lv_pmos L=0.13u W=2u AS=0.68p AD=0.68p PS=4.68u
+ PD=4.68u rfmode=0
M$1727 VDD \$29 \$7 VDD sg13_lv_pmos L=0.13u W=2u AS=0.68p AD=0.68p PS=4.68u
+ PD=4.68u rfmode=0
M$1728 VSS \$71 \$7 VDD sg13_lv_pmos L=0.13u W=2u AS=0.68p AD=0.68p PS=4.68u
+ PD=4.68u rfmode=0
M$1729 VDD \$34 \$21 VDD sg13_lv_pmos L=0.13u W=2u AS=0.68p AD=0.68p PS=4.68u
+ PD=4.68u rfmode=0
M$1730 \$22 \$35 VDD VDD sg13_lv_pmos L=0.13u W=2u AS=0.68p AD=0.68p PS=4.68u
+ PD=4.68u rfmode=0
M$1731 \$9 \$84 VSS VDD sg13_lv_pmos L=0.13u W=2u AS=0.68p AD=0.68p PS=4.68u
+ PD=4.68u rfmode=0
M$1732 \$9 \$40 VDD VDD sg13_lv_pmos L=0.13u W=2u AS=0.68p AD=0.68p PS=4.68u
+ PD=4.68u rfmode=0
M$1733 VDD \$31 \$18 VDD sg13_lv_pmos L=0.13u W=2u AS=0.68p AD=0.68p PS=4.68u
+ PD=4.68u rfmode=0
M$1734 VSS \$73 \$18 VDD sg13_lv_pmos L=0.13u W=2u AS=0.68p AD=0.68p PS=4.68u
+ PD=4.68u rfmode=0
M$1735 VDD \$32 \$20 VDD sg13_lv_pmos L=0.13u W=2u AS=0.68p AD=0.68p PS=4.68u
+ PD=4.68u rfmode=0
M$1736 VSS \$74 \$20 VDD sg13_lv_pmos L=0.13u W=2u AS=0.68p AD=0.68p PS=4.68u
+ PD=4.68u rfmode=0
M$1737 VDD \$33 \$24 VDD sg13_lv_pmos L=0.13u W=2u AS=0.68p AD=0.68p PS=4.68u
+ PD=4.68u rfmode=0
M$1738 VSS \$75 \$24 VDD sg13_lv_pmos L=0.13u W=2u AS=0.68p AD=0.68p PS=4.68u
+ PD=4.68u rfmode=0
M$1739 VSS \$77 \$21 VDD sg13_lv_pmos L=0.13u W=2u AS=0.68p AD=0.68p PS=4.68u
+ PD=4.68u rfmode=0
M$1740 \$22 \$78 VSS VDD sg13_lv_pmos L=0.13u W=2u AS=0.68p AD=0.68p PS=4.68u
+ PD=4.68u rfmode=0
M$1741 \$27 \$80 VSS VDD sg13_lv_pmos L=0.13u W=2u AS=0.68p AD=0.68p PS=4.68u
+ PD=4.68u rfmode=0
M$1742 \$27 \$36 VDD VDD sg13_lv_pmos L=0.13u W=2u AS=0.68p AD=0.68p PS=4.68u
+ PD=4.68u rfmode=0
M$1743 \$23 \$81 VSS VDD sg13_lv_pmos L=0.13u W=2u AS=0.68p AD=0.68p PS=4.68u
+ PD=4.68u rfmode=0
M$1744 \$23 \$37 VDD VDD sg13_lv_pmos L=0.13u W=2u AS=0.68p AD=0.68p PS=4.68u
+ PD=4.68u rfmode=0
M$1745 \$19 \$82 VSS VDD sg13_lv_pmos L=0.13u W=2u AS=0.68p AD=0.68p PS=4.68u
+ PD=4.68u rfmode=0
M$1746 \$19 \$38 VDD VDD sg13_lv_pmos L=0.13u W=2u AS=0.68p AD=0.68p PS=4.68u
+ PD=4.68u rfmode=0
M$1747 VDD \$29 \$71 VDD sg13_lv_pmos L=0.13u W=0.8u AS=0.272p AD=0.272p
+ PS=2.28u PD=2.28u rfmode=0
M$1748 VDD \$30 \$72 VDD sg13_lv_pmos L=0.13u W=0.8u AS=0.272p AD=0.272p
+ PS=2.28u PD=2.28u rfmode=0
M$1749 VDD \$31 \$73 VDD sg13_lv_pmos L=0.13u W=0.8u AS=0.272p AD=0.272p
+ PS=2.28u PD=2.28u rfmode=0
M$1750 VDD \$32 \$74 VDD sg13_lv_pmos L=0.13u W=0.8u AS=0.272p AD=0.272p
+ PS=2.28u PD=2.28u rfmode=0
M$1751 VDD \$33 \$75 VDD sg13_lv_pmos L=0.13u W=0.8u AS=0.272p AD=0.272p
+ PS=2.28u PD=2.28u rfmode=0
M$1752 VDD \$41 \$25 VDD sg13_lv_pmos L=0.13u W=2u AS=0.68p AD=0.68p PS=4.68u
+ PD=4.68u rfmode=0
M$1753 VDD \$41 \$76 VDD sg13_lv_pmos L=0.13u W=0.8u AS=0.272p AD=0.272p
+ PS=2.28u PD=2.28u rfmode=0
M$1754 VSS \$76 \$25 VDD sg13_lv_pmos L=0.13u W=2u AS=0.68p AD=0.68p PS=4.68u
+ PD=4.68u rfmode=0
M$1755 VDD \$34 \$77 VDD sg13_lv_pmos L=0.13u W=0.8u AS=0.272p AD=0.272p
+ PS=2.28u PD=2.28u rfmode=0
M$1756 \$201 bias VDD \$200 sg13_lv_pmos L=0.3u W=18u AS=4.095p AD=4.095p
+ PS=24.32u PD=24.32u rfmode=0
M$1760 \$205 clk_comp \$201 \$200 sg13_lv_pmos L=0.3u W=18u AS=4.095p AD=4.095p
+ PS=24.32u PD=24.32u rfmode=0
M$1764 \$78 \$35 VDD VDD sg13_lv_pmos L=0.13u W=0.8u AS=0.272p AD=0.272p
+ PS=2.28u PD=2.28u rfmode=0
M$1765 \$26 \$79 VSS VDD sg13_lv_pmos L=0.13u W=2u AS=0.68p AD=0.68p PS=4.68u
+ PD=4.68u rfmode=0
M$1766 \$79 \$42 VDD VDD sg13_lv_pmos L=0.13u W=0.8u AS=0.272p AD=0.272p
+ PS=2.28u PD=2.28u rfmode=0
M$1767 \$26 \$42 VDD VDD sg13_lv_pmos L=0.13u W=2u AS=0.68p AD=0.68p PS=4.68u
+ PD=4.68u rfmode=0
M$1768 \$80 \$36 VDD VDD sg13_lv_pmos L=0.13u W=0.8u AS=0.272p AD=0.272p
+ PS=2.28u PD=2.28u rfmode=0
M$1769 \$81 \$37 VDD VDD sg13_lv_pmos L=0.13u W=0.8u AS=0.272p AD=0.272p
+ PS=2.28u PD=2.28u rfmode=0
M$1770 \$82 \$38 VDD VDD sg13_lv_pmos L=0.13u W=0.8u AS=0.272p AD=0.272p
+ PS=2.28u PD=2.28u rfmode=0
M$1771 \$83 \$39 VDD VDD sg13_lv_pmos L=0.13u W=0.8u AS=0.272p AD=0.272p
+ PS=2.28u PD=2.28u rfmode=0
M$1772 \$84 \$40 VDD VDD sg13_lv_pmos L=0.13u W=0.8u AS=0.272p AD=0.272p
+ PS=2.28u PD=2.28u rfmode=0
M$1773 Op \$202 VDD \$200 sg13_lv_pmos L=0.2u W=8u AS=2.12p AD=2.12p PS=13.06u
+ PD=13.06u rfmode=0
M$1775 Om \$203 VDD \$200 sg13_lv_pmos L=0.2u W=8u AS=2.12p AD=2.12p PS=13.06u
+ PD=13.06u rfmode=0
M$1777 \$226 \$224 VDD VDD sg13_lv_pmos L=0.13u W=0.8u AS=0.272p AD=0.272p
+ PS=2.28u PD=2.28u rfmode=0
M$1778 \$224 fclk_samp VDD VDD sg13_lv_pmos L=0.13u W=0.8u AS=0.272p AD=0.272p
+ PS=2.28u PD=2.28u rfmode=0
M$1779 VDD fclk_samp \$227 VDD sg13_lv_pmos L=0.13u W=0.8u AS=0.272p AD=0.272p
+ PS=2.28u PD=2.28u rfmode=0
M$1780 VDD \$227 \$228 VDD sg13_lv_pmos L=0.13u W=0.8u AS=0.272p AD=0.272p
+ PS=2.28u PD=2.28u rfmode=0
M$1781 \$205 \$10 \$202 \$200 sg13_lv_pmos L=0.2u W=32u AS=8.48p AD=8.48p
+ PS=52.24u PD=52.24u rfmode=0
M$1783 \$205 \$8 \$203 \$200 sg13_lv_pmos L=0.2u W=32u AS=8.48p AD=8.48p
+ PS=52.24u PD=52.24u rfmode=0
M$1793 \$260 \$278 \$280 \$280 sg13_lv_pmos L=0.13u W=0.5u AS=0.17p AD=0.17p
+ PS=1.68u PD=1.68u rfmode=0
M$1794 \$278 \$274 VDD VDD sg13_lv_pmos L=0.13u W=0.8u AS=0.272p AD=0.272p
+ PS=2.28u PD=2.28u rfmode=0
M$1795 VDD \$274 \$261 VDD sg13_lv_pmos L=0.13u W=0.5u AS=0.17p AD=0.17p
+ PS=1.68u PD=1.68u rfmode=0
M$1796 \$239 \$279 VDD VDD sg13_lv_pmos L=0.13u W=0.5u AS=0.17p AD=0.17p
+ PS=1.68u PD=1.68u rfmode=0
M$1797 VDD \$279 \$275 VDD sg13_lv_pmos L=0.13u W=0.8u AS=0.272p AD=0.272p
+ PS=2.28u PD=2.28u rfmode=0
M$1798 \$249 \$275 \$250 \$249 sg13_lv_pmos L=0.13u W=0.5u AS=0.17p AD=0.17p
+ PS=1.68u PD=1.68u rfmode=0
M$1801 VDD Op \$302 VDD sg13_lv_pmos L=0.13u W=0.5u AS=0.17p AD=0.095p PS=1.68u
+ PD=0.88u rfmode=0
M$1802 \$302 Om VDD VDD sg13_lv_pmos L=0.13u W=0.5u AS=0.095p AD=0.17p PS=0.88u
+ PD=1.68u rfmode=0
M$1805 \$388 \$332 VDD VDD sg13_lv_pmos L=0.13u W=1.12u AS=0.3864p AD=0.41165p
+ PS=2.93u PD=2.12u rfmode=0
M$1806 VDD \$369 \$332 VDD sg13_lv_pmos L=0.13u W=1.12u AS=0.41165p AD=0.4088p
+ PS=2.12u PD=2.97u rfmode=0
M$1807 \$34 \$345 VDD VDD sg13_lv_pmos L=0.13u W=1.12u AS=0.42p AD=0.2114p
+ PS=2.99u PD=1.54u rfmode=0
M$1808 VDD \$350 \$345 VDD sg13_lv_pmos L=0.13u W=0.84u AS=0.2114p AD=0.2856p
+ PS=1.54u PD=2.36u rfmode=0
M$1809 VDD Op \$346 VDD sg13_lv_pmos L=0.13u W=0.84u AS=0.2114p AD=0.2856p
+ PS=1.54u PD=2.36u rfmode=0
M$1810 VDD \$346 \$310 VDD sg13_lv_pmos L=0.13u W=1.12u AS=0.2114p AD=0.42p
+ PS=1.54u PD=2.99u rfmode=0
M$1811 VDD \$385 \$347 VDD sg13_lv_pmos L=0.13u W=0.84u AS=0.2114p AD=0.2856p
+ PS=1.54u PD=2.36u rfmode=0
M$1812 VDD \$347 clk_comp VDD sg13_lv_pmos L=0.13u W=1.12u AS=0.2114p AD=0.42p
+ PS=1.54u PD=2.99u rfmode=0
M$1813 \$311 \$348 VDD VDD sg13_lv_pmos L=0.13u W=0.84u AS=0.2856p AD=0.253p
+ PS=2.36u PD=1.53u rfmode=0
M$1814 VDD \$348 \$394 VDD sg13_lv_pmos L=0.13u W=1u AS=0.253p AD=0.3325p
+ PS=1.53u PD=1.665u rfmode=0
M$1815 \$394 \$350 \$312 VDD sg13_lv_pmos L=0.13u W=1u AS=0.3325p AD=0.2225p
+ PS=1.665u PD=1.445u rfmode=0
M$1816 \$312 \$349 \$396 VDD sg13_lv_pmos L=0.13u W=1u AS=0.2225p AD=0.2975p
+ PS=1.445u PD=1.595u rfmode=0
M$1817 \$396 \$311 VDD VDD sg13_lv_pmos L=0.13u W=1u AS=0.2975p AD=0.2198p
+ PS=1.595u PD=1.52u rfmode=0
M$1818 VDD \$312 \$313 VDD sg13_lv_pmos L=0.13u W=1.12u AS=0.2198p AD=0.6048p
+ PS=1.52u PD=3.32u rfmode=0
M$1819 VDD \$315 \$314 VDD sg13_lv_pmos L=0.13u W=17.92u AS=3.5896p AD=3.4048p
+ PS=25.45u PD=24u rfmode=0
M$1835 VDD fclk_in \$315 VDD sg13_lv_pmos L=0.13u W=6.72u AS=1.2768p AD=1.4448p
+ PS=9u PD=10.42u rfmode=0
M$1841 \$318 \$353 \$386 VDD sg13_lv_pmos L=0.13u W=1.12u AS=0.3808p AD=0.2128p
+ PS=2.92u PD=1.5u rfmode=0
M$1842 \$386 \$354 VDD VDD sg13_lv_pmos L=0.13u W=1.12u AS=0.2128p AD=0.2128p
+ PS=1.5u PD=1.5u rfmode=0
M$1843 VDD \$352 \$386 VDD sg13_lv_pmos L=0.13u W=1.12u AS=0.2128p AD=0.3808p
+ PS=1.5u PD=2.92u rfmode=0
M$1844 VDD \$355 \$319 VDD sg13_lv_pmos L=0.13u W=0.84u AS=0.4536p AD=0.1596p
+ PS=2.76u PD=1.22u rfmode=0
M$1845 VDD \$317 \$319 VDD sg13_lv_pmos L=0.13u W=0.84u AS=0.2891p AD=0.1596p
+ PS=1.695u PD=1.22u rfmode=0
M$1846 VDD \$355 \$404 VDD sg13_lv_pmos L=0.13u W=1.12u AS=0.2891p AD=0.1428p
+ PS=1.695u PD=1.375u rfmode=0
M$1847 \$404 \$317 \$387 VDD sg13_lv_pmos L=0.13u W=1.12u AS=0.1428p AD=0.2408p
+ PS=1.375u PD=1.55u rfmode=0
M$1848 \$387 \$319 VDD VDD sg13_lv_pmos L=0.13u W=1.12u AS=0.2408p AD=0.3808p
+ PS=1.55u PD=2.92u rfmode=0
M$1849 VDD \$357 \$356 VDD sg13_lv_pmos L=0.5u W=1u AS=0.2254p AD=0.34p
+ PS=1.53u PD=2.68u rfmode=0
M$1850 \$354 \$356 VDD VDD sg13_lv_pmos L=0.13u W=1.12u AS=0.4256p AD=0.2254p
+ PS=3u PD=1.53u rfmode=0
M$1851 VDD \$360 \$359 VDD sg13_lv_pmos L=0.5u W=1u AS=0.2254p AD=0.34p
+ PS=1.53u PD=2.68u rfmode=0
M$1852 \$322 \$359 VDD VDD sg13_lv_pmos L=0.13u W=1.12u AS=0.4256p AD=0.2254p
+ PS=3u PD=1.53u rfmode=0
M$1853 VDD \$362 \$361 VDD sg13_lv_pmos L=0.5u W=1u AS=0.2254p AD=0.34p
+ PS=1.53u PD=2.68u rfmode=0
M$1854 \$355 \$361 VDD VDD sg13_lv_pmos L=0.13u W=1.12u AS=0.4256p AD=0.2254p
+ PS=3u PD=1.53u rfmode=0
M$1855 \$325 \$364 VDD VDD sg13_lv_pmos L=0.13u W=1.12u AS=0.42p AD=0.2114p
+ PS=2.99u PD=1.54u rfmode=0
M$1856 VDD rst \$364 VDD sg13_lv_pmos L=0.13u W=0.84u AS=0.2114p AD=0.2856p
+ PS=1.54u PD=2.36u rfmode=0
M$1857 \$366 \$327 VDD VDD sg13_lv_pmos L=0.5u W=1u AS=0.34p AD=0.2254p
+ PS=2.68u PD=1.53u rfmode=0
M$1858 VDD \$366 \$328 VDD sg13_lv_pmos L=0.13u W=1.12u AS=0.2254p AD=0.4256p
+ PS=1.53u PD=3u rfmode=0
M$1859 \$335 \$370 VDD VDD sg13_lv_pmos L=0.13u W=1.12u AS=0.3864p AD=0.2128p
+ PS=2.93u PD=1.5u rfmode=0
M$1860 VDD \$335 \$336 VDD sg13_lv_pmos L=0.13u W=1.12u AS=0.2128p AD=0.3808p
+ PS=1.5u PD=2.92u rfmode=0
M$1861 \$371 \$310 VDD VDD sg13_lv_pmos L=0.13u W=0.84u AS=0.2856p AD=0.2618p
+ PS=2.36u PD=1.63u rfmode=0
M$1862 VDD \$371 \$397 VDD sg13_lv_pmos L=0.13u W=1.12u AS=0.2618p AD=0.1176p
+ PS=1.63u PD=1.33u rfmode=0
M$1863 \$397 \$372 \$339 VDD sg13_lv_pmos L=0.13u W=1.12u AS=0.1176p AD=0.3808p
+ PS=1.33u PD=2.92u rfmode=0
M$1864 \$340 \$373 VDD VDD sg13_lv_pmos L=0.13u W=1.12u AS=0.42p AD=0.2114p
+ PS=2.99u PD=1.54u rfmode=0
M$1865 VDD \$667 \$373 VDD sg13_lv_pmos L=0.13u W=0.84u AS=0.2114p AD=0.2856p
+ PS=1.54u PD=2.36u rfmode=0
M$1866 VDD \$302 \$374 VDD sg13_lv_pmos L=0.13u W=0.84u AS=0.2114p AD=0.2856p
+ PS=1.54u PD=2.36u rfmode=0
M$1867 VDD \$374 \$341 VDD sg13_lv_pmos L=0.13u W=1.12u AS=0.2114p AD=0.42p
+ PS=1.54u PD=2.99u rfmode=0
M$1868 fclk_samp \$375 VDD VDD sg13_lv_pmos L=0.13u W=1.12u AS=0.42p AD=0.2114p
+ PS=2.99u PD=1.54u rfmode=0
M$1869 VDD \$389 \$375 VDD sg13_lv_pmos L=0.13u W=0.84u AS=0.2114p AD=0.2856p
+ PS=1.54u PD=2.36u rfmode=0
M$1870 \$372 \$376 VDD VDD sg13_lv_pmos L=0.13u W=1.12u AS=0.42p AD=0.2114p
+ PS=2.99u PD=1.54u rfmode=0
M$1871 VDD Om \$376 VDD sg13_lv_pmos L=0.13u W=0.84u AS=0.2114p AD=0.2856p
+ PS=1.54u PD=2.36u rfmode=0
M$1872 VDD \$465 \$377 VDD sg13_lv_pmos L=0.13u W=0.84u AS=0.2114p AD=0.2856p
+ PS=1.54u PD=2.36u rfmode=0
M$1873 VDD \$377 \$35 VDD sg13_lv_pmos L=0.13u W=1.12u AS=0.2114p AD=0.42p
+ PS=1.54u PD=2.99u rfmode=0
M$1874 VDD VSS VDD VDD sg13_lv_pmos L=1u W=595u AS=159.85p AD=159.85p
+ PS=1226.7u PD=1226.7u rfmode=0
M$1882 VDD \$354 \$317 VDD sg13_lv_pmos L=0.13u W=1.12u AS=0.3808p AD=0.2128p
+ PS=2.92u PD=1.5u rfmode=0
M$1883 \$317 \$351 VDD VDD sg13_lv_pmos L=0.13u W=1.12u AS=0.2128p AD=0.2128p
+ PS=1.5u PD=1.5u rfmode=0
M$1884 VDD \$352 \$317 VDD sg13_lv_pmos L=0.13u W=1.12u AS=0.2128p AD=0.3808p
+ PS=1.5u PD=2.92u rfmode=0
M$1885 \$353 \$354 \$403 VDD sg13_lv_pmos L=0.13u W=1u AS=0.34p AD=0.1225p
+ PS=2.68u PD=1.245u rfmode=0
M$1886 \$403 \$352 VDD VDD sg13_lv_pmos L=0.13u W=1u AS=0.1225p AD=0.36p
+ PS=1.245u PD=2.72u rfmode=0
M$1887 VDD \$358 \$321 VDD sg13_lv_pmos L=0.13u W=0.42u AS=0.1523p AD=0.1428p
+ PS=1.38u PD=1.52u rfmode=0
M$1888 \$357 \$321 VDD VDD sg13_lv_pmos L=0.5u W=1u AS=0.34p AD=0.1523p
+ PS=2.68u PD=1.38u rfmode=0
M$1890 VDD \$387 \$323 VDD sg13_lv_pmos L=0.13u W=0.42u AS=0.1523p AD=0.1428p
+ PS=1.38u PD=1.52u rfmode=0
M$1891 \$360 \$323 VDD VDD sg13_lv_pmos L=0.5u W=1u AS=0.34p AD=0.1523p
+ PS=2.68u PD=1.38u rfmode=0
M$1892 VDD \$363 \$324 VDD sg13_lv_pmos L=0.13u W=0.42u AS=0.1523p AD=0.1428p
+ PS=1.38u PD=1.52u rfmode=0
M$1893 \$362 \$324 VDD VDD sg13_lv_pmos L=0.5u W=1u AS=0.34p AD=0.1523p
+ PS=2.68u PD=1.38u rfmode=0
M$1894 VDD \$365 \$326 VDD sg13_lv_pmos L=0.13u W=0.42u AS=0.1523p AD=0.1428p
+ PS=1.38u PD=1.52u rfmode=0
M$1895 VDD \$326 \$327 VDD sg13_lv_pmos L=0.5u W=1u AS=0.1523p AD=0.34p
+ PS=1.38u PD=2.68u rfmode=0
M$1896 VDD \$328 \$329 VDD sg13_lv_pmos L=0.13u W=0.42u AS=0.1428p AD=0.0798p
+ PS=1.52u PD=0.8u rfmode=0
M$1897 VDD \$368 \$329 VDD sg13_lv_pmos L=0.13u W=0.42u AS=0.3623875p
+ AD=0.0798p PS=2.605u PD=0.8u rfmode=0
M$1898 VDD \$367 \$331 VDD sg13_lv_pmos L=0.13u W=1u AS=0.3623875p AD=0.34p
+ PS=2.605u PD=2.68u rfmode=0
M$1899 \$370 \$388 \$390 VDD sg13_lv_pmos L=0.13u W=0.42u AS=0.2048p
+ AD=0.09345p PS=1.63u PD=0.865u rfmode=0
M$1900 \$390 \$334 VDD VDD sg13_lv_pmos L=0.13u W=0.42u AS=0.09345p AD=0.204p
+ PS=0.865u PD=1.835u rfmode=0
M$1901 VDD \$368 \$334 VDD sg13_lv_pmos L=0.13u W=0.42u AS=0.204p AD=0.0798p
+ PS=1.835u PD=0.8u rfmode=0
M$1902 \$334 \$370 VDD VDD sg13_lv_pmos L=0.13u W=0.42u AS=0.0798p AD=0.4659p
+ PS=0.8u PD=3.65u rfmode=0
M$1903 \$331 \$332 \$370 VDD sg13_lv_pmos L=0.13u W=1u AS=0.34p AD=0.2048p
+ PS=2.68u PD=1.63u rfmode=0
M$1904 VDD \$566 \$399 VDD sg13_lv_pmos L=0.15u W=1.12u AS=0.3808p AD=0.2128p
+ PS=2.92u PD=1.5u rfmode=0
M$1905 \$399 \$442 \$338 VDD sg13_lv_pmos L=0.15u W=1.12u AS=0.2128p AD=0.2128p
+ PS=1.5u PD=1.5u rfmode=0
M$1906 \$338 \$389 VDD VDD sg13_lv_pmos L=0.15u W=1.12u AS=0.2128p AD=0.3808p
+ PS=1.5u PD=2.92u rfmode=0
M$1907 VDD \$629 \$368 VDD sg13_lv_pmos L=0.13u W=1.12u AS=0.3808p AD=0.3808p
+ PS=2.92u PD=2.92u rfmode=0
M$1919 VDD \$340 \$342 VDD sg13_lv_pmos L=0.13u W=1.12u AS=0.3808p AD=0.3808p
+ PS=2.92u PD=2.92u rfmode=0
M$1935 VDD \$406 \$407 VDD sg13_lv_pmos L=0.13u W=0.84u AS=0.2114p AD=0.2856p
+ PS=1.54u PD=2.36u rfmode=0
M$1936 \$41 \$407 VDD VDD sg13_lv_pmos L=0.13u W=1.12u AS=0.42p AD=0.2114p
+ PS=2.99u PD=1.54u rfmode=0
M$1949 \$408 \$409 VDD VDD sg13_lv_pmos L=0.13u W=1.12u AS=0.3808p AD=0.3808p
+ PS=2.92u PD=2.92u rfmode=0
M$1950 VDD \$599 \$410 VDD sg13_lv_pmos L=0.13u W=0.84u AS=0.2114p AD=0.2856p
+ PS=1.54u PD=2.36u rfmode=0
M$1951 \$385 \$410 VDD VDD sg13_lv_pmos L=0.13u W=1.12u AS=0.42p AD=0.2114p
+ PS=2.99u PD=1.54u rfmode=0
M$1952 VDD \$313 \$411 VDD sg13_lv_pmos L=0.13u W=0.42u AS=0.1428p AD=0.0798p
+ PS=1.52u PD=0.8u rfmode=0
M$1953 VDD \$408 \$411 VDD sg13_lv_pmos L=0.13u W=0.42u AS=0.3623875p
+ AD=0.0798p PS=2.605u PD=0.8u rfmode=0
M$1954 VDD \$413 \$412 VDD sg13_lv_pmos L=0.13u W=1u AS=0.3623875p AD=0.34p
+ PS=2.605u PD=2.68u rfmode=0
M$1955 VDD \$408 \$413 VDD sg13_lv_pmos L=0.13u W=0.42u AS=0.1563p AD=0.147p
+ PS=1.22u PD=1.54u rfmode=0
M$1956 VDD \$412 \$479 VDD sg13_lv_pmos L=0.13u W=0.42u AS=0.1563p AD=0.063p
+ PS=1.22u PD=0.72u rfmode=0
M$1957 \$479 \$415 \$413 VDD sg13_lv_pmos L=0.13u W=0.42u AS=0.063p AD=0.0798p
+ PS=0.72u PD=0.8u rfmode=0
M$1958 \$413 \$414 \$411 VDD sg13_lv_pmos L=0.13u W=0.42u AS=0.0798p AD=0.1428p
+ PS=0.8u PD=1.52u rfmode=0
M$1959 VDD \$415 \$414 VDD sg13_lv_pmos L=0.13u W=1.12u AS=0.41165p AD=0.3864p
+ PS=2.12u PD=2.93u rfmode=0
M$1960 VDD \$496 \$415 VDD sg13_lv_pmos L=0.13u W=1.12u AS=0.41165p AD=0.4088p
+ PS=2.12u PD=2.97u rfmode=0
M$1961 \$412 \$415 \$416 VDD sg13_lv_pmos L=0.13u W=1u AS=0.34p AD=0.2048p
+ PS=2.68u PD=1.63u rfmode=0
M$1962 \$416 \$414 \$480 VDD sg13_lv_pmos L=0.13u W=0.42u AS=0.2048p
+ AD=0.09345p PS=1.63u PD=0.865u rfmode=0
M$1963 VDD \$417 \$480 VDD sg13_lv_pmos L=0.13u W=0.42u AS=0.204p AD=0.09345p
+ PS=1.835u PD=0.865u rfmode=0
M$1964 VDD \$408 \$417 VDD sg13_lv_pmos L=0.13u W=0.42u AS=0.204p AD=0.0798p
+ PS=1.835u PD=0.8u rfmode=0
M$1965 VDD \$416 \$417 VDD sg13_lv_pmos L=0.13u W=0.42u AS=0.4659p AD=0.0798p
+ PS=3.65u PD=0.8u rfmode=0
M$1966 \$418 \$416 VDD VDD sg13_lv_pmos L=0.13u W=1.12u AS=0.3864p AD=0.2128p
+ PS=2.93u PD=1.5u rfmode=0
M$1967 VDD \$418 \$350 VDD sg13_lv_pmos L=0.13u W=1.12u AS=0.2128p AD=0.3808p
+ PS=1.5u PD=2.92u rfmode=0
M$1968 VDD \$419 \$420 VDD sg13_lv_pmos L=0.13u W=0.84u AS=0.2114p AD=0.2856p
+ PS=1.54u PD=2.36u rfmode=0
M$1969 \$409 \$420 VDD VDD sg13_lv_pmos L=0.13u W=1.12u AS=0.42p AD=0.2114p
+ PS=2.99u PD=1.54u rfmode=0
M$1970 VDD \$318 \$421 VDD sg13_lv_pmos L=0.13u W=0.42u AS=0.1428p AD=0.0798p
+ PS=1.52u PD=0.8u rfmode=0
M$1971 VDD \$424 \$421 VDD sg13_lv_pmos L=0.13u W=0.42u AS=0.3623875p
+ AD=0.0798p PS=2.605u PD=0.8u rfmode=0
M$1972 VDD \$423 \$422 VDD sg13_lv_pmos L=0.13u W=1u AS=0.3623875p AD=0.34p
+ PS=2.605u PD=2.68u rfmode=0
M$1973 VDD \$424 \$423 VDD sg13_lv_pmos L=0.13u W=0.42u AS=0.1563p AD=0.147p
+ PS=1.22u PD=1.54u rfmode=0
M$1974 VDD \$422 \$481 VDD sg13_lv_pmos L=0.13u W=0.42u AS=0.1563p AD=0.063p
+ PS=1.22u PD=0.72u rfmode=0
M$1975 \$481 \$426 \$423 VDD sg13_lv_pmos L=0.13u W=0.42u AS=0.063p AD=0.0798p
+ PS=0.72u PD=0.8u rfmode=0
M$1976 \$423 \$425 \$421 VDD sg13_lv_pmos L=0.13u W=0.42u AS=0.0798p AD=0.1428p
+ PS=0.8u PD=1.52u rfmode=0
M$1977 VDD \$426 \$425 VDD sg13_lv_pmos L=0.13u W=1.12u AS=0.41165p AD=0.3864p
+ PS=2.12u PD=2.93u rfmode=0
M$1978 VDD \$498 \$426 VDD sg13_lv_pmos L=0.13u W=1.12u AS=0.41165p AD=0.4088p
+ PS=2.12u PD=2.97u rfmode=0
M$1979 \$422 \$426 \$427 VDD sg13_lv_pmos L=0.13u W=1u AS=0.34p AD=0.2048p
+ PS=2.68u PD=1.63u rfmode=0
M$1980 \$427 \$425 \$482 VDD sg13_lv_pmos L=0.13u W=0.42u AS=0.2048p
+ AD=0.09345p PS=1.63u PD=0.865u rfmode=0
M$1981 VDD \$428 \$482 VDD sg13_lv_pmos L=0.13u W=0.42u AS=0.204p AD=0.09345p
+ PS=1.835u PD=0.865u rfmode=0
M$1982 VDD \$424 \$428 VDD sg13_lv_pmos L=0.13u W=0.42u AS=0.204p AD=0.0798p
+ PS=1.835u PD=0.8u rfmode=0
M$1983 VDD \$427 \$428 VDD sg13_lv_pmos L=0.13u W=0.42u AS=0.4659p AD=0.0798p
+ PS=3.65u PD=0.8u rfmode=0
M$1984 \$429 \$427 VDD VDD sg13_lv_pmos L=0.13u W=1.12u AS=0.3864p AD=0.2128p
+ PS=2.93u PD=1.5u rfmode=0
M$1985 VDD \$429 \$358 VDD sg13_lv_pmos L=0.13u W=1.12u AS=0.2128p AD=0.3808p
+ PS=1.5u PD=2.92u rfmode=0
M$1986 VDD \$322 \$430 VDD sg13_lv_pmos L=0.13u W=0.42u AS=0.1428p AD=0.0798p
+ PS=1.52u PD=0.8u rfmode=0
M$1987 VDD \$433 \$430 VDD sg13_lv_pmos L=0.13u W=0.42u AS=0.3623875p
+ AD=0.0798p PS=2.605u PD=0.8u rfmode=0
M$1988 VDD \$432 \$431 VDD sg13_lv_pmos L=0.13u W=1u AS=0.3623875p AD=0.34p
+ PS=2.605u PD=2.68u rfmode=0
M$1989 VDD \$433 \$432 VDD sg13_lv_pmos L=0.13u W=0.42u AS=0.1563p AD=0.147p
+ PS=1.22u PD=1.54u rfmode=0
M$1990 VDD \$431 \$483 VDD sg13_lv_pmos L=0.13u W=0.42u AS=0.1563p AD=0.063p
+ PS=1.22u PD=0.72u rfmode=0
M$1991 \$483 \$435 \$432 VDD sg13_lv_pmos L=0.13u W=0.42u AS=0.063p AD=0.0798p
+ PS=0.72u PD=0.8u rfmode=0
M$1992 \$432 \$434 \$430 VDD sg13_lv_pmos L=0.13u W=0.42u AS=0.0798p AD=0.1428p
+ PS=0.8u PD=1.52u rfmode=0
M$1993 VDD \$435 \$434 VDD sg13_lv_pmos L=0.13u W=1.12u AS=0.41165p AD=0.3864p
+ PS=2.12u PD=2.93u rfmode=0
M$1994 VDD \$498 \$435 VDD sg13_lv_pmos L=0.13u W=1.12u AS=0.41165p AD=0.4088p
+ PS=2.12u PD=2.97u rfmode=0
M$1995 \$431 \$435 \$436 VDD sg13_lv_pmos L=0.13u W=1u AS=0.34p AD=0.2048p
+ PS=2.68u PD=1.63u rfmode=0
M$1996 \$436 \$434 \$484 VDD sg13_lv_pmos L=0.13u W=0.42u AS=0.2048p
+ AD=0.09345p PS=1.63u PD=0.865u rfmode=0
M$1997 VDD \$437 \$484 VDD sg13_lv_pmos L=0.13u W=0.42u AS=0.204p AD=0.09345p
+ PS=1.835u PD=0.865u rfmode=0
M$1998 VDD \$433 \$437 VDD sg13_lv_pmos L=0.13u W=0.42u AS=0.204p AD=0.0798p
+ PS=1.835u PD=0.8u rfmode=0
M$1999 VDD \$436 \$437 VDD sg13_lv_pmos L=0.13u W=0.42u AS=0.4659p AD=0.0798p
+ PS=3.65u PD=0.8u rfmode=0
M$2000 \$438 \$436 VDD VDD sg13_lv_pmos L=0.13u W=1.12u AS=0.3864p AD=0.2128p
+ PS=2.93u PD=1.5u rfmode=0
M$2001 VDD \$438 \$363 VDD sg13_lv_pmos L=0.13u W=1.12u AS=0.2128p AD=0.3808p
+ PS=1.5u PD=2.92u rfmode=0
M$2002 VDD \$604 \$439 VDD sg13_lv_pmos L=0.13u W=0.42u AS=0.1523p AD=0.1428p
+ PS=1.38u PD=1.52u rfmode=0
M$2003 VDD \$439 \$440 VDD sg13_lv_pmos L=0.5u W=1u AS=0.1523p AD=0.34p
+ PS=1.38u PD=2.68u rfmode=0
M$2004 VDD \$440 \$441 VDD sg13_lv_pmos L=0.5u W=1u AS=0.2254p AD=0.34p
+ PS=1.53u PD=2.68u rfmode=0
M$2005 VDD \$441 \$442 VDD sg13_lv_pmos L=0.13u W=1.12u AS=0.2254p AD=0.4256p
+ PS=1.53u PD=3u rfmode=0
M$2006 \$443 \$328 \$485 VDD sg13_lv_pmos L=0.13u W=1.12u AS=0.3808p AD=0.1176p
+ PS=2.92u PD=1.33u rfmode=0
M$2007 \$485 \$444 VDD VDD sg13_lv_pmos L=0.13u W=1.12u AS=0.1176p AD=0.2618p
+ PS=1.33u PD=1.63u rfmode=0
M$2008 VDD \$338 \$444 VDD sg13_lv_pmos L=0.13u W=0.84u AS=0.2618p AD=0.2856p
+ PS=1.63u PD=2.36u rfmode=0
M$2009 \$367 \$368 VDD VDD sg13_lv_pmos L=0.13u W=0.42u AS=0.147p AD=0.1563p
+ PS=1.54u PD=1.22u rfmode=0
M$2010 VDD \$331 \$402 VDD sg13_lv_pmos L=0.13u W=0.42u AS=0.1563p AD=0.063p
+ PS=1.22u PD=0.72u rfmode=0
M$2011 \$402 \$332 \$367 VDD sg13_lv_pmos L=0.13u W=0.42u AS=0.063p AD=0.0798p
+ PS=0.72u PD=0.8u rfmode=0
M$2012 \$367 \$388 \$329 VDD sg13_lv_pmos L=0.13u W=0.42u AS=0.0798p AD=0.1428p
+ PS=0.8u PD=1.52u rfmode=0
M$2013 VDD \$509 \$445 VDD sg13_lv_pmos L=0.13u W=0.42u AS=0.1428p AD=0.0798p
+ PS=1.52u PD=0.8u rfmode=0
M$2014 VDD \$500 \$445 VDD sg13_lv_pmos L=0.13u W=0.42u AS=0.3623875p
+ AD=0.0798p PS=2.605u PD=0.8u rfmode=0
M$2015 VDD \$447 \$446 VDD sg13_lv_pmos L=0.13u W=1u AS=0.3623875p AD=0.34p
+ PS=2.605u PD=2.68u rfmode=0
M$2016 VDD \$500 \$447 VDD sg13_lv_pmos L=0.13u W=0.42u AS=0.1563p AD=0.147p
+ PS=1.22u PD=1.54u rfmode=0
M$2017 VDD \$446 \$486 VDD sg13_lv_pmos L=0.13u W=0.42u AS=0.1563p AD=0.063p
+ PS=1.22u PD=0.72u rfmode=0
M$2018 \$486 \$449 \$447 VDD sg13_lv_pmos L=0.13u W=0.42u AS=0.063p AD=0.0798p
+ PS=0.72u PD=0.8u rfmode=0
M$2019 \$447 \$448 \$445 VDD sg13_lv_pmos L=0.13u W=0.42u AS=0.0798p AD=0.1428p
+ PS=0.8u PD=1.52u rfmode=0
M$2020 VDD \$449 \$448 VDD sg13_lv_pmos L=0.13u W=1.12u AS=0.41165p AD=0.3864p
+ PS=2.12u PD=2.93u rfmode=0
M$2021 VDD \$369 \$449 VDD sg13_lv_pmos L=0.13u W=1.12u AS=0.41165p AD=0.4088p
+ PS=2.12u PD=2.97u rfmode=0
M$2022 \$446 \$449 \$450 VDD sg13_lv_pmos L=0.13u W=1u AS=0.34p AD=0.2048p
+ PS=2.68u PD=1.63u rfmode=0
M$2023 \$450 \$448 \$487 VDD sg13_lv_pmos L=0.13u W=0.42u AS=0.2048p
+ AD=0.09345p PS=1.63u PD=0.865u rfmode=0
M$2024 VDD \$451 \$487 VDD sg13_lv_pmos L=0.13u W=0.42u AS=0.204p AD=0.09345p
+ PS=1.835u PD=0.865u rfmode=0
M$2025 VDD \$500 \$451 VDD sg13_lv_pmos L=0.13u W=0.42u AS=0.204p AD=0.0798p
+ PS=1.835u PD=0.8u rfmode=0
M$2026 VDD \$450 \$451 VDD sg13_lv_pmos L=0.13u W=0.42u AS=0.4659p AD=0.0798p
+ PS=3.65u PD=0.8u rfmode=0
M$2027 \$452 \$450 VDD VDD sg13_lv_pmos L=0.13u W=1.12u AS=0.3864p AD=0.2128p
+ PS=2.93u PD=1.5u rfmode=0
M$2028 VDD \$452 \$453 VDD sg13_lv_pmos L=0.13u W=1.12u AS=0.2128p AD=0.3808p
+ PS=1.5u PD=2.92u rfmode=0
M$2029 \$454 \$348 \$489 VDD sg13_lv_pmos L=0.13u W=1.12u AS=0.3808p AD=0.1176p
+ PS=2.92u PD=1.33u rfmode=0
M$2030 \$489 \$465 VDD VDD sg13_lv_pmos L=0.13u W=1.12u AS=0.1176p AD=0.4032p
+ PS=1.33u PD=2.96u rfmode=0
M$2031 \$455 \$454 \$456 VDD sg13_lv_pmos L=0.13u W=1.12u AS=0.3808p AD=0.2128p
+ PS=2.92u PD=1.5u rfmode=0
M$2032 \$456 \$348 VDD VDD sg13_lv_pmos L=0.13u W=1.12u AS=0.2128p AD=0.2128p
+ PS=1.5u PD=1.5u rfmode=0
M$2033 VDD \$349 \$456 VDD sg13_lv_pmos L=0.13u W=1.12u AS=0.2128p AD=0.3808p
+ PS=1.5u PD=2.92u rfmode=0
M$2034 VDD \$455 \$457 VDD sg13_lv_pmos L=0.13u W=0.42u AS=0.1428p AD=0.0798p
+ PS=1.52u PD=0.8u rfmode=0
M$2035 VDD \$502 \$457 VDD sg13_lv_pmos L=0.13u W=0.42u AS=0.3623875p
+ AD=0.0798p PS=2.605u PD=0.8u rfmode=0
M$2036 VDD \$459 \$458 VDD sg13_lv_pmos L=0.13u W=1u AS=0.3623875p AD=0.34p
+ PS=2.605u PD=2.68u rfmode=0
M$2037 VDD \$502 \$459 VDD sg13_lv_pmos L=0.13u W=0.42u AS=0.1563p AD=0.147p
+ PS=1.22u PD=1.54u rfmode=0
M$2038 VDD \$458 \$490 VDD sg13_lv_pmos L=0.13u W=0.42u AS=0.1563p AD=0.063p
+ PS=1.22u PD=0.72u rfmode=0
M$2039 \$490 \$461 \$459 VDD sg13_lv_pmos L=0.13u W=0.42u AS=0.063p AD=0.0798p
+ PS=0.72u PD=0.8u rfmode=0
M$2040 \$459 \$460 \$457 VDD sg13_lv_pmos L=0.13u W=0.42u AS=0.0798p AD=0.1428p
+ PS=0.8u PD=1.52u rfmode=0
M$2041 VDD \$461 \$460 VDD sg13_lv_pmos L=0.13u W=1.12u AS=0.41165p AD=0.3864p
+ PS=2.12u PD=2.93u rfmode=0
M$2042 VDD \$504 \$461 VDD sg13_lv_pmos L=0.13u W=1.12u AS=0.41165p AD=0.4088p
+ PS=2.12u PD=2.97u rfmode=0
M$2043 \$458 \$461 \$462 VDD sg13_lv_pmos L=0.13u W=1u AS=0.34p AD=0.2048p
+ PS=2.68u PD=1.63u rfmode=0
M$2044 \$462 \$460 \$492 VDD sg13_lv_pmos L=0.13u W=0.42u AS=0.2048p
+ AD=0.09345p PS=1.63u PD=0.865u rfmode=0
M$2045 VDD \$463 \$492 VDD sg13_lv_pmos L=0.13u W=0.42u AS=0.204p AD=0.09345p
+ PS=1.835u PD=0.865u rfmode=0
M$2046 VDD \$502 \$463 VDD sg13_lv_pmos L=0.13u W=0.42u AS=0.204p AD=0.0798p
+ PS=1.835u PD=0.8u rfmode=0
M$2047 VDD \$462 \$463 VDD sg13_lv_pmos L=0.13u W=0.42u AS=0.4659p AD=0.0798p
+ PS=3.65u PD=0.8u rfmode=0
M$2048 \$464 \$462 VDD VDD sg13_lv_pmos L=0.13u W=1.12u AS=0.3864p AD=0.2128p
+ PS=2.93u PD=1.5u rfmode=0
M$2049 VDD \$464 \$465 VDD sg13_lv_pmos L=0.13u W=1.12u AS=0.2128p AD=0.3808p
+ PS=1.5u PD=2.92u rfmode=0
M$2052 VDD \$924 \$466 VDD sg13_lv_pmos L=0.13u W=0.84u AS=0.253p AD=0.2856p
+ PS=1.53u PD=2.36u rfmode=0
M$2053 VDD \$924 \$493 VDD sg13_lv_pmos L=0.13u W=1u AS=0.253p AD=0.3325p
+ PS=1.53u PD=1.665u rfmode=0
M$2054 \$493 \$477 \$467 VDD sg13_lv_pmos L=0.13u W=1u AS=0.3325p AD=0.2225p
+ PS=1.665u PD=1.445u rfmode=0
M$2055 \$467 \$619 \$494 VDD sg13_lv_pmos L=0.13u W=1u AS=0.2225p AD=0.2975p
+ PS=1.445u PD=1.595u rfmode=0
M$2056 VDD \$466 \$494 VDD sg13_lv_pmos L=0.13u W=1u AS=0.2198p AD=0.2975p
+ PS=1.52u PD=1.595u rfmode=0
M$2057 VDD \$467 \$468 VDD sg13_lv_pmos L=0.13u W=1.12u AS=0.2198p AD=0.6048p
+ PS=1.52u PD=3.32u rfmode=0
M$2058 VDD \$468 \$469 VDD sg13_lv_pmos L=0.13u W=0.42u AS=0.1428p AD=0.0798p
+ PS=1.52u PD=0.8u rfmode=0
M$2059 VDD \$342 \$469 VDD sg13_lv_pmos L=0.13u W=0.42u AS=0.3623875p
+ AD=0.0798p PS=2.605u PD=0.8u rfmode=0
M$2060 VDD \$471 \$470 VDD sg13_lv_pmos L=0.13u W=1u AS=0.3623875p AD=0.34p
+ PS=2.605u PD=2.68u rfmode=0
M$2061 VDD \$342 \$471 VDD sg13_lv_pmos L=0.13u W=0.42u AS=0.1563p AD=0.147p
+ PS=1.22u PD=1.54u rfmode=0
M$2062 VDD \$470 \$491 VDD sg13_lv_pmos L=0.13u W=0.42u AS=0.1563p AD=0.063p
+ PS=1.22u PD=0.72u rfmode=0
M$2063 \$491 \$473 \$471 VDD sg13_lv_pmos L=0.13u W=0.42u AS=0.063p AD=0.0798p
+ PS=0.72u PD=0.8u rfmode=0
M$2064 \$471 \$472 \$469 VDD sg13_lv_pmos L=0.13u W=0.42u AS=0.0798p AD=0.1428p
+ PS=0.8u PD=1.52u rfmode=0
M$2065 VDD \$473 \$472 VDD sg13_lv_pmos L=0.13u W=1.12u AS=0.41165p AD=0.3864p
+ PS=2.12u PD=2.93u rfmode=0
M$2066 VDD \$504 \$473 VDD sg13_lv_pmos L=0.13u W=1.12u AS=0.41165p AD=0.4088p
+ PS=2.12u PD=2.97u rfmode=0
M$2067 \$470 \$473 \$474 VDD sg13_lv_pmos L=0.13u W=1u AS=0.34p AD=0.2048p
+ PS=2.68u PD=1.63u rfmode=0
M$2068 \$474 \$472 \$488 VDD sg13_lv_pmos L=0.13u W=0.42u AS=0.2048p
+ AD=0.09345p PS=1.63u PD=0.865u rfmode=0
M$2069 VDD \$475 \$488 VDD sg13_lv_pmos L=0.13u W=0.42u AS=0.204p AD=0.09345p
+ PS=1.835u PD=0.865u rfmode=0
M$2070 VDD \$342 \$475 VDD sg13_lv_pmos L=0.13u W=0.42u AS=0.204p AD=0.0798p
+ PS=1.835u PD=0.8u rfmode=0
M$2071 VDD \$474 \$475 VDD sg13_lv_pmos L=0.13u W=0.42u AS=0.4659p AD=0.0798p
+ PS=3.65u PD=0.8u rfmode=0
M$2072 \$476 \$474 VDD VDD sg13_lv_pmos L=0.13u W=1.12u AS=0.3864p AD=0.2128p
+ PS=2.93u PD=1.5u rfmode=0
M$2073 VDD \$476 \$477 VDD sg13_lv_pmos L=0.13u W=1.12u AS=0.2128p AD=0.3808p
+ PS=1.5u PD=2.92u rfmode=0
M$2085 \$478 \$477 VDD VDD sg13_lv_pmos L=0.13u W=0.84u AS=0.2856p AD=0.2114p
+ PS=2.36u PD=1.54u rfmode=0
M$2086 VDD \$478 \$42 VDD sg13_lv_pmos L=0.13u W=1.12u AS=0.2114p AD=0.42p
+ PS=1.54u PD=2.99u rfmode=0
M$2101 VDD \$409 \$539 VDD sg13_lv_pmos L=0.13u W=1.12u AS=0.3808p AD=0.3808p
+ PS=2.92u PD=2.92u rfmode=0
M$2102 VDD \$541 \$540 VDD sg13_lv_pmos L=0.13u W=0.42u AS=0.1428p AD=0.0798p
+ PS=1.52u PD=0.8u rfmode=0
M$2103 VDD \$539 \$540 VDD sg13_lv_pmos L=0.13u W=0.42u AS=0.3623875p
+ AD=0.0798p PS=2.605u PD=0.8u rfmode=0
M$2104 VDD \$580 \$542 VDD sg13_lv_pmos L=0.13u W=1u AS=0.3623875p AD=0.34p
+ PS=2.605u PD=2.68u rfmode=0
M$2105 \$581 \$544 VDD VDD sg13_lv_pmos L=0.13u W=1.12u AS=0.3864p AD=0.41165p
+ PS=2.93u PD=2.12u rfmode=0
M$2106 VDD \$496 \$544 VDD sg13_lv_pmos L=0.13u W=1.12u AS=0.41165p AD=0.4088p
+ PS=2.12u PD=2.97u rfmode=0
M$2107 \$546 \$581 \$585 VDD sg13_lv_pmos L=0.13u W=0.42u AS=0.2048p
+ AD=0.09345p PS=1.63u PD=0.865u rfmode=0
M$2108 \$585 \$547 VDD VDD sg13_lv_pmos L=0.13u W=0.42u AS=0.09345p AD=0.204p
+ PS=0.865u PD=1.835u rfmode=0
M$2109 VDD \$539 \$547 VDD sg13_lv_pmos L=0.13u W=0.42u AS=0.204p AD=0.0798p
+ PS=1.835u PD=0.8u rfmode=0
M$2110 \$547 \$546 VDD VDD sg13_lv_pmos L=0.13u W=0.42u AS=0.0798p AD=0.4659p
+ PS=0.8u PD=3.65u rfmode=0
M$2111 \$542 \$544 \$546 VDD sg13_lv_pmos L=0.13u W=1u AS=0.34p AD=0.2048p
+ PS=2.68u PD=1.63u rfmode=0
M$2112 \$548 \$546 VDD VDD sg13_lv_pmos L=0.13u W=1.12u AS=0.3864p AD=0.2128p
+ PS=2.93u PD=1.5u rfmode=0
M$2113 VDD \$548 \$406 VDD sg13_lv_pmos L=0.13u W=1.12u AS=0.2128p AD=0.3808p
+ PS=1.5u PD=2.92u rfmode=0
M$2114 VDD En \$549 VDD sg13_lv_pmos L=0.13u W=0.84u AS=0.2114p AD=0.2856p
+ PS=1.54u PD=2.36u rfmode=0
M$2115 VDD \$549 \$352 VDD sg13_lv_pmos L=0.13u W=1.12u AS=0.2114p AD=0.42p
+ PS=1.54u PD=2.99u rfmode=0
M$2116 \$496 \$550 VDD VDD sg13_lv_pmos L=0.13u W=1.12u AS=0.42p AD=0.2114p
+ PS=2.99u PD=1.54u rfmode=0
M$2117 VDD \$762 \$550 VDD sg13_lv_pmos L=0.13u W=0.84u AS=0.2114p AD=0.2856p
+ PS=1.54u PD=2.36u rfmode=0
M$2118 \$424 \$409 VDD VDD sg13_lv_pmos L=0.13u W=1.12u AS=0.3808p AD=0.3808p
+ PS=2.92u PD=2.92u rfmode=0
M$2119 VDD \$552 \$551 VDD sg13_lv_pmos L=0.13u W=0.42u AS=0.1428p AD=0.0798p
+ PS=1.52u PD=0.8u rfmode=0
M$2120 VDD \$582 \$551 VDD sg13_lv_pmos L=0.13u W=0.42u AS=0.3623875p
+ AD=0.0798p PS=2.605u PD=0.8u rfmode=0
M$2121 VDD \$583 \$553 VDD sg13_lv_pmos L=0.13u W=1u AS=0.3623875p AD=0.34p
+ PS=2.605u PD=2.68u rfmode=0
M$2122 \$584 \$555 VDD VDD sg13_lv_pmos L=0.13u W=1.12u AS=0.3864p AD=0.41165p
+ PS=2.93u PD=2.12u rfmode=0
M$2123 VDD \$498 \$555 VDD sg13_lv_pmos L=0.13u W=1.12u AS=0.41165p AD=0.4088p
+ PS=2.12u PD=2.97u rfmode=0
M$2124 \$557 \$584 \$586 VDD sg13_lv_pmos L=0.13u W=0.42u AS=0.2048p
+ AD=0.09345p PS=1.63u PD=0.865u rfmode=0
M$2125 \$586 \$558 VDD VDD sg13_lv_pmos L=0.13u W=0.42u AS=0.09345p AD=0.204p
+ PS=0.865u PD=1.835u rfmode=0
M$2126 VDD \$582 \$558 VDD sg13_lv_pmos L=0.13u W=0.42u AS=0.204p AD=0.0798p
+ PS=1.835u PD=0.8u rfmode=0
M$2127 \$558 \$557 VDD VDD sg13_lv_pmos L=0.13u W=0.42u AS=0.0798p AD=0.4659p
+ PS=0.8u PD=3.65u rfmode=0
M$2128 \$553 \$555 \$557 VDD sg13_lv_pmos L=0.13u W=1u AS=0.34p AD=0.2048p
+ PS=2.68u PD=1.63u rfmode=0
M$2129 \$559 \$557 VDD VDD sg13_lv_pmos L=0.13u W=1.12u AS=0.3864p AD=0.2128p
+ PS=2.93u PD=1.5u rfmode=0
M$2130 VDD \$559 \$560 VDD sg13_lv_pmos L=0.13u W=1.12u AS=0.2128p AD=0.3808p
+ PS=1.5u PD=2.92u rfmode=0
M$2131 VDD \$562 \$561 VDD sg13_lv_pmos L=0.5u W=1u AS=0.2254p AD=0.34p
+ PS=1.53u PD=2.68u rfmode=0
M$2132 \$351 \$561 VDD VDD sg13_lv_pmos L=0.13u W=1.12u AS=0.4256p AD=0.2254p
+ PS=3u PD=1.53u rfmode=0
M$2133 VDD \$560 \$563 VDD sg13_lv_pmos L=0.13u W=0.42u AS=0.1523p AD=0.1428p
+ PS=1.38u PD=1.52u rfmode=0
M$2134 \$562 \$563 VDD VDD sg13_lv_pmos L=0.5u W=1u AS=0.34p AD=0.1523p
+ PS=2.68u PD=1.38u rfmode=0
M$2135 VDD \$564 \$565 VDD sg13_lv_pmos L=0.13u W=17.92u AS=3.5896p AD=3.4048p
+ PS=25.45u PD=24u rfmode=0
M$2151 VDD \$675 \$564 VDD sg13_lv_pmos L=0.13u W=6.72u AS=1.2768p AD=1.4448p
+ PS=9u PD=10.42u rfmode=0
M$2157 VDD \$568 \$567 VDD sg13_lv_pmos L=0.5u W=1u AS=0.2254p AD=0.34p
+ PS=1.53u PD=2.68u rfmode=0
M$2158 \$566 \$567 VDD VDD sg13_lv_pmos L=0.13u W=1.12u AS=0.4256p AD=0.2254p
+ PS=3u PD=1.53u rfmode=0
M$2159 VDD \$453 \$569 VDD sg13_lv_pmos L=0.13u W=0.42u AS=0.1523p AD=0.1428p
+ PS=1.38u PD=1.52u rfmode=0
M$2160 \$568 \$569 VDD VDD sg13_lv_pmos L=0.5u W=1u AS=0.34p AD=0.1523p
+ PS=2.68u PD=1.38u rfmode=0
M$2161 VDD \$565 \$570 VDD sg13_lv_pmos L=0.13u W=6.72u AS=1.4448p AD=1.2768p
+ PS=10.42u PD=9u rfmode=0
M$2167 VDD \$570 \$369 VDD sg13_lv_pmos L=0.13u W=17.92u AS=3.4048p AD=3.5896p
+ PS=24u PD=25.45u rfmode=0
M$2183 VDD \$372 \$571 VDD sg13_lv_pmos L=0.13u W=0.84u AS=0.2198p AD=0.2856p
+ PS=1.53u PD=2.36u rfmode=0
M$2184 VDD \$571 \$349 VDD sg13_lv_pmos L=0.13u W=1.12u AS=0.3808p AD=0.2128p
+ PS=2.92u PD=1.5u rfmode=0
M$2185 \$349 \$310 VDD VDD sg13_lv_pmos L=0.13u W=1.12u AS=0.2128p AD=0.2198p
+ PS=1.5u PD=1.53u rfmode=0
M$2186 \$502 \$340 VDD VDD sg13_lv_pmos L=0.13u W=1.12u AS=0.3808p AD=0.3808p
+ PS=2.92u PD=2.92u rfmode=0
M$2200 \$504 \$572 VDD VDD sg13_lv_pmos L=0.13u W=1.12u AS=0.42p AD=0.2114p
+ PS=2.99u PD=1.54u rfmode=0
M$2201 VDD \$341 \$572 VDD sg13_lv_pmos L=0.13u W=0.84u AS=0.2114p AD=0.2856p
+ PS=1.54u PD=2.36u rfmode=0
M$2231 VDD \$314 \$598 VDD sg13_lv_pmos L=0.13u W=6.72u AS=1.4448p AD=1.2768p
+ PS=10.42u PD=9u rfmode=0
M$2237 VDD \$598 \$599 VDD sg13_lv_pmos L=0.13u W=17.92u AS=3.4048p AD=3.5896p
+ PS=24u PD=25.45u rfmode=0
M$2253 \$580 \$539 VDD VDD sg13_lv_pmos L=0.13u W=0.42u AS=0.147p AD=0.1563p
+ PS=1.54u PD=1.22u rfmode=0
M$2254 VDD \$542 \$590 VDD sg13_lv_pmos L=0.13u W=0.42u AS=0.1563p AD=0.063p
+ PS=1.22u PD=0.72u rfmode=0
M$2255 \$590 \$544 \$580 VDD sg13_lv_pmos L=0.13u W=0.42u AS=0.063p AD=0.0798p
+ PS=0.72u PD=0.8u rfmode=0
M$2256 \$580 \$581 \$540 VDD sg13_lv_pmos L=0.13u W=0.42u AS=0.0798p AD=0.1428p
+ PS=0.8u PD=1.52u rfmode=0
M$2257 \$600 \$628 VDD VDD sg13_lv_pmos L=0.13u W=1.12u AS=0.6048p AD=0.2198p
+ PS=3.32u PD=1.52u rfmode=0
M$2258 VDD \$601 \$622 VDD sg13_lv_pmos L=0.13u W=1u AS=0.2198p AD=0.2975p
+ PS=1.52u PD=1.595u rfmode=0
M$2259 \$622 \$349 \$628 VDD sg13_lv_pmos L=0.13u W=1u AS=0.2975p AD=0.2225p
+ PS=1.595u PD=1.445u rfmode=0
M$2260 \$628 \$710 \$623 VDD sg13_lv_pmos L=0.13u W=1u AS=0.2225p AD=0.3325p
+ PS=1.445u PD=1.665u rfmode=0
M$2261 \$623 \$602 VDD VDD sg13_lv_pmos L=0.13u W=1u AS=0.3325p AD=0.253p
+ PS=1.665u PD=1.53u rfmode=0
M$2262 VDD \$602 \$601 VDD sg13_lv_pmos L=0.13u W=0.84u AS=0.253p AD=0.2856p
+ PS=1.53u PD=2.36u rfmode=0
M$2264 VDD \$409 \$582 VDD sg13_lv_pmos L=0.13u W=1.12u AS=0.3808p AD=0.3808p
+ PS=2.92u PD=2.92u rfmode=0
M$2265 VDD \$603 \$498 VDD sg13_lv_pmos L=0.13u W=17.92u AS=3.5896p AD=3.4048p
+ PS=25.45u PD=24u rfmode=0
M$2281 VDD \$565 \$603 VDD sg13_lv_pmos L=0.13u W=6.72u AS=1.2768p AD=1.4448p
+ PS=9u PD=10.42u rfmode=0
M$2287 \$583 \$582 VDD VDD sg13_lv_pmos L=0.13u W=0.42u AS=0.147p AD=0.1563p
+ PS=1.54u PD=1.22u rfmode=0
M$2288 VDD \$553 \$596 VDD sg13_lv_pmos L=0.13u W=0.42u AS=0.1563p AD=0.063p
+ PS=1.22u PD=0.72u rfmode=0
M$2289 \$596 \$555 \$583 VDD sg13_lv_pmos L=0.13u W=0.42u AS=0.063p AD=0.0798p
+ PS=0.72u PD=0.8u rfmode=0
M$2290 \$583 \$584 \$551 VDD sg13_lv_pmos L=0.13u W=0.42u AS=0.0798p AD=0.1428p
+ PS=0.8u PD=1.52u rfmode=0
M$2291 VDD \$358 \$604 VDD sg13_lv_pmos L=0.13u W=1.12u AS=0.3808p AD=0.2128p
+ PS=2.92u PD=1.5u rfmode=0
M$2292 \$604 \$351 VDD VDD sg13_lv_pmos L=0.13u W=1.12u AS=0.2128p AD=0.2128p
+ PS=1.5u PD=1.5u rfmode=0
M$2293 VDD \$355 \$604 VDD sg13_lv_pmos L=0.13u W=1.12u AS=0.2128p AD=0.2128p
+ PS=1.5u PD=1.5u rfmode=0
M$2294 \$604 \$352 VDD VDD sg13_lv_pmos L=0.13u W=1.12u AS=0.2128p AD=0.3808p
+ PS=1.5u PD=2.92u rfmode=0
M$2295 VDD \$352 \$605 VDD sg13_lv_pmos L=0.13u W=1.12u AS=0.3808p AD=0.2128p
+ PS=2.92u PD=1.5u rfmode=0
M$2296 \$605 \$389 VDD VDD sg13_lv_pmos L=0.13u W=1.12u AS=0.2128p AD=0.3808p
+ PS=1.5u PD=2.92u rfmode=0
M$2297 \$365 \$604 \$624 VDD sg13_lv_pmos L=0.13u W=1.12u AS=0.3808p AD=0.2128p
+ PS=2.92u PD=1.5u rfmode=0
M$2298 \$624 \$389 \$625 VDD sg13_lv_pmos L=0.13u W=1.12u AS=0.2128p AD=0.2464p
+ PS=1.5u PD=1.56u rfmode=0
M$2299 \$625 \$566 VDD VDD sg13_lv_pmos L=0.13u W=1.12u AS=0.2464p AD=0.3808p
+ PS=1.56u PD=2.92u rfmode=0
M$2300 VDD \$666 \$606 VDD sg13_lv_pmos L=0.13u W=0.84u AS=0.2198p AD=0.2856p
+ PS=1.53u PD=2.36u rfmode=0
M$2301 VDD \$352 \$607 VDD sg13_lv_pmos L=0.13u W=1.12u AS=0.2198p AD=0.2128p
+ PS=1.53u PD=1.5u rfmode=0
M$2302 \$607 \$608 VDD VDD sg13_lv_pmos L=0.13u W=1.12u AS=0.2128p AD=0.2128p
+ PS=1.5u PD=1.5u rfmode=0
M$2303 VDD \$606 \$607 VDD sg13_lv_pmos L=0.13u W=1.12u AS=0.2128p AD=0.3808p
+ PS=1.5u PD=2.92u rfmode=0
M$2304 VDD \$566 \$610 VDD sg13_lv_pmos L=0.13u W=0.84u AS=0.2856p AD=0.1596p
+ PS=2.36u PD=1.22u rfmode=0
M$2305 \$610 \$442 VDD VDD sg13_lv_pmos L=0.13u W=0.84u AS=0.1596p AD=0.1918p
+ PS=1.22u PD=1.5u rfmode=0
M$2306 VDD \$610 \$509 VDD sg13_lv_pmos L=0.13u W=1.12u AS=0.1918p AD=0.3808p
+ PS=1.5u PD=2.92u rfmode=0
M$2307 VDD \$629 \$500 VDD sg13_lv_pmos L=0.13u W=1.12u AS=0.3808p AD=0.3808p
+ PS=2.92u PD=2.92u rfmode=0
M$2308 \$618 \$616 VDD VDD sg13_lv_pmos L=0.13u W=1.12u AS=0.3864p AD=0.2128p
+ PS=2.93u PD=1.5u rfmode=0
M$2309 VDD \$618 \$608 VDD sg13_lv_pmos L=0.13u W=1.12u AS=0.2128p AD=0.3808p
+ PS=1.5u PD=2.92u rfmode=0
M$2312 VDD \$619 \$620 VDD sg13_lv_pmos L=0.13u W=0.84u AS=0.2114p AD=0.2856p
+ PS=1.54u PD=2.36u rfmode=0
M$2313 \$685 \$620 VDD VDD sg13_lv_pmos L=0.13u W=1.12u AS=0.42p AD=0.2114p
+ PS=2.99u PD=1.54u rfmode=0
M$2314 VDD \$340 \$621 VDD sg13_lv_pmos L=0.13u W=1.12u AS=0.3808p AD=0.3808p
+ PS=2.92u PD=2.92u rfmode=0
M$2347 \$33 \$650 VDD VDD sg13_lv_pmos L=0.13u W=1.12u AS=0.42p AD=0.2114p
+ PS=2.99u PD=1.54u rfmode=0
M$2348 VDD \$710 \$650 VDD sg13_lv_pmos L=0.13u W=0.84u AS=0.2114p AD=0.2856p
+ PS=1.54u PD=2.36u rfmode=0
M$2363 VDD \$924 \$652 VDD sg13_lv_pmos L=0.13u W=0.84u AS=0.253p AD=0.2856p
+ PS=1.53u PD=2.36u rfmode=0
M$2364 VDD \$652 \$719 VDD sg13_lv_pmos L=0.13u W=1u AS=0.2198p AD=0.2975p
+ PS=1.52u PD=1.595u rfmode=0
M$2365 \$719 \$349 \$651 VDD sg13_lv_pmos L=0.13u W=1u AS=0.2975p AD=0.2225p
+ PS=1.595u PD=1.445u rfmode=0
M$2366 \$651 \$406 \$721 VDD sg13_lv_pmos L=0.13u W=1u AS=0.2225p AD=0.3325p
+ PS=1.445u PD=1.665u rfmode=0
M$2367 \$721 \$924 VDD VDD sg13_lv_pmos L=0.13u W=1u AS=0.3325p AD=0.253p
+ PS=1.665u PD=1.53u rfmode=0
M$2368 \$541 \$651 VDD VDD sg13_lv_pmos L=0.13u W=1.12u AS=0.6048p AD=0.2198p
+ PS=3.32u PD=1.52u rfmode=0
M$2370 VDD \$409 \$653 VDD sg13_lv_pmos L=0.13u W=1.12u AS=0.3808p AD=0.3808p
+ PS=2.92u PD=2.92u rfmode=0
M$2371 VDD \$600 \$654 VDD sg13_lv_pmos L=0.13u W=0.42u AS=0.1428p AD=0.0798p
+ PS=1.52u PD=0.8u rfmode=0
M$2372 VDD \$653 \$654 VDD sg13_lv_pmos L=0.13u W=0.42u AS=0.3623875p
+ AD=0.0798p PS=2.605u PD=0.8u rfmode=0
M$2373 VDD \$711 \$655 VDD sg13_lv_pmos L=0.13u W=1u AS=0.3623875p AD=0.34p
+ PS=2.605u PD=2.68u rfmode=0
M$2374 \$712 \$657 VDD VDD sg13_lv_pmos L=0.13u W=1.12u AS=0.3864p AD=0.41165p
+ PS=2.93u PD=2.12u rfmode=0
M$2375 VDD \$496 \$657 VDD sg13_lv_pmos L=0.13u W=1.12u AS=0.41165p AD=0.4088p
+ PS=2.12u PD=2.97u rfmode=0
M$2376 \$659 \$712 \$718 VDD sg13_lv_pmos L=0.13u W=0.42u AS=0.2048p
+ AD=0.09345p PS=1.63u PD=0.865u rfmode=0
M$2377 \$718 \$660 VDD VDD sg13_lv_pmos L=0.13u W=0.42u AS=0.09345p AD=0.204p
+ PS=0.865u PD=1.835u rfmode=0
M$2378 VDD \$653 \$660 VDD sg13_lv_pmos L=0.13u W=0.42u AS=0.204p AD=0.0798p
+ PS=1.835u PD=0.8u rfmode=0
M$2379 \$660 \$659 VDD VDD sg13_lv_pmos L=0.13u W=0.42u AS=0.0798p AD=0.4659p
+ PS=0.8u PD=3.65u rfmode=0
M$2380 \$655 \$657 \$659 VDD sg13_lv_pmos L=0.13u W=1u AS=0.34p AD=0.2048p
+ PS=2.68u PD=1.63u rfmode=0
M$2381 \$661 \$659 VDD VDD sg13_lv_pmos L=0.13u W=1.12u AS=0.3864p AD=0.2128p
+ PS=2.93u PD=1.5u rfmode=0
M$2382 VDD \$661 \$710 VDD sg13_lv_pmos L=0.13u W=1.12u AS=0.2128p AD=0.3808p
+ PS=1.5u PD=2.92u rfmode=0
M$2383 \$552 \$663 VDD VDD sg13_lv_pmos L=0.13u W=1.12u AS=0.3808p AD=0.1918p
+ PS=2.92u PD=1.5u rfmode=0
M$2384 VDD \$662 \$663 VDD sg13_lv_pmos L=0.13u W=0.84u AS=0.1918p AD=0.1596p
+ PS=1.5u PD=1.22u rfmode=0
M$2385 \$663 \$317 VDD VDD sg13_lv_pmos L=0.13u W=0.84u AS=0.1596p AD=0.2856p
+ PS=1.22u PD=2.36u rfmode=0
M$2386 \$662 \$664 VDD VDD sg13_lv_pmos L=0.13u W=1.12u AS=0.3808p AD=0.3808p
+ PS=2.92u PD=2.92u rfmode=0
M$2387 \$664 \$351 \$713 VDD sg13_lv_pmos L=0.13u W=1u AS=0.35p AD=0.2125p
+ PS=2.7u PD=1.425u rfmode=0
M$2388 \$713 \$352 VDD VDD sg13_lv_pmos L=0.13u W=1u AS=0.2125p AD=0.19p
+ PS=1.425u PD=1.38u rfmode=0
M$2389 VDD \$354 \$713 VDD sg13_lv_pmos L=0.13u W=1u AS=0.19p AD=0.34p PS=1.38u
+ PD=2.68u rfmode=0
M$2390 \$665 \$666 VDD VDD sg13_lv_pmos L=0.13u W=1.12u AS=0.3808p AD=0.3808p
+ PS=2.92u PD=2.92u rfmode=0
M$2391 \$667 \$668 VDD VDD sg13_lv_pmos L=0.13u W=1.12u AS=0.42p AD=0.2114p
+ PS=2.99u PD=1.54u rfmode=0
M$2392 VDD \$325 \$668 VDD sg13_lv_pmos L=0.13u W=0.84u AS=0.2114p AD=0.2856p
+ PS=1.54u PD=2.36u rfmode=0
M$2393 VDD \$667 \$669 VDD sg13_lv_pmos L=0.13u W=0.84u AS=0.2114p AD=0.2856p
+ PS=1.54u PD=2.36u rfmode=0
M$2394 VDD \$669 \$629 VDD sg13_lv_pmos L=0.13u W=1.12u AS=0.2114p AD=0.42p
+ PS=1.54u PD=2.99u rfmode=0
M$2395 \$671 \$670 VDD VDD sg13_lv_pmos L=0.13u W=1.12u AS=0.3808p AD=0.3808p
+ PS=2.92u PD=2.92u rfmode=0
M$2396 \$670 \$791 \$714 VDD sg13_lv_pmos L=0.13u W=1u AS=0.35p AD=0.2125p
+ PS=2.7u PD=1.425u rfmode=0
M$2397 \$714 \$666 VDD VDD sg13_lv_pmos L=0.13u W=1u AS=0.2125p AD=0.19p
+ PS=1.425u PD=1.38u rfmode=0
M$2398 VDD \$605 \$714 VDD sg13_lv_pmos L=0.13u W=1u AS=0.19p AD=0.34p PS=1.38u
+ PD=2.68u rfmode=0
M$2399 VDD \$389 \$727 VDD sg13_lv_pmos L=0.15u W=1.12u AS=0.3808p AD=0.2128p
+ PS=2.92u PD=1.5u rfmode=0
M$2400 \$727 \$665 \$673 VDD sg13_lv_pmos L=0.15u W=1.12u AS=0.2128p AD=0.2128p
+ PS=1.5u PD=1.5u rfmode=0
M$2401 \$673 \$352 VDD VDD sg13_lv_pmos L=0.15u W=1.12u AS=0.2128p AD=0.3808p
+ PS=1.5u PD=2.92u rfmode=0
M$2402 VDD fclk_in \$674 VDD sg13_lv_pmos L=0.13u W=6.72u AS=1.4448p AD=1.2768p
+ PS=10.42u PD=9u rfmode=0
M$2408 VDD \$674 \$675 VDD sg13_lv_pmos L=0.13u W=17.92u AS=3.4048p AD=3.5896p
+ PS=24u PD=25.45u rfmode=0
M$2424 VDD \$443 \$611 VDD sg13_lv_pmos L=0.13u W=0.42u AS=0.1428p AD=0.0798p
+ PS=1.52u PD=0.8u rfmode=0
M$2425 VDD \$609 \$611 VDD sg13_lv_pmos L=0.13u W=0.42u AS=0.3623875p
+ AD=0.0798p PS=2.605u PD=0.8u rfmode=0
M$2426 VDD \$612 \$613 VDD sg13_lv_pmos L=0.13u W=1u AS=0.3623875p AD=0.34p
+ PS=2.605u PD=2.68u rfmode=0
M$2427 VDD \$609 \$612 VDD sg13_lv_pmos L=0.13u W=0.42u AS=0.1563p AD=0.147p
+ PS=1.22u PD=1.54u rfmode=0
M$2428 VDD \$613 \$626 VDD sg13_lv_pmos L=0.13u W=0.42u AS=0.1563p AD=0.063p
+ PS=1.22u PD=0.72u rfmode=0
M$2429 \$626 \$615 \$612 VDD sg13_lv_pmos L=0.13u W=0.42u AS=0.063p AD=0.0798p
+ PS=0.72u PD=0.8u rfmode=0
M$2430 \$612 \$614 \$611 VDD sg13_lv_pmos L=0.13u W=0.42u AS=0.0798p AD=0.1428p
+ PS=0.8u PD=1.52u rfmode=0
M$2431 fdac_clk \$677 VDD VDD sg13_lv_pmos L=0.13u W=1.12u AS=0.42p AD=0.2114p
+ PS=2.99u PD=1.54u rfmode=0
M$2432 VDD \$336 \$677 VDD sg13_lv_pmos L=0.13u W=0.84u AS=0.2114p AD=0.2856p
+ PS=1.54u PD=2.36u rfmode=0
M$2433 VDD \$615 \$614 VDD sg13_lv_pmos L=0.13u W=1.12u AS=0.41165p AD=0.3864p
+ PS=2.12u PD=2.93u rfmode=0
M$2434 VDD \$369 \$615 VDD sg13_lv_pmos L=0.13u W=1.12u AS=0.41165p AD=0.4088p
+ PS=2.12u PD=2.97u rfmode=0
M$2435 VDD \$419 \$678 VDD sg13_lv_pmos L=0.13u W=1.12u AS=0.3808p AD=0.3808p
+ PS=2.92u PD=2.92u rfmode=0
M$2436 \$613 \$615 \$616 VDD sg13_lv_pmos L=0.13u W=1u AS=0.34p AD=0.2048p
+ PS=2.68u PD=1.63u rfmode=0
M$2437 \$616 \$614 \$627 VDD sg13_lv_pmos L=0.13u W=0.42u AS=0.2048p
+ AD=0.09345p PS=1.63u PD=0.865u rfmode=0
M$2438 VDD \$617 \$627 VDD sg13_lv_pmos L=0.13u W=0.42u AS=0.204p AD=0.09345p
+ PS=1.835u PD=0.865u rfmode=0
M$2439 VDD \$609 \$617 VDD sg13_lv_pmos L=0.13u W=0.42u AS=0.204p AD=0.0798p
+ PS=1.835u PD=0.8u rfmode=0
M$2440 VDD \$616 \$617 VDD sg13_lv_pmos L=0.13u W=0.42u AS=0.4659p AD=0.0798p
+ PS=3.65u PD=0.8u rfmode=0
M$2441 \$389 \$679 VDD VDD sg13_lv_pmos L=0.13u W=1.12u AS=0.3808p AD=0.3808p
+ PS=2.92u PD=2.92u rfmode=0
M$2442 VDD \$681 \$680 VDD sg13_lv_pmos L=0.5u W=1u AS=0.2254p AD=0.34p
+ PS=1.53u PD=2.68u rfmode=0
M$2443 \$679 \$680 VDD VDD sg13_lv_pmos L=0.13u W=1.12u AS=0.4256p AD=0.2254p
+ PS=3u PD=1.53u rfmode=0
M$2444 VDD \$608 \$682 VDD sg13_lv_pmos L=0.13u W=0.42u AS=0.1523p AD=0.1428p
+ PS=1.38u PD=1.52u rfmode=0
M$2445 \$681 \$682 VDD VDD sg13_lv_pmos L=0.5u W=1u AS=0.34p AD=0.1523p
+ PS=2.68u PD=1.38u rfmode=0
M$2446 \$683 \$602 VDD VDD sg13_lv_pmos L=0.13u W=0.84u AS=0.2856p AD=0.253p
+ PS=2.36u PD=1.53u rfmode=0
M$2447 VDD \$602 \$723 VDD sg13_lv_pmos L=0.13u W=1u AS=0.253p AD=0.3325p
+ PS=1.53u PD=1.665u rfmode=0
M$2448 \$723 \$686 \$684 VDD sg13_lv_pmos L=0.13u W=1u AS=0.3325p AD=0.2225p
+ PS=1.665u PD=1.445u rfmode=0
M$2449 \$684 \$685 \$722 VDD sg13_lv_pmos L=0.13u W=1u AS=0.2225p AD=0.2975p
+ PS=1.445u PD=1.595u rfmode=0
M$2450 \$722 \$683 VDD VDD sg13_lv_pmos L=0.13u W=1u AS=0.2975p AD=0.2198p
+ PS=1.595u PD=1.52u rfmode=0
M$2451 VDD \$684 \$687 VDD sg13_lv_pmos L=0.13u W=1.12u AS=0.2198p AD=0.6048p
+ PS=1.52u PD=3.32u rfmode=0
M$2452 VDD \$687 \$688 VDD sg13_lv_pmos L=0.13u W=0.42u AS=0.1428p AD=0.0798p
+ PS=1.52u PD=0.8u rfmode=0
M$2453 VDD \$621 \$688 VDD sg13_lv_pmos L=0.13u W=0.42u AS=0.3623875p
+ AD=0.0798p PS=2.605u PD=0.8u rfmode=0
M$2454 VDD \$715 \$689 VDD sg13_lv_pmos L=0.13u W=1u AS=0.3623875p AD=0.34p
+ PS=2.605u PD=2.68u rfmode=0
M$2455 \$716 \$691 VDD VDD sg13_lv_pmos L=0.13u W=1.12u AS=0.3864p AD=0.41165p
+ PS=2.93u PD=2.12u rfmode=0
M$2456 VDD \$504 \$691 VDD sg13_lv_pmos L=0.13u W=1.12u AS=0.41165p AD=0.4088p
+ PS=2.12u PD=2.97u rfmode=0
M$2457 \$693 \$716 \$717 VDD sg13_lv_pmos L=0.13u W=0.42u AS=0.2048p
+ AD=0.09345p PS=1.63u PD=0.865u rfmode=0
M$2458 \$717 \$694 VDD VDD sg13_lv_pmos L=0.13u W=0.42u AS=0.09345p AD=0.204p
+ PS=0.865u PD=1.835u rfmode=0
M$2459 VDD \$621 \$694 VDD sg13_lv_pmos L=0.13u W=0.42u AS=0.204p AD=0.0798p
+ PS=1.835u PD=0.8u rfmode=0
M$2460 \$694 \$693 VDD VDD sg13_lv_pmos L=0.13u W=0.42u AS=0.0798p AD=0.4659p
+ PS=0.8u PD=3.65u rfmode=0
M$2461 \$689 \$691 \$693 VDD sg13_lv_pmos L=0.13u W=1u AS=0.34p AD=0.2048p
+ PS=2.68u PD=1.63u rfmode=0
M$2462 \$695 \$693 VDD VDD sg13_lv_pmos L=0.13u W=1.12u AS=0.3864p AD=0.2128p
+ PS=2.93u PD=1.5u rfmode=0
M$2463 VDD \$695 \$686 VDD sg13_lv_pmos L=0.13u W=1.12u AS=0.2128p AD=0.3808p
+ PS=1.5u PD=2.92u rfmode=0
M$2489 VDD \$686 \$696 VDD sg13_lv_pmos L=0.13u W=0.84u AS=0.2114p AD=0.2856p
+ PS=1.54u PD=2.36u rfmode=0
M$2490 VDD \$696 \$36 VDD sg13_lv_pmos L=0.13u W=1.12u AS=0.2114p AD=0.42p
+ PS=1.54u PD=2.99u rfmode=0
M$2513 \$711 \$653 VDD VDD sg13_lv_pmos L=0.13u W=0.42u AS=0.147p AD=0.1563p
+ PS=1.54u PD=1.22u rfmode=0
M$2514 VDD \$655 \$724 VDD sg13_lv_pmos L=0.13u W=0.42u AS=0.1563p AD=0.063p
+ PS=1.22u PD=0.72u rfmode=0
M$2515 \$724 \$657 \$711 VDD sg13_lv_pmos L=0.13u W=0.42u AS=0.063p AD=0.0798p
+ PS=0.72u PD=0.8u rfmode=0
M$2516 \$711 \$712 \$654 VDD sg13_lv_pmos L=0.13u W=0.42u AS=0.0798p AD=0.1428p
+ PS=0.8u PD=1.52u rfmode=0
M$2518 \$728 \$761 VDD VDD sg13_lv_pmos L=0.13u W=1.12u AS=0.6048p AD=0.2198p
+ PS=3.32u PD=1.52u rfmode=0
M$2519 VDD \$729 \$754 VDD sg13_lv_pmos L=0.13u W=1u AS=0.2198p AD=0.2975p
+ PS=1.52u PD=1.595u rfmode=0
M$2520 \$754 \$349 \$761 VDD sg13_lv_pmos L=0.13u W=1u AS=0.2975p AD=0.2225p
+ PS=1.595u PD=1.445u rfmode=0
M$2521 \$761 \$730 \$755 VDD sg13_lv_pmos L=0.13u W=1u AS=0.2225p AD=0.3325p
+ PS=1.445u PD=1.665u rfmode=0
M$2522 \$755 \$731 VDD VDD sg13_lv_pmos L=0.13u W=1u AS=0.3325p AD=0.253p
+ PS=1.665u PD=1.53u rfmode=0
M$2523 VDD \$731 \$729 VDD sg13_lv_pmos L=0.13u W=0.84u AS=0.253p AD=0.2856p
+ PS=1.53u PD=2.36u rfmode=0
M$2528 \$433 \$629 VDD VDD sg13_lv_pmos L=0.13u W=1.12u AS=0.3808p AD=0.3808p
+ PS=2.92u PD=2.92u rfmode=0
M$2529 VDD \$667 \$732 VDD sg13_lv_pmos L=0.13u W=0.84u AS=0.2114p AD=0.2856p
+ PS=1.54u PD=2.36u rfmode=0
M$2530 \$419 \$732 VDD VDD sg13_lv_pmos L=0.13u W=1.12u AS=0.42p AD=0.2114p
+ PS=2.99u PD=1.54u rfmode=0
M$2531 VDD \$671 \$733 VDD sg13_lv_pmos L=0.13u W=0.42u AS=0.1428p AD=0.0798p
+ PS=1.52u PD=0.8u rfmode=0
M$2532 VDD \$736 \$733 VDD sg13_lv_pmos L=0.13u W=0.42u AS=0.3623875p
+ AD=0.0798p PS=2.605u PD=0.8u rfmode=0
M$2533 VDD \$734 \$735 VDD sg13_lv_pmos L=0.13u W=1u AS=0.3623875p AD=0.34p
+ PS=2.605u PD=2.68u rfmode=0
M$2534 VDD \$736 \$734 VDD sg13_lv_pmos L=0.13u W=0.42u AS=0.1563p AD=0.147p
+ PS=1.22u PD=1.54u rfmode=0
M$2535 VDD \$735 \$756 VDD sg13_lv_pmos L=0.13u W=0.42u AS=0.1563p AD=0.063p
+ PS=1.22u PD=0.72u rfmode=0
M$2536 \$756 \$738 \$734 VDD sg13_lv_pmos L=0.13u W=0.42u AS=0.063p AD=0.0798p
+ PS=0.72u PD=0.8u rfmode=0
M$2537 \$734 \$737 \$733 VDD sg13_lv_pmos L=0.13u W=0.42u AS=0.0798p AD=0.1428p
+ PS=0.8u PD=1.52u rfmode=0
M$2538 VDD \$738 \$737 VDD sg13_lv_pmos L=0.13u W=1.12u AS=0.41165p AD=0.3864p
+ PS=2.12u PD=2.93u rfmode=0
M$2539 VDD \$762 \$738 VDD sg13_lv_pmos L=0.13u W=1.12u AS=0.41165p AD=0.4088p
+ PS=2.12u PD=2.97u rfmode=0
M$2540 \$735 \$738 \$739 VDD sg13_lv_pmos L=0.13u W=1u AS=0.34p AD=0.2048p
+ PS=2.68u PD=1.63u rfmode=0
M$2541 \$739 \$737 \$757 VDD sg13_lv_pmos L=0.13u W=0.42u AS=0.2048p
+ AD=0.09345p PS=1.63u PD=0.865u rfmode=0
M$2542 VDD \$740 \$757 VDD sg13_lv_pmos L=0.13u W=0.42u AS=0.204p AD=0.09345p
+ PS=1.835u PD=0.865u rfmode=0
M$2543 VDD \$736 \$740 VDD sg13_lv_pmos L=0.13u W=0.42u AS=0.204p AD=0.0798p
+ PS=1.835u PD=0.8u rfmode=0
M$2544 VDD \$739 \$740 VDD sg13_lv_pmos L=0.13u W=0.42u AS=0.4659p AD=0.0798p
+ PS=3.65u PD=0.8u rfmode=0
M$2545 \$741 \$739 VDD VDD sg13_lv_pmos L=0.13u W=1.12u AS=0.3864p AD=0.2128p
+ PS=2.93u PD=1.5u rfmode=0
M$2546 VDD \$741 \$666 VDD sg13_lv_pmos L=0.13u W=1.12u AS=0.2128p AD=0.3808p
+ PS=1.5u PD=2.92u rfmode=0
M$2547 VDD \$629 \$609 VDD sg13_lv_pmos L=0.13u W=1.12u AS=0.3808p AD=0.3808p
+ PS=2.92u PD=2.92u rfmode=0
M$2548 VDD \$673 \$742 VDD sg13_lv_pmos L=0.13u W=1.12u AS=0.3808p AD=0.2128p
+ PS=2.92u PD=1.5u rfmode=0
M$2549 \$742 \$765 VDD VDD sg13_lv_pmos L=0.13u W=1.12u AS=0.2128p AD=0.3808p
+ PS=1.5u PD=2.92u rfmode=0
M$2550 VDD \$765 \$758 VDD sg13_lv_pmos L=0.15u W=1.12u AS=0.3808p AD=0.2128p
+ PS=2.92u PD=1.5u rfmode=0
M$2551 \$758 \$794 \$743 VDD sg13_lv_pmos L=0.15u W=1.12u AS=0.2128p AD=0.2128p
+ PS=1.5u PD=1.5u rfmode=0
M$2552 \$743 \$742 VDD VDD sg13_lv_pmos L=0.15u W=1.12u AS=0.2128p AD=0.3808p
+ PS=1.5u PD=2.92u rfmode=0
M$2553 VDD \$743 \$744 VDD sg13_lv_pmos L=0.13u W=0.42u AS=0.1428p AD=0.0798p
+ PS=1.52u PD=0.8u rfmode=0
M$2554 VDD \$678 \$744 VDD sg13_lv_pmos L=0.13u W=0.42u AS=0.3623875p
+ AD=0.0798p PS=2.605u PD=0.8u rfmode=0
M$2555 VDD \$745 \$746 VDD sg13_lv_pmos L=0.13u W=1u AS=0.3623875p AD=0.34p
+ PS=2.605u PD=2.68u rfmode=0
M$2556 VDD \$678 \$745 VDD sg13_lv_pmos L=0.13u W=0.42u AS=0.1563p AD=0.147p
+ PS=1.22u PD=1.54u rfmode=0
M$2557 VDD \$746 \$759 VDD sg13_lv_pmos L=0.13u W=0.42u AS=0.1563p AD=0.063p
+ PS=1.22u PD=0.72u rfmode=0
M$2558 \$759 \$748 \$745 VDD sg13_lv_pmos L=0.13u W=0.42u AS=0.063p AD=0.0798p
+ PS=0.72u PD=0.8u rfmode=0
M$2559 \$745 \$747 \$744 VDD sg13_lv_pmos L=0.13u W=0.42u AS=0.0798p AD=0.1428p
+ PS=0.8u PD=1.52u rfmode=0
M$2560 VDD \$748 \$747 VDD sg13_lv_pmos L=0.13u W=1.12u AS=0.41165p AD=0.3864p
+ PS=2.12u PD=2.93u rfmode=0
M$2561 VDD \$762 \$748 VDD sg13_lv_pmos L=0.13u W=1.12u AS=0.41165p AD=0.4088p
+ PS=2.12u PD=2.97u rfmode=0
M$2562 \$746 \$748 \$749 VDD sg13_lv_pmos L=0.13u W=1u AS=0.34p AD=0.2048p
+ PS=2.68u PD=1.63u rfmode=0
M$2563 \$749 \$747 \$760 VDD sg13_lv_pmos L=0.13u W=0.42u AS=0.2048p
+ AD=0.09345p PS=1.63u PD=0.865u rfmode=0
M$2564 VDD \$750 \$760 VDD sg13_lv_pmos L=0.13u W=0.42u AS=0.204p AD=0.09345p
+ PS=1.835u PD=0.865u rfmode=0
M$2565 VDD \$678 \$750 VDD sg13_lv_pmos L=0.13u W=0.42u AS=0.204p AD=0.0798p
+ PS=1.835u PD=0.8u rfmode=0
M$2566 VDD \$749 \$750 VDD sg13_lv_pmos L=0.13u W=0.42u AS=0.4659p AD=0.0798p
+ PS=3.65u PD=0.8u rfmode=0
M$2567 \$751 \$749 VDD VDD sg13_lv_pmos L=0.13u W=1.12u AS=0.3864p AD=0.2128p
+ PS=2.93u PD=1.5u rfmode=0
M$2568 VDD \$751 \$765 VDD sg13_lv_pmos L=0.13u W=1.12u AS=0.2128p AD=0.3808p
+ PS=1.5u PD=2.92u rfmode=0
M$2571 VDD \$339 \$752 VDD sg13_lv_pmos L=0.13u W=0.84u AS=0.2114p AD=0.2856p
+ PS=1.54u PD=2.36u rfmode=0
M$2572 \$619 \$752 VDD VDD sg13_lv_pmos L=0.13u W=1.12u AS=0.42p AD=0.2114p
+ PS=2.99u PD=1.54u rfmode=0
M$2575 \$715 \$621 VDD VDD sg13_lv_pmos L=0.13u W=0.42u AS=0.147p AD=0.1563p
+ PS=1.54u PD=1.22u rfmode=0
M$2576 VDD \$689 \$720 VDD sg13_lv_pmos L=0.13u W=0.42u AS=0.1563p AD=0.063p
+ PS=1.22u PD=0.72u rfmode=0
M$2577 \$720 \$691 \$715 VDD sg13_lv_pmos L=0.13u W=0.42u AS=0.063p AD=0.0798p
+ PS=0.72u PD=0.8u rfmode=0
M$2578 \$715 \$716 \$688 VDD sg13_lv_pmos L=0.13u W=0.42u AS=0.0798p AD=0.1428p
+ PS=0.8u PD=1.52u rfmode=0
M$2580 VDD \$340 \$753 VDD sg13_lv_pmos L=0.13u W=1.12u AS=0.3808p AD=0.3808p
+ PS=2.92u PD=2.92u rfmode=0
M$2631 VDD \$409 \$781 VDD sg13_lv_pmos L=0.13u W=1.12u AS=0.3808p AD=0.3808p
+ PS=2.92u PD=2.92u rfmode=0
M$2632 VDD \$728 \$782 VDD sg13_lv_pmos L=0.13u W=0.42u AS=0.1428p AD=0.0798p
+ PS=1.52u PD=0.8u rfmode=0
M$2633 VDD \$781 \$782 VDD sg13_lv_pmos L=0.13u W=0.42u AS=0.3623875p
+ AD=0.0798p PS=2.605u PD=0.8u rfmode=0
M$2634 VDD \$817 \$783 VDD sg13_lv_pmos L=0.13u W=1u AS=0.3623875p AD=0.34p
+ PS=2.605u PD=2.68u rfmode=0
M$2635 \$818 \$785 VDD VDD sg13_lv_pmos L=0.13u W=1.12u AS=0.3864p AD=0.41165p
+ PS=2.93u PD=2.12u rfmode=0
M$2636 VDD \$496 \$785 VDD sg13_lv_pmos L=0.13u W=1.12u AS=0.41165p AD=0.4088p
+ PS=2.12u PD=2.97u rfmode=0
M$2637 \$787 \$818 \$823 VDD sg13_lv_pmos L=0.13u W=0.42u AS=0.2048p
+ AD=0.09345p PS=1.63u PD=0.865u rfmode=0
M$2638 \$823 \$788 VDD VDD sg13_lv_pmos L=0.13u W=0.42u AS=0.09345p AD=0.204p
+ PS=0.865u PD=1.835u rfmode=0
M$2639 VDD \$781 \$788 VDD sg13_lv_pmos L=0.13u W=0.42u AS=0.204p AD=0.0798p
+ PS=1.835u PD=0.8u rfmode=0
M$2640 \$788 \$787 VDD VDD sg13_lv_pmos L=0.13u W=0.42u AS=0.0798p AD=0.4659p
+ PS=0.8u PD=3.65u rfmode=0
M$2641 \$783 \$785 \$787 VDD sg13_lv_pmos L=0.13u W=1u AS=0.34p AD=0.2048p
+ PS=2.68u PD=1.63u rfmode=0
M$2642 \$789 \$787 VDD VDD sg13_lv_pmos L=0.13u W=1.12u AS=0.3864p AD=0.2128p
+ PS=2.93u PD=1.5u rfmode=0
M$2643 VDD \$789 \$730 VDD sg13_lv_pmos L=0.13u W=1.12u AS=0.2128p AD=0.3808p
+ PS=1.5u PD=2.92u rfmode=0
M$2646 VDD \$419 \$736 VDD sg13_lv_pmos L=0.13u W=1.12u AS=0.3808p AD=0.3808p
+ PS=2.92u PD=2.92u rfmode=0
M$2649 \$791 \$790 \$835 VDD sg13_lv_pmos L=0.13u W=1.12u AS=0.3808p AD=0.1176p
+ PS=2.92u PD=1.33u rfmode=0
M$2650 \$835 \$792 VDD VDD sg13_lv_pmos L=0.13u W=1.12u AS=0.1176p AD=0.4032p
+ PS=1.33u PD=2.96u rfmode=0
M$2651 VDD \$851 \$834 VDD sg13_lv_pmos L=0.13u W=1.12u AS=0.3808p AD=0.2464p
+ PS=2.92u PD=1.56u rfmode=0
M$2652 \$834 \$792 \$833 VDD sg13_lv_pmos L=0.13u W=1.12u AS=0.2464p AD=0.2128p
+ PS=1.56u PD=1.5u rfmode=0
M$2653 \$833 \$794 \$731 VDD sg13_lv_pmos L=0.13u W=1.12u AS=0.2128p AD=0.3808p
+ PS=1.5u PD=2.92u rfmode=0
M$2654 VDD \$793 \$829 VDD sg13_lv_pmos L=0.13u W=1.12u AS=0.4032p AD=0.1176p
+ PS=2.96u PD=1.33u rfmode=0
M$2655 \$829 \$794 \$796 VDD sg13_lv_pmos L=0.13u W=1.12u AS=0.1176p AD=0.3808p
+ PS=1.33u PD=2.92u rfmode=0
M$2658 \$794 \$797 VDD VDD sg13_lv_pmos L=0.13u W=1.12u AS=0.42p AD=0.2114p
+ PS=2.99u PD=1.54u rfmode=0
M$2659 VDD \$607 \$797 VDD sg13_lv_pmos L=0.13u W=0.84u AS=0.2114p AD=0.2856p
+ PS=1.54u PD=2.36u rfmode=0
M$2664 \$762 \$798 VDD VDD sg13_lv_pmos L=0.13u W=1.12u AS=0.42p AD=0.2114p
+ PS=2.99u PD=1.54u rfmode=0
M$2665 VDD \$341 \$798 VDD sg13_lv_pmos L=0.13u W=0.84u AS=0.2114p AD=0.2856p
+ PS=1.54u PD=2.36u rfmode=0
M$2671 \$799 \$731 \$826 VDD sg13_lv_pmos L=0.13u W=1.12u AS=0.3808p AD=0.1176p
+ PS=2.92u PD=1.33u rfmode=0
M$2672 \$826 \$800 VDD VDD sg13_lv_pmos L=0.13u W=1.12u AS=0.1176p AD=0.4032p
+ PS=1.33u PD=2.96u rfmode=0
M$2673 \$819 \$349 VDD VDD sg13_lv_pmos L=0.13u W=1.12u AS=0.3808p AD=0.2128p
+ PS=2.92u PD=1.5u rfmode=0
M$2674 VDD \$731 \$819 VDD sg13_lv_pmos L=0.13u W=1.12u AS=0.2128p AD=0.2128p
+ PS=1.5u PD=1.5u rfmode=0
M$2675 \$819 \$799 \$801 VDD sg13_lv_pmos L=0.13u W=1.12u AS=0.2128p AD=0.3808p
+ PS=1.5u PD=2.92u rfmode=0
M$2676 VDD \$801 \$802 VDD sg13_lv_pmos L=0.13u W=0.42u AS=0.1428p AD=0.0798p
+ PS=1.52u PD=0.8u rfmode=0
M$2677 VDD \$753 \$802 VDD sg13_lv_pmos L=0.13u W=0.42u AS=0.3623875p
+ AD=0.0798p PS=2.605u PD=0.8u rfmode=0
M$2678 VDD \$820 \$803 VDD sg13_lv_pmos L=0.13u W=1u AS=0.3623875p AD=0.34p
+ PS=2.605u PD=2.68u rfmode=0
M$2679 \$821 \$805 VDD VDD sg13_lv_pmos L=0.13u W=1.12u AS=0.3864p AD=0.41165p
+ PS=2.93u PD=2.12u rfmode=0
M$2680 VDD \$504 \$805 VDD sg13_lv_pmos L=0.13u W=1.12u AS=0.41165p AD=0.4088p
+ PS=2.12u PD=2.97u rfmode=0
M$2681 \$807 \$821 \$822 VDD sg13_lv_pmos L=0.13u W=0.42u AS=0.2048p
+ AD=0.09345p PS=1.63u PD=0.865u rfmode=0
M$2682 \$822 \$808 VDD VDD sg13_lv_pmos L=0.13u W=0.42u AS=0.09345p AD=0.204p
+ PS=0.865u PD=1.835u rfmode=0
M$2683 VDD \$753 \$808 VDD sg13_lv_pmos L=0.13u W=0.42u AS=0.204p AD=0.0798p
+ PS=1.835u PD=0.8u rfmode=0
M$2684 \$808 \$807 VDD VDD sg13_lv_pmos L=0.13u W=0.42u AS=0.0798p AD=0.4659p
+ PS=0.8u PD=3.65u rfmode=0
M$2685 \$803 \$805 \$807 VDD sg13_lv_pmos L=0.13u W=1u AS=0.34p AD=0.2048p
+ PS=2.68u PD=1.63u rfmode=0
M$2686 \$809 \$807 VDD VDD sg13_lv_pmos L=0.13u W=1.12u AS=0.3864p AD=0.2128p
+ PS=2.93u PD=1.5u rfmode=0
M$2687 VDD \$809 \$800 VDD sg13_lv_pmos L=0.13u W=1.12u AS=0.2128p AD=0.3808p
+ PS=1.5u PD=2.92u rfmode=0
M$2711 VDD \$730 \$836 VDD sg13_lv_pmos L=0.13u W=0.84u AS=0.2114p AD=0.2856p
+ PS=1.54u PD=2.36u rfmode=0
M$2712 \$32 \$836 VDD VDD sg13_lv_pmos L=0.13u W=1.12u AS=0.42p AD=0.2114p
+ PS=2.99u PD=1.54u rfmode=0
M$2727 \$838 \$837 \$839 VDD sg13_lv_pmos L=0.13u W=1.12u AS=0.3808p AD=0.2128p
+ PS=2.92u PD=1.5u rfmode=0
M$2728 \$839 \$348 VDD VDD sg13_lv_pmos L=0.13u W=1.12u AS=0.2128p AD=0.2128p
+ PS=1.5u PD=1.5u rfmode=0
M$2729 VDD \$349 \$839 VDD sg13_lv_pmos L=0.13u W=1.12u AS=0.2128p AD=0.3808p
+ PS=1.5u PD=2.92u rfmode=0
M$2738 \$817 \$781 VDD VDD sg13_lv_pmos L=0.13u W=0.42u AS=0.147p AD=0.1563p
+ PS=1.54u PD=1.22u rfmode=0
M$2739 VDD \$783 \$828 VDD sg13_lv_pmos L=0.13u W=0.42u AS=0.1563p AD=0.063p
+ PS=1.22u PD=0.72u rfmode=0
M$2740 \$828 \$785 \$817 VDD sg13_lv_pmos L=0.13u W=0.42u AS=0.063p AD=0.0798p
+ PS=0.72u PD=0.8u rfmode=0
M$2741 \$817 \$818 \$782 VDD sg13_lv_pmos L=0.13u W=0.42u AS=0.0798p AD=0.1428p
+ PS=0.8u PD=1.52u rfmode=0
M$2743 VDD \$731 \$840 VDD sg13_lv_pmos L=0.13u W=0.84u AS=0.2198p AD=0.2856p
+ PS=1.53u PD=2.36u rfmode=0
M$2744 VDD \$878 \$841 VDD sg13_lv_pmos L=0.13u W=1.12u AS=0.2198p AD=0.2128p
+ PS=1.53u PD=1.5u rfmode=0
M$2745 \$841 \$840 VDD VDD sg13_lv_pmos L=0.13u W=1.12u AS=0.2128p AD=0.3808p
+ PS=1.5u PD=2.92u rfmode=0
M$2746 VDD \$847 \$846 VDD sg13_lv_pmos L=0.13u W=1.12u AS=0.41165p AD=0.3864p
+ PS=2.12u PD=2.93u rfmode=0
M$2747 VDD \$762 \$847 VDD sg13_lv_pmos L=0.13u W=1.12u AS=0.41165p AD=0.4088p
+ PS=2.12u PD=2.97u rfmode=0
M$2748 \$850 \$848 VDD VDD sg13_lv_pmos L=0.13u W=1.12u AS=0.3864p AD=0.2128p
+ PS=2.93u PD=1.5u rfmode=0
M$2749 VDD \$850 \$851 VDD sg13_lv_pmos L=0.13u W=1.12u AS=0.2128p AD=0.3808p
+ PS=1.5u PD=2.92u rfmode=0
M$2750 VDD \$792 \$852 VDD sg13_lv_pmos L=0.13u W=1.12u AS=0.3808p AD=0.2716p
+ PS=2.92u PD=1.605u rfmode=0
M$2751 \$852 \$673 \$878 VDD sg13_lv_pmos L=0.13u W=1.12u AS=0.2716p AD=0.2128p
+ PS=1.605u PD=1.5u rfmode=0
M$2752 \$878 \$851 \$852 VDD sg13_lv_pmos L=0.13u W=1.12u AS=0.2128p AD=0.2744p
+ PS=1.5u PD=1.61u rfmode=0
M$2753 \$852 \$796 VDD VDD sg13_lv_pmos L=0.13u W=1.12u AS=0.2744p AD=0.3808p
+ PS=1.61u PD=2.92u rfmode=0
M$2754 \$795 \$794 \$830 VDD sg13_lv_pmos L=0.13u W=0.84u AS=0.2856p AD=0.1596p
+ PS=2.36u PD=1.22u rfmode=0
M$2755 VDD \$793 \$830 VDD sg13_lv_pmos L=0.13u W=0.84u AS=0.2226p AD=0.1596p
+ PS=1.535u PD=1.22u rfmode=0
M$2756 VDD \$795 \$790 VDD sg13_lv_pmos L=0.13u W=1.12u AS=0.2226p AD=0.3976p
+ PS=1.535u PD=2.95u rfmode=0
M$2757 VDD \$881 \$792 VDD sg13_lv_pmos L=0.13u W=1.12u AS=0.3808p AD=0.2128p
+ PS=2.92u PD=1.5u rfmode=0
M$2758 \$792 \$765 VDD VDD sg13_lv_pmos L=0.13u W=1.12u AS=0.2128p AD=0.3808p
+ PS=1.5u PD=2.92u rfmode=0
M$2759 VDD \$881 \$873 VDD sg13_lv_pmos L=0.13u W=1.12u AS=0.3808p AD=0.2464p
+ PS=2.92u PD=1.56u rfmode=0
M$2760 \$873 \$765 \$874 VDD sg13_lv_pmos L=0.13u W=1.12u AS=0.2464p AD=0.2128p
+ PS=1.56u PD=1.5u rfmode=0
M$2761 \$874 \$790 \$602 VDD sg13_lv_pmos L=0.13u W=1.12u AS=0.2128p AD=0.3808p
+ PS=1.5u PD=2.92u rfmode=0
M$2762 \$853 \$673 VDD VDD sg13_lv_pmos L=0.13u W=1u AS=0.34p AD=0.19p PS=2.68u
+ PD=1.38u rfmode=0
M$2763 VDD \$881 \$853 VDD sg13_lv_pmos L=0.13u W=1u AS=0.19p AD=0.2125p
+ PS=1.38u PD=1.425u rfmode=0
M$2764 \$853 \$854 \$855 VDD sg13_lv_pmos L=0.13u W=1u AS=0.2125p AD=0.35p
+ PS=1.425u PD=2.7u rfmode=0
M$2765 VDD \$855 \$856 VDD sg13_lv_pmos L=0.13u W=1.12u AS=0.3808p AD=0.3808p
+ PS=2.92u PD=2.92u rfmode=0
M$2766 \$857 \$340 VDD VDD sg13_lv_pmos L=0.13u W=1.12u AS=0.3808p AD=0.3808p
+ PS=2.92u PD=2.92u rfmode=0
M$2767 VDD \$862 \$861 VDD sg13_lv_pmos L=0.13u W=1.12u AS=0.41165p AD=0.3864p
+ PS=2.12u PD=2.93u rfmode=0
M$2768 VDD \$762 \$862 VDD sg13_lv_pmos L=0.13u W=1.12u AS=0.41165p AD=0.4088p
+ PS=2.12u PD=2.97u rfmode=0
M$2769 \$865 \$863 VDD VDD sg13_lv_pmos L=0.13u W=1.12u AS=0.3864p AD=0.2128p
+ PS=2.93u PD=1.5u rfmode=0
M$2770 VDD \$865 \$881 VDD sg13_lv_pmos L=0.13u W=1.12u AS=0.2128p AD=0.3808p
+ PS=1.5u PD=2.92u rfmode=0
M$2771 VDD \$884 \$877 VDD sg13_lv_pmos L=0.13u W=1.12u AS=0.4032p AD=0.1176p
+ PS=2.96u PD=1.33u rfmode=0
M$2772 \$877 \$731 \$866 VDD sg13_lv_pmos L=0.13u W=1.12u AS=0.1176p AD=0.3808p
+ PS=1.33u PD=2.92u rfmode=0
M$2773 \$867 \$866 \$868 VDD sg13_lv_pmos L=0.13u W=1.12u AS=0.3808p AD=0.2128p
+ PS=2.92u PD=1.5u rfmode=0
M$2774 \$868 \$731 VDD VDD sg13_lv_pmos L=0.13u W=1.12u AS=0.2128p AD=0.2128p
+ PS=1.5u PD=1.5u rfmode=0
M$2775 VDD \$349 \$868 VDD sg13_lv_pmos L=0.13u W=1.12u AS=0.2128p AD=0.3808p
+ PS=1.5u PD=2.92u rfmode=0
M$2780 \$820 \$753 VDD VDD sg13_lv_pmos L=0.13u W=0.42u AS=0.147p AD=0.1563p
+ PS=1.54u PD=1.22u rfmode=0
M$2781 VDD \$803 \$825 VDD sg13_lv_pmos L=0.13u W=0.42u AS=0.1563p AD=0.063p
+ PS=1.22u PD=0.72u rfmode=0
M$2782 \$825 \$805 \$820 VDD sg13_lv_pmos L=0.13u W=0.42u AS=0.063p AD=0.0798p
+ PS=0.72u PD=0.8u rfmode=0
M$2783 \$820 \$821 \$802 VDD sg13_lv_pmos L=0.13u W=0.42u AS=0.0798p AD=0.1428p
+ PS=0.8u PD=1.52u rfmode=0
M$2790 VDD \$885 \$869 VDD sg13_lv_pmos L=0.13u W=1.12u AS=0.3808p AD=0.3808p
+ PS=2.92u PD=2.92u rfmode=0
M$2811 \$870 \$800 VDD VDD sg13_lv_pmos L=0.13u W=0.84u AS=0.2856p AD=0.2114p
+ PS=2.36u PD=1.54u rfmode=0
M$2812 VDD \$870 \$37 VDD sg13_lv_pmos L=0.13u W=1.12u AS=0.2114p AD=0.42p
+ PS=1.54u PD=2.99u rfmode=0
M$2827 VDD \$409 \$907 VDD sg13_lv_pmos L=0.13u W=1.12u AS=0.3808p AD=0.3808p
+ PS=2.92u PD=2.92u rfmode=0
M$2828 VDD \$838 \$910 VDD sg13_lv_pmos L=0.13u W=0.42u AS=0.1428p AD=0.0798p
+ PS=1.52u PD=0.8u rfmode=0
M$2829 VDD \$907 \$910 VDD sg13_lv_pmos L=0.13u W=0.42u AS=0.3623875p
+ AD=0.0798p PS=2.605u PD=0.8u rfmode=0
M$2830 VDD \$961 \$908 VDD sg13_lv_pmos L=0.13u W=1u AS=0.3623875p AD=0.34p
+ PS=2.605u PD=2.68u rfmode=0
M$2831 \$962 \$911 VDD VDD sg13_lv_pmos L=0.13u W=1.12u AS=0.3864p AD=0.41165p
+ PS=2.93u PD=2.12u rfmode=0
M$2832 VDD \$496 \$911 VDD sg13_lv_pmos L=0.13u W=1.12u AS=0.41165p AD=0.4088p
+ PS=2.12u PD=2.97u rfmode=0
M$2833 \$913 \$962 \$970 VDD sg13_lv_pmos L=0.13u W=0.42u AS=0.2048p
+ AD=0.09345p PS=1.63u PD=0.865u rfmode=0
M$2834 \$970 \$915 VDD VDD sg13_lv_pmos L=0.13u W=0.42u AS=0.09345p AD=0.204p
+ PS=0.865u PD=1.835u rfmode=0
M$2835 VDD \$907 \$915 VDD sg13_lv_pmos L=0.13u W=0.42u AS=0.204p AD=0.0798p
+ PS=1.835u PD=0.8u rfmode=0
M$2836 \$915 \$913 VDD VDD sg13_lv_pmos L=0.13u W=0.42u AS=0.0798p AD=0.4659p
+ PS=0.8u PD=3.65u rfmode=0
M$2837 \$908 \$911 \$913 VDD sg13_lv_pmos L=0.13u W=1u AS=0.34p AD=0.2048p
+ PS=2.68u PD=1.63u rfmode=0
M$2838 \$916 \$913 VDD VDD sg13_lv_pmos L=0.13u W=1.12u AS=0.3864p AD=0.2128p
+ PS=2.93u PD=1.5u rfmode=0
M$2839 VDD \$916 \$917 VDD sg13_lv_pmos L=0.13u W=1.12u AS=0.2128p AD=0.3808p
+ PS=1.5u PD=2.92u rfmode=0
M$2842 \$914 \$918 \$963 VDD sg13_lv_pmos L=0.13u W=1.12u AS=0.3808p AD=0.2128p
+ PS=2.92u PD=1.5u rfmode=0
M$2843 \$963 \$619 VDD VDD sg13_lv_pmos L=0.13u W=1.12u AS=0.2128p AD=0.2128p
+ PS=1.5u PD=1.5u rfmode=0
M$2844 VDD \$919 \$963 VDD sg13_lv_pmos L=0.13u W=1.12u AS=0.2128p AD=0.3808p
+ PS=1.5u PD=2.92u rfmode=0
M$2846 VDD \$841 \$842 VDD sg13_lv_pmos L=0.13u W=0.42u AS=0.1428p AD=0.0798p
+ PS=1.52u PD=0.8u rfmode=0
M$2847 VDD \$845 \$842 VDD sg13_lv_pmos L=0.13u W=0.42u AS=0.3623875p
+ AD=0.0798p PS=2.605u PD=0.8u rfmode=0
M$2848 VDD \$843 \$844 VDD sg13_lv_pmos L=0.13u W=1u AS=0.3623875p AD=0.34p
+ PS=2.605u PD=2.68u rfmode=0
M$2849 VDD \$419 \$845 VDD sg13_lv_pmos L=0.13u W=1.12u AS=0.3808p AD=0.3808p
+ PS=2.92u PD=2.92u rfmode=0
M$2852 VDD \$845 \$843 VDD sg13_lv_pmos L=0.13u W=0.42u AS=0.1563p AD=0.147p
+ PS=1.22u PD=1.54u rfmode=0
M$2853 VDD \$844 \$871 VDD sg13_lv_pmos L=0.13u W=0.42u AS=0.1563p AD=0.063p
+ PS=1.22u PD=0.72u rfmode=0
M$2854 \$871 \$847 \$843 VDD sg13_lv_pmos L=0.13u W=0.42u AS=0.063p AD=0.0798p
+ PS=0.72u PD=0.8u rfmode=0
M$2855 \$843 \$846 \$842 VDD sg13_lv_pmos L=0.13u W=0.42u AS=0.0798p AD=0.1428p
+ PS=0.8u PD=1.52u rfmode=0
M$2858 \$844 \$847 \$848 VDD sg13_lv_pmos L=0.13u W=1u AS=0.34p AD=0.2048p
+ PS=2.68u PD=1.63u rfmode=0
M$2859 \$848 \$846 \$872 VDD sg13_lv_pmos L=0.13u W=0.42u AS=0.2048p
+ AD=0.09345p PS=1.63u PD=0.865u rfmode=0
M$2860 VDD \$849 \$872 VDD sg13_lv_pmos L=0.13u W=0.42u AS=0.204p AD=0.09345p
+ PS=1.835u PD=0.865u rfmode=0
M$2861 VDD \$845 \$849 VDD sg13_lv_pmos L=0.13u W=0.42u AS=0.204p AD=0.0798p
+ PS=1.835u PD=0.8u rfmode=0
M$2862 VDD \$848 \$849 VDD sg13_lv_pmos L=0.13u W=0.42u AS=0.4659p AD=0.0798p
+ PS=3.65u PD=0.8u rfmode=0
M$2865 VDD \$793 \$990 VDD sg13_lv_pmos L=0.13u W=1.12u AS=0.3808p AD=0.2464p
+ PS=2.92u PD=1.56u rfmode=0
M$2866 \$990 \$794 \$989 VDD sg13_lv_pmos L=0.13u W=1.12u AS=0.2464p AD=0.2128p
+ PS=1.56u PD=1.5u rfmode=0
M$2867 \$989 \$920 \$348 VDD sg13_lv_pmos L=0.13u W=1.12u AS=0.2128p AD=0.3808p
+ PS=1.5u PD=2.92u rfmode=0
M$2868 VDD \$851 \$987 VDD sg13_lv_pmos L=0.13u W=1.12u AS=0.3808p AD=0.2464p
+ PS=2.92u PD=1.56u rfmode=0
M$2869 \$987 \$607 \$988 VDD sg13_lv_pmos L=0.13u W=1.12u AS=0.2464p AD=0.2128p
+ PS=1.56u PD=1.5u rfmode=0
M$2870 \$988 \$920 \$919 VDD sg13_lv_pmos L=0.13u W=1.12u AS=0.2128p AD=0.3808p
+ PS=1.5u PD=2.92u rfmode=0
M$2871 VDD \$765 \$921 VDD sg13_lv_pmos L=0.13u W=0.84u AS=0.2198p AD=0.2856p
+ PS=1.53u PD=2.36u rfmode=0
M$2872 VDD \$921 \$920 VDD sg13_lv_pmos L=0.13u W=1.12u AS=0.3808p AD=0.2128p
+ PS=2.92u PD=1.5u rfmode=0
M$2873 \$920 \$881 VDD VDD sg13_lv_pmos L=0.13u W=1.12u AS=0.2128p AD=0.2198p
+ PS=1.5u PD=1.53u rfmode=0
M$2874 \$964 \$920 VDD VDD sg13_lv_pmos L=0.13u W=1.12u AS=0.3808p AD=0.2128p
+ PS=2.92u PD=1.5u rfmode=0
M$2875 VDD \$922 \$964 VDD sg13_lv_pmos L=0.13u W=1.12u AS=0.2128p AD=0.2128p
+ PS=1.5u PD=1.5u rfmode=0
M$2876 \$964 \$794 \$854 VDD sg13_lv_pmos L=0.13u W=1.12u AS=0.2128p AD=0.3808p
+ PS=1.5u PD=2.92u rfmode=0
M$2877 \$923 \$881 VDD VDD sg13_lv_pmos L=0.13u W=0.84u AS=0.2856p AD=0.2198p
+ PS=2.36u PD=1.53u rfmode=0
M$2878 VDD \$765 \$922 VDD sg13_lv_pmos L=0.13u W=1.12u AS=0.2198p AD=0.2128p
+ PS=1.53u PD=1.5u rfmode=0
M$2879 \$922 \$923 VDD VDD sg13_lv_pmos L=0.13u W=1.12u AS=0.2128p AD=0.3808p
+ PS=1.5u PD=2.92u rfmode=0
M$2880 \$924 \$922 \$986 VDD sg13_lv_pmos L=0.13u W=1.12u AS=0.3808p AD=0.1176p
+ PS=2.92u PD=1.33u rfmode=0
M$2881 \$986 \$790 VDD VDD sg13_lv_pmos L=0.13u W=1.12u AS=0.1176p AD=0.4032p
+ PS=1.33u PD=2.96u rfmode=0
M$2884 VDD \$856 \$858 VDD sg13_lv_pmos L=0.13u W=0.42u AS=0.1428p AD=0.0798p
+ PS=1.52u PD=0.8u rfmode=0
M$2885 VDD \$857 \$858 VDD sg13_lv_pmos L=0.13u W=0.42u AS=0.3623875p
+ AD=0.0798p PS=2.605u PD=0.8u rfmode=0
M$2886 VDD \$859 \$860 VDD sg13_lv_pmos L=0.13u W=1u AS=0.3623875p AD=0.34p
+ PS=2.605u PD=2.68u rfmode=0
M$2887 VDD \$857 \$859 VDD sg13_lv_pmos L=0.13u W=0.42u AS=0.1563p AD=0.147p
+ PS=1.22u PD=1.54u rfmode=0
M$2888 VDD \$860 \$875 VDD sg13_lv_pmos L=0.13u W=0.42u AS=0.1563p AD=0.063p
+ PS=1.22u PD=0.72u rfmode=0
M$2889 \$875 \$862 \$859 VDD sg13_lv_pmos L=0.13u W=0.42u AS=0.063p AD=0.0798p
+ PS=0.72u PD=0.8u rfmode=0
M$2890 \$859 \$861 \$858 VDD sg13_lv_pmos L=0.13u W=0.42u AS=0.0798p AD=0.1428p
+ PS=0.8u PD=1.52u rfmode=0
M$2895 \$860 \$862 \$863 VDD sg13_lv_pmos L=0.13u W=1u AS=0.34p AD=0.2048p
+ PS=2.68u PD=1.63u rfmode=0
M$2896 \$863 \$861 \$876 VDD sg13_lv_pmos L=0.13u W=0.42u AS=0.2048p
+ AD=0.09345p PS=1.63u PD=0.865u rfmode=0
M$2897 VDD \$864 \$876 VDD sg13_lv_pmos L=0.13u W=0.42u AS=0.204p AD=0.09345p
+ PS=1.835u PD=0.865u rfmode=0
M$2898 VDD \$857 \$864 VDD sg13_lv_pmos L=0.13u W=0.42u AS=0.204p AD=0.0798p
+ PS=1.835u PD=0.8u rfmode=0
M$2899 VDD \$863 \$864 VDD sg13_lv_pmos L=0.13u W=0.42u AS=0.4659p AD=0.0798p
+ PS=3.65u PD=0.8u rfmode=0
M$2902 VDD \$340 \$925 VDD sg13_lv_pmos L=0.13u W=1.12u AS=0.3808p AD=0.3808p
+ PS=2.92u PD=2.92u rfmode=0
M$2903 VDD \$867 \$928 VDD sg13_lv_pmos L=0.13u W=0.42u AS=0.1428p AD=0.0798p
+ PS=1.52u PD=0.8u rfmode=0
M$2904 VDD \$925 \$928 VDD sg13_lv_pmos L=0.13u W=0.42u AS=0.3623875p
+ AD=0.0798p PS=2.605u PD=0.8u rfmode=0
M$2905 VDD \$965 \$926 VDD sg13_lv_pmos L=0.13u W=1u AS=0.3623875p AD=0.34p
+ PS=2.605u PD=2.68u rfmode=0
M$2906 \$966 \$929 VDD VDD sg13_lv_pmos L=0.13u W=1.12u AS=0.3864p AD=0.41165p
+ PS=2.93u PD=2.12u rfmode=0
M$2907 VDD \$504 \$929 VDD sg13_lv_pmos L=0.13u W=1.12u AS=0.41165p AD=0.4088p
+ PS=2.12u PD=2.97u rfmode=0
M$2908 \$931 \$966 \$979 VDD sg13_lv_pmos L=0.13u W=0.42u AS=0.2048p
+ AD=0.09345p PS=1.63u PD=0.865u rfmode=0
M$2909 \$979 \$932 VDD VDD sg13_lv_pmos L=0.13u W=0.42u AS=0.09345p AD=0.204p
+ PS=0.865u PD=1.835u rfmode=0
M$2910 VDD \$925 \$932 VDD sg13_lv_pmos L=0.13u W=0.42u AS=0.204p AD=0.0798p
+ PS=1.835u PD=0.8u rfmode=0
M$2911 \$932 \$931 VDD VDD sg13_lv_pmos L=0.13u W=0.42u AS=0.0798p AD=0.4659p
+ PS=0.8u PD=3.65u rfmode=0
M$2912 \$926 \$929 \$931 VDD sg13_lv_pmos L=0.13u W=1u AS=0.34p AD=0.2048p
+ PS=2.68u PD=1.63u rfmode=0
M$2913 \$933 \$931 VDD VDD sg13_lv_pmos L=0.13u W=1.12u AS=0.3864p AD=0.2128p
+ PS=2.93u PD=1.5u rfmode=0
M$2914 VDD \$933 \$884 VDD sg13_lv_pmos L=0.13u W=1.12u AS=0.2128p AD=0.3808p
+ PS=1.5u PD=2.92u rfmode=0
M$2915 \$934 \$919 VDD VDD sg13_lv_pmos L=0.13u W=0.84u AS=0.2856p AD=0.253p
+ PS=2.36u PD=1.53u rfmode=0
M$2916 VDD \$919 \$983 VDD sg13_lv_pmos L=0.13u W=1u AS=0.253p AD=0.3325p
+ PS=1.53u PD=1.665u rfmode=0
M$2917 \$983 \$936 \$935 VDD sg13_lv_pmos L=0.13u W=1u AS=0.3325p AD=0.2225p
+ PS=1.665u PD=1.445u rfmode=0
M$2918 \$935 \$685 \$982 VDD sg13_lv_pmos L=0.13u W=1u AS=0.2225p AD=0.2975p
+ PS=1.445u PD=1.595u rfmode=0
M$2919 \$982 \$934 VDD VDD sg13_lv_pmos L=0.13u W=1u AS=0.2975p AD=0.2198p
+ PS=1.595u PD=1.52u rfmode=0
M$2920 VDD \$935 \$937 VDD sg13_lv_pmos L=0.13u W=1.12u AS=0.2198p AD=0.6048p
+ PS=1.52u PD=3.32u rfmode=0
M$2921 VDD \$937 \$940 VDD sg13_lv_pmos L=0.13u W=0.42u AS=0.1428p AD=0.0798p
+ PS=1.52u PD=0.8u rfmode=0
M$2922 VDD \$869 \$940 VDD sg13_lv_pmos L=0.13u W=0.42u AS=0.3623875p
+ AD=0.0798p PS=2.605u PD=0.8u rfmode=0
M$2923 VDD \$967 \$938 VDD sg13_lv_pmos L=0.13u W=1u AS=0.3623875p AD=0.34p
+ PS=2.605u PD=2.68u rfmode=0
M$2924 \$968 \$941 VDD VDD sg13_lv_pmos L=0.13u W=1.12u AS=0.3864p AD=0.41165p
+ PS=2.93u PD=2.12u rfmode=0
M$2925 VDD \$504 \$941 VDD sg13_lv_pmos L=0.13u W=1.12u AS=0.41165p AD=0.4088p
+ PS=2.12u PD=2.97u rfmode=0
M$2926 \$943 \$968 \$973 VDD sg13_lv_pmos L=0.13u W=0.42u AS=0.2048p
+ AD=0.09345p PS=1.63u PD=0.865u rfmode=0
M$2927 \$973 \$944 VDD VDD sg13_lv_pmos L=0.13u W=0.42u AS=0.09345p AD=0.204p
+ PS=0.865u PD=1.835u rfmode=0
M$2928 VDD \$869 \$944 VDD sg13_lv_pmos L=0.13u W=0.42u AS=0.204p AD=0.0798p
+ PS=1.835u PD=0.8u rfmode=0
M$2929 \$944 \$943 VDD VDD sg13_lv_pmos L=0.13u W=0.42u AS=0.0798p AD=0.4659p
+ PS=0.8u PD=3.65u rfmode=0
M$2930 \$938 \$941 \$943 VDD sg13_lv_pmos L=0.13u W=1u AS=0.34p AD=0.2048p
+ PS=2.68u PD=1.63u rfmode=0
M$2931 \$945 \$943 VDD VDD sg13_lv_pmos L=0.13u W=1.12u AS=0.3864p AD=0.2128p
+ PS=2.93u PD=1.5u rfmode=0
M$2932 VDD \$945 \$936 VDD sg13_lv_pmos L=0.13u W=1.12u AS=0.2128p AD=0.3808p
+ PS=1.5u PD=2.92u rfmode=0
M$2948 VDD \$991 \$992 VDD sg13_lv_pmos L=0.13u W=0.84u AS=0.2114p AD=0.2856p
+ PS=1.54u PD=2.36u rfmode=0
M$2949 \$31 \$992 VDD VDD sg13_lv_pmos L=0.13u W=1.12u AS=0.42p AD=0.2114p
+ PS=2.99u PD=1.54u rfmode=0
M$2964 \$961 \$907 VDD VDD sg13_lv_pmos L=0.13u W=0.42u AS=0.147p AD=0.1563p
+ PS=1.54u PD=1.22u rfmode=0
M$2965 VDD \$908 \$985 VDD sg13_lv_pmos L=0.13u W=0.42u AS=0.1563p AD=0.063p
+ PS=1.22u PD=0.72u rfmode=0
M$2966 \$985 \$911 \$961 VDD sg13_lv_pmos L=0.13u W=0.42u AS=0.063p AD=0.0798p
+ PS=0.72u PD=0.8u rfmode=0
M$2967 \$961 \$962 \$910 VDD sg13_lv_pmos L=0.13u W=0.42u AS=0.0798p AD=0.1428p
+ PS=0.8u PD=1.52u rfmode=0
M$2968 \$837 \$348 \$1015 VDD sg13_lv_pmos L=0.13u W=1.12u AS=0.3808p
+ AD=0.1176p PS=2.92u PD=1.33u rfmode=0
M$2969 \$1015 \$917 VDD VDD sg13_lv_pmos L=0.13u W=1.12u AS=0.1176p AD=0.4032p
+ PS=1.33u PD=2.96u rfmode=0
M$2972 \$993 \$419 VDD VDD sg13_lv_pmos L=0.13u W=1.12u AS=0.3808p AD=0.3808p
+ PS=2.92u PD=2.92u rfmode=0
M$2973 VDD \$914 \$994 VDD sg13_lv_pmos L=0.13u W=0.42u AS=0.1428p AD=0.0798p
+ PS=1.52u PD=0.8u rfmode=0
M$2974 VDD \$993 \$994 VDD sg13_lv_pmos L=0.13u W=0.42u AS=0.3623875p
+ AD=0.0798p PS=2.605u PD=0.8u rfmode=0
M$2975 VDD \$995 \$996 VDD sg13_lv_pmos L=0.13u W=1u AS=0.3623875p AD=0.34p
+ PS=2.605u PD=2.68u rfmode=0
M$2976 VDD \$998 \$997 VDD sg13_lv_pmos L=0.13u W=1.12u AS=0.41165p AD=0.3864p
+ PS=2.12u PD=2.93u rfmode=0
M$2977 VDD \$496 \$998 VDD sg13_lv_pmos L=0.13u W=1.12u AS=0.41165p AD=0.4088p
+ PS=2.12u PD=2.97u rfmode=0
M$2978 \$996 \$998 \$999 VDD sg13_lv_pmos L=0.13u W=1u AS=0.34p AD=0.2048p
+ PS=2.68u PD=1.63u rfmode=0
M$2979 \$999 \$997 \$1017 VDD sg13_lv_pmos L=0.13u W=0.42u AS=0.2048p
+ AD=0.09345p PS=1.63u PD=0.865u rfmode=0
M$2980 VDD \$1000 \$1017 VDD sg13_lv_pmos L=0.13u W=0.42u AS=0.204p AD=0.09345p
+ PS=1.835u PD=0.865u rfmode=0
M$2981 VDD \$993 \$1000 VDD sg13_lv_pmos L=0.13u W=0.42u AS=0.204p AD=0.0798p
+ PS=1.835u PD=0.8u rfmode=0
M$2982 VDD \$999 \$1000 VDD sg13_lv_pmos L=0.13u W=0.42u AS=0.4659p AD=0.0798p
+ PS=3.65u PD=0.8u rfmode=0
M$2983 \$1001 \$999 VDD VDD sg13_lv_pmos L=0.13u W=1.12u AS=0.3864p AD=0.2128p
+ PS=2.93u PD=1.5u rfmode=0
M$2984 VDD \$1001 \$991 VDD sg13_lv_pmos L=0.13u W=1.12u AS=0.2128p AD=0.3808p
+ PS=1.5u PD=2.92u rfmode=0
M$2985 VDD \$991 \$1018 VDD sg13_lv_pmos L=0.13u W=1.12u AS=0.4032p AD=0.1176p
+ PS=2.96u PD=1.33u rfmode=0
M$2986 \$1018 \$919 \$918 VDD sg13_lv_pmos L=0.13u W=1.12u AS=0.1176p
+ AD=0.3808p PS=1.33u PD=2.92u rfmode=0
M$2995 \$793 \$851 VDD VDD sg13_lv_pmos L=0.13u W=1.12u AS=0.3808p AD=0.3808p
+ PS=2.92u PD=2.92u rfmode=0
M$2996 VDD \$851 \$1019 VDD sg13_lv_pmos L=0.13u W=1.12u AS=0.3808p AD=0.2464p
+ PS=2.92u PD=1.56u rfmode=0
M$2997 \$1019 \$881 \$1020 VDD sg13_lv_pmos L=0.13u W=1.12u AS=0.2464p
+ AD=0.2128p PS=1.56u PD=1.5u rfmode=0
M$2998 \$1020 \$794 \$1002 VDD sg13_lv_pmos L=0.13u W=1.12u AS=0.2128p
+ AD=0.3808p PS=1.5u PD=2.92u rfmode=0
M$2999 VDD \$851 \$1021 VDD sg13_lv_pmos L=0.13u W=1.12u AS=0.3808p AD=0.2464p
+ PS=2.92u PD=1.56u rfmode=0
M$3000 \$1021 \$794 \$1022 VDD sg13_lv_pmos L=0.13u W=1.12u AS=0.2464p
+ AD=0.2128p PS=1.56u PD=1.5u rfmode=0
M$3001 \$1022 \$922 \$1003 VDD sg13_lv_pmos L=0.13u W=1.12u AS=0.2128p
+ AD=0.3808p PS=1.5u PD=2.92u rfmode=0
M$3002 VDD \$922 \$1023 VDD sg13_lv_pmos L=0.13u W=1.12u AS=0.4032p AD=0.1176p
+ PS=2.96u PD=1.33u rfmode=0
M$3003 \$1023 \$619 \$1004 VDD sg13_lv_pmos L=0.13u W=1.12u AS=0.1176p
+ AD=0.3808p PS=1.33u PD=2.92u rfmode=0
M$3008 VDD \$881 \$1024 VDD sg13_lv_pmos L=0.13u W=1.12u AS=0.3808p AD=0.2464p
+ PS=2.92u PD=1.56u rfmode=0
M$3009 \$1024 \$765 \$1025 VDD sg13_lv_pmos L=0.13u W=1.12u AS=0.2464p
+ AD=0.2128p PS=1.56u PD=1.5u rfmode=0
M$3010 \$1025 \$685 \$1005 VDD sg13_lv_pmos L=0.13u W=1.12u AS=0.2128p
+ AD=0.3808p PS=1.5u PD=2.92u rfmode=0
M$3011 VDD \$1002 \$1026 VDD sg13_lv_pmos L=0.15u W=1.12u AS=0.3808p AD=0.2128p
+ PS=2.92u PD=1.5u rfmode=0
M$3012 \$1026 \$348 \$1006 VDD sg13_lv_pmos L=0.15u W=1.12u AS=0.2128p
+ AD=0.2128p PS=1.5u PD=1.5u rfmode=0
M$3013 \$1006 \$1005 VDD VDD sg13_lv_pmos L=0.15u W=1.12u AS=0.2128p AD=0.3808p
+ PS=1.5u PD=2.92u rfmode=0
M$3019 \$965 \$925 VDD VDD sg13_lv_pmos L=0.13u W=0.42u AS=0.147p AD=0.1563p
+ PS=1.54u PD=1.22u rfmode=0
M$3020 VDD \$926 \$984 VDD sg13_lv_pmos L=0.13u W=0.42u AS=0.1563p AD=0.063p
+ PS=1.22u PD=0.72u rfmode=0
M$3021 \$984 \$929 \$965 VDD sg13_lv_pmos L=0.13u W=0.42u AS=0.063p AD=0.0798p
+ PS=0.72u PD=0.8u rfmode=0
M$3022 \$965 \$966 \$928 VDD sg13_lv_pmos L=0.13u W=0.42u AS=0.0798p AD=0.1428p
+ PS=0.8u PD=1.52u rfmode=0
M$3023 \$1007 \$1034 VDD VDD sg13_lv_pmos L=0.13u W=1.12u AS=0.6048p AD=0.2198p
+ PS=3.32u PD=1.52u rfmode=0
M$3024 VDD \$1008 \$1027 VDD sg13_lv_pmos L=0.13u W=1u AS=0.2198p AD=0.2975p
+ PS=1.52u PD=1.595u rfmode=0
M$3025 \$1027 \$685 \$1034 VDD sg13_lv_pmos L=0.13u W=1u AS=0.2975p AD=0.2225p
+ PS=1.595u PD=1.445u rfmode=0
M$3026 \$1034 \$1009 \$1028 VDD sg13_lv_pmos L=0.13u W=1u AS=0.2225p AD=0.3325p
+ PS=1.445u PD=1.665u rfmode=0
M$3027 \$1028 \$919 VDD VDD sg13_lv_pmos L=0.13u W=1u AS=0.3325p AD=0.253p
+ PS=1.665u PD=1.53u rfmode=0
M$3028 VDD \$919 \$1008 VDD sg13_lv_pmos L=0.13u W=0.84u AS=0.253p AD=0.2856p
+ PS=1.53u PD=2.36u rfmode=0
M$3032 VDD \$1003 \$1010 VDD sg13_lv_pmos L=0.13u W=0.84u AS=0.253p AD=0.2856p
+ PS=1.53u PD=2.36u rfmode=0
M$3033 VDD \$1003 \$1029 VDD sg13_lv_pmos L=0.13u W=1u AS=0.253p AD=0.3325p
+ PS=1.53u PD=1.665u rfmode=0
M$3034 \$1029 \$1035 \$1011 VDD sg13_lv_pmos L=0.13u W=1u AS=0.3325p AD=0.2225p
+ PS=1.665u PD=1.445u rfmode=0
M$3035 \$1011 \$685 \$1030 VDD sg13_lv_pmos L=0.13u W=1u AS=0.2225p AD=0.2975p
+ PS=1.445u PD=1.595u rfmode=0
M$3036 VDD \$1010 \$1030 VDD sg13_lv_pmos L=0.13u W=1u AS=0.2198p AD=0.2975p
+ PS=1.52u PD=1.595u rfmode=0
M$3037 VDD \$1011 \$1012 VDD sg13_lv_pmos L=0.13u W=1.12u AS=0.2198p AD=0.6048p
+ PS=1.52u PD=3.32u rfmode=0
M$3038 \$1013 \$667 VDD VDD sg13_lv_pmos L=0.13u W=0.84u AS=0.2856p AD=0.2114p
+ PS=2.36u PD=1.54u rfmode=0
M$3039 VDD \$1013 \$885 VDD sg13_lv_pmos L=0.13u W=1.12u AS=0.2114p AD=0.42p
+ PS=1.54u PD=2.99u rfmode=0
M$3040 \$967 \$869 VDD VDD sg13_lv_pmos L=0.13u W=0.42u AS=0.147p AD=0.1563p
+ PS=1.54u PD=1.22u rfmode=0
M$3041 VDD \$938 \$981 VDD sg13_lv_pmos L=0.13u W=0.42u AS=0.1563p AD=0.063p
+ PS=1.22u PD=0.72u rfmode=0
M$3042 \$981 \$941 \$967 VDD sg13_lv_pmos L=0.13u W=0.42u AS=0.063p AD=0.0798p
+ PS=0.72u PD=0.8u rfmode=0
M$3043 \$967 \$968 \$940 VDD sg13_lv_pmos L=0.13u W=0.42u AS=0.0798p AD=0.1428p
+ PS=0.8u PD=1.52u rfmode=0
M$3064 \$1014 \$936 VDD VDD sg13_lv_pmos L=0.13u W=0.84u AS=0.2856p AD=0.2114p
+ PS=2.36u PD=1.54u rfmode=0
M$3065 VDD \$1014 \$38 VDD sg13_lv_pmos L=0.13u W=1.12u AS=0.2114p AD=0.42p
+ PS=1.54u PD=2.99u rfmode=0
M$3086 VDD \$1054 \$1053 VDD sg13_lv_pmos L=0.13u W=0.42u AS=0.1428p AD=0.0798p
+ PS=1.52u PD=0.8u rfmode=0
M$3087 VDD \$1056 \$1053 VDD sg13_lv_pmos L=0.13u W=0.42u AS=0.3623875p
+ AD=0.0798p PS=2.605u PD=0.8u rfmode=0
M$3088 VDD \$1122 \$1055 VDD sg13_lv_pmos L=0.13u W=1u AS=0.3623875p AD=0.34p
+ PS=2.605u PD=2.68u rfmode=0
M$3089 VDD \$993 \$995 VDD sg13_lv_pmos L=0.13u W=0.42u AS=0.1563p AD=0.147p
+ PS=1.22u PD=1.54u rfmode=0
M$3090 VDD \$996 \$1016 VDD sg13_lv_pmos L=0.13u W=0.42u AS=0.1563p AD=0.063p
+ PS=1.22u PD=0.72u rfmode=0
M$3091 \$1016 \$998 \$995 VDD sg13_lv_pmos L=0.13u W=0.42u AS=0.063p AD=0.0798p
+ PS=0.72u PD=0.8u rfmode=0
M$3092 \$995 \$997 \$994 VDD sg13_lv_pmos L=0.13u W=0.42u AS=0.0798p AD=0.1428p
+ PS=0.8u PD=1.52u rfmode=0
M$3093 \$1123 \$1058 VDD VDD sg13_lv_pmos L=0.13u W=1.12u AS=0.3864p
+ AD=0.41165p PS=2.93u PD=2.12u rfmode=0
M$3094 VDD \$496 \$1058 VDD sg13_lv_pmos L=0.13u W=1.12u AS=0.41165p AD=0.4088p
+ PS=2.12u PD=2.97u rfmode=0
M$3095 \$1060 \$1123 \$1144 VDD sg13_lv_pmos L=0.13u W=0.42u AS=0.2048p
+ AD=0.09345p PS=1.63u PD=0.865u rfmode=0
M$3096 \$1144 \$1061 VDD VDD sg13_lv_pmos L=0.13u W=0.42u AS=0.09345p AD=0.204p
+ PS=0.865u PD=1.835u rfmode=0
M$3097 VDD \$1056 \$1061 VDD sg13_lv_pmos L=0.13u W=0.42u AS=0.204p AD=0.0798p
+ PS=1.835u PD=0.8u rfmode=0
M$3098 \$1061 \$1060 VDD VDD sg13_lv_pmos L=0.13u W=0.42u AS=0.0798p AD=0.4659p
+ PS=0.8u PD=3.65u rfmode=0
M$3099 \$1055 \$1058 \$1060 VDD sg13_lv_pmos L=0.13u W=1u AS=0.34p AD=0.2048p
+ PS=2.68u PD=1.63u rfmode=0
M$3100 \$1062 \$1060 VDD VDD sg13_lv_pmos L=0.13u W=1.12u AS=0.3864p AD=0.2128p
+ PS=2.93u PD=1.5u rfmode=0
M$3101 VDD \$1062 \$1063 VDD sg13_lv_pmos L=0.13u W=1.12u AS=0.2128p AD=0.3808p
+ PS=1.5u PD=2.92u rfmode=0
M$3102 VDD \$409 \$1231 VDD sg13_lv_pmos L=0.13u W=1.12u AS=0.3808p AD=0.3808p
+ PS=2.92u PD=2.92u rfmode=0
M$3107 VDD \$602 \$1067 VDD sg13_lv_pmos L=0.13u W=0.84u AS=0.253p AD=0.2856p
+ PS=1.53u PD=2.36u rfmode=0
M$3108 VDD \$1067 \$1149 VDD sg13_lv_pmos L=0.13u W=1u AS=0.2198p AD=0.2975p
+ PS=1.52u PD=1.595u rfmode=0
M$3109 \$1149 \$619 \$1065 VDD sg13_lv_pmos L=0.13u W=1u AS=0.2975p AD=0.2225p
+ PS=1.595u PD=1.445u rfmode=0
M$3110 \$1065 \$1066 \$1150 VDD sg13_lv_pmos L=0.13u W=1u AS=0.2225p AD=0.3325p
+ PS=1.445u PD=1.665u rfmode=0
M$3111 \$1150 \$602 VDD VDD sg13_lv_pmos L=0.13u W=1u AS=0.3325p AD=0.253p
+ PS=1.665u PD=1.53u rfmode=0
M$3112 \$1064 \$1065 VDD VDD sg13_lv_pmos L=0.13u W=1.12u AS=0.6048p AD=0.2198p
+ PS=3.32u PD=1.52u rfmode=0
M$3117 VDD \$1068 \$1069 VDD sg13_lv_pmos L=0.13u W=1.12u AS=0.3808p AD=0.3808p
+ PS=2.92u PD=2.92u rfmode=0
M$3118 VDD \$1069 \$1151 VDD sg13_lv_pmos L=0.15u W=1.12u AS=0.3808p AD=0.2128p
+ PS=2.92u PD=1.5u rfmode=0
M$3119 \$1151 \$1003 \$1072 VDD sg13_lv_pmos L=0.15u W=1.12u AS=0.2128p
+ AD=0.2128p PS=1.5u PD=1.5u rfmode=0
M$3120 \$1072 \$1071 VDD VDD sg13_lv_pmos L=0.15u W=1.12u AS=0.2128p AD=0.3808p
+ PS=1.5u PD=2.92u rfmode=0
M$3121 VDD \$1004 \$1071 VDD sg13_lv_pmos L=0.15u W=1.12u AS=0.3808p AD=0.2128p
+ PS=2.92u PD=1.5u rfmode=0
M$3122 \$1071 \$348 \$1148 VDD sg13_lv_pmos L=0.15u W=1.12u AS=0.2128p
+ AD=0.2128p PS=1.5u PD=1.5u rfmode=0
M$3123 \$1148 \$1002 VDD VDD sg13_lv_pmos L=0.15u W=1.12u AS=0.2128p AD=0.3808p
+ PS=1.5u PD=2.92u rfmode=0
M$3127 \$1074 \$1002 VDD VDD sg13_lv_pmos L=0.13u W=0.84u AS=0.2856p AD=0.2618p
+ PS=2.36u PD=1.63u rfmode=0
M$3128 VDD \$1074 \$1146 VDD sg13_lv_pmos L=0.13u W=1.12u AS=0.2618p AD=0.1176p
+ PS=1.63u PD=1.33u rfmode=0
M$3129 \$1146 \$765 \$1124 VDD sg13_lv_pmos L=0.13u W=1.12u AS=0.1176p
+ AD=0.3808p PS=1.33u PD=2.92u rfmode=0
M$3130 VDD \$1125 \$1145 VDD sg13_lv_pmos L=0.15u W=1.12u AS=0.3808p AD=0.2128p
+ PS=2.92u PD=1.5u rfmode=0
M$3131 \$1145 \$1124 \$1076 VDD sg13_lv_pmos L=0.15u W=1.12u AS=0.2128p
+ AD=0.2128p PS=1.5u PD=1.5u rfmode=0
M$3132 \$1076 \$1006 VDD VDD sg13_lv_pmos L=0.15u W=1.12u AS=0.2128p AD=0.3808p
+ PS=1.5u PD=2.92u rfmode=0
M$3133 \$1077 \$340 VDD VDD sg13_lv_pmos L=0.13u W=1.12u AS=0.3808p AD=0.3808p
+ PS=2.92u PD=2.92u rfmode=0
M$3136 VDD \$340 \$1078 VDD sg13_lv_pmos L=0.13u W=1.12u AS=0.3808p AD=0.3808p
+ PS=2.92u PD=2.92u rfmode=0
M$3137 VDD \$1007 \$1079 VDD sg13_lv_pmos L=0.13u W=0.42u AS=0.1428p AD=0.0798p
+ PS=1.52u PD=0.8u rfmode=0
M$3138 VDD \$1078 \$1079 VDD sg13_lv_pmos L=0.13u W=0.42u AS=0.3623875p
+ AD=0.0798p PS=2.605u PD=0.8u rfmode=0
M$3139 VDD \$1126 \$1080 VDD sg13_lv_pmos L=0.13u W=1u AS=0.3623875p AD=0.34p
+ PS=2.605u PD=2.68u rfmode=0
M$3140 \$1127 \$1082 VDD VDD sg13_lv_pmos L=0.13u W=1.12u AS=0.3864p
+ AD=0.41165p PS=2.93u PD=2.12u rfmode=0
M$3141 VDD \$504 \$1082 VDD sg13_lv_pmos L=0.13u W=1.12u AS=0.41165p AD=0.4088p
+ PS=2.12u PD=2.97u rfmode=0
M$3142 \$1084 \$1127 \$1140 VDD sg13_lv_pmos L=0.13u W=0.42u AS=0.2048p
+ AD=0.09345p PS=1.63u PD=0.865u rfmode=0
M$3143 \$1140 \$1085 VDD VDD sg13_lv_pmos L=0.13u W=0.42u AS=0.09345p AD=0.204p
+ PS=0.865u PD=1.835u rfmode=0
M$3144 VDD \$1078 \$1085 VDD sg13_lv_pmos L=0.13u W=0.42u AS=0.204p AD=0.0798p
+ PS=1.835u PD=0.8u rfmode=0
M$3145 \$1085 \$1084 VDD VDD sg13_lv_pmos L=0.13u W=0.42u AS=0.0798p AD=0.4659p
+ PS=0.8u PD=3.65u rfmode=0
M$3146 \$1080 \$1082 \$1084 VDD sg13_lv_pmos L=0.13u W=1u AS=0.34p AD=0.2048p
+ PS=2.68u PD=1.63u rfmode=0
M$3147 \$1086 \$1084 VDD VDD sg13_lv_pmos L=0.13u W=1.12u AS=0.3864p AD=0.2128p
+ PS=2.93u PD=1.5u rfmode=0
M$3148 VDD \$1086 \$1009 VDD sg13_lv_pmos L=0.13u W=1.12u AS=0.2128p AD=0.3808p
+ PS=1.5u PD=2.92u rfmode=0
M$3149 \$1087 \$885 VDD VDD sg13_lv_pmos L=0.13u W=1.12u AS=0.3808p AD=0.3808p
+ PS=2.92u PD=2.92u rfmode=0
M$3150 VDD \$885 \$1088 VDD sg13_lv_pmos L=0.13u W=1.12u AS=0.3808p AD=0.3808p
+ PS=2.92u PD=2.92u rfmode=0
M$3151 VDD \$1012 \$1089 VDD sg13_lv_pmos L=0.13u W=0.42u AS=0.1428p AD=0.0798p
+ PS=1.52u PD=0.8u rfmode=0
M$3152 VDD \$1088 \$1089 VDD sg13_lv_pmos L=0.13u W=0.42u AS=0.3623875p
+ AD=0.0798p PS=2.605u PD=0.8u rfmode=0
M$3153 VDD \$1128 \$1090 VDD sg13_lv_pmos L=0.13u W=1u AS=0.3623875p AD=0.34p
+ PS=2.605u PD=2.68u rfmode=0
M$3154 \$1129 \$1092 VDD VDD sg13_lv_pmos L=0.13u W=1.12u AS=0.3864p
+ AD=0.41165p PS=2.93u PD=2.12u rfmode=0
M$3155 VDD \$1093 \$1092 VDD sg13_lv_pmos L=0.13u W=1.12u AS=0.41165p
+ AD=0.4088p PS=2.12u PD=2.97u rfmode=0
M$3156 \$1095 \$1129 \$1135 VDD sg13_lv_pmos L=0.13u W=0.42u AS=0.2048p
+ AD=0.09345p PS=1.63u PD=0.865u rfmode=0
M$3157 \$1135 \$1096 VDD VDD sg13_lv_pmos L=0.13u W=0.42u AS=0.09345p AD=0.204p
+ PS=0.865u PD=1.835u rfmode=0
M$3158 VDD \$1088 \$1096 VDD sg13_lv_pmos L=0.13u W=0.42u AS=0.204p AD=0.0798p
+ PS=1.835u PD=0.8u rfmode=0
M$3159 \$1096 \$1095 VDD VDD sg13_lv_pmos L=0.13u W=0.42u AS=0.0798p AD=0.4659p
+ PS=0.8u PD=3.65u rfmode=0
M$3160 \$1090 \$1092 \$1095 VDD sg13_lv_pmos L=0.13u W=1u AS=0.34p AD=0.2048p
+ PS=2.68u PD=1.63u rfmode=0
M$3161 \$1097 \$1095 VDD VDD sg13_lv_pmos L=0.13u W=1.12u AS=0.3864p AD=0.2128p
+ PS=2.93u PD=1.5u rfmode=0
M$3162 VDD \$1097 \$1035 VDD sg13_lv_pmos L=0.13u W=1.12u AS=0.2128p AD=0.3808p
+ PS=1.5u PD=2.92u rfmode=0
M$3164 VDD \$885 \$1098 VDD sg13_lv_pmos L=0.13u W=1.12u AS=0.3808p AD=0.3808p
+ PS=2.92u PD=2.92u rfmode=0
M$3165 VDD \$1299 \$1099 VDD sg13_lv_pmos L=0.13u W=0.42u AS=0.1428p AD=0.0798p
+ PS=1.52u PD=0.8u rfmode=0
M$3166 VDD \$1098 \$1099 VDD sg13_lv_pmos L=0.13u W=0.42u AS=0.3623875p
+ AD=0.0798p PS=2.605u PD=0.8u rfmode=0
M$3167 VDD \$1130 \$1100 VDD sg13_lv_pmos L=0.13u W=1u AS=0.3623875p AD=0.34p
+ PS=2.605u PD=2.68u rfmode=0
M$3168 \$1131 \$1102 VDD VDD sg13_lv_pmos L=0.13u W=1.12u AS=0.3864p
+ AD=0.41165p PS=2.93u PD=2.12u rfmode=0
M$3169 VDD \$1093 \$1102 VDD sg13_lv_pmos L=0.13u W=1.12u AS=0.41165p
+ AD=0.4088p PS=2.12u PD=2.97u rfmode=0
M$3170 \$1104 \$1131 \$1133 VDD sg13_lv_pmos L=0.13u W=0.42u AS=0.2048p
+ AD=0.09345p PS=1.63u PD=0.865u rfmode=0
M$3171 \$1133 \$1105 VDD VDD sg13_lv_pmos L=0.13u W=0.42u AS=0.09345p AD=0.204p
+ PS=0.865u PD=1.835u rfmode=0
M$3172 VDD \$1098 \$1105 VDD sg13_lv_pmos L=0.13u W=0.42u AS=0.204p AD=0.0798p
+ PS=1.835u PD=0.8u rfmode=0
M$3173 \$1105 \$1104 VDD VDD sg13_lv_pmos L=0.13u W=0.42u AS=0.0798p AD=0.4659p
+ PS=0.8u PD=3.65u rfmode=0
M$3174 \$1100 \$1102 \$1104 VDD sg13_lv_pmos L=0.13u W=1u AS=0.34p AD=0.2048p
+ PS=2.68u PD=1.63u rfmode=0
M$3175 \$1106 \$1104 VDD VDD sg13_lv_pmos L=0.13u W=1.12u AS=0.3864p AD=0.2128p
+ PS=2.93u PD=1.5u rfmode=0
M$3176 VDD \$1106 \$1107 VDD sg13_lv_pmos L=0.13u W=1.12u AS=0.2128p AD=0.3808p
+ PS=1.5u PD=2.92u rfmode=0
M$3203 VDD \$419 \$1056 VDD sg13_lv_pmos L=0.13u W=1.12u AS=0.3808p AD=0.3808p
+ PS=2.92u PD=2.92u rfmode=0
M$3204 \$1122 \$1056 VDD VDD sg13_lv_pmos L=0.13u W=0.42u AS=0.147p AD=0.1563p
+ PS=1.54u PD=1.22u rfmode=0
M$3205 VDD \$1055 \$1141 VDD sg13_lv_pmos L=0.13u W=0.42u AS=0.1563p AD=0.063p
+ PS=1.22u PD=0.72u rfmode=0
M$3206 \$1141 \$1058 \$1122 VDD sg13_lv_pmos L=0.13u W=0.42u AS=0.063p
+ AD=0.0798p PS=0.72u PD=0.8u rfmode=0
M$3207 \$1122 \$1123 \$1053 VDD sg13_lv_pmos L=0.13u W=0.42u AS=0.0798p
+ AD=0.1428p PS=0.8u PD=1.52u rfmode=0
M$3208 \$1054 \$1230 VDD VDD sg13_lv_pmos L=0.13u W=1.12u AS=0.6048p AD=0.2198p
+ PS=3.32u PD=1.52u rfmode=0
M$3209 VDD \$1153 \$1212 VDD sg13_lv_pmos L=0.13u W=1u AS=0.2198p AD=0.2975p
+ PS=1.52u PD=1.595u rfmode=0
M$3210 \$1212 \$619 \$1230 VDD sg13_lv_pmos L=0.13u W=1u AS=0.2975p AD=0.2225p
+ PS=1.595u PD=1.445u rfmode=0
M$3211 \$1230 \$1063 \$1213 VDD sg13_lv_pmos L=0.13u W=1u AS=0.2225p AD=0.3325p
+ PS=1.445u PD=1.665u rfmode=0
M$3212 \$1213 \$924 VDD VDD sg13_lv_pmos L=0.13u W=1u AS=0.3325p AD=0.253p
+ PS=1.665u PD=1.53u rfmode=0
M$3213 VDD \$924 \$1153 VDD sg13_lv_pmos L=0.13u W=0.84u AS=0.253p AD=0.2856p
+ PS=1.53u PD=2.36u rfmode=0
M$3214 VDD \$1285 \$1154 VDD sg13_lv_pmos L=0.13u W=0.42u AS=0.1428p AD=0.0798p
+ PS=1.52u PD=0.8u rfmode=0
M$3215 VDD \$1231 \$1154 VDD sg13_lv_pmos L=0.13u W=0.42u AS=0.3623875p
+ AD=0.0798p PS=2.605u PD=0.8u rfmode=0
M$3216 VDD \$1156 \$1155 VDD sg13_lv_pmos L=0.13u W=1u AS=0.3623875p AD=0.34p
+ PS=2.605u PD=2.68u rfmode=0
M$3217 VDD \$1231 \$1156 VDD sg13_lv_pmos L=0.13u W=0.42u AS=0.1563p AD=0.147p
+ PS=1.22u PD=1.54u rfmode=0
M$3218 VDD \$1155 \$1214 VDD sg13_lv_pmos L=0.13u W=0.42u AS=0.1563p AD=0.063p
+ PS=1.22u PD=0.72u rfmode=0
M$3219 \$1214 \$1158 \$1156 VDD sg13_lv_pmos L=0.13u W=0.42u AS=0.063p
+ AD=0.0798p PS=0.72u PD=0.8u rfmode=0
M$3220 \$1156 \$1157 \$1154 VDD sg13_lv_pmos L=0.13u W=0.42u AS=0.0798p
+ AD=0.1428p PS=0.8u PD=1.52u rfmode=0
M$3221 VDD \$1158 \$1157 VDD sg13_lv_pmos L=0.13u W=1.12u AS=0.41165p
+ AD=0.3864p PS=2.12u PD=2.93u rfmode=0
M$3222 VDD \$496 \$1158 VDD sg13_lv_pmos L=0.13u W=1.12u AS=0.41165p AD=0.4088p
+ PS=2.12u PD=2.97u rfmode=0
M$3223 \$1155 \$1158 \$1159 VDD sg13_lv_pmos L=0.13u W=1u AS=0.34p AD=0.2048p
+ PS=2.68u PD=1.63u rfmode=0
M$3224 \$1159 \$1157 \$1215 VDD sg13_lv_pmos L=0.13u W=0.42u AS=0.2048p
+ AD=0.09345p PS=1.63u PD=0.865u rfmode=0
M$3225 VDD \$1160 \$1215 VDD sg13_lv_pmos L=0.13u W=0.42u AS=0.204p AD=0.09345p
+ PS=1.835u PD=0.865u rfmode=0
M$3226 VDD \$1231 \$1160 VDD sg13_lv_pmos L=0.13u W=0.42u AS=0.204p AD=0.0798p
+ PS=1.835u PD=0.8u rfmode=0
M$3227 VDD \$1159 \$1160 VDD sg13_lv_pmos L=0.13u W=0.42u AS=0.4659p AD=0.0798p
+ PS=3.65u PD=0.8u rfmode=0
M$3228 \$1161 \$1159 VDD VDD sg13_lv_pmos L=0.13u W=1.12u AS=0.3864p AD=0.2128p
+ PS=2.93u PD=1.5u rfmode=0
M$3229 VDD \$1161 \$1280 VDD sg13_lv_pmos L=0.13u W=1.12u AS=0.2128p AD=0.3808p
+ PS=1.5u PD=2.92u rfmode=0
M$3230 VDD \$1064 \$1162 VDD sg13_lv_pmos L=0.13u W=0.42u AS=0.1428p AD=0.0798p
+ PS=1.52u PD=0.8u rfmode=0
M$3231 VDD \$1165 \$1162 VDD sg13_lv_pmos L=0.13u W=0.42u AS=0.3623875p
+ AD=0.0798p PS=2.605u PD=0.8u rfmode=0
M$3232 VDD \$1164 \$1163 VDD sg13_lv_pmos L=0.13u W=1u AS=0.3623875p AD=0.34p
+ PS=2.605u PD=2.68u rfmode=0
M$3233 VDD \$1165 \$1164 VDD sg13_lv_pmos L=0.13u W=0.42u AS=0.1563p AD=0.147p
+ PS=1.22u PD=1.54u rfmode=0
M$3234 VDD \$1163 \$1216 VDD sg13_lv_pmos L=0.13u W=0.42u AS=0.1563p AD=0.063p
+ PS=1.22u PD=0.72u rfmode=0
M$3235 \$1216 \$1167 \$1164 VDD sg13_lv_pmos L=0.13u W=0.42u AS=0.063p
+ AD=0.0798p PS=0.72u PD=0.8u rfmode=0
M$3236 \$1164 \$1166 \$1162 VDD sg13_lv_pmos L=0.13u W=0.42u AS=0.0798p
+ AD=0.1428p PS=0.8u PD=1.52u rfmode=0
M$3237 VDD \$1167 \$1166 VDD sg13_lv_pmos L=0.13u W=1.12u AS=0.41165p
+ AD=0.3864p PS=2.12u PD=2.93u rfmode=0
M$3238 VDD \$762 \$1167 VDD sg13_lv_pmos L=0.13u W=1.12u AS=0.41165p AD=0.4088p
+ PS=2.12u PD=2.97u rfmode=0
M$3239 \$1163 \$1167 \$1168 VDD sg13_lv_pmos L=0.13u W=1u AS=0.34p AD=0.2048p
+ PS=2.68u PD=1.63u rfmode=0
M$3240 \$1168 \$1166 \$1218 VDD sg13_lv_pmos L=0.13u W=0.42u AS=0.2048p
+ AD=0.09345p PS=1.63u PD=0.865u rfmode=0
M$3241 VDD \$1169 \$1218 VDD sg13_lv_pmos L=0.13u W=0.42u AS=0.204p AD=0.09345p
+ PS=1.835u PD=0.865u rfmode=0
M$3242 VDD \$1165 \$1169 VDD sg13_lv_pmos L=0.13u W=0.42u AS=0.204p AD=0.0798p
+ PS=1.835u PD=0.8u rfmode=0
M$3243 VDD \$1168 \$1169 VDD sg13_lv_pmos L=0.13u W=0.42u AS=0.4659p AD=0.0798p
+ PS=3.65u PD=0.8u rfmode=0
M$3244 \$1170 \$1168 VDD VDD sg13_lv_pmos L=0.13u W=1.12u AS=0.3864p AD=0.2128p
+ PS=2.93u PD=1.5u rfmode=0
M$3245 VDD \$1170 \$1066 VDD sg13_lv_pmos L=0.13u W=1.12u AS=0.2128p AD=0.3808p
+ PS=1.5u PD=2.92u rfmode=0
M$3246 VDD \$1072 \$1171 VDD sg13_lv_pmos L=0.13u W=0.42u AS=0.1428p AD=0.0798p
+ PS=1.52u PD=0.8u rfmode=0
M$3247 VDD \$1174 \$1171 VDD sg13_lv_pmos L=0.13u W=0.42u AS=0.3623875p
+ AD=0.0798p PS=2.605u PD=0.8u rfmode=0
M$3248 VDD \$1173 \$1172 VDD sg13_lv_pmos L=0.13u W=1u AS=0.3623875p AD=0.34p
+ PS=2.605u PD=2.68u rfmode=0
M$3249 VDD \$1174 \$1173 VDD sg13_lv_pmos L=0.13u W=0.42u AS=0.1563p AD=0.147p
+ PS=1.22u PD=1.54u rfmode=0
M$3250 VDD \$1172 \$1219 VDD sg13_lv_pmos L=0.13u W=0.42u AS=0.1563p AD=0.063p
+ PS=1.22u PD=0.72u rfmode=0
M$3251 \$1219 \$1176 \$1173 VDD sg13_lv_pmos L=0.13u W=0.42u AS=0.063p
+ AD=0.0798p PS=0.72u PD=0.8u rfmode=0
M$3252 \$1173 \$1175 \$1171 VDD sg13_lv_pmos L=0.13u W=0.42u AS=0.0798p
+ AD=0.1428p PS=0.8u PD=1.52u rfmode=0
M$3253 VDD \$1176 \$1175 VDD sg13_lv_pmos L=0.13u W=1.12u AS=0.41165p
+ AD=0.3864p PS=2.12u PD=2.93u rfmode=0
M$3254 VDD \$762 \$1176 VDD sg13_lv_pmos L=0.13u W=1.12u AS=0.41165p AD=0.4088p
+ PS=2.12u PD=2.97u rfmode=0
M$3255 \$1172 \$1176 \$1177 VDD sg13_lv_pmos L=0.13u W=1u AS=0.34p AD=0.2048p
+ PS=2.68u PD=1.63u rfmode=0
M$3256 \$1177 \$1175 \$1220 VDD sg13_lv_pmos L=0.13u W=0.42u AS=0.2048p
+ AD=0.09345p PS=1.63u PD=0.865u rfmode=0
M$3257 VDD \$1178 \$1220 VDD sg13_lv_pmos L=0.13u W=0.42u AS=0.204p AD=0.09345p
+ PS=1.835u PD=0.865u rfmode=0
M$3258 VDD \$1174 \$1178 VDD sg13_lv_pmos L=0.13u W=0.42u AS=0.204p AD=0.0798p
+ PS=1.835u PD=0.8u rfmode=0
M$3259 VDD \$1177 \$1178 VDD sg13_lv_pmos L=0.13u W=0.42u AS=0.4659p AD=0.0798p
+ PS=3.65u PD=0.8u rfmode=0
M$3260 \$1179 \$1177 VDD VDD sg13_lv_pmos L=0.13u W=1.12u AS=0.3864p AD=0.2128p
+ PS=2.93u PD=1.5u rfmode=0
M$3261 VDD \$1179 \$1068 VDD sg13_lv_pmos L=0.13u W=1.12u AS=0.2128p AD=0.3808p
+ PS=1.5u PD=2.92u rfmode=0
M$3262 VDD \$1076 \$1180 VDD sg13_lv_pmos L=0.13u W=0.42u AS=0.1428p AD=0.0798p
+ PS=1.52u PD=0.8u rfmode=0
M$3263 VDD \$1077 \$1180 VDD sg13_lv_pmos L=0.13u W=0.42u AS=0.3623875p
+ AD=0.0798p PS=2.605u PD=0.8u rfmode=0
M$3264 VDD \$1182 \$1181 VDD sg13_lv_pmos L=0.13u W=1u AS=0.3623875p AD=0.34p
+ PS=2.605u PD=2.68u rfmode=0
M$3265 VDD \$1077 \$1182 VDD sg13_lv_pmos L=0.13u W=0.42u AS=0.1563p AD=0.147p
+ PS=1.22u PD=1.54u rfmode=0
M$3266 VDD \$1181 \$1222 VDD sg13_lv_pmos L=0.13u W=0.42u AS=0.1563p AD=0.063p
+ PS=1.22u PD=0.72u rfmode=0
M$3267 \$1222 \$1184 \$1182 VDD sg13_lv_pmos L=0.13u W=0.42u AS=0.063p
+ AD=0.0798p PS=0.72u PD=0.8u rfmode=0
M$3268 \$1182 \$1183 \$1180 VDD sg13_lv_pmos L=0.13u W=0.42u AS=0.0798p
+ AD=0.1428p PS=0.8u PD=1.52u rfmode=0
M$3269 VDD \$1184 \$1183 VDD sg13_lv_pmos L=0.13u W=1.12u AS=0.41165p
+ AD=0.3864p PS=2.12u PD=2.93u rfmode=0
M$3270 VDD \$504 \$1184 VDD sg13_lv_pmos L=0.13u W=1.12u AS=0.41165p AD=0.4088p
+ PS=2.12u PD=2.97u rfmode=0
M$3271 \$1181 \$1184 \$1185 VDD sg13_lv_pmos L=0.13u W=1u AS=0.34p AD=0.2048p
+ PS=2.68u PD=1.63u rfmode=0
M$3272 \$1185 \$1183 \$1223 VDD sg13_lv_pmos L=0.13u W=0.42u AS=0.2048p
+ AD=0.09345p PS=1.63u PD=0.865u rfmode=0
M$3273 VDD \$1186 \$1223 VDD sg13_lv_pmos L=0.13u W=0.42u AS=0.204p AD=0.09345p
+ PS=1.835u PD=0.865u rfmode=0
M$3274 VDD \$1077 \$1186 VDD sg13_lv_pmos L=0.13u W=0.42u AS=0.204p AD=0.0798p
+ PS=1.835u PD=0.8u rfmode=0
M$3275 VDD \$1185 \$1186 VDD sg13_lv_pmos L=0.13u W=0.42u AS=0.4659p AD=0.0798p
+ PS=3.65u PD=0.8u rfmode=0
M$3276 \$1187 \$1185 VDD VDD sg13_lv_pmos L=0.13u W=1.12u AS=0.3864p AD=0.2128p
+ PS=2.93u PD=1.5u rfmode=0
M$3277 VDD \$1187 \$1188 VDD sg13_lv_pmos L=0.13u W=1.12u AS=0.2128p AD=0.3808p
+ PS=1.5u PD=2.92u rfmode=0
M$3278 \$1126 \$1078 VDD VDD sg13_lv_pmos L=0.13u W=0.42u AS=0.147p AD=0.1563p
+ PS=1.54u PD=1.22u rfmode=0
M$3279 VDD \$1080 \$1142 VDD sg13_lv_pmos L=0.13u W=0.42u AS=0.1563p AD=0.063p
+ PS=1.22u PD=0.72u rfmode=0
M$3280 \$1142 \$1082 \$1126 VDD sg13_lv_pmos L=0.13u W=0.42u AS=0.063p
+ AD=0.0798p PS=0.72u PD=0.8u rfmode=0
M$3281 \$1126 \$1127 \$1079 VDD sg13_lv_pmos L=0.13u W=0.42u AS=0.0798p
+ AD=0.1428p PS=0.8u PD=1.52u rfmode=0
M$3284 VDD \$1003 \$1189 VDD sg13_lv_pmos L=0.13u W=0.84u AS=0.253p AD=0.2856p
+ PS=1.53u PD=2.36u rfmode=0
M$3285 VDD \$1003 \$1224 VDD sg13_lv_pmos L=0.13u W=1u AS=0.253p AD=0.3325p
+ PS=1.53u PD=1.665u rfmode=0
M$3286 \$1224 \$1200 \$1190 VDD sg13_lv_pmos L=0.13u W=1u AS=0.3325p AD=0.2225p
+ PS=1.665u PD=1.445u rfmode=0
M$3287 \$1190 \$685 \$1225 VDD sg13_lv_pmos L=0.13u W=1u AS=0.2225p AD=0.2975p
+ PS=1.445u PD=1.595u rfmode=0
M$3288 VDD \$1189 \$1225 VDD sg13_lv_pmos L=0.13u W=1u AS=0.2198p AD=0.2975p
+ PS=1.52u PD=1.595u rfmode=0
M$3289 VDD \$1190 \$1191 VDD sg13_lv_pmos L=0.13u W=1.12u AS=0.2198p AD=0.6048p
+ PS=1.52u PD=3.32u rfmode=0
M$3290 VDD \$1191 \$1192 VDD sg13_lv_pmos L=0.13u W=0.42u AS=0.1428p AD=0.0798p
+ PS=1.52u PD=0.8u rfmode=0
M$3291 VDD \$1087 \$1192 VDD sg13_lv_pmos L=0.13u W=0.42u AS=0.3623875p
+ AD=0.0798p PS=2.605u PD=0.8u rfmode=0
M$3292 VDD \$1194 \$1193 VDD sg13_lv_pmos L=0.13u W=1u AS=0.3623875p AD=0.34p
+ PS=2.605u PD=2.68u rfmode=0
M$3293 VDD \$1087 \$1194 VDD sg13_lv_pmos L=0.13u W=0.42u AS=0.1563p AD=0.147p
+ PS=1.22u PD=1.54u rfmode=0
M$3294 VDD \$1193 \$1226 VDD sg13_lv_pmos L=0.13u W=0.42u AS=0.1563p AD=0.063p
+ PS=1.22u PD=0.72u rfmode=0
M$3295 \$1226 \$1196 \$1194 VDD sg13_lv_pmos L=0.13u W=0.42u AS=0.063p
+ AD=0.0798p PS=0.72u PD=0.8u rfmode=0
M$3296 \$1194 \$1195 \$1192 VDD sg13_lv_pmos L=0.13u W=0.42u AS=0.0798p
+ AD=0.1428p PS=0.8u PD=1.52u rfmode=0
M$3297 VDD \$1196 \$1195 VDD sg13_lv_pmos L=0.13u W=1.12u AS=0.41165p
+ AD=0.3864p PS=2.12u PD=2.93u rfmode=0
M$3298 VDD \$1093 \$1196 VDD sg13_lv_pmos L=0.13u W=1.12u AS=0.41165p
+ AD=0.4088p PS=2.12u PD=2.97u rfmode=0
M$3299 \$1128 \$1088 VDD VDD sg13_lv_pmos L=0.13u W=0.42u AS=0.147p AD=0.1563p
+ PS=1.54u PD=1.22u rfmode=0
M$3300 VDD \$1090 \$1136 VDD sg13_lv_pmos L=0.13u W=0.42u AS=0.1563p AD=0.063p
+ PS=1.22u PD=0.72u rfmode=0
M$3301 \$1136 \$1092 \$1128 VDD sg13_lv_pmos L=0.13u W=0.42u AS=0.063p
+ AD=0.0798p PS=0.72u PD=0.8u rfmode=0
M$3302 \$1128 \$1129 \$1089 VDD sg13_lv_pmos L=0.13u W=0.42u AS=0.0798p
+ AD=0.1428p PS=0.8u PD=1.52u rfmode=0
M$3303 \$1193 \$1196 \$1197 VDD sg13_lv_pmos L=0.13u W=1u AS=0.34p AD=0.2048p
+ PS=2.68u PD=1.63u rfmode=0
M$3304 \$1197 \$1195 \$1229 VDD sg13_lv_pmos L=0.13u W=0.42u AS=0.2048p
+ AD=0.09345p PS=1.63u PD=0.865u rfmode=0
M$3305 VDD \$1198 \$1229 VDD sg13_lv_pmos L=0.13u W=0.42u AS=0.204p AD=0.09345p
+ PS=1.835u PD=0.865u rfmode=0
M$3306 VDD \$1087 \$1198 VDD sg13_lv_pmos L=0.13u W=0.42u AS=0.204p AD=0.0798p
+ PS=1.835u PD=0.8u rfmode=0
M$3307 VDD \$1197 \$1198 VDD sg13_lv_pmos L=0.13u W=0.42u AS=0.4659p AD=0.0798p
+ PS=3.65u PD=0.8u rfmode=0
M$3308 \$1199 \$1197 VDD VDD sg13_lv_pmos L=0.13u W=1.12u AS=0.3864p AD=0.2128p
+ PS=2.93u PD=1.5u rfmode=0
M$3309 VDD \$1199 \$1200 VDD sg13_lv_pmos L=0.13u W=1.12u AS=0.2128p AD=0.3808p
+ PS=1.5u PD=2.92u rfmode=0
M$3312 VDD \$1124 \$1201 VDD sg13_lv_pmos L=0.13u W=0.84u AS=0.253p AD=0.2856p
+ PS=1.53u PD=2.36u rfmode=0
M$3313 VDD \$1124 \$1228 VDD sg13_lv_pmos L=0.13u W=1u AS=0.253p AD=0.3325p
+ PS=1.53u PD=1.665u rfmode=0
M$3314 \$1228 \$1232 \$1202 VDD sg13_lv_pmos L=0.13u W=1u AS=0.3325p AD=0.2225p
+ PS=1.665u PD=1.445u rfmode=0
M$3315 \$1202 \$685 \$1227 VDD sg13_lv_pmos L=0.13u W=1u AS=0.2225p AD=0.2975p
+ PS=1.445u PD=1.595u rfmode=0
M$3316 VDD \$1201 \$1227 VDD sg13_lv_pmos L=0.13u W=1u AS=0.2198p AD=0.2975p
+ PS=1.52u PD=1.595u rfmode=0
M$3317 VDD \$1202 \$1203 VDD sg13_lv_pmos L=0.13u W=1.12u AS=0.2198p AD=0.6048p
+ PS=1.52u PD=3.32u rfmode=0
M$3318 VDD \$1203 \$1204 VDD sg13_lv_pmos L=0.13u W=0.42u AS=0.1428p AD=0.0798p
+ PS=1.52u PD=0.8u rfmode=0
M$3319 VDD \$1233 \$1204 VDD sg13_lv_pmos L=0.13u W=0.42u AS=0.3623875p
+ AD=0.0798p PS=2.605u PD=0.8u rfmode=0
M$3320 VDD \$1206 \$1205 VDD sg13_lv_pmos L=0.13u W=1u AS=0.3623875p AD=0.34p
+ PS=2.605u PD=2.68u rfmode=0
M$3321 \$1130 \$1098 VDD VDD sg13_lv_pmos L=0.13u W=0.42u AS=0.147p AD=0.1563p
+ PS=1.54u PD=1.22u rfmode=0
M$3322 VDD \$1100 \$1134 VDD sg13_lv_pmos L=0.13u W=0.42u AS=0.1563p AD=0.063p
+ PS=1.22u PD=0.72u rfmode=0
M$3323 \$1134 \$1102 \$1130 VDD sg13_lv_pmos L=0.13u W=0.42u AS=0.063p
+ AD=0.0798p PS=0.72u PD=0.8u rfmode=0
M$3324 \$1130 \$1131 \$1099 VDD sg13_lv_pmos L=0.13u W=0.42u AS=0.0798p
+ AD=0.1428p PS=0.8u PD=1.52u rfmode=0
M$3325 VDD \$1233 \$1206 VDD sg13_lv_pmos L=0.13u W=0.42u AS=0.1563p AD=0.147p
+ PS=1.22u PD=1.54u rfmode=0
M$3326 VDD \$1205 \$1221 VDD sg13_lv_pmos L=0.13u W=0.42u AS=0.1563p AD=0.063p
+ PS=1.22u PD=0.72u rfmode=0
M$3327 \$1221 \$1208 \$1206 VDD sg13_lv_pmos L=0.13u W=0.42u AS=0.063p
+ AD=0.0798p PS=0.72u PD=0.8u rfmode=0
M$3328 \$1206 \$1207 \$1204 VDD sg13_lv_pmos L=0.13u W=0.42u AS=0.0798p
+ AD=0.1428p PS=0.8u PD=1.52u rfmode=0
M$3329 VDD \$1208 \$1207 VDD sg13_lv_pmos L=0.13u W=1.12u AS=0.41165p
+ AD=0.3864p PS=2.12u PD=2.93u rfmode=0
M$3330 VDD \$1093 \$1208 VDD sg13_lv_pmos L=0.13u W=1.12u AS=0.41165p
+ AD=0.4088p PS=2.12u PD=2.97u rfmode=0
M$3331 \$1205 \$1208 \$1209 VDD sg13_lv_pmos L=0.13u W=1u AS=0.34p AD=0.2048p
+ PS=2.68u PD=1.63u rfmode=0
M$3332 \$1209 \$1207 \$1217 VDD sg13_lv_pmos L=0.13u W=0.42u AS=0.2048p
+ AD=0.09345p PS=1.63u PD=0.865u rfmode=0
M$3333 VDD \$1210 \$1217 VDD sg13_lv_pmos L=0.13u W=0.42u AS=0.204p AD=0.09345p
+ PS=1.835u PD=0.865u rfmode=0
M$3334 VDD \$1233 \$1210 VDD sg13_lv_pmos L=0.13u W=0.42u AS=0.204p AD=0.0798p
+ PS=1.835u PD=0.8u rfmode=0
M$3335 VDD \$1209 \$1210 VDD sg13_lv_pmos L=0.13u W=0.42u AS=0.4659p AD=0.0798p
+ PS=3.65u PD=0.8u rfmode=0
M$3336 \$1211 \$1209 VDD VDD sg13_lv_pmos L=0.13u W=1.12u AS=0.3864p AD=0.2128p
+ PS=2.93u PD=1.5u rfmode=0
M$3337 VDD \$1211 \$1232 VDD sg13_lv_pmos L=0.13u W=1.12u AS=0.2128p AD=0.3808p
+ PS=1.5u PD=2.92u rfmode=0
M$3343 \$30 \$1276 VDD VDD sg13_lv_pmos L=0.13u W=1.12u AS=0.42p AD=0.2114p
+ PS=2.99u PD=1.54u rfmode=0
M$3344 VDD \$1068 \$1276 VDD sg13_lv_pmos L=0.13u W=0.84u AS=0.2114p AD=0.2856p
+ PS=1.54u PD=2.36u rfmode=0
M$3345 \$29 \$1277 VDD VDD sg13_lv_pmos L=0.13u W=1.12u AS=0.42p AD=0.2114p
+ PS=2.99u PD=1.54u rfmode=0
M$3346 VDD \$1188 \$1277 VDD sg13_lv_pmos L=0.13u W=0.84u AS=0.2114p AD=0.2856p
+ PS=1.54u PD=2.36u rfmode=0
M$3349 D0 \$1279 VDD VDD sg13_lv_pmos L=0.13u W=1.12u AS=0.42p AD=0.2114p
+ PS=2.99u PD=1.54u rfmode=0
M$3350 VDD \$1280 \$1279 VDD sg13_lv_pmos L=0.13u W=0.84u AS=0.2114p AD=0.2856p
+ PS=1.54u PD=2.36u rfmode=0
M$3361 D1 \$1282 VDD VDD sg13_lv_pmos L=0.13u W=1.12u AS=0.42p AD=0.2114p
+ PS=2.99u PD=1.54u rfmode=0
M$3362 VDD \$917 \$1282 VDD sg13_lv_pmos L=0.13u W=0.84u AS=0.2114p AD=0.2856p
+ PS=1.54u PD=2.36u rfmode=0
M$3372 D2 \$1284 VDD VDD sg13_lv_pmos L=0.13u W=1.12u AS=0.42p AD=0.2114p
+ PS=2.99u PD=1.54u rfmode=0
M$3373 VDD \$1063 \$1284 VDD sg13_lv_pmos L=0.13u W=0.84u AS=0.2114p AD=0.2856p
+ PS=1.54u PD=2.36u rfmode=0
M$3374 VDD \$791 \$1287 VDD sg13_lv_pmos L=0.13u W=0.84u AS=0.253p AD=0.2856p
+ PS=1.53u PD=2.36u rfmode=0
M$3375 VDD \$1287 \$1315 VDD sg13_lv_pmos L=0.13u W=1u AS=0.2198p AD=0.2975p
+ PS=1.52u PD=1.595u rfmode=0
M$3376 \$1315 \$619 \$1286 VDD sg13_lv_pmos L=0.13u W=1u AS=0.2975p AD=0.2225p
+ PS=1.595u PD=1.445u rfmode=0
M$3377 \$1286 \$1280 \$1316 VDD sg13_lv_pmos L=0.13u W=1u AS=0.2225p AD=0.3325p
+ PS=1.445u PD=1.665u rfmode=0
M$3378 \$1316 \$791 VDD VDD sg13_lv_pmos L=0.13u W=1u AS=0.3325p AD=0.253p
+ PS=1.665u PD=1.53u rfmode=0
M$3379 \$1285 \$1286 VDD VDD sg13_lv_pmos L=0.13u W=1.12u AS=0.6048p AD=0.2198p
+ PS=3.32u PD=1.52u rfmode=0
M$3383 VDD \$419 \$1165 VDD sg13_lv_pmos L=0.13u W=1.12u AS=0.3808p AD=0.3808p
+ PS=2.92u PD=2.92u rfmode=0
M$3387 D3 \$1289 VDD VDD sg13_lv_pmos L=0.13u W=1.12u AS=0.42p AD=0.2114p
+ PS=2.99u PD=1.54u rfmode=0
M$3388 VDD \$1066 \$1289 VDD sg13_lv_pmos L=0.13u W=0.84u AS=0.2114p AD=0.2856p
+ PS=1.54u PD=2.36u rfmode=0
M$3391 VDD \$419 \$1174 VDD sg13_lv_pmos L=0.13u W=1.12u AS=0.3808p AD=0.3808p
+ PS=2.92u PD=2.92u rfmode=0
M$3398 VDD \$1188 \$1125 VDD sg13_lv_pmos L=0.13u W=1.12u AS=0.3808p AD=0.3808p
+ PS=2.92u PD=2.92u rfmode=0
M$3399 D4 \$1291 VDD VDD sg13_lv_pmos L=0.13u W=1.12u AS=0.42p AD=0.2114p
+ PS=2.99u PD=1.54u rfmode=0
M$3400 VDD \$884 \$1291 VDD sg13_lv_pmos L=0.13u W=0.84u AS=0.2114p AD=0.2856p
+ PS=1.54u PD=2.36u rfmode=0
M$3411 D5 \$1293 VDD VDD sg13_lv_pmos L=0.13u W=1.12u AS=0.42p AD=0.2114p
+ PS=2.99u PD=1.54u rfmode=0
M$3412 VDD \$1009 \$1293 VDD sg13_lv_pmos L=0.13u W=0.84u AS=0.2114p AD=0.2856p
+ PS=1.54u PD=2.36u rfmode=0
M$3416 \$1093 \$1294 VDD VDD sg13_lv_pmos L=0.13u W=1.12u AS=0.42p AD=0.2114p
+ PS=2.99u PD=1.54u rfmode=0
M$3417 VDD \$341 \$1294 VDD sg13_lv_pmos L=0.13u W=0.84u AS=0.2114p AD=0.2856p
+ PS=1.54u PD=2.36u rfmode=0
M$3422 VDD \$1200 \$1295 VDD sg13_lv_pmos L=0.13u W=0.84u AS=0.2114p AD=0.2856p
+ PS=1.54u PD=2.36u rfmode=0
M$3423 VDD \$1295 D6 VDD sg13_lv_pmos L=0.13u W=1.12u AS=0.2114p AD=0.42p
+ PS=1.54u PD=2.99u rfmode=0
M$3424 \$1297 \$1124 VDD VDD sg13_lv_pmos L=0.13u W=0.84u AS=0.2856p AD=0.253p
+ PS=2.36u PD=1.53u rfmode=0
M$3425 VDD \$1124 \$1311 VDD sg13_lv_pmos L=0.13u W=1u AS=0.253p AD=0.3325p
+ PS=1.53u PD=1.665u rfmode=0
M$3426 \$1311 \$1107 \$1298 VDD sg13_lv_pmos L=0.13u W=1u AS=0.3325p AD=0.2225p
+ PS=1.665u PD=1.445u rfmode=0
M$3427 \$1298 \$685 \$1310 VDD sg13_lv_pmos L=0.13u W=1u AS=0.2225p AD=0.2975p
+ PS=1.445u PD=1.595u rfmode=0
M$3428 \$1310 \$1297 VDD VDD sg13_lv_pmos L=0.13u W=1u AS=0.2975p AD=0.2198p
+ PS=1.595u PD=1.52u rfmode=0
M$3429 VDD \$1298 \$1299 VDD sg13_lv_pmos L=0.13u W=1.12u AS=0.2198p AD=0.6048p
+ PS=1.52u PD=3.32u rfmode=0
M$3430 VDD \$885 \$1233 VDD sg13_lv_pmos L=0.13u W=1.12u AS=0.3808p AD=0.3808p
+ PS=2.92u PD=2.92u rfmode=0
M$3439 D7 \$1301 VDD VDD sg13_lv_pmos L=0.13u W=1.12u AS=0.42p AD=0.2114p
+ PS=2.99u PD=1.54u rfmode=0
M$3440 VDD \$1232 \$1301 VDD sg13_lv_pmos L=0.13u W=0.84u AS=0.2114p AD=0.2856p
+ PS=1.54u PD=2.36u rfmode=0
M$3441 VDD \$1107 \$1302 VDD sg13_lv_pmos L=0.13u W=0.84u AS=0.2114p AD=0.2856p
+ PS=1.54u PD=2.36u rfmode=0
M$3442 VDD \$1302 \$40 VDD sg13_lv_pmos L=0.13u W=1.12u AS=0.2114p AD=0.42p
+ PS=1.54u PD=2.99u rfmode=0
M$3443 VDD \$1035 \$1303 VDD sg13_lv_pmos L=0.13u W=0.84u AS=0.2114p AD=0.2856p
+ PS=1.54u PD=2.36u rfmode=0
M$3444 VDD \$1303 \$39 VDD sg13_lv_pmos L=0.13u W=1.12u AS=0.2114p AD=0.42p
+ PS=1.54u PD=2.99u rfmode=0
C$3445 \$5 \$3 cap_cmim w=5.71u l=5.71u A=32.6041p P=22.84u m=40
C$3457 \$6 \$4 cap_cmim w=5.71u l=5.71u A=32.6041p P=22.84u m=40
C$3470 \$8 \$7 cap_cmim w=5.71u l=5.71u A=32.6041p P=22.84u m=64
C$3483 \$10 \$9 cap_cmim w=5.71u l=5.71u A=32.6041p P=22.84u m=64
C$3505 \$11 \$8 cap_cmim w=1.49u l=1.49u A=2.2201p P=5.96u m=1
C$3506 \$12 \$10 cap_cmim w=1.49u l=1.49u A=2.2201p P=5.96u m=1
C$3523 \$8 \$17 cap_cmim w=5.71u l=5.71u A=32.6041p P=22.84u m=32
C$3531 \$10 \$28 cap_cmim w=5.71u l=5.71u A=32.6041p P=22.84u m=32
C$3550 \$8 \$18 cap_cmim w=5.71u l=5.71u A=32.6041p P=22.84u m=16
C$3554 \$8 VDD cap_cmim w=5.71u l=5.71u A=32.6041p P=22.84u m=1
C$3555 \$10 VDD cap_cmim w=5.71u l=5.71u A=32.6041p P=22.84u m=1
C$3556 \$10 \$19 cap_cmim w=5.71u l=5.71u A=32.6041p P=22.84u m=16
C$3575 \$8 \$20 cap_cmim w=5.71u l=5.71u A=32.6041p P=22.84u m=8
C$3578 \$8 \$21 cap_cmim w=5.71u l=5.71u A=32.6041p P=22.84u m=1
C$3579 \$10 \$22 cap_cmim w=5.71u l=5.71u A=32.6041p P=22.84u m=1
C$3581 \$10 \$23 cap_cmim w=5.71u l=5.71u A=32.6041p P=22.84u m=8
C$3600 \$8 \$24 cap_cmim w=5.71u l=5.71u A=32.6041p P=22.84u m=4
C$3601 \$8 \$25 cap_cmim w=5.71u l=5.71u A=32.6041p P=22.84u m=2
C$3603 \$10 \$26 cap_cmim w=5.71u l=5.71u A=32.6041p P=22.84u m=2
C$3605 \$10 \$27 cap_cmim w=5.71u l=5.71u A=32.6041p P=22.84u m=4
C$3783 \$280 \$225 cap_cmim w=9.39u l=6.99u A=65.6361p P=32.76u m=1
C$3784 \$248 \$226 cap_cmim w=4.665u l=6.99u A=32.60835p P=23.31u m=1
C$3785 \$295 \$224 cap_cmim w=4.665u l=6.99u A=32.60835p P=23.31u m=1
C$3786 \$302 VSS cap_cmim w=3.59u l=3.59u A=12.8881p P=14.36u m=1
C$3787 \$296 \$227 cap_cmim w=4.665u l=6.99u A=32.60835p P=23.31u m=1
C$3788 \$297 \$228 cap_cmim w=4.665u l=6.99u A=32.60835p P=23.31u m=1
C$3789 \$249 \$229 cap_cmim w=9.39u l=6.99u A=65.6361p P=32.76u m=1
R$3790 VDD \$200 ntap1 A=15.376p P=99.2u
.ENDS SAR_ADC
