** sch_path: /home/designer/shared/IHP-AnalogAcademy/modules/module_3_8_bit_SAR_ADC/part_5_analog_layout/SAR_ADC_TOP/schematic/SAR_ADC.sch
.subckt SAR_ADC vin_pos vin_neg VDD VSS bias D0 D1 D2 D3 D4 D5 D7 D6 fclk_in rst En fdac_clk
*.PININFO vin_pos:I vin_neg:I VDD:B VSS:B bias:I D0:O D1:O D2:O D3:O D4:O D5:O D7:O D6:O fclk_in:I rst:I En:I fdac_clk:O
x7 VDD VDD VSS net12 net11 BN5 BN6 net10 BN_MSB net16 net15 BN1 BN2 net14 BN3 net13 BN4 switch_array
x4 VDD VDD VSS net7 net8 B5 B6 net9 B_MSB net3 net4 B1 B2 net5 B3 net6 B4 switch_array
x8 VDD clk_algo Om Op VSS nand_gate
x1 VDD vin_pos net2 clk_samp VSS bootstrap_switch
x6 VDD vin_neg net1 clk_samp VSS bootstrap_switch
x9 VDD bias CDAC_v+ CDAC_v- Om Op clk_comp VSS DIFF_COMPARATOR
x3 net2 CDAC_v+ net7 net8 net5 net6 net4 net3 VDD net9 CDAC
x2 net1 CDAC_v- net12 net11 net14 net13 net15 net16 VDD net10 CDAC
C1 clk_algo VSS cap_cmim w=3.59e-6 l=3.59e-6 m=1
x5 En Om Op VDD VSS clk_algo clk_comp fclk_in clk_samp fdac_clk rst B1 B2 B3 B4 B5 B6 B_MSB BN1 BN2 BN3 BN4 BN5 BN6 BN_MSB D0 D1 D2 D3 D4 D5 D6 D7 sar_algo
.ends

* expanding   symbol:
*+  /home/designer/shared/IHP-AnalogAcademy/modules/module_3_8_bit_SAR_ADC/part_5_analog_layout/switch_array/schematic/switch_array.sym # of pins=17
** sym_path: /home/designer/shared/IHP-AnalogAcademy/modules/module_3_8_bit_SAR_ADC/part_5_analog_layout/switch_array/schematic/switch_array.sym
** sch_path: /home/designer/shared/IHP-AnalogAcademy/modules/module_3_8_bit_SAR_ADC/part_5_analog_layout/switch_array/schematic/switch_array.sch
.subckt switch_array vref vdd gnd S5 S6 D5 D6 S_MSB D_MSB S1 S2 D1 D2 S3 D3 S4 D4
*.PININFO S_MSB:B S6:B D_MSB:B D6:B S5:B D5:B S4:B S3:B S2:B D4:B D3:B D2:B S1:B D1:B vdd:B vref:B gnd:B
x22 D_MSB vref S_MSB gnd net1 vdd T_gate
x1 net1 gnd S_MSB gnd D_MSB vdd T_gate
x7 vdd D_MSB net1 gnd inverter
x2 D6 vref S6 gnd net2 vdd T_gate
x3 net2 gnd S6 gnd D6 vdd T_gate
x4 vdd D6 net2 gnd inverter
x5 D5 vref S5 gnd net3 vdd T_gate
x6 net3 gnd S5 gnd D5 vdd T_gate
x8 vdd D5 net3 gnd inverter
x9 D4 vref S4 gnd net4 vdd T_gate
x10 net4 gnd S4 gnd D4 vdd T_gate
x11 vdd D4 net4 gnd inverter
x12 net5 gnd S3 gnd D3 vdd T_gate
x13 D3 vref S3 gnd net5 vdd T_gate
x14 vdd D3 net5 gnd inverter
x15 D2 vref S2 gnd net6 vdd T_gate
x16 net6 gnd S2 gnd D2 vdd T_gate
x17 vdd D2 net6 gnd inverter
x18 D1 vref S1 gnd net7 vdd T_gate
x19 net7 gnd S1 gnd D1 vdd T_gate
x20 vdd D1 net7 gnd inverter
.ends

* expanding   symbol:
*+  /home/designer/shared/IHP-AnalogAcademy/modules/module_3_8_bit_SAR_ADC/part_2_digital_comps/nand_gate/schematic/nand_gate.sym # of pins=5
** sym_path: /home/designer/shared/IHP-AnalogAcademy/modules/module_3_8_bit_SAR_ADC/part_2_digital_comps/nand_gate/schematic/nand_gate.sym
** sch_path: /home/designer/shared/IHP-AnalogAcademy/modules/module_3_8_bit_SAR_ADC/part_2_digital_comps/nand_gate/schematic/nand_gate.sch
.subckt nand_gate vdd Vo B A gnd
*.PININFO vdd:B gnd:B A:I Vo:O B:I
M5 Vo A vdd vdd sg13_lv_pmos w=0.5u l=0.13u ng=1 m=1
M6 Vo A net1 gnd sg13_lv_nmos w=0.25u l=0.13u ng=1 m=1
M1 net1 B gnd gnd sg13_lv_nmos w=0.25u l=0.13u ng=1 m=1
M2 Vo B vdd vdd sg13_lv_pmos w=0.5u l=0.13u ng=1 m=1
.ends

* expanding   symbol:
*+  /home/designer/shared/IHP-AnalogAcademy/modules/module_3_8_bit_SAR_ADC/part_2_digital_comps/bootstrap_switch/schematic/bootstrap_switch.sym # of pins=5
** sym_path: /home/designer/shared/IHP-AnalogAcademy/modules/module_3_8_bit_SAR_ADC/part_2_digital_comps/bootstrap_switch/schematic/bootstrap_switch.sym
** sch_path: /home/designer/shared/IHP-AnalogAcademy/modules/module_3_8_bit_SAR_ADC/part_2_digital_comps/bootstrap_switch/schematic/bootstrap_switch.sch
.subckt bootstrap_switch vdd vi vo clk gnd
*.PININFO gnd:B vdd:B vi:B vo:B clk:B
M1 vdd net2 net1 gnd sg13_lv_nmos w=1.3u l=0.13u ng=1 m=1
M3 vdd net1 net2 gnd sg13_lv_nmos w=1.3u l=0.13u ng=1 m=1
M4 net7 net10 net3 net3 sg13_lv_pmos w=500n l=0.13u ng=1 m=1
M2 vdd net2 net3 gnd sg13_lv_nmos w=1.3u l=0.13u ng=1 m=1
M6 net5 gp vdd vdd sg13_lv_pmos w=500n l=130n ng=1 m=1
M5 net5 vdd net4 gnd sg13_lv_nmos w=3u l=0.13u ng=1 m=1
M7 net4 clk_not gnd gnd sg13_lv_nmos w=3u l=0.13u ng=1 m=1
C5 net2 clk_not cap_cmim w=4.665e-6 l=6.99e-6 m=1
C6 net3 net6 cap_cmim w=9.39e-6 l=6.99e-6 m=1
M8 net6 net5 vi gnd sg13_lv_nmos w=3u l=0.13u ng=1 m=1
M9 vo net7 vi gnd sg13_lv_nmos w=2.5u l=0.13u ng=1 m=1
M10 net8 vdd net7 gnd sg13_lv_nmos w=500n l=0.13u ng=1 m=1
M11 gnd clk_not net8 gnd sg13_lv_nmos w=500n l=0.13u ng=1 m=1
M12 net6 clk_not gnd gnd sg13_lv_nmos w=1.3u l=0.4u ng=1 m=1
C1 net1 net9 cap_cmim w=4.665e-6 l=6.99e-6 m=1
x1 vdd clk clk_not gnd inverter
x2 vdd gp net10 gnd inverter
x3 vdd clk_not net9 gnd inverter
.ends

* expanding   symbol:
*+  /home/designer/shared/IHP-AnalogAcademy/modules/module_3_8_bit_SAR_ADC/part_5_analog_layout/comparator/layout/schematic/DIFF_COMPARATOR.sym # of pins=8
** sym_path: /home/designer/shared/IHP-AnalogAcademy/modules/module_3_8_bit_SAR_ADC/part_5_analog_layout/comparator/layout/schematic/DIFF_COMPARATOR.sym
** sch_path: /home/designer/shared/IHP-AnalogAcademy/modules/module_3_8_bit_SAR_ADC/part_5_analog_layout/comparator/layout/schematic/DIFF_COMPARATOR.sch
.subckt DIFF_COMPARATOR vdd vbias v+ v- out- out+ clk gnd
*.PININFO vdd:B gnd:B v+:I v-:I clk:I out-:O out+:O vbias:I
M2 net3 v+ net1 well sg13_lv_pmos w=8u l=200n ng=2 m=4
M1 net2 v- net1 well sg13_lv_pmos w=8u l=200n ng=2 m=4
M4 out- net2 vdd well sg13_lv_pmos w=8u l=0.200u ng=2 m=1
M5 out+ net3 vdd well sg13_lv_pmos w=8u l=0.200u ng=2 m=1
M11 gnd net3 out+ gnd sg13_lv_nmos w=4.0u l=0.200u ng=2 m=1
M12 gnd net2 out- gnd sg13_lv_nmos w=4.0u l=0.200u ng=2 m=1
M6 gnd net2 net3 gnd sg13_lv_nmos w=4.0u l=0.200u ng=1 m=1
M10 gnd clk net3 gnd sg13_lv_nmos w=4.0u l=0.200u ng=1 m=1
M7 gnd clk net2 gnd sg13_lv_nmos w=4.0u l=0.200u ng=1 m=1
M8 gnd net3 net2 gnd sg13_lv_nmos w=4.0u l=0.200u ng=1 m=1
M3 gnd gnd gnd gnd sg13_lv_nmos w=4.0u l=0.200u ng=1 m=4
M13 net1 clk net4 well sg13_lv_pmos w=18u l=0.3u ng=4 m=1
M9 net4 vbias vdd well sg13_lv_pmos w=18u l=0.3u ng=4 m=1
R1 vdd well ntap1 A=1.5376e-11 P=9.92e-05
.ends

* expanding   symbol:
*+  /home/designer/shared/IHP-AnalogAcademy/modules/module_3_8_bit_SAR_ADC/part_5_analog_layout/CDAC/schematic/CDAC.sym # of pins=10
** sym_path: /home/designer/shared/IHP-AnalogAcademy/modules/module_3_8_bit_SAR_ADC/part_5_analog_layout/CDAC/schematic/CDAC.sym
** sch_path: /home/designer/shared/IHP-AnalogAcademy/modules/module_3_8_bit_SAR_ADC/part_5_analog_layout/CDAC/schematic/CDAC.sch
.subckt CDAC vin vo C5 C6 C3 C4 C2 C1 vref C_MSB
*.PININFO vin:B vo:B C6:B C5:B C4:B C3:B C2:B C1:B vref:B C_MSB:B
C1 vo vref cap_cmim w=5.71e-6 l=5.71e-6 m=1
C2 vo C1 cap_cmim w=5.71e-6 l=5.71e-6 m=1
C3 vo C2 cap_cmim w=5.71e-6 l=5.71e-6 m=2
C4 vo C3 cap_cmim w=5.71e-6 l=5.71e-6 m=4
C5 vo C4 cap_cmim w=5.71e-6 l=5.71e-6 m=8
C6 vo C5 cap_cmim w=5.71e-6 l=5.71e-6 m=16
C7 vo C6 cap_cmim w=5.71e-6 l=5.71e-6 m=32
C8 vo C_MSB cap_cmim w=5.71e-6 l=5.71e-6 m=64
C9 net1 net2 cap_cmim w=5.71e-6 l=5.71e-6 m=40
* noconn #net1
* noconn #net2
C10 vin vo cap_cmim w=1.49e-6 l=1.49e-6 m=1
.ends

* expanding   symbol:
*+  /home/designer/shared/IHP-AnalogAcademy/modules/module_3_8_bit_SAR_ADC/part_5_analog_layout/switch_array/schematic/T_gate.sym # of pins=6
** sym_path: /home/designer/shared/IHP-AnalogAcademy/modules/module_3_8_bit_SAR_ADC/part_5_analog_layout/switch_array/schematic/T_gate.sym
** sch_path: /home/designer/shared/IHP-AnalogAcademy/modules/module_3_8_bit_SAR_ADC/part_5_analog_layout/switch_array/schematic/T_gate.sch
.subckt T_gate !Control Vin Vout gnd Control vdd
*.PININFO Vout:B Vin:B !Control:B Control:B gnd:B vdd:B
M1 Vin Control Vout gnd sg13_lv_nmos w=1u l=0.13u ng=1 m=1
M2 Vin !Control Vout vdd sg13_lv_pmos w=2u l=0.13u ng=1 m=1
.ends

* expanding   symbol:
*+  /home/designer/shared/IHP-AnalogAcademy/modules/module_3_8_bit_SAR_ADC/part_5_analog_layout/switch_array/schematic/inverter.sym # of pins=4
** sym_path: /home/designer/shared/IHP-AnalogAcademy/modules/module_3_8_bit_SAR_ADC/part_5_analog_layout/switch_array/schematic/inverter.sym
** sch_path: /home/designer/shared/IHP-AnalogAcademy/modules/module_3_8_bit_SAR_ADC/part_5_analog_layout/switch_array/schematic/inverter.sch
.subckt inverter vdd vi vo gnd
*.PININFO vi:B vo:B gnd:B vdd:B
M5 vo vi vdd vdd sg13_lv_pmos w=800n l=130n ng=1 m=1
M7 vo vi gnd gnd sg13_lv_nmos w=400n l=130n ng=1 m=1
.ends

.include "/home/dkits/ihp-sg13g2/v0.3.0/ihp-sg13g2/libs.ref/sg13g2_stdcell/cdl/sg13g2_stdcell.cdl"

.SUBCKT sar_algo En Om Op VDD VSS clk_algo fclk_comp fclk_in fclk_samp fdac_clk rst B[0] B[1] B[2] B[3] B[4] B[5] B[6] BN[0] BN[1] BN[2] BN[3] BN[4] BN[5] BN[6] D[0] D[1] D[2] D[3] D[4] D[5] D[6] D[7]

X_104_ net29 net51 VDD VSS sg13g2_inv_1
X_105_ _065_ counter[3] VDD VSS sg13g2_inv_1
X_106_ _066_ counter[2] VDD VSS sg13g2_inv_1
X_107_ _067_ net12 VDD VSS sg13g2_inv_1
X_108_ _068_ net11 VDD VSS sg13g2_inv_1
X_109_ _002_ net37 VDD VSS sg13g2_inv_1
X_110_ _069_ net1 net48 net50 VDD VSS sg13g2_nand3_1
X_111_ _070_ net1 net46 net48 cnt[0] VDD VSS sg13g2_nand4_1
X_112_ _064_ net44 net49 VDD VSS sg13g2_and2_1
X_113_ _063_ net46 _069_ VDD VSS sg13g2_xnor2_1
X_114_ _071_ net1 net50 net48 VDD VSS sg13g2_a21o_1
X_115_ _062_ _069_ _071_ VDD VSS sg13g2_and2_1
X_116_ _061_ net1 net50 VDD VSS sg13g2_xor2_1
X_117_ _000_ net44 net29 _070_ VDD VSS sg13g2_nor3_1
X_118_ _072_ net44 net49 net29 VDD VSS sg13g2_o21ai_1
X_119_ _060_ net45 _072_ VDD VSS sg13g2_nor2b_1
X_120_ _073_ counter[1] counter[0] VDD VSS sg13g2_nand2_1
X_121_ _074_ counter[3] _001_ net1 VDD VSS sg13g2_nand3b_1
X_122_ _075_ _066_ net31 VDD VSS sg13g2_nor2_1
X_123_ _076_ _066_ net31 VDD VSS sg13g2_or2_1
X_124_ _077_ _073_ _076_ VDD VSS sg13g2_nor2_1
X_125_ _078_ net1 net29 VDD VSS sg13g2_nand2_1
X_126_ _059_ counter[3] _078_ _077_ VDD VSS sg13g2_a21o_1
X_127_ _079_ counter[2] _073_ net31 VDD VSS sg13g2_nor3_1
X_128_ _080_ net29 _065_ net1 VDD VSS sg13g2_o21ai_1
X_129_ _081_ _073_ _075_ _080_ counter[2] VDD VSS sg13g2_a22oi_1
X_130_ _058_ _079_ _081_ VDD VSS sg13g2_nand2b_1
X_131_ _082_ counter[1] counter[0] VDD VSS sg13g2_nand2b_1
X_132_ _083_ counter[0] counter[1] VDD VSS sg13g2_nand2b_1
X_133_ _084_ _082_ _083_ net31 VDD VSS sg13g2_a21oi_1
X_134_ _057_ counter[1] _080_ _084_ VDD VSS sg13g2_a21o_1
X_135_ _085_ counter[0] _080_ VDD VSS sg13g2_nand2_1
X_136_ _056_ counter[0] net31 _085_ VDD VSS sg13g2_o21ai_1
X_137_ _086_ counter[2] counter[1] net31 VDD VSS sg13g2_nor3_1
X_138_ _087_ counter[0] _086_ VDD VSS sg13g2_nor2b_1
X_139_ _088_ _066_ net31 _083_ VDD VSS sg13g2_nor3_1
X_140_ _089_ net2 net3 VDD VSS sg13g2_nor2b_1
X_141_ _090_ net2 net3 VDD VSS sg13g2_nand2b_1
X_142_ _091_ counter[1] counter[0] net32 VDD VSS sg13g2_nor3_1
X_143_ _092_ _086_ _088_ _091_ VDD VSS sg13g2_o21ai_1
X_144_ _055_ _067_ _087_ _092_ VDD VSS sg13g2_o21ai_1
X_145_ _093_ counter[2] net31 _082_ VDD VSS sg13g2_nor3_1
X_146_ _094_ _082_ net33 VDD VSS sg13g2_nor2_1
X_147_ _095_ _086_ _088_ _094_ VDD VSS sg13g2_o21ai_1
X_148_ _054_ _068_ _093_ _095_ VDD VSS sg13g2_o21ai_1
X_149_ _096_ counter[2] _074_ _083_ VDD VSS sg13g2_nor3_1
X_150_ _097_ net10 _096_ VDD VSS sg13g2_nor2_1
X_151_ _053_ net33 _096_ _097_ VDD VSS sg13g2_a21oi_1
X_152_ _052_ net9 _090_ _079_ VDD VSS sg13g2_mux2_1
X_153_ _098_ counter[1] counter[0] _076_ VDD VSS sg13g2_nor3_1
X_154_ _051_ net8 _090_ _098_ VDD VSS sg13g2_mux2_1
X_155_ _099_ _076_ _082_ VDD VSS sg13g2_nor2_1
X_156_ _050_ net7 _090_ _099_ VDD VSS sg13g2_mux2_1
X_157_ _049_ net6 _090_ _088_ VDD VSS sg13g2_mux2_1
X_158_ _048_ net27 net32 _087_ VDD VSS sg13g2_mux2_1
X_159_ _047_ net26 net32 _093_ VDD VSS sg13g2_mux2_1
X_160_ _046_ net25 net32 _096_ VDD VSS sg13g2_mux2_1
X_161_ _100_ net24 _079_ VDD VSS sg13g2_nor2_1
X_162_ _045_ _079_ _090_ _100_ VDD VSS sg13g2_a21oi_1
X_163_ _044_ net23 net33 _098_ VDD VSS sg13g2_mux2_1
X_164_ _043_ net22 net33 _099_ VDD VSS sg13g2_mux2_1
X_165_ _101_ net21 _088_ VDD VSS sg13g2_nor2_1
X_166_ _042_ _088_ _090_ _101_ VDD VSS sg13g2_a21oi_1
X_167_ _041_ net20 net33 _077_ VDD VSS sg13g2_mux2_1
X_168_ _040_ net19 net32 _087_ VDD VSS sg13g2_mux2_1
X_169_ _039_ net18 net32 _093_ VDD VSS sg13g2_mux2_1
X_170_ _038_ net17 net32 _096_ VDD VSS sg13g2_mux2_1
X_171_ _102_ net16 _079_ VDD VSS sg13g2_nor2_1
X_172_ _037_ _079_ _090_ _102_ VDD VSS sg13g2_a21oi_1
X_173_ _036_ net15 net32 _098_ VDD VSS sg13g2_mux2_1
X_174_ _035_ net14 net33 _099_ VDD VSS sg13g2_mux2_1
X_175_ _103_ net13 _088_ VDD VSS sg13g2_nor2_1
X_176_ _034_ _088_ _090_ _103_ VDD VSS sg13g2_a21oi_1
X_177_ _003_ net37 VDD VSS sg13g2_inv_1
X_178_ _004_ net37 VDD VSS sg13g2_inv_1
X_179_ _005_ net37 VDD VSS sg13g2_inv_1
X_180_ _006_ net38 VDD VSS sg13g2_inv_1
X_181_ _007_ net38 VDD VSS sg13g2_inv_1
X_182_ _008_ net38 VDD VSS sg13g2_inv_1
X_183_ _009_ net34 VDD VSS sg13g2_inv_1
X_184_ _010_ net34 VDD VSS sg13g2_inv_1
X_185_ _011_ net35 VDD VSS sg13g2_inv_1
X_186_ _012_ net35 VDD VSS sg13g2_inv_1
X_187_ _013_ net37 VDD VSS sg13g2_inv_1
X_188_ _014_ net37 VDD VSS sg13g2_inv_1
X_189_ _015_ net38 VDD VSS sg13g2_inv_1
X_190_ _016_ net38 VDD VSS sg13g2_inv_1
X_191_ _017_ net34 VDD VSS sg13g2_inv_1
X_192_ _018_ net34 VDD VSS sg13g2_inv_1
X_193_ _019_ net34 VDD VSS sg13g2_inv_1
X_194_ _020_ net34 VDD VSS sg13g2_inv_1
X_195_ _021_ net35 VDD VSS sg13g2_inv_1
X_196_ _022_ net35 VDD VSS sg13g2_inv_1
X_197_ _023_ net37 VDD VSS sg13g2_inv_1
X_198_ _024_ net35 VDD VSS sg13g2_inv_1
X_199_ _025_ net37 VDD VSS sg13g2_inv_1
X_200_ _026_ net35 VDD VSS sg13g2_inv_1
X_201_ _027_ net35 VDD VSS sg13g2_inv_1
X_202_ _028_ net36 VDD VSS sg13g2_inv_1
X_203_ _029_ net34 VDD VSS sg13g2_inv_1
X_204_ _030_ net34 VDD VSS sg13g2_inv_1
X_205_ _031_ net36 VDD VSS sg13g2_inv_1
X_206_ _032_ net36 VDD VSS sg13g2_inv_1
X_207_ _033_ net36 VDD VSS sg13g2_inv_1
X_208_ net13 net42 _034_ _002_ VDD VSS sg13g2_dfrbpq_1
X_209_ net14 net42 _035_ _003_ VDD VSS sg13g2_dfrbpq_1
X_210_ net15 net42 _036_ _004_ VDD VSS sg13g2_dfrbpq_1
X_211_ net16 net42 _037_ _005_ VDD VSS sg13g2_dfrbpq_1
X_212_ net17 net42 _038_ _006_ VDD VSS sg13g2_dfrbpq_1
X_213_ net18 net43 _039_ _007_ VDD VSS sg13g2_dfrbpq_1
X_214_ net19 net43 _040_ _008_ VDD VSS sg13g2_dfrbpq_1
X_215_ net20 net40 _041_ _009_ VDD VSS sg13g2_dfrbpq_1
X_216_ net21 net40 _042_ _010_ VDD VSS sg13g2_dfrbpq_1
X_217_ net22 net40 _043_ _011_ VDD VSS sg13g2_dfrbpq_1
X_218_ net23 net41 _044_ _012_ VDD VSS sg13g2_dfrbpq_1
X_219_ net24 net42 _045_ _013_ VDD VSS sg13g2_dfrbpq_1
X_220_ net25 net42 _046_ _014_ VDD VSS sg13g2_dfrbpq_1
X_221_ net26 net43 _047_ _015_ VDD VSS sg13g2_dfrbpq_1
X_222_ net27 net43 _048_ _016_ VDD VSS sg13g2_dfrbpq_1
X_223_ net6 net40 _049_ _017_ VDD VSS sg13g2_dfrbpq_1
X_224_ net7 net40 _050_ _018_ VDD VSS sg13g2_dfrbpq_1
X_225_ net8 net40 _051_ _019_ VDD VSS sg13g2_dfrbpq_1
X_226_ net9 net40 _052_ _020_ VDD VSS sg13g2_dfrbpq_1
X_227_ net10 net40 _053_ _021_ VDD VSS sg13g2_dfrbpq_1
X_228_ net11 net41 _054_ _022_ VDD VSS sg13g2_dfrbpq_1
X_229_ net12 net42 _055_ _023_ VDD VSS sg13g2_dfrbpq_1
X_230_ counter[0] net41 _056_ _024_ VDD VSS sg13g2_dfrbpq_1
X_231_ counter[1] net41 _057_ _025_ VDD VSS sg13g2_dfrbpq_1
X_232_ counter[2] net41 _058_ _026_ VDD VSS sg13g2_dfrbpq_1
X_233_ counter[3] net41 _059_ _027_ VDD VSS sg13g2_dfrbpq_1
X_234_ _001_ clknet_1_1__leaf_fclk_in_regs _060_ _028_ VDD VSS sg13g2_dfrbpq_1
X_235_ cnt[0] clknet_1_0__leaf_fclk_in_regs _061_ _029_ VDD VSS sg13g2_dfrbpq_1
X_236_ cnt[1] clknet_1_0__leaf_fclk_in_regs _062_ _030_ VDD VSS sg13g2_dfrbpq_1
X_237_ cnt[2] clknet_1_0__leaf_fclk_in_regs net47 _031_ VDD VSS sg13g2_dfrbpq_1
X_238_ cnt[3] clknet_1_1__leaf_fclk_in_regs _064_ _032_ VDD VSS sg13g2_dfrbpq_1
X_239_ net30 clknet_1_1__leaf_fclk_in_regs net45 _033_ VDD VSS sg13g2_dfrbpq_1
X_240_ net28 clknet_1_0__leaf_fclk_in VDD VSS sg13g2_buf_1
Xinput1 net1 En VDD VSS sg13g2_buf_1
Xinput2 net2 Om VDD VSS sg13g2_buf_1
Xinput3 net3 Op VDD VSS sg13g2_buf_1
Xinput4 net4 clk_algo VDD VSS sg13g2_buf_1
Xinput5 net5 rst VDD VSS sg13g2_buf_1
Xoutput6 BN[0] net6 VDD VSS sg13g2_buf_1
Xoutput7 BN[1] net7 VDD VSS sg13g2_buf_1
Xoutput8 BN[2] net8 VDD VSS sg13g2_buf_1
Xoutput9 BN[3] net9 VDD VSS sg13g2_buf_1
Xoutput10 BN[4] net10 VDD VSS sg13g2_buf_1
Xoutput11 BN[5] net11 VDD VSS sg13g2_buf_1
Xoutput12 BN[6] net12 VDD VSS sg13g2_buf_1
Xoutput13 B[0] net13 VDD VSS sg13g2_buf_1
Xoutput14 B[1] net14 VDD VSS sg13g2_buf_1
Xoutput15 B[2] net15 VDD VSS sg13g2_buf_1
Xoutput16 B[3] net16 VDD VSS sg13g2_buf_1
Xoutput17 B[4] net17 VDD VSS sg13g2_buf_1
Xoutput18 B[5] net18 VDD VSS sg13g2_buf_1
Xoutput19 B[6] net19 VDD VSS sg13g2_buf_1
Xoutput20 D[0] net20 VDD VSS sg13g2_buf_1
Xoutput21 D[1] net21 VDD VSS sg13g2_buf_1
Xoutput22 D[2] net22 VDD VSS sg13g2_buf_1
Xoutput23 D[3] net23 VDD VSS sg13g2_buf_1
Xoutput24 D[4] net24 VDD VSS sg13g2_buf_1
Xoutput25 D[5] net25 VDD VSS sg13g2_buf_1
Xoutput26 D[6] net26 VDD VSS sg13g2_buf_1
Xoutput27 D[7] net27 VDD VSS sg13g2_buf_1
Xoutput28 fclk_comp net28 VDD VSS sg13g2_buf_1
Xoutput29 fclk_samp net29 VDD VSS sg13g2_buf_1
Xoutput30 fdac_clk net30 VDD VSS sg13g2_buf_1
Xfanout31 net31 _074_ VDD VSS sg13g2_buf_1
Xfanout32 net32 net33 VDD VSS sg13g2_buf_1
Xfanout33 net33 _089_ VDD VSS sg13g2_buf_1
Xfanout34 net34 net35 VDD VSS sg13g2_buf_1
Xfanout35 net35 net39 VDD VSS sg13g2_buf_1
Xfanout36 net36 net39 VDD VSS sg13g2_buf_1
Xfanout37 net37 net39 VDD VSS sg13g2_buf_1
Xfanout38 net38 net39 VDD VSS sg13g2_buf_1
Xfanout39 net39 net5 VDD VSS sg13g2_buf_1
Xfanout40 net40 net41 VDD VSS sg13g2_buf_1
Xfanout41 net41 net4 VDD VSS sg13g2_buf_1
Xfanout42 net42 net4 VDD VSS sg13g2_buf_1
Xfanout43 net43 net4 VDD VSS sg13g2_buf_1
Xclkbuf_regs_0_fclk_in fclk_in_regs fclk_in VDD VSS sg13g2_buf_16
Xclkbuf_0_fclk_in clknet_0_fclk_in fclk_in VDD VSS sg13g2_buf_16
Xclkbuf_1_0__f_fclk_in clknet_1_0__leaf_fclk_in clknet_0_fclk_in VDD VSS sg13g2_buf_16
Xclkbuf_0_fclk_in_regs clknet_0_fclk_in_regs fclk_in_regs VDD VSS sg13g2_buf_16
Xclkbuf_1_0__f_fclk_in_regs clknet_1_0__leaf_fclk_in_regs clknet_0_fclk_in_regs VDD VSS sg13g2_buf_16
Xclkbuf_1_1__f_fclk_in_regs clknet_1_1__leaf_fclk_in_regs clknet_0_fclk_in_regs VDD VSS sg13g2_buf_16
Xhold44 net44 cnt[3] VDD VSS sg13g2_dlygate4sd3_1
Xhold45 net45 _000_ VDD VSS sg13g2_dlygate4sd3_1
Xhold46 net46 cnt[2] VDD VSS sg13g2_dlygate4sd3_1
Xhold47 net47 _063_ VDD VSS sg13g2_dlygate4sd3_1
Xhold48 net48 cnt[1] VDD VSS sg13g2_dlygate4sd3_1
Xhold49 net49 _070_ VDD VSS sg13g2_dlygate4sd3_1
Xhold50 net50 cnt[0] VDD VSS sg13g2_dlygate4sd3_1
Xhold51 net51 _001_ VDD VSS sg13g2_dlygate4sd3_1
XFILLER_0_4 VDD VSS sg13g2_decap_8
XFILLER_0_15 VDD VSS sg13g2_decap_8
XFILLER_0_22 VDD VSS sg13g2_decap_8
XFILLER_0_29 VDD VSS sg13g2_decap_8
XFILLER_0_36 VDD VSS sg13g2_fill_2
XFILLER_0_77 VDD VSS sg13g2_fill_2
XFILLER_0_79 VDD VSS sg13g2_fill_1
XFILLER_0_110 VDD VSS sg13g2_decap_4
XFILLER_0_123 VDD VSS sg13g2_fill_2
XFILLER_0_182 VDD VSS sg13g2_decap_8
XFILLER_0_189 VDD VSS sg13g2_fill_2
XFILLER_0_200 VDD VSS sg13g2_decap_8
XFILLER_0_207 VDD VSS sg13g2_decap_8
XFILLER_0_214 VDD VSS sg13g2_decap_8
XFILLER_0_221 VDD VSS sg13g2_decap_4
XFILLER_0_225 VDD VSS sg13g2_fill_2
XFILLER_0_231 VDD VSS sg13g2_decap_8
XFILLER_0_238 VDD VSS sg13g2_fill_1
XFILLER_0_242 VDD VSS sg13g2_decap_8
XFILLER_0_249 VDD VSS sg13g2_decap_8
XFILLER_0_256 VDD VSS sg13g2_decap_8
XFILLER_0_267 VDD VSS sg13g2_decap_8
XFILLER_0_274 VDD VSS sg13g2_decap_8
XFILLER_0_281 VDD VSS sg13g2_decap_8
XFILLER_0_288 VDD VSS sg13g2_decap_8
XFILLER_0_295 VDD VSS sg13g2_decap_4
XFILLER_0_303 VDD VSS sg13g2_fill_2
XFILLER_1_4 VDD VSS sg13g2_decap_8
XFILLER_1_11 VDD VSS sg13g2_decap_8
XFILLER_1_18 VDD VSS sg13g2_decap_8
XFILLER_1_25 VDD VSS sg13g2_decap_8
XFILLER_1_32 VDD VSS sg13g2_decap_8
XFILLER_1_39 VDD VSS sg13g2_decap_8
XFILLER_1_80 VDD VSS sg13g2_fill_1
XFILLER_1_153 VDD VSS sg13g2_fill_1
XFILLER_1_181 VDD VSS sg13g2_fill_1
XFILLER_1_218 VDD VSS sg13g2_decap_8
XFILLER_1_225 VDD VSS sg13g2_fill_2
XFILLER_1_264 VDD VSS sg13g2_decap_8
XFILLER_1_271 VDD VSS sg13g2_decap_8
XFILLER_1_278 VDD VSS sg13g2_decap_8
XFILLER_1_285 VDD VSS sg13g2_decap_8
XFILLER_1_292 VDD VSS sg13g2_decap_8
XFILLER_1_299 VDD VSS sg13g2_decap_4
XFILLER_1_303 VDD VSS sg13g2_fill_2
XFILLER_2_0 VDD VSS sg13g2_decap_8
XFILLER_2_7 VDD VSS sg13g2_decap_8
XFILLER_2_14 VDD VSS sg13g2_decap_8
XFILLER_2_21 VDD VSS sg13g2_decap_8
XFILLER_2_28 VDD VSS sg13g2_decap_8
XFILLER_2_35 VDD VSS sg13g2_decap_8
XFILLER_2_42 VDD VSS sg13g2_decap_8
XFILLER_2_49 VDD VSS sg13g2_fill_1
XFILLER_2_80 VDD VSS sg13g2_fill_2
XFILLER_2_82 VDD VSS sg13g2_fill_1
XFILLER_2_94 VDD VSS sg13g2_fill_2
XFILLER_2_132 VDD VSS sg13g2_fill_2
XFILLER_2_159 VDD VSS sg13g2_fill_2
XFILLER_2_170 VDD VSS sg13g2_fill_1
XFILLER_2_204 VDD VSS sg13g2_decap_8
XFILLER_2_211 VDD VSS sg13g2_decap_8
XFILLER_2_218 VDD VSS sg13g2_decap_8
XFILLER_2_225 VDD VSS sg13g2_decap_8
XFILLER_2_232 VDD VSS sg13g2_decap_8
XFILLER_2_239 VDD VSS sg13g2_decap_8
XFILLER_2_246 VDD VSS sg13g2_decap_4
XFILLER_2_250 VDD VSS sg13g2_fill_1
XFILLER_2_255 VDD VSS sg13g2_decap_8
XFILLER_2_262 VDD VSS sg13g2_decap_8
XFILLER_2_269 VDD VSS sg13g2_decap_8
XFILLER_2_276 VDD VSS sg13g2_decap_8
XFILLER_2_283 VDD VSS sg13g2_decap_8
XFILLER_2_290 VDD VSS sg13g2_decap_8
XFILLER_2_297 VDD VSS sg13g2_decap_8
XFILLER_2_304 VDD VSS sg13g2_decap_4
XFILLER_2_308 VDD VSS sg13g2_fill_1
XFILLER_3_0 VDD VSS sg13g2_decap_8
XFILLER_3_7 VDD VSS sg13g2_decap_8
XFILLER_3_14 VDD VSS sg13g2_decap_8
XFILLER_3_21 VDD VSS sg13g2_decap_8
XFILLER_3_28 VDD VSS sg13g2_decap_8
XFILLER_3_35 VDD VSS sg13g2_decap_8
XFILLER_3_42 VDD VSS sg13g2_decap_8
XFILLER_3_49 VDD VSS sg13g2_fill_2
XFILLER_3_51 VDD VSS sg13g2_fill_1
XFILLER_3_87 VDD VSS sg13g2_decap_4
XFILLER_3_91 VDD VSS sg13g2_fill_2
XFILLER_3_178 VDD VSS sg13g2_decap_8
XFILLER_3_185 VDD VSS sg13g2_fill_1
XFILLER_3_190 VDD VSS sg13g2_fill_2
XFILLER_3_195 VDD VSS sg13g2_decap_8
XFILLER_3_202 VDD VSS sg13g2_decap_8
XFILLER_3_209 VDD VSS sg13g2_decap_8
XFILLER_3_216 VDD VSS sg13g2_decap_8
XFILLER_3_223 VDD VSS sg13g2_decap_8
XFILLER_3_230 VDD VSS sg13g2_decap_8
XFILLER_3_237 VDD VSS sg13g2_decap_8
XFILLER_3_244 VDD VSS sg13g2_decap_8
XFILLER_3_251 VDD VSS sg13g2_decap_8
XFILLER_3_258 VDD VSS sg13g2_decap_8
XFILLER_3_265 VDD VSS sg13g2_decap_8
XFILLER_3_272 VDD VSS sg13g2_decap_8
XFILLER_3_279 VDD VSS sg13g2_decap_8
XFILLER_3_286 VDD VSS sg13g2_decap_8
XFILLER_3_293 VDD VSS sg13g2_decap_8
XFILLER_3_300 VDD VSS sg13g2_decap_8
XFILLER_3_307 VDD VSS sg13g2_fill_2
XFILLER_4_4 VDD VSS sg13g2_decap_8
XFILLER_4_11 VDD VSS sg13g2_decap_8
XFILLER_4_18 VDD VSS sg13g2_decap_8
XFILLER_4_25 VDD VSS sg13g2_decap_8
XFILLER_4_32 VDD VSS sg13g2_decap_8
XFILLER_4_39 VDD VSS sg13g2_decap_8
XFILLER_4_46 VDD VSS sg13g2_decap_8
XFILLER_4_63 VDD VSS sg13g2_decap_4
XFILLER_4_97 VDD VSS sg13g2_fill_2
XFILLER_4_166 VDD VSS sg13g2_fill_2
XFILLER_4_217 VDD VSS sg13g2_decap_8
XFILLER_4_224 VDD VSS sg13g2_decap_8
XFILLER_4_231 VDD VSS sg13g2_decap_8
XFILLER_4_238 VDD VSS sg13g2_decap_8
XFILLER_4_245 VDD VSS sg13g2_decap_8
XFILLER_4_252 VDD VSS sg13g2_decap_8
XFILLER_4_259 VDD VSS sg13g2_decap_8
XFILLER_4_266 VDD VSS sg13g2_decap_8
XFILLER_4_273 VDD VSS sg13g2_decap_8
XFILLER_4_280 VDD VSS sg13g2_decap_8
XFILLER_4_287 VDD VSS sg13g2_decap_8
XFILLER_4_294 VDD VSS sg13g2_decap_8
XFILLER_4_301 VDD VSS sg13g2_decap_4
XFILLER_5_0 VDD VSS sg13g2_decap_8
XFILLER_5_7 VDD VSS sg13g2_decap_8
XFILLER_5_14 VDD VSS sg13g2_decap_8
XFILLER_5_21 VDD VSS sg13g2_decap_8
XFILLER_5_28 VDD VSS sg13g2_decap_8
XFILLER_5_35 VDD VSS sg13g2_decap_8
XFILLER_5_42 VDD VSS sg13g2_decap_8
XFILLER_5_49 VDD VSS sg13g2_decap_8
XFILLER_5_56 VDD VSS sg13g2_decap_8
XFILLER_5_63 VDD VSS sg13g2_decap_8
XFILLER_5_70 VDD VSS sg13g2_decap_8
XFILLER_5_77 VDD VSS sg13g2_decap_4
XFILLER_5_91 VDD VSS sg13g2_decap_8
XFILLER_5_98 VDD VSS sg13g2_decap_8
XFILLER_5_105 VDD VSS sg13g2_fill_1
XFILLER_5_152 VDD VSS sg13g2_fill_1
XFILLER_5_180 VDD VSS sg13g2_decap_8
XFILLER_5_191 VDD VSS sg13g2_decap_8
XFILLER_5_198 VDD VSS sg13g2_decap_4
XFILLER_5_205 VDD VSS sg13g2_decap_8
XFILLER_5_212 VDD VSS sg13g2_decap_8
XFILLER_5_219 VDD VSS sg13g2_decap_8
XFILLER_5_226 VDD VSS sg13g2_decap_8
XFILLER_5_233 VDD VSS sg13g2_decap_8
XFILLER_5_240 VDD VSS sg13g2_decap_8
XFILLER_5_247 VDD VSS sg13g2_decap_8
XFILLER_5_254 VDD VSS sg13g2_decap_8
XFILLER_5_261 VDD VSS sg13g2_decap_8
XFILLER_5_268 VDD VSS sg13g2_decap_8
XFILLER_5_275 VDD VSS sg13g2_decap_8
XFILLER_5_282 VDD VSS sg13g2_decap_8
XFILLER_5_289 VDD VSS sg13g2_decap_8
XFILLER_5_296 VDD VSS sg13g2_decap_8
XFILLER_5_303 VDD VSS sg13g2_decap_4
XFILLER_5_307 VDD VSS sg13g2_fill_2
XFILLER_6_0 VDD VSS sg13g2_decap_8
XFILLER_6_7 VDD VSS sg13g2_decap_8
XFILLER_6_14 VDD VSS sg13g2_decap_8
XFILLER_6_21 VDD VSS sg13g2_decap_8
XFILLER_6_28 VDD VSS sg13g2_decap_8
XFILLER_6_35 VDD VSS sg13g2_decap_8
XFILLER_6_42 VDD VSS sg13g2_decap_8
XFILLER_6_49 VDD VSS sg13g2_decap_8
XFILLER_6_56 VDD VSS sg13g2_decap_8
XFILLER_6_63 VDD VSS sg13g2_decap_8
XFILLER_6_70 VDD VSS sg13g2_decap_4
XFILLER_6_104 VDD VSS sg13g2_decap_8
XFILLER_6_111 VDD VSS sg13g2_fill_2
XFILLER_6_113 VDD VSS sg13g2_fill_1
XFILLER_6_117 VDD VSS sg13g2_decap_8
XFILLER_6_142 VDD VSS sg13g2_decap_8
XFILLER_6_153 VDD VSS sg13g2_decap_8
XFILLER_6_160 VDD VSS sg13g2_decap_8
XFILLER_6_171 VDD VSS sg13g2_decap_8
XFILLER_6_178 VDD VSS sg13g2_decap_8
XFILLER_6_185 VDD VSS sg13g2_decap_4
XFILLER_6_189 VDD VSS sg13g2_fill_1
XFILLER_6_226 VDD VSS sg13g2_decap_8
XFILLER_6_233 VDD VSS sg13g2_decap_8
XFILLER_6_240 VDD VSS sg13g2_decap_8
XFILLER_6_247 VDD VSS sg13g2_decap_8
XFILLER_6_254 VDD VSS sg13g2_decap_8
XFILLER_6_261 VDD VSS sg13g2_decap_8
XFILLER_6_268 VDD VSS sg13g2_decap_8
XFILLER_6_275 VDD VSS sg13g2_decap_8
XFILLER_6_282 VDD VSS sg13g2_decap_8
XFILLER_6_289 VDD VSS sg13g2_decap_8
XFILLER_6_296 VDD VSS sg13g2_decap_8
XFILLER_6_303 VDD VSS sg13g2_decap_4
XFILLER_6_307 VDD VSS sg13g2_fill_2
XFILLER_7_4 VDD VSS sg13g2_decap_8
XFILLER_7_11 VDD VSS sg13g2_decap_8
XFILLER_7_18 VDD VSS sg13g2_decap_8
XFILLER_7_25 VDD VSS sg13g2_decap_8
XFILLER_7_32 VDD VSS sg13g2_decap_8
XFILLER_7_39 VDD VSS sg13g2_decap_8
XFILLER_7_46 VDD VSS sg13g2_decap_8
XFILLER_7_53 VDD VSS sg13g2_fill_2
XFILLER_7_60 VDD VSS sg13g2_decap_8
XFILLER_7_67 VDD VSS sg13g2_decap_8
XFILLER_7_74 VDD VSS sg13g2_decap_8
XFILLER_7_81 VDD VSS sg13g2_decap_8
XFILLER_7_88 VDD VSS sg13g2_decap_4
XFILLER_7_92 VDD VSS sg13g2_fill_2
XFILLER_7_126 VDD VSS sg13g2_fill_2
XFILLER_7_128 VDD VSS sg13g2_fill_1
XFILLER_7_144 VDD VSS sg13g2_fill_2
XFILLER_7_153 VDD VSS sg13g2_fill_1
XFILLER_7_193 VDD VSS sg13g2_decap_8
XFILLER_7_200 VDD VSS sg13g2_decap_8
XFILLER_7_207 VDD VSS sg13g2_decap_8
XFILLER_7_214 VDD VSS sg13g2_decap_8
XFILLER_7_221 VDD VSS sg13g2_decap_8
XFILLER_7_228 VDD VSS sg13g2_fill_2
XFILLER_7_233 VDD VSS sg13g2_decap_8
XFILLER_7_240 VDD VSS sg13g2_decap_8
XFILLER_7_247 VDD VSS sg13g2_decap_8
XFILLER_7_254 VDD VSS sg13g2_decap_8
XFILLER_7_261 VDD VSS sg13g2_decap_8
XFILLER_7_268 VDD VSS sg13g2_decap_8
XFILLER_7_275 VDD VSS sg13g2_decap_8
XFILLER_7_282 VDD VSS sg13g2_decap_8
XFILLER_7_289 VDD VSS sg13g2_decap_8
XFILLER_7_296 VDD VSS sg13g2_decap_8
XFILLER_7_303 VDD VSS sg13g2_fill_2
XFILLER_8_0 VDD VSS sg13g2_decap_8
XFILLER_8_7 VDD VSS sg13g2_decap_8
XFILLER_8_14 VDD VSS sg13g2_decap_8
XFILLER_8_21 VDD VSS sg13g2_decap_8
XFILLER_8_28 VDD VSS sg13g2_decap_8
XFILLER_8_35 VDD VSS sg13g2_decap_8
XFILLER_8_42 VDD VSS sg13g2_decap_8
XFILLER_8_79 VDD VSS sg13g2_decap_8
XFILLER_8_86 VDD VSS sg13g2_fill_2
XFILLER_8_88 VDD VSS sg13g2_fill_1
XFILLER_8_94 VDD VSS sg13g2_decap_4
XFILLER_8_98 VDD VSS sg13g2_fill_2
XFILLER_8_103 VDD VSS sg13g2_decap_8
XFILLER_8_110 VDD VSS sg13g2_decap_8
XFILLER_8_117 VDD VSS sg13g2_decap_8
XFILLER_8_124 VDD VSS sg13g2_fill_2
XFILLER_8_126 VDD VSS sg13g2_fill_1
XFILLER_8_156 VDD VSS sg13g2_decap_8
XFILLER_8_163 VDD VSS sg13g2_decap_8
XFILLER_8_170 VDD VSS sg13g2_decap_8
XFILLER_8_177 VDD VSS sg13g2_decap_8
XFILLER_8_184 VDD VSS sg13g2_fill_1
XFILLER_8_215 VDD VSS sg13g2_fill_2
XFILLER_8_217 VDD VSS sg13g2_fill_1
XFILLER_8_255 VDD VSS sg13g2_decap_8
XFILLER_8_262 VDD VSS sg13g2_decap_8
XFILLER_8_269 VDD VSS sg13g2_decap_8
XFILLER_8_276 VDD VSS sg13g2_decap_8
XFILLER_8_283 VDD VSS sg13g2_decap_8
XFILLER_8_290 VDD VSS sg13g2_decap_8
XFILLER_8_297 VDD VSS sg13g2_decap_8
XFILLER_8_304 VDD VSS sg13g2_decap_4
XFILLER_8_308 VDD VSS sg13g2_fill_1
XFILLER_9_4 VDD VSS sg13g2_decap_8
XFILLER_9_11 VDD VSS sg13g2_decap_8
XFILLER_9_18 VDD VSS sg13g2_decap_8
XFILLER_9_25 VDD VSS sg13g2_decap_8
XFILLER_9_32 VDD VSS sg13g2_decap_8
XFILLER_9_39 VDD VSS sg13g2_decap_8
XFILLER_9_46 VDD VSS sg13g2_decap_8
XFILLER_9_53 VDD VSS sg13g2_fill_2
XFILLER_9_55 VDD VSS sg13g2_fill_1
XFILLER_9_60 VDD VSS sg13g2_decap_8
XFILLER_9_67 VDD VSS sg13g2_fill_1
XFILLER_9_102 VDD VSS sg13g2_decap_8
XFILLER_9_109 VDD VSS sg13g2_decap_8
XFILLER_9_116 VDD VSS sg13g2_decap_8
XFILLER_9_123 VDD VSS sg13g2_decap_8
XFILLER_9_130 VDD VSS sg13g2_fill_2
XFILLER_9_132 VDD VSS sg13g2_fill_1
XFILLER_9_136 VDD VSS sg13g2_fill_2
XFILLER_9_138 VDD VSS sg13g2_fill_1
XFILLER_9_153 VDD VSS sg13g2_decap_8
XFILLER_9_160 VDD VSS sg13g2_decap_8
XFILLER_9_177 VDD VSS sg13g2_decap_8
XFILLER_9_184 VDD VSS sg13g2_decap_8
XFILLER_9_191 VDD VSS sg13g2_decap_4
XFILLER_9_195 VDD VSS sg13g2_fill_2
XFILLER_9_207 VDD VSS sg13g2_decap_8
XFILLER_9_214 VDD VSS sg13g2_decap_4
XFILLER_9_228 VDD VSS sg13g2_fill_2
XFILLER_9_230 VDD VSS sg13g2_fill_1
XFILLER_9_235 VDD VSS sg13g2_decap_8
XFILLER_9_242 VDD VSS sg13g2_decap_8
XFILLER_9_249 VDD VSS sg13g2_decap_8
XFILLER_9_256 VDD VSS sg13g2_decap_8
XFILLER_9_263 VDD VSS sg13g2_decap_8
XFILLER_9_270 VDD VSS sg13g2_decap_8
XFILLER_9_277 VDD VSS sg13g2_decap_8
XFILLER_9_284 VDD VSS sg13g2_decap_8
XFILLER_9_291 VDD VSS sg13g2_decap_8
XFILLER_9_298 VDD VSS sg13g2_decap_8
XFILLER_10_0 VDD VSS sg13g2_decap_8
XFILLER_10_7 VDD VSS sg13g2_decap_8
XFILLER_10_14 VDD VSS sg13g2_decap_8
XFILLER_10_21 VDD VSS sg13g2_decap_8
XFILLER_10_28 VDD VSS sg13g2_decap_8
XFILLER_10_35 VDD VSS sg13g2_decap_8
XFILLER_10_42 VDD VSS sg13g2_decap_8
XFILLER_10_49 VDD VSS sg13g2_decap_8
XFILLER_10_56 VDD VSS sg13g2_decap_8
XFILLER_10_63 VDD VSS sg13g2_decap_8
XFILLER_10_70 VDD VSS sg13g2_fill_2
XFILLER_10_102 VDD VSS sg13g2_decap_8
XFILLER_10_109 VDD VSS sg13g2_decap_8
XFILLER_10_116 VDD VSS sg13g2_fill_2
XFILLER_10_128 VDD VSS sg13g2_decap_8
XFILLER_10_135 VDD VSS sg13g2_decap_8
XFILLER_10_142 VDD VSS sg13g2_fill_2
XFILLER_10_157 VDD VSS sg13g2_decap_8
XFILLER_10_164 VDD VSS sg13g2_decap_4
XFILLER_10_181 VDD VSS sg13g2_decap_8
XFILLER_10_188 VDD VSS sg13g2_fill_1
XFILLER_10_222 VDD VSS sg13g2_fill_2
XFILLER_10_224 VDD VSS sg13g2_fill_1
XFILLER_10_255 VDD VSS sg13g2_decap_4
XFILLER_10_289 VDD VSS sg13g2_decap_8
XFILLER_10_296 VDD VSS sg13g2_decap_8
XFILLER_10_303 VDD VSS sg13g2_decap_4
XFILLER_10_307 VDD VSS sg13g2_fill_2
XFILLER_11_0 VDD VSS sg13g2_decap_8
XFILLER_11_7 VDD VSS sg13g2_decap_8
XFILLER_11_14 VDD VSS sg13g2_decap_8
XFILLER_11_21 VDD VSS sg13g2_decap_8
XFILLER_11_28 VDD VSS sg13g2_decap_8
XFILLER_11_35 VDD VSS sg13g2_decap_8
XFILLER_11_42 VDD VSS sg13g2_decap_8
XFILLER_11_49 VDD VSS sg13g2_decap_8
XFILLER_11_56 VDD VSS sg13g2_decap_8
XFILLER_11_63 VDD VSS sg13g2_decap_8
XFILLER_11_70 VDD VSS sg13g2_decap_4
XFILLER_11_77 VDD VSS sg13g2_fill_2
XFILLER_11_79 VDD VSS sg13g2_fill_1
XFILLER_11_171 VDD VSS sg13g2_fill_1
XFILLER_11_199 VDD VSS sg13g2_decap_8
XFILLER_11_206 VDD VSS sg13g2_fill_1
XFILLER_11_244 VDD VSS sg13g2_decap_8
XFILLER_11_251 VDD VSS sg13g2_fill_1
XFILLER_11_289 VDD VSS sg13g2_decap_8
XFILLER_11_296 VDD VSS sg13g2_decap_8
XFILLER_11_303 VDD VSS sg13g2_decap_4
XFILLER_11_307 VDD VSS sg13g2_fill_2
XFILLER_12_8 VDD VSS sg13g2_decap_8
XFILLER_12_19 VDD VSS sg13g2_decap_8
XFILLER_12_26 VDD VSS sg13g2_decap_8
XFILLER_12_33 VDD VSS sg13g2_decap_8
XFILLER_12_40 VDD VSS sg13g2_decap_8
XFILLER_12_47 VDD VSS sg13g2_decap_8
XFILLER_12_54 VDD VSS sg13g2_fill_1
XFILLER_12_59 VDD VSS sg13g2_decap_8
XFILLER_12_66 VDD VSS sg13g2_decap_8
XFILLER_12_73 VDD VSS sg13g2_decap_8
XFILLER_12_80 VDD VSS sg13g2_decap_8
XFILLER_12_87 VDD VSS sg13g2_decap_4
XFILLER_12_91 VDD VSS sg13g2_fill_2
XFILLER_12_107 VDD VSS sg13g2_decap_8
XFILLER_12_114 VDD VSS sg13g2_decap_4
XFILLER_12_118 VDD VSS sg13g2_fill_1
XFILLER_12_122 VDD VSS sg13g2_decap_8
XFILLER_12_129 VDD VSS sg13g2_decap_4
XFILLER_12_133 VDD VSS sg13g2_fill_2
XFILLER_12_139 VDD VSS sg13g2_decap_8
XFILLER_12_146 VDD VSS sg13g2_fill_1
XFILLER_12_150 VDD VSS sg13g2_decap_8
XFILLER_12_157 VDD VSS sg13g2_decap_8
XFILLER_12_164 VDD VSS sg13g2_decap_8
XFILLER_12_171 VDD VSS sg13g2_fill_1
XFILLER_12_179 VDD VSS sg13g2_decap_8
XFILLER_12_186 VDD VSS sg13g2_decap_8
XFILLER_12_193 VDD VSS sg13g2_decap_8
XFILLER_12_200 VDD VSS sg13g2_decap_8
XFILLER_12_207 VDD VSS sg13g2_decap_8
XFILLER_12_214 VDD VSS sg13g2_fill_1
XFILLER_12_219 VDD VSS sg13g2_decap_8
XFILLER_12_226 VDD VSS sg13g2_decap_4
XFILLER_12_230 VDD VSS sg13g2_fill_1
XFILLER_12_235 VDD VSS sg13g2_decap_8
XFILLER_12_242 VDD VSS sg13g2_decap_8
XFILLER_12_249 VDD VSS sg13g2_fill_1
XFILLER_12_267 VDD VSS sg13g2_decap_8
XFILLER_12_274 VDD VSS sg13g2_decap_8
XFILLER_12_281 VDD VSS sg13g2_decap_8
XFILLER_12_288 VDD VSS sg13g2_decap_8
XFILLER_12_299 VDD VSS sg13g2_fill_2

.ENDS sar_algo
